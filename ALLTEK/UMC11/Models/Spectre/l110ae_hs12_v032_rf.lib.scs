simulator lang=spectre insensitive=yes
//  ******************************************************************************
//  TT: Typical n-ch MOSFET and Typical p-ch MOSFET
//  FF: Fast n-ch MOSFET and Fast p-ch MOSFET
//  SS: Slow n-ch MOSFET and Slow p-ch MOSFET
//  FNSP: Fast n-ch MOSFET and Slow p-ch MOSFET
//  SNFP: Slow n-ch MOSFET and Fast p-ch MOSFET
//  ******************************************************************************
//

library mylib

section tt
parameters dtox_n_12_hsrf=0
parameters dxl_n_12_hsrf=0
parameters du0_n_12_hsrf=0
parameters dvth0_n_12_hsrf=0
parameters drdsw_n_12_hsrf=0
parameters dxw_n_12_hsrf=0
parameters dnlx_n_12_hsrf=0
parameters dk3_n_12_hsrf=0
parameters dpvth0_n_12_hsrf=0
parameters dwwl_n_12_hsrf=0
parameters ddlc_n_12_hsrf=0
parameters ddwc_n_12_hsrf=0
parameters dcgdo_n_12_hsrf=0
parameters dcgso_n_12_hsrf=0
parameters dleta0_n_12_hsrf=0
parameters dcj_n_12_hsrf=0
parameters dcjsw_n_12_hsrf=0
parameters dcjswg_n_12_hsrf=0
parameters dpvsat_n_12_hsrf=0
parameters drgi_n_12_hsrf=0
parameters drch_n_12_hsrf=0
parameters drgc_n_12_hsrf=0
parameters dcgd_ext_n_12_hsrf=0
parameters dcds_ext_n_12_hsrf=0
parameters dcj_nwtw_n_12bpw_hsrf=0
parameters dcjsw_nw_n_12bpw_hsrf=0
parameters dcjsw_nwtw_n_12bpw_hsrf=0
parameters dcj_nw_n_12bpw_hsrf=0
parameters dtox_p_12_hsrf=0
parameters dxl_p_12_hsrf=0
parameters du0_p_12_hsrf=0
parameters dvth0_p_12_hsrf=0
parameters drdsw_p_12_hsrf=0
parameters dxw_p_12_hsrf=0
parameters dnlx_p_12_hsrf=0
parameters dk3_p_12_hsrf=0
parameters dpvth0_p_12_hsrf=0
parameters dwwl_p_12_hsrf=0
parameters ddlc_p_12_hsrf=0
parameters dwlc_p_12_hsrf=0
parameters dcgdo_p_12_hsrf=0
parameters dcgso_p_12_hsrf=0
parameters dcj_p_12_hsrf=0
parameters dcjsw_p_12_hsrf=0
parameters dcjswg_p_12_hsrf=0
parameters drgi_p_12_hsrf=0
parameters drch_p_12_hsrf=0
parameters drgc_p_12_hsrf=0
parameters dcgd_ext_p_12_hsrf=0
parameters dcds_ext_p_12_hsrf=0
parameters dcj_nw_p_12_hsrf=0
parameters cjsw_nw_p_12_hsrf=0
//
include "l110ae_hs12_v032_rf.mdl.scs"
endsection tt

section ff
parameters dtox_n_12_hsrf=-7.89000e-11
parameters dxl_n_12_hsrf=-5.00000e-09
parameters du0_n_12_hsrf=0.51190e-03
parameters dvth0_n_12_hsrf=-5.11890e-02
parameters drdsw_n_12_hsrf=-10.92330e+00
parameters dxw_n_12_hsrf=7.55640e-09
parameters dnlx_n_12_hsrf=1e-9
parameters dk3_n_12_hsrf=-2.66620e+00
parameters dpvth0_n_12_hsrf=-2.56580e-15
parameters dwwl_n_12_hsrf=0
parameters ddlc_n_12_hsrf=3.5e-9
parameters ddwc_n_12_hsrf=0
parameters dcgdo_n_12_hsrf=1.80500e-11
parameters dcgso_n_12_hsrf=1.805e-11
parameters dleta0_n_12_hsrf=-1.5e-9
parameters dcj_n_12_hsrf=-0.000072
parameters dcjsw_n_12_hsrf=-1.06e-11
parameters dcjswg_n_12_hsrf=-0.1
parameters dpvsat_n_12_hsrf=-3e-10
parameters drgi_n_12_hsrf=-0.2
parameters drch_n_12_hsrf=-0.2
parameters drgc_n_12_hsrf=-0.2
parameters dcgd_ext_n_12_hsrf=-0.2
parameters dcds_ext_n_12_hsrf=-0.2
parameters dcj_nwtw_n_12bpw_hsrf=-0.1
parameters dcjsw_nw_n_12bpw_hsrf=-0.1
parameters dcjsw_nwtw_n_12bpw_hsrf=-0.1
parameters dcj_nw_n_12bpw_hsrf=-0.1
parameters dtox_p_12_hsrf=-8.49000e-11
parameters dxl_p_12_hsrf=-5.00000e-09
parameters du0_p_12_hsrf=0.01510e-04
parameters dvth0_p_12_hsrf=3.99150e-02
parameters drdsw_p_12_hsrf=-0.00040e+01
parameters dxw_p_12_hsrf=-1.00000e-08
parameters dnlx_p_12_hsrf=-9.82190e-09
parameters dk3_p_12_hsrf=-2.00000e+01
parameters dpvth0_p_12_hsrf=2.14850e-16
parameters dwwl_p_12_hsrf=5.09010e-23
parameters ddlc_p_12_hsrf=6e-9
parameters dwlc_p_12_hsrf=-5e-15
parameters dcgdo_p_12_hsrf=2.00000e-11
parameters dcgso_p_12_hsrf=2.00000e-11
parameters dcj_p_12_hsrf=-0.1
parameters dcjsw_p_12_hsrf=-1.18e-11
parameters dcjswg_p_12_hsrf=-4.82e-011
parameters drgi_p_12_hsrf=-0.2
parameters drch_p_12_hsrf=-0.2
parameters drgc_p_12_hsrf=-0.2
parameters dcgd_ext_p_12_hsrf=-0.2
parameters dcds_ext_p_12_hsrf=-0.2
parameters dcj_nw_p_12_hsrf=-0.1
parameters cjsw_nw_p_12_hsrf=-0.1
//
include "l110ae_hs12_v032_rf.mdl.scs"
endsection ff

section ss
parameters dtox_n_12_hsrf=7.89000e-11
parameters dxl_n_12_hsrf=5.00000e-09
parameters du0_n_12_hsrf=-1.00460e-03
parameters dvth0_n_12_hsrf=4.81690e-02
parameters drdsw_n_12_hsrf=20.7592e+00
parameters dxw_n_12_hsrf=-1.00000e-08
parameters dnlx_n_12_hsrf=1e-9
parameters dk3_n_12_hsrf=1.43710e+00
parameters dpvth0_n_12_hsrf=2.54610e-15
parameters dwwl_n_12_hsrf=4.28220e-23
parameters ddlc_n_12_hsrf=-7e-9
parameters ddwc_n_12_hsrf=0
parameters dcgdo_n_12_hsrf=-1.80500e-11
parameters dcgso_n_12_hsrf=-1.80500e-11
parameters dleta0_n_12_hsrf=1.5e-9
parameters dcj_n_12_hsrf=0.000072
parameters dcjsw_n_12_hsrf=1.06e-11
parameters dcjswg_n_12_hsrf=0.1
parameters dpvsat_n_12_hsrf=2.5e-10
parameters drgi_n_12_hsrf=0.2
parameters drch_n_12_hsrf=0.2
parameters drgc_n_12_hsrf=0.2
parameters dcgd_ext_n_12_hsrf=0.2
parameters dcds_ext_n_12_hsrf=0.2
parameters dcj_nwtw_n_12bpw_hsrf=0.1
parameters dcjsw_nw_n_12bpw_hsrf=0.1
parameters dcjsw_nwtw_n_12bpw_hsrf=0.1
parameters dcj_nw_n_12bpw_hsrf=0.1
parameters dtox_p_12_hsrf=8.49000e-11
parameters dxl_p_12_hsrf=5.00000e-09
parameters du0_p_12_hsrf=1.56170e-05
parameters dvth0_p_12_hsrf=-4.28110e-02
parameters drdsw_p_12_hsrf=1.35980e+01
parameters dxw_p_12_hsrf=8.00000e-09
parameters dnlx_p_12_hsrf=1.26490e-08
parameters dk3_p_12_hsrf=2.00000e+01
parameters dpvth0_p_12_hsrf=-5.54950e-16
parameters dwwl_p_12_hsrf=5.73340e-23
parameters ddlc_p_12_hsrf=-0.9e-8
parameters dwlc_p_12_hsrf=2e-15
parameters dcgdo_p_12_hsrf=-2.00000e-11
parameters dcgso_p_12_hsrf=-2.00000e-11
parameters dcj_p_12_hsrf=0.1
parameters dcjsw_p_12_hsrf=1.18e-11
parameters dcjswg_p_12_hsrf=4.82e-011
parameters drgi_p_12_hsrf=0.2
parameters drch_p_12_hsrf=0.2
parameters drgc_p_12_hsrf=0.2
parameters dcgd_ext_p_12_hsrf=0.2
parameters dcds_ext_p_12_hsrf=0.2
parameters dcj_nw_p_12_hsrf=0.1
parameters cjsw_nw_p_12_hsrf=0.1
//
include "l110ae_hs12_v032_rf.mdl.scs"
endsection ss

section fnsp
parameters dtox_n_12_hsrf=0.00000e+00
parameters dxl_n_12_hsrf=-5.00000e-09
parameters du0_n_12_hsrf=1.50810e-03
parameters dvth0_n_12_hsrf=-2.00120e-02
parameters drdsw_n_12_hsrf=-6.1490e+00
parameters dxw_n_12_hsrf=4.28290e-09
parameters dnlx_n_12_hsrf=5e-9
parameters dk3_n_12_hsrf=-1.26830e+00
parameters dpvth0_n_12_hsrf=-1.50280e-15
parameters dwwl_n_12_hsrf=-2.73940e-23
parameters ddlc_n_12_hsrf=0.5e-9
parameters ddwc_n_12_hsrf=0
parameters dcgdo_n_12_hsrf=0
parameters dcgso_n_12_hsrf=0
parameters dleta0_n_12_hsrf=-1.8e-9
parameters dcj_n_12_hsrf=-0.000072
parameters dcjsw_n_12_hsrf=-1.06e-11
parameters dcjswg_n_12_hsrf=-0.1
parameters dpvsat_n_12_hsrf=-3e-10
parameters drgi_n_12_hsrf=-0.1
parameters drch_n_12_hsrf=-0.1
parameters drgc_n_12_hsrf=-0.1
parameters dcgd_ext_n_12_hsrf=-0.10
parameters dcds_ext_n_12_hsrf=-0.1
parameters dcj_nwtw_n_12bpw_hsrf=-0.05
parameters dcjsw_nw_n_12bpw_hsrf=-0.05
parameters dcjsw_nwtw_n_12bpw_hsrf=-0.05
parameters dcj_nw_n_12bpw_hsrf=-0.05
parameters dtox_p_12_hsrf=0.00000e+00
parameters dxl_p_12_hsrf=2.00000e-09
parameters du0_p_12_hsrf=-8.06760e-05
parameters dvth0_p_12_hsrf=-1.89480e-02
parameters drdsw_p_12_hsrf=-0.00040e+02
parameters dxw_p_12_hsrf=1.41980e-09
parameters dnlx_p_12_hsrf=8.07720e-09
parameters dk3_p_12_hsrf=9.37480e+00
parameters dpvth0_p_12_hsrf=-3.53360e-16
parameters dwwl_p_12_hsrf=-0.59500e-23
parameters ddlc_p_12_hsrf=-2.5e-9
parameters dwlc_p_12_hsrf=1e-15
parameters dcgdo_p_12_hsrf=0
parameters dcgso_p_12_hsrf=0
parameters dcj_p_12_hsrf=0.1
parameters dcjsw_p_12_hsrf=1.18e-11
parameters dcjswg_p_12_hsrf=4.82e-011
parameters drgi_p_12_hsrf=0.1
parameters drch_p_12_hsrf=0.1
parameters drgc_p_12_hsrf=0.1
parameters dcgd_ext_p_12_hsrf=0.1
parameters dcds_ext_p_12_hsrf=0.1
parameters dcj_nw_p_12_hsrf=0.05
parameters cjsw_nw_p_12_hsrf=0.05
//
include "l110ae_hs12_v032_rf.mdl.scs"
endsection fnsp

section snfp
parameters dtox_n_12_hsrf=0.00000e+00
parameters dxl_n_12_hsrf=5.00000e-09
parameters du0_n_12_hsrf=-0.81640e-03
parameters dvth0_n_12_hsrf=2.49920e-02
parameters drdsw_n_12_hsrf=5.04740e+00
parameters dxw_n_12_hsrf=-5.69290e-09
parameters dnlx_n_12_hsrf=0
parameters dk3_n_12_hsrf=1.08930e+00
parameters dpvth0_n_12_hsrf=8.95970e-16
parameters dwwl_n_12_hsrf=2.28410e-23
parameters ddlc_n_12_hsrf=-2.5e-9
parameters ddwc_n_12_hsrf=0
parameters dcgdo_n_12_hsrf=0
parameters dcgso_n_12_hsrf=0
parameters dleta0_n_12_hsrf=2.1e-9
parameters dcj_n_12_hsrf=0.000072
parameters dcjsw_n_12_hsrf=1.06e-11
parameters dcjswg_n_12_hsrf=0.1
parameters dpvsat_n_12_hsrf=3e-10
parameters drgi_n_12_hsrf=0.1
parameters drch_n_12_hsrf=0.1
parameters drgc_n_12_hsrf=0.1
parameters dcgd_ext_n_12_hsrf=0.1
parameters dcds_ext_n_12_hsrf=0.1
parameters dcj_nwtw_n_12bpw_hsrf=0.05
parameters dcjsw_nw_n_12bpw_hsrf=0.05
parameters dcjsw_nwtw_n_12bpw_hsrf=0.05
parameters dcj_nw_n_12bpw_hsrf=0.05
parameters dtox_p_12_hsrf=0.00000e+00
parameters dxl_p_12_hsrf=-2.00000e-09
parameters du0_p_12_hsrf=5.43150e-05
parameters dvth0_p_12_hsrf=2.10530e-02
parameters drdsw_p_12_hsrf=0.000250e+02
parameters dxw_p_12_hsrf=-5.79360e-09
parameters dnlx_p_12_hsrf=-5.48120e-09
parameters dk3_p_12_hsrf=-8.50100e+00
parameters dpvth0_p_12_hsrf=3.81110e-16
parameters dwwl_p_12_hsrf=0.72640e-23
parameters ddlc_p_12_hsrf=2.5e-9
parameters dwlc_p_12_hsrf=-2.5e-15
parameters dcgdo_p_12_hsrf=0
parameters dcgso_p_12_hsrf=0
parameters dcj_p_12_hsrf=-0.1
parameters dcjsw_p_12_hsrf=-1.18e-11
parameters dcjswg_p_12_hsrf=-4.82e-011
parameters drgi_p_12_hsrf=-0.1
parameters drch_p_12_hsrf=-0.1
parameters drgc_p_12_hsrf=-0.1
parameters dcgd_ext_p_12_hsrf=-0.1
parameters dcds_ext_p_12_hsrf=-0.1
parameters dcj_nw_p_12_hsrf=-0.05
parameters cjsw_nw_p_12_hsrf=-0.05
//
include "l110ae_hs12_v032_rf.mdl.scs"
endsection snfp

endlibrary mylib
