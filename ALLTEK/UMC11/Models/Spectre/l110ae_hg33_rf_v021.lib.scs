//******************************************************************************
simulator lang=spectre insensitive=yes
//TT: Typical n-ch MOSFET and Typical p-ch MOSFET
//FF: Fast n-ch MOSFET and Fast p-ch MOSFET
//SS: Slow n-ch MOSFET and Slow p-ch MOSFET
//FNSP: Fast n-ch MOSFET and Slow p-ch MOSFET
//SNFP: Slow n-ch MOSFET and Fast p-ch MOSFET
//******************************************************************************
//
library mylib
section tt
parameters dtox_n_33_hgl110aerf=0.0000000e+000
parameters dxl_n_33_hgl110aerf=0.0000000e+000
parameters du0_n_33_hgl110aerf=0.0000000e+000
parameters dvth0_n_33_hgl110aerf=0.0000000e+000
parameters drdsw_n_33_hgl110aerf=0.0000000e+000
parameters dxw_n_33_hgl110aerf=0.0000000e+000
parameters dlvth0_n_33_hgl110aerf=0.0000000e+000
parameters dk3_n_33_hgl110aerf=0.0000000e+000
parameters dpvth0_n_33_hgl110aerf=0.0000000e+000
parameters dwwl_n_33_hgl110aerf=0.0000000e+000
parameters dvsat_n_33_hgl110aerf=0.0000000e+000
parameters db0_n_33_hgl110aerf=0.0000000e+000
parameters dcgdo_n_33_hgl110aerf=0.0000000e+000
parameters dcgso_n_33_hgl110aerf=0.0000000e+000
parameters dags_n_33_hgl110aerf=0.0000000e+000
parameters dcj_n_33_hgl110aerf=0.0000000e+000
parameters dcjsw_n_33_hgl110aerf=0.0000000e+000
parameters dcjswg_n_33_hgl110aerf=0.0000000e+000
parameters dcgdl_n_33_hgl110aerf=0.0000000e+000
parameters dcgsl_n_33_hgl110aerf=0.0000000e+000
parameters dpvsat_n_33_hgl110aerf=0.0000000e+000
parameters drshg_n_33_hgl110aerf=0
parameters drcnt_n_33_hgl110aerf=0
parameters drvia_n_33_hgl110aerf=0
parameters dcgd_ext_n_33_hgl110aerf=0
parameters dcgb_ext_n_33_hgl110aerf=0
parameters dcds_ext_n_33_hgl110aerf=0
parameters drch_n_33_hgl110aerf=0
parameters ddlc_n_33_hgl110aerf=0
parameters ddwc_n_33_hgl110aerf=0
parameters dcj_nwtw_n_33bpw_hgl110aerf=0.0000000e+000
parameters dcjsw_nwtw_n_33bpw_hgl110aerf=0.0000000e+000
parameters dcj_nw_n_33bpw_hgl110aerf=0.0000000e+000
parameters dcjsw_nw_n_33bpw_hgl110aerf=0.0000000e+000
parameters dtox_p_33_hgl110aerf=0.0000000e+000
parameters dxl_p_33_hgl110aerf=0.0000000e+000
parameters du0_p_33_hgl110aerf=0.0000000e+000
parameters dvth0_p_33_hgl110aerf=0.0000000e+000
parameters drdsw_p_33_hgl110aerf=0.0000000e+000
parameters dxw_p_33_hgl110aerf=0.0000000e+000
parameters dlvth0_p_33_hgl110aerf=0.0000000e+000
parameters dk3_p_33_hgl110aerf=0.0000000e+000
parameters dpvth0_p_33_hgl110aerf=0.0000000e+000
parameters dwwl_p_33_hgl110aerf=0.0000000e+000
parameters dcgdl_p_33_hgl110aerf=0.0000000e+000
parameters dcgsl_p_33_hgl110aerf=0.0000000e+000
parameters dcgdo_p_33_hgl110aerf=0.0000000e+000
parameters dcgso_p_33_hgl110aerf=0.0000000e+000
parameters dags_p_33_hgl110aerf=0.0000000e+000
parameters dcj_p_33_hgl110aerf=0.0000000e+000
parameters dcjsw_p_33_hgl110aerf=0.0000000e+000
parameters dcjswg_p_33_hgl110aerf=0.0000000e+000
parameters dvsat_p_33_hgl110aerf=0.0000000e+000
parameters db0_p_33_hgl110aerf=0.0000000e+000
parameters dpags_p_33_hgl110aerf=0.0000000e+000
parameters drshg_p_33_hgl110aerf=0
parameters drcnt_p_33_hgl110aerf=0
parameters drvia_p_33_hgl110aerf=0
parameters dcgd_ext_p_33_hgl110aerf=0
parameters dcgb_ext_p_33_hgl110aerf=0
parameters dcds_ext_p_33_hgl110aerf=0
parameters drch_p_33_hgl110aerf=0
parameters ddlc_p_33_hgl110aerf=0
parameters ddwc_p_33_hgl110aerf=0
parameters dcj_nw_p_33_hgl110aerf=0
parameters dcjsw_nw_p_33_hgl110aerf=0
+
include "l110ae_hg33_rf_v021.mdl.scs"
+
endsection tt
//
section ff
parameters dtox_n_33_hgl110aerf=-2.2500000e-010
parameters dxl_n_33_hgl110aerf=-3.4000000e-008
parameters du0_n_33_hgl110aerf=2.5270382e-003
parameters dvth0_n_33_hgl110aerf=-1.2959188e-002
parameters drdsw_n_33_hgl110aerf=-11.8727109e+001
parameters dxw_n_33_hgl110aerf=9.9941214e-009
parameters dlvth0_n_33_hgl110aerf=-1.0117572e-008
parameters dk3_n_33_hgl110aerf=-1.8532690e+000
parameters dpvth0_n_33_hgl110aerf=-2.3456373e-016
parameters dwwl_n_33_hgl110aerf=3.2564506e-021
parameters dvsat_n_33_hgl110aerf=0.9626913e+004
parameters db0_n_33_hgl110aerf=5.9350063e-007
parameters dcgdo_n_33_hgl110aerf=0.1
parameters dcgso_n_33_hgl110aerf=0.1
parameters dags_n_33_hgl110aerf=-28.0933630e-003
parameters dcj_n_33_hgl110aerf=-0.1
parameters dcjsw_n_33_hgl110aerf=-0.1
parameters dcjswg_n_33_hgl110aerf=-0.1
parameters dcgdl_n_33_hgl110aerf=0.1
parameters dcgsl_n_33_hgl110aerf=0.1
parameters dpvsat_n_33_hgl110aerf=3.7226029e-011
parameters drshg_n_33_hgl110aerf=-0.2
parameters drcnt_n_33_hgl110aerf=-0.2
parameters drvia_n_33_hgl110aerf=-0.2
parameters dcgd_ext_n_33_hgl110aerf=-0.2
parameters dcgb_ext_n_33_hgl110aerf=-0.2
parameters dcds_ext_n_33_hgl110aerf=-0.2
parameters drch_n_33_hgl110aerf=-0.2
parameters ddlc_n_33_hgl110aerf=7e-9
parameters ddwc_n_33_hgl110aerf=0
parameters dcj_nwtw_n_33bpw_hgl110aerf=-1.0000000e-001
parameters dcjsw_nwtw_n_33bpw_hgl110aerf=-1.0000000e-001
parameters dcj_nw_n_33bpw_hgl110aerf=-1.0000000e-001
parameters dcjsw_nw_n_33bpw_hgl110aerf=-1.0000000e-001
parameters dtox_p_33_hgl110aerf=-2.2500000e-010
parameters dxl_p_33_hgl110aerf=-2.5200000e-008
parameters du0_p_33_hgl110aerf=6.2990321e-004
parameters dvth0_p_33_hgl110aerf=1.6423221e-002
parameters drdsw_p_33_hgl110aerf=-0.1610280e+001
parameters dxw_p_33_hgl110aerf=1.4120073e-008
parameters dlvth0_p_33_hgl110aerf=1.9422164e-009
parameters dk3_p_33_hgl110aerf=-1.0678961e+001
parameters dpvth0_p_33_hgl110aerf=3.1530937e-015
parameters dwwl_p_33_hgl110aerf=-4.5880211e-022
parameters dcgdl_p_33_hgl110aerf=0.1
parameters dcgsl_p_33_hgl110aerf=0.1
parameters dcgdo_p_33_hgl110aerf=0.1
parameters dcgso_p_33_hgl110aerf=0.1
parameters dags_p_33_hgl110aerf=-2.5854088e-002
parameters dcj_p_33_hgl110aerf=-0.1
parameters dcjsw_p_33_hgl110aerf=-0.1
parameters dcjswg_p_33_hgl110aerf=-0.1
parameters dvsat_p_33_hgl110aerf=-4.8375539e+003
parameters db0_p_33_hgl110aerf=5.5055015e-009
parameters dpags_p_33_hgl110aerf=-2.4191732e-014
parameters drshg_p_33_hgl110aerf=-0.2
parameters drcnt_p_33_hgl110aerf=-0.2
parameters drvia_p_33_hgl110aerf=-0.2
parameters dcgd_ext_p_33_hgl110aerf=-0.2
parameters dcgb_ext_p_33_hgl110aerf=-0.2
parameters dcds_ext_p_33_hgl110aerf=-0.2
parameters drch_p_33_hgl110aerf=-0.2
parameters ddlc_p_33_hgl110aerf=1.2e-8
parameters ddwc_p_33_hgl110aerf=5e-9
parameters dcj_nw_p_33_hgl110aerf=-0.1
parameters dcjsw_nw_p_33_hgl110aerf=-0.1
+
include "l110ae_hg33_rf_v021.mdl.scs"
+
endsection ff
//
section ss
parameters dtox_n_33_hgl110aerf=2.2500000e-010
parameters dxl_n_33_hgl110aerf=3.4000000e-008
parameters du0_n_33_hgl110aerf=-2.6497341e-003
parameters dvth0_n_33_hgl110aerf=1.2187316e-002
parameters drdsw_n_33_hgl110aerf=1.9847603e+002
parameters dxw_n_33_hgl110aerf=-1.2172646e-008
parameters dlvth0_n_33_hgl110aerf=1.2494691e-008
parameters dk3_n_33_hgl110aerf=1.5974425e+000
parameters dpvth0_n_33_hgl110aerf=5.2748233e-016
parameters dwwl_n_33_hgl110aerf=-3.7666198e-021
parameters dvsat_n_33_hgl110aerf=-1.2116516e+004
parameters db0_n_33_hgl110aerf=-5.4613379e-007
parameters dcgdo_n_33_hgl110aerf=-0.1
parameters dcgso_n_33_hgl110aerf=-0.1
parameters dags_n_33_hgl110aerf=7.3327767e-003
parameters dcj_n_33_hgl110aerf=0.1
parameters dcjsw_n_33_hgl110aerf=0.1
parameters dcjswg_n_33_hgl110aerf=0.1
parameters dcgdl_n_33_hgl110aerf=-0.1
parameters dcgsl_n_33_hgl110aerf=-0.1
parameters dpvsat_n_33_hgl110aerf=-8.3378680e-012
parameters drshg_n_33_hgl110aerf=0.2
parameters drcnt_n_33_hgl110aerf=0.2
parameters drvia_n_33_hgl110aerf=0.2
parameters dcgd_ext_n_33_hgl110aerf=0.2
parameters dcgb_ext_n_33_hgl110aerf=0.2
parameters dcds_ext_n_33_hgl110aerf=0.2
parameters drch_n_33_hgl110aerf=0.2
parameters ddlc_n_33_hgl110aerf=-7e-9
parameters ddwc_n_33_hgl110aerf=-2e-9
parameters dcj_nwtw_n_33bpw_hgl110aerf=1.0000000e-001
parameters dcjsw_nwtw_n_33bpw_hgl110aerf=1.0000000e-001
parameters dcj_nw_n_33bpw_hgl110aerf=1.0000000e-001
parameters dcjsw_nw_n_33bpw_hgl110aerf=1.0000000e-001
parameters dtox_p_33_hgl110aerf=2.2500000e-010
parameters dxl_p_33_hgl110aerf=3.8760000e-008
parameters du0_p_33_hgl110aerf=-6.8800000e-004
parameters dvth0_p_33_hgl110aerf=-1.6050000e-002
parameters drdsw_p_33_hgl110aerf=0.0215451e+002
parameters dxw_p_33_hgl110aerf=-1.9500000e-008
parameters dlvth0_p_33_hgl110aerf=-1.9000000e-009
parameters dk3_p_33_hgl110aerf=9.4500000e+000
parameters dpvth0_p_33_hgl110aerf=-3.0000000e-015
parameters dwwl_p_33_hgl110aerf=6.3059158e-022
parameters dcgdl_p_33_hgl110aerf=-0.1
parameters dcgsl_p_33_hgl110aerf=-0.1
parameters dcgdo_p_33_hgl110aerf=-0.1
parameters dcgso_p_33_hgl110aerf=-0.1
parameters dags_p_33_hgl110aerf=2.5004907e-002
parameters dcj_p_33_hgl110aerf=0.1
parameters dcjsw_p_33_hgl110aerf=0.1
parameters dcjswg_p_33_hgl110aerf=0.1
parameters dvsat_p_33_hgl110aerf=7.0500000e+003
parameters db0_p_33_hgl110aerf=-1.0400000e-008
parameters dpags_p_33_hgl110aerf=0.0000000e+000
parameters drshg_p_33_hgl110aerf=0.2
parameters drcnt_p_33_hgl110aerf=0.2
parameters drvia_p_33_hgl110aerf=0.2
parameters dcgd_ext_p_33_hgl110aerf=0.2
parameters dcgb_ext_p_33_hgl110aerf=0.2
parameters dcds_ext_p_33_hgl110aerf=0.2
parameters drch_p_33_hgl110aerf=0.2
parameters ddlc_p_33_hgl110aerf=-8e-9
parameters ddwc_p_33_hgl110aerf=-2e-9
parameters dcj_nw_p_33_hgl110aerf=0.1
parameters dcjsw_nw_p_33_hgl110aerf=0.1
+
include "l110ae_hg33_rf_v021.mdl.scs"
+
endsection ss
//
section fnsp
parameters dtox_n_33_hgl110aerf=0.0000000e+000
parameters dxl_n_33_hgl110aerf=-1.0000000e-008
parameters du0_n_33_hgl110aerf=1.4436704e-003
parameters dvth0_n_33_hgl110aerf=-1.6652053e-002
parameters drdsw_n_33_hgl110aerf=-7.9809183e+001
parameters dxw_n_33_hgl110aerf=4.4196328e-009
parameters dlvth0_n_33_hgl110aerf=-5.4991786e-009
parameters dk3_n_33_hgl110aerf=-8.7740389e-001
parameters dpvth0_n_33_hgl110aerf=-1.5886657e-016
parameters dwwl_n_33_hgl110aerf=1.3207671e-021
parameters dvsat_n_33_hgl110aerf=8.4750178e+003
parameters db0_n_33_hgl110aerf=2.7706237e-007
parameters dcgdo_n_33_hgl110aerf=0.0000000e+000
parameters dcgso_n_33_hgl110aerf=0.0000000e+000
parameters dags_n_33_hgl110aerf=-2.8998529e-003
parameters dcj_n_33_hgl110aerf=-0.05
parameters dcjsw_n_33_hgl110aerf=-0.05
parameters dcjswg_n_33_hgl110aerf=-0.05
parameters dcgdl_n_33_hgl110aerf=0.0000000e+000
parameters dcgsl_n_33_hgl110aerf=0.0000000e+000
parameters dpvsat_n_33_hgl110aerf=2.4874867e-024
parameters drshg_n_33_hgl110aerf=-0.1
parameters drcnt_n_33_hgl110aerf=-0.1
parameters drvia_n_33_hgl110aerf=-0.1
parameters dcgd_ext_n_33_hgl110aerf=-0.1
parameters dcgb_ext_n_33_hgl110aerf=-0.1
parameters dcds_ext_n_33_hgl110aerf=-0.1
parameters drch_n_33_hgl110aerf=-0.05
parameters ddlc_n_33_hgl110aerf=-1e-9
parameters ddwc_n_33_hgl110aerf=0
parameters dcj_nwtw_n_33bpw_hgl110aerf=-5.0000000e-002
parameters dcjsw_nwtw_n_33bpw_hgl110aerf=-5.0000000e-002
parameters dcj_nw_n_33bpw_hgl110aerf=-5.0000000e-002
parameters dcjsw_nw_n_33bpw_hgl110aerf=-5.0000000e-002
parameters dtox_p_33_hgl110aerf=0.0000000e+000
parameters dxl_p_33_hgl110aerf=6.5000000e-009
parameters du0_p_33_hgl110aerf=-3.9415239e-004
parameters dvth0_p_33_hgl110aerf=-2.1783303e-002
parameters drdsw_p_33_hgl110aerf=1.2153229e+002
parameters dxw_p_33_hgl110aerf=-8.2799792e-009
parameters dlvth0_p_33_hgl110aerf=-2.5963477e-009
parameters dk3_p_33_hgl110aerf=4.8959608e+000
parameters dpvth0_p_33_hgl110aerf=-1.4557899e-015
parameters dwwl_p_33_hgl110aerf=3.8087512e-022
parameters dcgdl_p_33_hgl110aerf=0.0000000e+000
parameters dcgsl_p_33_hgl110aerf=0.0000000e+000
parameters dcgdo_p_33_hgl110aerf=0.0000000e+000
parameters dcgso_p_33_hgl110aerf=0.0000000e+000
parameters dags_p_33_hgl110aerf=9.6826654e-003
parameters dcj_p_33_hgl110aerf=0.05
parameters dcjsw_p_33_hgl110aerf=0.05
parameters dcjswg_p_33_hgl110aerf=0.05
parameters dvsat_p_33_hgl110aerf=-7.1686432e+003
parameters db0_p_33_hgl110aerf=-4.7804295e-009
parameters dpags_p_33_hgl110aerf=-7.2490407e-016
parameters drshg_p_33_hgl110aerf=0.1
parameters drcnt_p_33_hgl110aerf=0.1
parameters drvia_p_33_hgl110aerf=0.1
parameters dcgd_ext_p_33_hgl110aerf=0.1
parameters dcgb_ext_p_33_hgl110aerf=0.1
parameters dcds_ext_p_33_hgl110aerf=0.1
parameters drch_p_33_hgl110aerf=0.1
parameters ddlc_p_33_hgl110aerf=-1e-9
parameters ddwc_p_33_hgl110aerf=0
parameters dcj_nw_p_33_hgl110aerf=0.05
parameters dcjsw_nw_p_33_hgl110aerf=0.05
+
include "l110ae_hg33_rf_v021.mdl.scs"
+
endsection fnsp
//
section snfp
parameters dtox_n_33_hgl110aerf=0.0000000e+000
parameters dxl_n_33_hgl110aerf=1.0000000e-008
parameters du0_n_33_hgl110aerf=-1.4591535e-003
parameters dvth0_n_33_hgl110aerf=1.6544911e-002
parameters drdsw_n_33_hgl110aerf=9.2655218e+001
parameters dxw_n_33_hgl110aerf=-5.4264458e-009
parameters dlvth0_n_33_hgl110aerf=5.8375341e-009
parameters dk3_n_33_hgl110aerf=8.4390008e-001
parameters dpvth0_n_33_hgl110aerf=2.2814302e-016
parameters dwwl_n_33_hgl110aerf=-1.4134610e-021
parameters dvsat_n_33_hgl110aerf=-0.9320272e+004
parameters db0_n_33_hgl110aerf=-3.3821010e-007
parameters dcgdo_n_33_hgl110aerf=0.0000000e+000
parameters dcgso_n_33_hgl110aerf=0.0000000e+000
parameters dags_n_33_hgl110aerf=0.0000000e+000
parameters dcj_n_33_hgl110aerf=0.05
parameters dcjsw_n_33_hgl110aerf=0.05
parameters dcjswg_n_33_hgl110aerf=0.05
parameters dcgdl_n_33_hgl110aerf=0.0000000e+000
parameters dcgsl_n_33_hgl110aerf=0.0000000e+000
parameters dpvsat_n_33_hgl110aerf=-7.1287430e-013
parameters drshg_n_33_hgl110aerf=0.1
parameters drcnt_n_33_hgl110aerf=0.1
parameters drvia_n_33_hgl110aerf=0.1
parameters dcgd_ext_n_33_hgl110aerf=0.1
parameters dcgb_ext_n_33_hgl110aerf=0.1
parameters dcds_ext_n_33_hgl110aerf=0.1
parameters drch_n_33_hgl110aerf=0.05
parameters ddlc_n_33_hgl110aerf=1e-9
parameters ddwc_n_33_hgl110aerf=3e-9
parameters dcj_nwtw_n_33bpw_hgl110aerf=5.0000000e-002
parameters dcjsw_nwtw_n_33bpw_hgl110aerf=5.0000000e-002
parameters dcj_nw_n_33bpw_hgl110aerf=5.0000000e-002
parameters dcjsw_nw_n_33bpw_hgl110aerf=5.0000000e-002
parameters dtox_p_33_hgl110aerf=0.0000000e+000
parameters dxl_p_33_hgl110aerf=-6.6120000e-009
parameters du0_p_33_hgl110aerf=3.8399172e-004
parameters dvth0_p_33_hgl110aerf=2.1967029e-002
parameters drdsw_p_33_hgl110aerf=-0.7905167e+002
parameters dxw_p_33_hgl110aerf=7.1518039e-009
parameters dlvth0_p_33_hgl110aerf=2.3552603e-009
parameters dk3_p_33_hgl110aerf=-5.0252599e+000
parameters dpvth0_p_33_hgl110aerf=1.5482021e-015
parameters dwwl_p_33_hgl110aerf=-2.6770717e-022
parameters dcgdl_p_33_hgl110aerf=0.0000000e+000
parameters dcgsl_p_33_hgl110aerf=0.0000000e+000
parameters dcgdo_p_33_hgl110aerf=0.0000000e+000
parameters dcgso_p_33_hgl110aerf=0.0000000e+000
parameters dags_p_33_hgl110aerf=-9.6576210e-003
parameters dcj_p_33_hgl110aerf=-0.1
parameters dcjsw_p_33_hgl110aerf=-0.1
parameters dcjswg_p_33_hgl110aerf=-0.1
parameters dvsat_p_33_hgl110aerf=5.3445166e+003
parameters db0_p_33_hgl110aerf=4.5056734e-009
parameters dpags_p_33_hgl110aerf=-1.3873620e-015
parameters drshg_p_33_hgl110aerf=-0.1
parameters drcnt_p_33_hgl110aerf=-0.1
parameters drvia_p_33_hgl110aerf=-0.1
parameters dcgd_ext_p_33_hgl110aerf=-0.1
parameters dcgb_ext_p_33_hgl110aerf=-0.1
parameters dcds_ext_p_33_hgl110aerf=-0.1
parameters drch_p_33_hgl110aerf=-0.1
parameters ddlc_p_33_hgl110aerf=1e-9
parameters ddwc_p_33_hgl110aerf=0
parameters dcj_nw_p_33_hgl110aerf=-0.05
parameters dcjsw_nw_p_33_hgl110aerf=-0.05
+
include "l110ae_hg33_rf_v021.mdl.scs"
+
endsection snfp
//
endlibrary mylib
