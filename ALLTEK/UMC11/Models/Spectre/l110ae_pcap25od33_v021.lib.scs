simulator lang=spectre insensitive=yes
library mylib
section tt
parameters dtoxe_pcap_25od33=0.0000e+00
parameters dxw_pcap_25od33=0.0000e+00
parameters dxl_pcap_25od33=0.0000e+00
parameters dcwwl_pcap_25od33=0.0000e+00
parameters dclwl_pcap_25od33=0.0000e+00
parameters dcmina_pcap_25od33=0.0000e+00
include "l110ae_pcap25od33_v021.mdl.scs"
endsection tt
section ss
parameters dtoxe_pcap_25od33=+5.65000e-10
parameters dxw_pcap_25od33=-1.2000e-08
parameters dxl_pcap_25od33=-4.300e-09
parameters dcwwl_pcap_25od33=-3.0e-09
parameters dclwl_pcap_25od33=+3.0000e-9
parameters dcmina_pcap_25od33=+7.45e-02
include "l110ae_pcap25od33_v021.mdl.scs"
endsection ss
section ff
parameters dtoxe_pcap_25od33=-4.5800e-10
parameters dxw_pcap_25od33=+7.800e-09
parameters dxl_pcap_25od33=+4.00e-09
parameters dcwwl_pcap_25od33=+3.100e-09
parameters dclwl_pcap_25od33=-4.000e-9
parameters dcmina_pcap_25od33=-6.25e-02
include "l110ae_pcap25od33_v021.mdl.scs"
endsection ff
endlibrary mylib
