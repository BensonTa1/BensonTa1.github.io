//
simulator lang=spectre insensitive=yes
library mylib

section tt
parameters dtox_n_12_hsl110e=0.0000000e+000
parameters dxl_n_12_hsl110e=0.0000000e+000
parameters du0_n_12_hsl110e=0.0000000e+000
parameters dvth0_n_12_hsl110e=0.0000000e+000
parameters drdsw_n_12_hsl110e=0.0000000e+000
parameters dxw_n_12_hsl110e=0.0000000e+000
parameters dnlx_n_12_hsl110e=0.0000000e+000
parameters dk3_n_12_hsl110e=0.0000000e+000
parameters dpvth0_n_12_hsl110e=0.0000000e+000
parameters dwwl_n_12_hsl110e=0.0000000e+000
parameters dags_n_12_hsl110e=0.0000000e+000
parameters dcgdo_n_12_hsl110e=0.0000000e+000
parameters dcgso_n_12_hsl110e=0.0000000e+000
parameters dcj_n_12_hsl110e=0.0000000e+000
parameters dcjsw_n_12_hsl110e=0.0000000e+000
parameters dcjswg_n_12_hsl110e=0.0000000e+000
parameters dvsat_n_12_hsl110e=0.0000000e+000
parameters dwags_n_12_hsl110e=0.0000000e+000
parameters dpvsat_n_12_hsl110e=0.0000000e+000
parameters dtox_p_12_hsl110e=0.0000000e+000
parameters dxl_p_12_hsl110e=0.0000000e+000
parameters du0_p_12_hsl110e=0.0000000e+000
parameters dvth0_p_12_hsl110e=0.0000000e+000
parameters drdsw_p_12_hsl110e=0.0000000e+000
parameters dxw_p_12_hsl110e=0.0000000e+000
parameters dnlx_p_12_hsl110e=0.0000000e+000
parameters dk3_p_12_hsl110e=0.0000000e+000
parameters dpvth0_p_12_hsl110e=0.0000000e+000
parameters dwwl_p_12_hsl110e=0.0000000e+000
parameters dags_p_12_hsl110e=0.0000000e+000
parameters dcgdo_p_12_hsl110e=0.0000000e+000
parameters dcgso_p_12_hsl110e=0.0000000e+000
parameters dcj_p_12_hsl110e=0.0000000e+000
parameters dcjsw_p_12_hsl110e=0.0000000e+000
parameters dcjswg_p_12_hsl110e=0.0000000e+000
parameters dvsat_p_12_hsl110e=0.0000000e+000
parameters dwags_p_12_hsl110e=0.0000000e+000
parameters dpvsat_p_12_hsl110e=0.0000000e+000
parameters dpags_p_12_hsl110e=0.0000000e+000
//
include "l110ae_hs12_v104.mdl.scs"
include "l110ae_hs12_v104.lib.scs" section=igate
endsection tt
//
section ff
parameters dtox_n_12_hsl110e=-5.2800000e-011
parameters dxl_n_12_hsl110e=-0.5600000e-009
parameters du0_n_12_hsl110e=1.2000000e-003
parameters dvth0_n_12_hsl110e=-3.1600000e-002
parameters drdsw_n_12_hsl110e=-8.8000000e+000
parameters dxw_n_12_hsl110e=1.2180000e-008
parameters dnlx_n_12_hsl110e=-2.4200000e-008
parameters dk3_n_12_hsl110e=-2.8300000e+000
parameters dpvth0_n_12_hsl110e=-7.4500000e-016
parameters dwwl_n_12_hsl110e=5.4800000e-023
parameters dags_n_12_hsl110e=-1.0550000e-001
parameters dcgdo_n_12_hsl110e=1.9000000e-011
parameters dcgso_n_12_hsl110e=1.9000000e-011
parameters dcj_n_12_hsl110e=-7.2000000e-005
parameters dcjsw_n_12_hsl110e=-9.9400000e-012
parameters dcjswg_n_12_hsl110e=-3.0300000e-011
parameters dvsat_n_12_hsl110e=-0.1520000e+003
parameters dwags_n_12_hsl110e=-6.8800000e-009
parameters dpvsat_n_12_hsl110e=1.7000000e-011
parameters dtox_p_12_hsl110e=-5.2800000e-011
parameters dxl_p_12_hsl110e=-0.7430000e-009
parameters du0_p_12_hsl110e=6.3300000e-004
parameters dvth0_p_12_hsl110e=3.0150000e-002
parameters drdsw_p_12_hsl110e=-4.2800000e+001
parameters dxw_p_12_hsl110e=5.1000000e-009
parameters dnlx_p_12_hsl110e=-1.2640000e-008
parameters dk3_p_12_hsl110e=-2.1400000e+001
parameters dpvth0_p_12_hsl110e=4.6800000e-016
parameters dwwl_p_12_hsl110e=-2.1600000e-023
parameters dags_p_12_hsl110e=-1.4100000e-001
parameters dcgdo_p_12_hsl110e=2.0000000e-011
parameters dcgso_p_12_hsl110e=2.0000000e-011
parameters dcj_p_12_hsl110e=-9.6900000e-005
parameters dcjsw_p_12_hsl110e=-1.1800000e-011
parameters dcjswg_p_12_hsl110e=-4.8200000e-011
parameters dvsat_p_12_hsl110e=-7.8400000e+003
parameters dwags_p_12_hsl110e=-1.0790000e-008
parameters dpvsat_p_12_hsl110e=-4.2750000e-010
parameters dpags_p_12_hsl110e=0.0000000e+000
include "l110ae_hs12_v104.mdl.scs"
include "l110ae_hs12_v104.lib.scs" section=igate
endsection ff
//
section ss
parameters dtox_n_12_hsl110e=5.2800000e-011
parameters dxl_n_12_hsl110e=2.3200000e-009
parameters du0_n_12_hsl110e=-1.4880000e-003
parameters dvth0_n_12_hsl110e=3.1150000e-002
parameters drdsw_n_12_hsl110e=9.4700000e+000
parameters dxw_n_12_hsl110e=-1.8400000e-008
parameters dnlx_n_12_hsl110e=2.5000000e-008
parameters dk3_n_12_hsl110e=2.3500000e+000
parameters dpvth0_n_12_hsl110e=8.5400000e-016
parameters dwwl_n_12_hsl110e=-2.4100000e-023
parameters dags_n_12_hsl110e=1.0920000e-001
parameters dcgdo_n_12_hsl110e=-1.9000000e-011
parameters dcgso_n_12_hsl110e=-1.9000000e-011
parameters dcj_n_12_hsl110e=7.2000000e-005
parameters dcjsw_n_12_hsl110e=9.9400000e-012
parameters dcjswg_n_12_hsl110e=3.0300000e-011
parameters dvsat_n_12_hsl110e=0.6500000e+003
parameters dwags_n_12_hsl110e=6.3200000e-009
parameters dpvsat_n_12_hsl110e=4.8400000e-011
parameters dtox_p_12_hsl110e=5.2800000e-011
parameters dxl_p_12_hsl110e=3.6800000e-009
parameters du0_p_12_hsl110e=-7.6400000e-004
parameters dvth0_p_12_hsl110e=-2.9300000e-002
parameters drdsw_p_12_hsl110e=4.2800000e+001
parameters dxw_p_12_hsl110e=-2.2000000e-008
parameters dnlx_p_12_hsl110e=1.2960000e-008
parameters dk3_p_12_hsl110e=2.0200000e+001
parameters dpvth0_p_12_hsl110e=-5.3900000e-016
parameters dwwl_p_12_hsl110e=3.3400000e-023
parameters dags_p_12_hsl110e=1.4680000e-001
parameters dcgdo_p_12_hsl110e=-2.0000000e-011
parameters dcgso_p_12_hsl110e=-2.0000000e-011
parameters dcj_p_12_hsl110e=9.6900000e-005
parameters dcjsw_p_12_hsl110e=1.1800000e-011
parameters dcjswg_p_12_hsl110e=4.8200000e-011
parameters dvsat_p_12_hsl110e=2.9100000e+004
parameters dwags_p_12_hsl110e=0.3750000e-008
parameters dpvsat_p_12_hsl110e=0.0000000e+000
parameters dpags_p_12_hsl110e=5.4100000e-014
include "l110ae_hs12_v104.mdl.scs"
include "l110ae_hs12_v104.lib.scs" section=igate
endsection ss
//
section fnsp
parameters dtox_n_12_hsl110e=0.0000000e+000
parameters dxl_n_12_hsl110e=-1.1500000e-009
parameters du0_n_12_hsl110e=0.7980000e-003
parameters dvth0_n_12_hsl110e=-1.8800000e-002
parameters drdsw_n_12_hsl110e=-2.6000000e+000
parameters dxw_n_12_hsl110e=0.6680000e-008
parameters dnlx_n_12_hsl110e=-1.5050000e-008
parameters dk3_n_12_hsl110e=-1.3320000e+000
parameters dpvth0_n_12_hsl110e=-3.6800000e-016
parameters dwwl_n_12_hsl110e=1.6700000e-023
parameters dags_n_12_hsl110e=-0.5070000e-001
parameters dcgdo_n_12_hsl110e=0.0000000e+000
parameters dcgso_n_12_hsl110e=0.0000000e+000
parameters dcj_n_12_hsl110e=-7.2000000e-005
parameters dcjsw_n_12_hsl110e=-9.9400000e-012
parameters dcjswg_n_12_hsl110e=-3.0300000e-011
parameters dvsat_n_12_hsl110e=0.4200000e+003
parameters dwags_n_12_hsl110e=-3.5200000e-009
parameters dpvsat_n_12_hsl110e=-0.3200000e-011
parameters dtox_p_12_hsl110e=0.0000000e+000
parameters dxl_p_12_hsl110e=1.3300000e-009
parameters du0_p_12_hsl110e=-4.2000000e-004
parameters dvth0_p_12_hsl110e=-1.8450000e-002
parameters drdsw_p_12_hsl110e=2.1400000e+001
parameters dxw_p_12_hsl110e=-0.7200000e-008
parameters dnlx_p_12_hsl110e=0.6750000e-008
parameters dk3_p_12_hsl110e=1.0400000e+001
parameters dpvth0_p_12_hsl110e=-2.5600000e-016
parameters dwwl_p_12_hsl110e=0.9900000e-023
parameters dags_p_12_hsl110e=0.6960000e-001
parameters dcgdo_p_12_hsl110e=0.0000000e+000
parameters dcgso_p_12_hsl110e=0.0000000e+000
parameters dcj_p_12_hsl110e=9.6900000e-005
parameters dcjsw_p_12_hsl110e=1.1800000e-011
parameters dcjswg_p_12_hsl110e=4.8200000e-011
parameters dvsat_p_12_hsl110e=0.8600000e+004
parameters dwags_p_12_hsl110e=0.3380000e-008
parameters dpvsat_p_12_hsl110e=0.0000000e+000
parameters dpags_p_12_hsl110e=2.4500000e-014
include "l110ae_hs12_v104.mdl.scs"
include "l110ae_hs12_v104.lib.scs" section=igate
endsection fnsp
//
section snfp
parameters dtox_n_12_hsl110e=0.0000000e+000
parameters dxl_n_12_hsl110e=1.1500000e-009
parameters du0_n_12_hsl110e=-0.8820000e-003
parameters dvth0_n_12_hsl110e=1.8200000e-002
parameters drdsw_n_12_hsl110e=3.5400000e+000
parameters dxw_n_12_hsl110e=-0.8050000e-008
parameters dnlx_n_12_hsl110e=1.5800000e-008
parameters dk3_n_12_hsl110e=1.2900000e+000
parameters dpvth0_n_12_hsl110e=3.9700000e-016
parameters dwwl_n_12_hsl110e=-1.3400000e-023
parameters dags_n_12_hsl110e=0.5110000e-001
parameters dcgdo_n_12_hsl110e=0.0000000e+000
parameters dcgso_n_12_hsl110e=0.0000000e+000
parameters dcj_n_12_hsl110e=7.2000000e-005
parameters dcjsw_n_12_hsl110e=9.9400000e-012
parameters dcjswg_n_12_hsl110e=3.0300000e-011
parameters dvsat_n_12_hsl110e=-0.7500000e+003
parameters dwags_n_12_hsl110e=3.6200000e-009
parameters dpvsat_n_12_hsl110e=1.8500000e-011
parameters dtox_p_12_hsl110e=0.0000000e+000
parameters dxl_p_12_hsl110e=-0.6350000e-009
parameters du0_p_12_hsl110e=3.8850000e-004
parameters dvth0_p_12_hsl110e=1.8900000e-002
parameters drdsw_p_12_hsl110e=-2.1400000e+001
parameters dxw_p_12_hsl110e=3.3400000e-009
parameters dnlx_p_12_hsl110e=-0.6480000e-008
parameters dk3_p_12_hsl110e=-1.0350000e+001
parameters dpvth0_p_12_hsl110e=2.4000000e-016
parameters dwwl_p_12_hsl110e=-1.1800000e-023
parameters dags_p_12_hsl110e=-0.6790000e-001
parameters dcgdo_p_12_hsl110e=0.0000000e+000
parameters dcgso_p_12_hsl110e=0.0000000e+000
parameters dcj_p_12_hsl110e=-9.6900000e-005
parameters dcjsw_p_12_hsl110e=-1.1800000e-011
parameters dcjswg_p_12_hsl110e=-4.8200000e-011
parameters dvsat_p_12_hsl110e=-4.1600000e+003
parameters dwags_p_12_hsl110e=-0.5210000e-008
parameters dpvsat_p_12_hsl110e=-3.2000000e-010
parameters dpags_p_12_hsl110e=0.0000000e+000
include "l110ae_hs12_v104.mdl.scs"
include "l110ae_hs12_v104.lib.scs" section=igate
endsection snfp
//
section igate
subckt n_12_hsl110e_ig ( n11 n2 n33 n4 )
parameters w=1u l=1u rsh=8.5 hdif=1.25e-07 nrd=hdif / w nrs=hdif / w ad=2 * hdif * w as=2 * hdif
+ * w pd=2 * (2 * hdif + w) ps=2 * (2 * hdif + w) dtemp=0 sa=2u sb=2u
+ tcig=1 + 1.55e-3 * (temp + dtemp - 25) area=w * 0.9 * (l * 0.9+8e-9) * 1e4 *
+ tcig toxg=(2.64e-09 + dtox_n_12_hsl110e) * 1e2 vdf0=3.11 vdfl= - 0.3e-08 vdfw=3.5e-09
+ vaf0=0.7 vafl= - 0.8e-10 vafw=1.0e-10 vdr0=5.78 vdrl=0e-07 vdrw=5.0e-09 var0=0.60
+ varl=0e-07 varw=1.0e-10 vdf=(vdf0 + vdfl / (l * 0.9+8e-9) + vdfw / (w * 0.9)) * 2.6e7
+ * toxg vaf=(vaf0 + vafl / (l * 0.9+8e-9) + vafw / (w * 0.9)) * 2.6e7 * toxg vdr=(vdr0
+ + vdrl / (l * 0.9+8e-9) + vdrw / (w * 0.9)) * 2.6e7 * toxg var=(var0 + varl / (l *
+ 0.9+8e-9) + varw / (w * 0.9)) * 2.6e7 * toxg igf=2.1e-7 * area * exp( - vdf) * pow(1
+ / toxg,2.0) igr=2.1e-7 * area / (l * 0.9+8e-9) * exp( - vdr) * pow(1 / toxg,2.0)
//
mnig ( n1 n2 n3 n4 ) n_12_hsl110e trise=dtemp w=w l=l m=1 nrd=nrd nrs=nrs ad=ad
+ as=as pd=pd ps=ps sa=sa sb=sb
gigcd ( n2 n1 ) bsource i =igf * pow((abs(v(n2,n1)) + v(n2,n1)) / 2,vaf) - igr *
+ pow((abs(v(n2,n1)) - v(n2,n1)) / 2,var)
gigcs ( n2 n3 ) bsource i =igf * pow((abs(v(n2,n3)) + v(n2,n3)) / 2,vaf) - igr *
+ pow((abs(v(n2,n3)) - v(n2,n3)) / 2,var)
rdn ( n1 n11 ) resistor r=rsh * nrd
rsn ( n3 n33 ) resistor r=rsh * nrs
ends n_12_hsl110e_ig
//
subckt p_12_hsl110e_ig ( p11 p2 p33 p4 )
parameters w=1u l=1u rsh=7.6 hdif=1.25e-07 nrd=hdif / w nrs=hdif / w ad=2 * hdif * w as=2 * hdif
+ * w pd=2 * (2 * hdif + w) ps=2 * (2 * hdif + w) dtemp=0 sa=2u sb=2u
+ tcig=1 + 2.25e-3 * (temp + dtemp - 25) area=w * 0.9 * (l * 0.9+8e-9) * 1e4 *
+ tcig toxg=(2.83e-09 + dtox_p_12_hsl110e) * 1e2 vdf0=3.22 vdfl= - 7.00e-09 vdfw=
+ - 6.0e-8 vaf0=0.6 vafl= - 1.5e-08 vafw= - 3.0e-8 vdr0=5.50 vdrl= + 1.50e-08 vdrw=
+ - 1.0e-07 var0=0.35 varl= + 1.50e-08 varw=4.0e-8 vdf=(vdf0 + vdfl / (l * 0.9+8e-9)
+ + vdfw / (w * 0.9)) * 2.6e7 * toxg vaf=(vaf0 + vafl / (l * 0.9+8e-9) + vafw / (w *
+ 0.9)) * 2.6e7 * toxg vdr=(vdr0 + vdrl / (l * 0.9+8e-9) + vdrw / (w * 0.9)) * 2.6e7
+ * toxg var=(var0 + varl / (l * 0.9+8e-9) + varw / (w * 0.9)) * 2.6e7 * toxg igf=2.1e-7
+ * area * exp( - vdf) * pow(1 / toxg,2.0) igr=2.1e-7 * area / (l * 0.9+8e-9) * exp( - vdr) *
+ pow(1 / toxg,2.0)
//
mpig ( p1 p2 p3 p4 ) p_12_hsl110e trise=dtemp w=w l=l m=1 nrd=nrd nrs=nrs ad=ad
+ as=as pd=pd ps=ps sa=sa sb=sb
gigcd ( p2 p1 ) bsource i = - igf * pow((abs(v(p2,p1)) - v(p2,p1)) / 2,vaf) + igr
+ * pow((abs(v(p2,p1)) + v(p2,p1)) / 2,var)
gigcs ( p2 p3 ) bsource i = - igf * pow((abs(v(p2,p3)) - v(p2,p3)) / 2,vaf) + igr
+ * pow((abs(v(p2,p3)) + v(p2,p3)) / 2,var)
rdp ( p1 p11 ) resistor r=rsh * nrd
rsp ( p3 p33 ) resistor r=rsh * nrs

ends p_12_hsl110e_ig
//
subckt n_12bpw_hsl110e_ig ( n11 n2 n33 n4 )
parameters w=1u l=1u rsh=8.5 hdif=1.25e-07 nrd=hdif / w nrs=hdif / w ad=2 * hdif * w as=2 * hdif
+ * w pd=2 * (2 * hdif + w) ps=2 * (2 * hdif + w) dtemp=0 sa=2u sb=2u
+ tcig=1 + 1.55e-3 * (temp + dtemp - 25) area=w * 0.9 * (l * 0.9+8e-9) * 1e4 *
+ tcig toxg=(2.64e-09 + dtox_n_12_hsl110e) * 1e2 vdf0=3.11 vdfl= - 0.3e-08 vdfw=3.5e-09
+ vaf0=0.7 vafl= - 0.8e-10 vafw=1.0e-10 vdr0=5.78 vdrl=0e-07 vdrw=5.0e-09 var0=0.60
+ varl=0e-07 varw=1.0e-10 vdf=(vdf0 + vdfl / (l * 0.9+8e-9) + vdfw / (w * 0.9)) * 2.6e7
+ * toxg vaf=(vaf0 + vafl / (l * 0.9+8e-9) + vafw / (w * 0.9)) * 2.6e7 * toxg vdr=(vdr0
+ + vdrl / (l * 0.9+8e-9) + vdrw / (w * 0.9)) * 2.6e7 * toxg var=(var0 + varl / (l *
+ 0.9+8e-9) + varw / (w * 0.9)) * 2.6e7 * toxg igf=2.1e-7 * area * exp( - vdf) * pow(1
+ / toxg,2.0) igr=2.1e-7 * area / (l * 0.9+8e-9) * exp( - vdr) * pow(1 / toxg,2.0)
//
mnig ( n1 n2 n3 n4 ) n_12bpw_hsl110e trise=dtemp w=w l=l m=1 nrd=nrd nrs=nrs ad=ad
+ as=as pd=pd ps=ps sa=sa sb=sb
gigcd ( n2 n1 ) bsource i =igf * pow((abs(v(n2,n1)) + v(n2,n1)) / 2,vaf) - igr *
+ pow((abs(v(n2,n1)) - v(n2,n1)) / 2,var)
gigcs ( n2 n3 ) bsource i =igf * pow((abs(v(n2,n3)) + v(n2,n3)) / 2,vaf) - igr *
+ pow((abs(v(n2,n3)) - v(n2,n3)) / 2,var)
rdn ( n1 n11 ) resistor r=rsh * nrd
rsn ( n3 n33 ) resistor r=rsh * nrs
ends n_12bpw_hsl110e_ig
//
endsection igate
//
section tt_tn
parameters dtox_n_12_hsl110e=0.0000000e+000
parameters dxl_n_12_hsl110e=0.0000000e+000
parameters du0_n_12_hsl110e=0.0000000e+000
parameters dvth0_n_12_hsl110e=0.0000000e+000
parameters drdsw_n_12_hsl110e=0.0000000e+000
parameters dxw_n_12_hsl110e=0.0000000e+000
parameters dnlx_n_12_hsl110e=0.0000000e+000
parameters dk3_n_12_hsl110e=0.0000000e+000
parameters dpvth0_n_12_hsl110e=0.0000000e+000
parameters dwwl_n_12_hsl110e=0.0000000e+000
parameters dags_n_12_hsl110e=0.0000000e+000
parameters dcgdo_n_12_hsl110e=0.0000000e+000
parameters dcgso_n_12_hsl110e=0.0000000e+000
parameters dcj_n_12_hsl110e=0.0000000e+000
parameters dcjsw_n_12_hsl110e=0.0000000e+000
parameters dcjswg_n_12_hsl110e=0.0000000e+000
parameters dvsat_n_12_hsl110e=0.0000000e+000
parameters dwags_n_12_hsl110e=0.0000000e+000
parameters dpvsat_n_12_hsl110e=0.0000000e+000
parameters dtox_p_12_hsl110e=0.0000000e+000
parameters dxl_p_12_hsl110e=0.0000000e+000
parameters du0_p_12_hsl110e=0.0000000e+000
parameters dvth0_p_12_hsl110e=0.0000000e+000
parameters drdsw_p_12_hsl110e=0.0000000e+000
parameters dxw_p_12_hsl110e=0.0000000e+000
parameters dnlx_p_12_hsl110e=0.0000000e+000
parameters dk3_p_12_hsl110e=0.0000000e+000
parameters dpvth0_p_12_hsl110e=0.0000000e+000
parameters dwwl_p_12_hsl110e=0.0000000e+000
parameters dags_p_12_hsl110e=0.0000000e+000
parameters dcgdo_p_12_hsl110e=0.0000000e+000
parameters dcgso_p_12_hsl110e=0.0000000e+000
parameters dcj_p_12_hsl110e=0.0000000e+000
parameters dcjsw_p_12_hsl110e=0.0000000e+000
parameters dcjswg_p_12_hsl110e=0.0000000e+000
parameters dvsat_p_12_hsl110e=0.0000000e+000
parameters dwags_p_12_hsl110e=0.0000000e+000
parameters dpvsat_p_12_hsl110e=0.0000000e+000
parameters dpags_p_12_hsl110e=0.0000000e+000
//
include "l110ae_hs12_v104_tn.mdl.scs"
endsection tt_tn
//
section ff_tn
parameters dtox_n_12_hsl110e=-5.2800000e-011
parameters dxl_n_12_hsl110e=-0.5600000e-009
parameters du0_n_12_hsl110e=1.2000000e-003
parameters dvth0_n_12_hsl110e=-3.1600000e-002
parameters drdsw_n_12_hsl110e=-8.8000000e+000
parameters dxw_n_12_hsl110e=1.2180000e-008
parameters dnlx_n_12_hsl110e=-2.4200000e-008
parameters dk3_n_12_hsl110e=-2.8300000e+000
parameters dpvth0_n_12_hsl110e=-7.4500000e-016
parameters dwwl_n_12_hsl110e=5.4800000e-023
parameters dags_n_12_hsl110e=-1.0550000e-001
parameters dcgdo_n_12_hsl110e=1.9000000e-011
parameters dcgso_n_12_hsl110e=1.9000000e-011
parameters dcj_n_12_hsl110e=-7.2000000e-005
parameters dcjsw_n_12_hsl110e=-9.9400000e-012
parameters dcjswg_n_12_hsl110e=-3.0300000e-011
parameters dvsat_n_12_hsl110e=-0.1520000e+003
parameters dwags_n_12_hsl110e=-6.8800000e-009
parameters dpvsat_n_12_hsl110e=1.7000000e-011
parameters dtox_p_12_hsl110e=-5.2800000e-011
parameters dxl_p_12_hsl110e=-0.7430000e-009
parameters du0_p_12_hsl110e=6.3300000e-004
parameters dvth0_p_12_hsl110e=3.0150000e-002
parameters drdsw_p_12_hsl110e=-4.2800000e+001
parameters dxw_p_12_hsl110e=5.1000000e-009
parameters dnlx_p_12_hsl110e=-1.2640000e-008
parameters dk3_p_12_hsl110e=-2.1400000e+001
parameters dpvth0_p_12_hsl110e=4.6800000e-016
parameters dwwl_p_12_hsl110e=-2.1600000e-023
parameters dags_p_12_hsl110e=-1.4100000e-001
parameters dcgdo_p_12_hsl110e=2.0000000e-011
parameters dcgso_p_12_hsl110e=2.0000000e-011
parameters dcj_p_12_hsl110e=-9.6900000e-005
parameters dcjsw_p_12_hsl110e=-1.1800000e-011
parameters dcjswg_p_12_hsl110e=-4.8200000e-011
parameters dvsat_p_12_hsl110e=-7.8400000e+003
parameters dwags_p_12_hsl110e=-1.0790000e-008
parameters dpvsat_p_12_hsl110e=-4.2750000e-010
parameters dpags_p_12_hsl110e=0.0000000e+000
include "l110ae_hs12_v104_tn.mdl.scs"
endsection ff_tn
//
section ss_tn
parameters dtox_n_12_hsl110e=5.2800000e-011
parameters dxl_n_12_hsl110e=2.3200000e-009
parameters du0_n_12_hsl110e=-1.4880000e-003
parameters dvth0_n_12_hsl110e=3.1150000e-002
parameters drdsw_n_12_hsl110e=9.4700000e+000
parameters dxw_n_12_hsl110e=-1.8400000e-008
parameters dnlx_n_12_hsl110e=2.5000000e-008
parameters dk3_n_12_hsl110e=2.3500000e+000
parameters dpvth0_n_12_hsl110e=8.5400000e-016
parameters dwwl_n_12_hsl110e=-2.4100000e-023
parameters dags_n_12_hsl110e=1.0920000e-001
parameters dcgdo_n_12_hsl110e=-1.9000000e-011
parameters dcgso_n_12_hsl110e=-1.9000000e-011
parameters dcj_n_12_hsl110e=7.2000000e-005
parameters dcjsw_n_12_hsl110e=9.9400000e-012
parameters dcjswg_n_12_hsl110e=3.0300000e-011
parameters dvsat_n_12_hsl110e=0.6500000e+003
parameters dwags_n_12_hsl110e=6.3200000e-009
parameters dpvsat_n_12_hsl110e=4.8400000e-011
parameters dtox_p_12_hsl110e=5.2800000e-011
parameters dxl_p_12_hsl110e=3.6800000e-009
parameters du0_p_12_hsl110e=-7.6400000e-004
parameters dvth0_p_12_hsl110e=-2.9300000e-002
parameters drdsw_p_12_hsl110e=4.2800000e+001
parameters dxw_p_12_hsl110e=-2.2000000e-008
parameters dnlx_p_12_hsl110e=1.2960000e-008
parameters dk3_p_12_hsl110e=2.0200000e+001
parameters dpvth0_p_12_hsl110e=-5.3900000e-016
parameters dwwl_p_12_hsl110e=3.3400000e-023
parameters dags_p_12_hsl110e=1.4680000e-001
parameters dcgdo_p_12_hsl110e=-2.0000000e-011
parameters dcgso_p_12_hsl110e=-2.0000000e-011
parameters dcj_p_12_hsl110e=9.6900000e-005
parameters dcjsw_p_12_hsl110e=1.1800000e-011
parameters dcjswg_p_12_hsl110e=4.8200000e-011
parameters dvsat_p_12_hsl110e=2.9100000e+004
parameters dwags_p_12_hsl110e=0.3750000e-008
parameters dpvsat_p_12_hsl110e=0.0000000e+000
parameters dpags_p_12_hsl110e=5.4100000e-014
include "l110ae_hs12_v104_tn.mdl.scs"
endsection ss_tn
//
section fnsp_tn
parameters dtox_n_12_hsl110e=0.0000000e+000
parameters dxl_n_12_hsl110e=-1.1500000e-009
parameters du0_n_12_hsl110e=0.7980000e-003
parameters dvth0_n_12_hsl110e=-1.8800000e-002
parameters drdsw_n_12_hsl110e=-2.6000000e+000
parameters dxw_n_12_hsl110e=0.6680000e-008
parameters dnlx_n_12_hsl110e=-1.5050000e-008
parameters dk3_n_12_hsl110e=-1.3320000e+000
parameters dpvth0_n_12_hsl110e=-3.6800000e-016
parameters dwwl_n_12_hsl110e=1.6700000e-023
parameters dags_n_12_hsl110e=-0.5070000e-001
parameters dcgdo_n_12_hsl110e=0.0000000e+000
parameters dcgso_n_12_hsl110e=0.0000000e+000
parameters dcj_n_12_hsl110e=-7.2000000e-005
parameters dcjsw_n_12_hsl110e=-9.9400000e-012
parameters dcjswg_n_12_hsl110e=-3.0300000e-011
parameters dvsat_n_12_hsl110e=0.4200000e+003
parameters dwags_n_12_hsl110e=-3.5200000e-009
parameters dpvsat_n_12_hsl110e=-0.3200000e-011
parameters dtox_p_12_hsl110e=0.0000000e+000
parameters dxl_p_12_hsl110e=1.3300000e-009
parameters du0_p_12_hsl110e=-4.2000000e-004
parameters dvth0_p_12_hsl110e=-1.8450000e-002
parameters drdsw_p_12_hsl110e=2.1400000e+001
parameters dxw_p_12_hsl110e=-0.7200000e-008
parameters dnlx_p_12_hsl110e=0.6750000e-008
parameters dk3_p_12_hsl110e=1.0400000e+001
parameters dpvth0_p_12_hsl110e=-2.5600000e-016
parameters dwwl_p_12_hsl110e=0.9900000e-023
parameters dags_p_12_hsl110e=0.6960000e-001
parameters dcgdo_p_12_hsl110e=0.0000000e+000
parameters dcgso_p_12_hsl110e=0.0000000e+000
parameters dcj_p_12_hsl110e=9.6900000e-005
parameters dcjsw_p_12_hsl110e=1.1800000e-011
parameters dcjswg_p_12_hsl110e=4.8200000e-011
parameters dvsat_p_12_hsl110e=0.8600000e+004
parameters dwags_p_12_hsl110e=0.3380000e-008
parameters dpvsat_p_12_hsl110e=0.0000000e+000
parameters dpags_p_12_hsl110e=2.4500000e-014
include "l110ae_hs12_v104_tn.mdl.scs"
endsection fnsp_tn
//
section snfp_tn
parameters dtox_n_12_hsl110e=0.0000000e+000
parameters dxl_n_12_hsl110e=1.1500000e-009
parameters du0_n_12_hsl110e=-0.8820000e-003
parameters dvth0_n_12_hsl110e=1.8200000e-002
parameters drdsw_n_12_hsl110e=3.5400000e+000
parameters dxw_n_12_hsl110e=-0.8050000e-008
parameters dnlx_n_12_hsl110e=1.5800000e-008
parameters dk3_n_12_hsl110e=1.2900000e+000
parameters dpvth0_n_12_hsl110e=3.9700000e-016
parameters dwwl_n_12_hsl110e=-1.3400000e-023
parameters dags_n_12_hsl110e=0.5110000e-001
parameters dcgdo_n_12_hsl110e=0.0000000e+000
parameters dcgso_n_12_hsl110e=0.0000000e+000
parameters dcj_n_12_hsl110e=7.2000000e-005
parameters dcjsw_n_12_hsl110e=9.9400000e-012
parameters dcjswg_n_12_hsl110e=3.0300000e-011
parameters dvsat_n_12_hsl110e=-0.7500000e+003
parameters dwags_n_12_hsl110e=3.6200000e-009
parameters dpvsat_n_12_hsl110e=1.8500000e-011
parameters dtox_p_12_hsl110e=0.0000000e+000
parameters dxl_p_12_hsl110e=-0.6350000e-009
parameters du0_p_12_hsl110e=3.8850000e-004
parameters dvth0_p_12_hsl110e=1.8900000e-002
parameters drdsw_p_12_hsl110e=-2.1400000e+001
parameters dxw_p_12_hsl110e=3.3400000e-009
parameters dnlx_p_12_hsl110e=-0.6480000e-008
parameters dk3_p_12_hsl110e=-1.0350000e+001
parameters dpvth0_p_12_hsl110e=2.4000000e-016
parameters dwwl_p_12_hsl110e=-1.1800000e-023
parameters dags_p_12_hsl110e=-0.6790000e-001
parameters dcgdo_p_12_hsl110e=0.0000000e+000
parameters dcgso_p_12_hsl110e=0.0000000e+000
parameters dcj_p_12_hsl110e=-9.6900000e-005
parameters dcjsw_p_12_hsl110e=-1.1800000e-011
parameters dcjswg_p_12_hsl110e=-4.8200000e-011
parameters dvsat_p_12_hsl110e=-4.1600000e+003
parameters dwags_p_12_hsl110e=-0.5210000e-008
parameters dpvsat_p_12_hsl110e=-3.2000000e-010
parameters dpags_p_12_hsl110e=0.0000000e+000
include "l110ae_hs12_v104_tn.mdl.scs"
endsection snfp_tn

endlibrary mylib
