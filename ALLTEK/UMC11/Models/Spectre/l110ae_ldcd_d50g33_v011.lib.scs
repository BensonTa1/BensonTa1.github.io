//  ******************************************************************************
//  TT: Typical n-ch MOSFET and Typical p-ch MOSFET
//  FF: Fast n-ch MOSFET and Fast p-ch MOSFET
//  SS: Slow n-ch MOSFET and Slow p-ch MOSFET
//  FNSP: Fast n-ch MOSFET and Slow p-ch MOSFET
//  SNFP: Slow n-ch MOSFET and Fast p-ch MOSFET
//  ******************************************************************************
simulator lang=spectre insensitive=yes
//
library mylib

section tt
parameters dtox_n_ldcd_d50g33_l110ae=0.0000000e+000
parameters dxl_n_ldcd_d50g33_l110ae=0.0000000e+000
parameters dxw_n_ldcd_d50g33_l110ae=0.0000000e+000
parameters dvth0_n_ldcd_d50g33_l110ae=0.0000000e+000
parameters du0_n_ldcd_d50g33_l110ae=0.0000000e+000
parameters drdsw_n_ldcd_d50g33_l110ae=0.0000000e+000
parameters dvsat_n_ldcd_d50g33_l110ae=0.0000000e+000
parameters dagidl_n_ldcd_d50g33_l110ae=0.0000000e+000
parameters dcgdo_n_ldcd_d50g33_l110ae=0.0000000e+000
parameters dcgso_n_ldcd_d50g33_l110ae=0.0000000e+000
parameters dcgdl_n_ldcd_d50g33_l110ae=0.0000000e+000
parameters dcgsl_n_ldcd_d50g33_l110ae=0.0000000e+000
parameters dcf_n_ldcd_d50g33_l110ae=0.0000000e+000
parameters dcj_n_ldcd_d50g33_l110ae=0.0000000e+000
parameters dcjsw_n_ldcd_d50g33_l110ae=0.0000000e+000
parameters dcjswg_n_ldcd_d50g33_l110ae=0.0000000e+000
parameters dtox_p_ldcd_d50g33_l110ae=0.0000000e+000
parameters dxl_p_ldcd_d50g33_l110ae=0.0000000e+000
parameters dxw_p_ldcd_d50g33_l110ae=0.0000000e+000
parameters dvth0_p_ldcd_d50g33_l110ae=0.0000000e+000
parameters du0_p_ldcd_d50g33_l110ae=0.0000000e+000
parameters drdsw_p_ldcd_d50g33_l110ae=0.0000000e+000
parameters dvsat_p_ldcd_d50g33_l110ae=0.0000000e+000
parameters dagidl_p_ldcd_d50g33_l110ae=0.0000000e+000
parameters dcgdo_p_ldcd_d50g33_l110ae=0.0000000e+000
parameters dcgso_p_ldcd_d50g33_l110ae=0.0000000e+000
parameters dcgdl_p_ldcd_d50g33_l110ae=0.0000000e+000
parameters dcgsl_p_ldcd_d50g33_l110ae=0.0000000e+000
parameters dcf_p_ldcd_d50g33_l110ae=0.0000000e+000
parameters dcj_p_ldcd_d50g33_l110ae=0.0000000e+000
parameters dcjsw_p_ldcd_d50g33_l110ae=0.0000000e+000
parameters dcjswg_p_ldcd_d50g33_l110ae=0.0000000e+000
//
include "l110ae_ldcd_d50g33_v011.mdl.scs"
//
endsection tt
//
section ff
parameters dtox_n_ldcd_d50g33_l110ae=-1.5000000e-010
parameters dxl_n_ldcd_d50g33_l110ae=-2.0000000e-008
parameters dxw_n_ldcd_d50g33_l110ae=1.0000000e-006
parameters dvth0_n_ldcd_d50g33_l110ae=-7.4529444e-002
parameters du0_n_ldcd_d50g33_l110ae=7.5604702e-003
parameters drdsw_n_ldcd_d50g33_l110ae=0.0000000e+000
parameters dvsat_n_ldcd_d50g33_l110ae=6.5903643e+003
parameters dagidl_n_ldcd_d50g33_l110ae=8.7293683e-006
parameters dcgdo_n_ldcd_d50g33_l110ae=5.0000000e-012
parameters dcgso_n_ldcd_d50g33_l110ae=5.0000000e-012
parameters dcgdl_n_ldcd_d50g33_l110ae=2.4800000e-010
parameters dcgsl_n_ldcd_d50g33_l110ae=1.8000000e-011
parameters dcf_n_ldcd_d50g33_l110ae=6.8300000e-012
parameters dcj_n_ldcd_d50g33_l110ae=-1.0976000e-005
parameters dcjsw_n_ldcd_d50g33_l110ae=-9.3620000e-011
parameters dcjswg_n_ldcd_d50g33_l110ae=-1.6786000e-010
parameters dtox_p_ldcd_d50g33_l110ae=-1.5000000e-010
parameters dxl_p_ldcd_d50g33_l110ae=-2.0000000e-008
parameters dxw_p_ldcd_d50g33_l110ae=1.0000000e-006
parameters dvth0_p_ldcd_d50g33_l110ae=8.7350927e-002
parameters du0_p_ldcd_d50g33_l110ae=4.9747647e-004
parameters drdsw_p_ldcd_d50g33_l110ae=0.0000000e+000
parameters dvsat_p_ldcd_d50g33_l110ae=1.3040866e+003
parameters dagidl_p_ldcd_d50g33_l110ae=2.9657421e-005
parameters dcgdo_p_ldcd_d50g33_l110ae=1.5000000e-012
parameters dcgso_p_ldcd_d50g33_l110ae=9.1120000e-012
parameters dcgdl_p_ldcd_d50g33_l110ae=1.5600000e-010
parameters dcgsl_p_ldcd_d50g33_l110ae=2.0171000e-011
parameters dcf_p_ldcd_d50g33_l110ae=6.7752000e-012
parameters dcj_p_ldcd_d50g33_l110ae=-1.1838000e-004
parameters dcjsw_p_ldcd_d50g33_l110ae=-3.3266000e-011
parameters dcjswg_p_ldcd_d50g33_l110ae=-3.6120000e-011
//
include "l110ae_ldcd_d50g33_v011.mdl.scs"
//
endsection ff
//
section ss
parameters dtox_n_ldcd_d50g33_l110ae=1.5000000e-010
parameters dxl_n_ldcd_d50g33_l110ae=2.0000000e-008
parameters dxw_n_ldcd_d50g33_l110ae=-1.0000000e-006
parameters dvth0_n_ldcd_d50g33_l110ae=7.0515368e-002
parameters du0_n_ldcd_d50g33_l110ae=-7.1051598e-003
parameters drdsw_n_ldcd_d50g33_l110ae=0.0000000e+000
parameters dvsat_n_ldcd_d50g33_l110ae=-9.3645763e+003
parameters dagidl_n_ldcd_d50g33_l110ae=-1.6161610e-006
parameters dcgdo_n_ldcd_d50g33_l110ae=-5.0000000e-012
parameters dcgso_n_ldcd_d50g33_l110ae=-5.0000000e-012
parameters dcgdl_n_ldcd_d50g33_l110ae=-2.4800000e-010
parameters dcgsl_n_ldcd_d50g33_l110ae=-1.8000000e-011
parameters dcf_n_ldcd_d50g33_l110ae=-6.8300000e-012
parameters dcj_n_ldcd_d50g33_l110ae=1.0976000e-005
parameters dcjsw_n_ldcd_d50g33_l110ae=9.3620000e-011
parameters dcjswg_n_ldcd_d50g33_l110ae=1.6786000e-010
parameters dtox_p_ldcd_d50g33_l110ae=1.5000000e-010
parameters dxl_p_ldcd_d50g33_l110ae=2.0000000e-008
parameters dxw_p_ldcd_d50g33_l110ae=-1.0000000e-006
parameters dvth0_p_ldcd_d50g33_l110ae=-8.4334478e-002
parameters du0_p_ldcd_d50g33_l110ae=-7.6778169e-004
parameters drdsw_p_ldcd_d50g33_l110ae=0.0000000e+000
parameters dvsat_p_ldcd_d50g33_l110ae=-2.5172371e+003
parameters dagidl_p_ldcd_d50g33_l110ae=-5.0174730e-006
parameters dcgdo_p_ldcd_d50g33_l110ae=-1.5000000e-012
parameters dcgso_p_ldcd_d50g33_l110ae=-9.1120000e-012
parameters dcgdl_p_ldcd_d50g33_l110ae=-1.5600000e-010
parameters dcgsl_p_ldcd_d50g33_l110ae=-2.0171000e-011
parameters dcf_p_ldcd_d50g33_l110ae=-6.7752000e-012
parameters dcj_p_ldcd_d50g33_l110ae=1.1838000e-004
parameters dcjsw_p_ldcd_d50g33_l110ae=3.3266000e-011
parameters dcjswg_p_ldcd_d50g33_l110ae=3.6120000e-011
//
include "l110ae_ldcd_d50g33_v011.mdl.scs"
//
endsection ss
//
section fnsp
parameters dtox_n_ldcd_d50g33_l110ae=0.0000000e+000
parameters dxl_n_ldcd_d50g33_l110ae=-1.0000000e-008
parameters dxw_n_ldcd_d50g33_l110ae=5.0000000e-007
parameters dvth0_n_ldcd_d50g33_l110ae=-3.6737819e-002
parameters du0_n_ldcd_d50g33_l110ae=3.8045057e-003
parameters drdsw_n_ldcd_d50g33_l110ae=0.0000000e+000
parameters dvsat_n_ldcd_d50g33_l110ae=4.4610311e+003
parameters dagidl_n_ldcd_d50g33_l110ae=1.8773034e-005
parameters dcgdo_n_ldcd_d50g33_l110ae=0.0000000e+000
parameters dcgso_n_ldcd_d50g33_l110ae=0.0000000e+000
parameters dcgdl_n_ldcd_d50g33_l110ae=0.0000000e+000
parameters dcgsl_n_ldcd_d50g33_l110ae=0.0000000e+000
parameters dcf_n_ldcd_d50g33_l110ae=0.0000000e+000
parameters dcj_n_ldcd_d50g33_l110ae=-1.0976000e-005
parameters dcjsw_n_ldcd_d50g33_l110ae=-9.3620000e-011
parameters dcjswg_n_ldcd_d50g33_l110ae=-1.6786000e-010
parameters dtox_p_ldcd_d50g33_l110ae=0.0000000e+000
parameters dxl_p_ldcd_d50g33_l110ae=1.0000000e-008
parameters dxw_p_ldcd_d50g33_l110ae=-5.0000000e-007
parameters dvth0_p_ldcd_d50g33_l110ae=-4.2458842e-002
parameters du0_p_ldcd_d50g33_l110ae=-3.6252856e-004
parameters drdsw_p_ldcd_d50g33_l110ae=0.0000000e+000
parameters dvsat_p_ldcd_d50g33_l110ae=-1.8636877e+003
parameters dagidl_p_ldcd_d50g33_l110ae=-5.6040786e-006
parameters dcgdo_p_ldcd_d50g33_l110ae=0.0000000e+000
parameters dcgso_p_ldcd_d50g33_l110ae=0.0000000e+000
parameters dcgdl_p_ldcd_d50g33_l110ae=0.0000000e+000
parameters dcgsl_p_ldcd_d50g33_l110ae=0.0000000e+000
parameters dcf_p_ldcd_d50g33_l110ae=0.0000000e+000
parameters dcj_p_ldcd_d50g33_l110ae=1.1838000e-004
parameters dcjsw_p_ldcd_d50g33_l110ae=3.3266000e-011
parameters dcjswg_p_ldcd_d50g33_l110ae=3.6120000e-011
//
include "l110ae_ldcd_d50g33_v011.mdl.scs"
//
endsection fnsp
//
section snfp
parameters dtox_n_ldcd_d50g33_l110ae=0.0000000e+000
parameters dxl_n_ldcd_d50g33_l110ae=1.0000000e-008
parameters dxw_n_ldcd_d50g33_l110ae=-5.0000000e-007
parameters dvth0_n_ldcd_d50g33_l110ae=3.5870095e-002
parameters du0_n_ldcd_d50g33_l110ae=-3.6671152e-003
parameters drdsw_n_ldcd_d50g33_l110ae=0.0000000e+000
parameters dvsat_n_ldcd_d50g33_l110ae=-5.0545227e+003
parameters dagidl_n_ldcd_d50g33_l110ae=-1.7896772e-006
parameters dcgdo_n_ldcd_d50g33_l110ae=0.0000000e+000
parameters dcgso_n_ldcd_d50g33_l110ae=0.0000000e+000
parameters dcgdl_n_ldcd_d50g33_l110ae=0.0000000e+000
parameters dcgsl_n_ldcd_d50g33_l110ae=0.0000000e+000
parameters dcf_n_ldcd_d50g33_l110ae=0.0000000e+000
parameters dcj_n_ldcd_d50g33_l110ae=1.0976000e-005
parameters dcjsw_n_ldcd_d50g33_l110ae=9.3620000e-011
parameters dcjswg_n_ldcd_d50g33_l110ae=1.6786000e-010
parameters dtox_p_ldcd_d50g33_l110ae=0.0000000e+000
parameters dxl_p_ldcd_d50g33_l110ae=-1.0000000e-008
parameters dxw_p_ldcd_d50g33_l110ae=5.0000000e-007
parameters dvth0_p_ldcd_d50g33_l110ae=4.3159646e-002
parameters du0_p_ldcd_d50g33_l110ae=2.9866676e-004
parameters drdsw_p_ldcd_d50g33_l110ae=0.0000000e+000
parameters dvsat_p_ldcd_d50g33_l110ae=1.5983669e+003
parameters dagidl_p_ldcd_d50g33_l110ae=5.9196490e-005
parameters dcgdo_p_ldcd_d50g33_l110ae=0.0000000e+000
parameters dcgso_p_ldcd_d50g33_l110ae=0.0000000e+000
parameters dcgdl_p_ldcd_d50g33_l110ae=0.0000000e+000
parameters dcgsl_p_ldcd_d50g33_l110ae=0.0000000e+000
parameters dcf_p_ldcd_d50g33_l110ae=0.0000000e+000
parameters dcj_p_ldcd_d50g33_l110ae=-1.1838000e-004
parameters dcjsw_p_ldcd_d50g33_l110ae=-3.3266000e-011
parameters dcjswg_p_ldcd_d50g33_l110ae=-3.6120000e-011
//
include "l110ae_ldcd_d50g33_v011.mdl.scs"
//
endsection snfp
//
endlibrary mylib
