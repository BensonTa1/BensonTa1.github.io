//********************************************************************************
//* TT:   Typical n-ch MOSFET and Typical p-ch MOSFET
//* FF:   Fast n-ch MOSFET and Fast p-ch MOSFET
//* SS:   Slow n-ch MOSFET and Slow p-ch MOSFET
//* FNSP: Fast n-ch MOSFET and Slow p-ch MOSFET
//* SNFP: Slow n-ch MOSFET and Fast p-ch MOSFET
//********************************************************************************
simulator lang=spectre insensitive=yes
library mylib

section setup
parameters noi_flag_n_25_l110ae     = 0
parameters noi_flag_n_bpw_25_l110ae = 0
parameters noi_flag_p_25_l110ae     = 0
parameters noi_sigma_25_l110ae      = 3
parameters dnoi_n_25_l110ae     = noi_flag_n_25_l110ae
parameters dnoi_n_bpw_25_l110ae = noi_flag_n_bpw_25_l110ae
parameters dnoi_p_25_l110ae     = noi_flag_p_25_l110ae
endsection setup
//*
section tt
include "l110ae_25_v051.lib.scs" section=setup
parameters
//*
+dtox_n_25_l110ae         =  0.0000000e+000   dxl_n_25_l110ae           =  0.0000000e+000   du0_n_25_l110ae           =  0.0000000e+000
+dvth0_n_25_l110ae        =  0.0000000e+000   drdsw_n_25_l110ae         =  0.0000000e+000   dxw_n_25_l110ae           =  0.0000000e+000
+dnlx_n_25_l110ae         =  0.0000000e+000   dk3_n_25_l110ae           =  0.0000000e+000   dpvth0_n_25_l110ae        =  0.0000000e+000
+dwwl_n_25_l110ae         =  0.0000000e+000   dvsat_n_25_l110ae         =  0.0000000e+000   dpvsat_n_25_l110ae        =  0.0000000e+000
+dcj_n_25_l110ae          =  0.0000000e+000   dcjsw_n_25_l110ae         =  0.0000000e+000   dcjswg_n_25_l110ae        =  0.0000000e+000
+dcgdo_n_25_l110ae        =  0.0000000e+000   dcgso_n_25_l110ae         =  0.0000000e+000   dags_n_25_l110ae          =  0.0000000e+000
+deta0_n_25_l110ae        =  0.0000000e+000   dcgdl_n_25_l110ae         =  0.0000000e+000   dcgsl_n_25_l110ae         =  0.0000000e+000
+dwags_n_25_l110ae        =  0.0000000e+000   dwb0_n_25_l110ae          =  0.0000000e+000   dwvsat_n_25_l110ae        =  0.0000000e+000
+db0_n_25_l110ae          =  0.0000000e+000   djtsswd_n_25_l110ae       =  0.0000000e+000   djtsswgd_n_25_l110ae      =  0.0000000e+000
+dprdsw_n_25_l110ae       =  0.0000000e+000   djtssws_n_25_l110ae       =  0.0000000e+000   djtsswgs_n_25_l110ae      =  0.0000000e+000
//*
+dtox_p_25_l110ae         =  0.0000000e+000   dxl_p_25_l110ae           =  0.0000000e+000   du0_p_25_l110ae           =  0.0000000e+000
+dvth0_p_25_l110ae        =  0.0000000e+000   drdsw_p_25_l110ae         =  0.0000000e+000   dwu0_p_25_l110ae          =  0.0000000e+000
+dlvth0_p_25_l110ae       =  0.0000000e+000   dwvth0_p_25_l110ae        =  0.0000000e+000   dpvth0_p_25_l110ae        =  0.0000000e+000
+dprdsw_p_25_l110ae       =  0.0000000e+000   dags_p_25_l110ae          =  0.0000000e+000   dlags_p_25_l110ae         =  0.0000000e+000
+dwags_p_25_l110ae        =  0.0000000e+000   dpags_p_25_l110ae         =  0.0000000e+000   dcgdo_p_25_l110ae         =  0.0000000e+000
+dcgso_p_25_l110ae        =  0.0000000e+000   dcgdl_p_25_l110ae         =  0.0000000e+000   dcgsl_p_25_l110ae         =  0.0000000e+000
+dcj_p_25_l110ae          =  0.0000000e+000   dcjsw_p_25_l110ae         =  0.0000000e+000   dcjswg_p_25_l110ae        =  0.0000000e+000
+djtsswgd_p_25_l110ae     =  0.0000000e+000   djtsswgs_p_25_l110ae     =  0.0000000e+000
//*
+dtox_n_bpw_25_l110ae     =  0.0000000e+000   dxl_n_bpw_25_l110ae       =  0.0000000e+000   dxw_n_bpw_25_l110ae       =  0.0000000e+000
+dvth0_n_bpw_25_l110ae    =  0.0000000e+000   dnlx_n_bpw_25_l110ae      =  0.0000000e+000   dk3_n_bpw_25_l110ae       =  0.0000000e+000
+dpvth0_n_bpw_25_l110ae   =  0.0000000e+000   du0_n_bpw_25_l110ae       =  0.0000000e+000   dlu0_n_bpw_25_l110ae      =  0.0000000e+000
+dwu0_n_bpw_25_l110ae     =  0.0000000e+000   dpu0_n_bpw_25_l110ae      =  0.0000000e+000   drdsw_n_bpw_25_l110ae     =  0.0000000e+000
+dags_n_bpw_25_l110ae     =  0.0000000e+000   dvsat_n_bpw_25_l110ae     =  0.0000000e+000   dwags_n_bpw_25_l110ae     =  0.0000000e+000
+dpvsat_n_bpw_25_l110ae   =  0.0000000e+000   dcj_n_bpw_25_l110ae       =  0.0000000e+000   dcjsw_n_bpw_25_l110ae     =  0.0000000e+000
+dcjswg_n_bpw_25_l110ae   =  0.0000000e+000   dcgdo_n_bpw_25_l110ae     =  0.0000000e+000   dcgso_n_bpw_25_l110ae     =  0.0000000e+000
+dcgdl_n_bpw_25_l110ae    =  0.0000000e+000   dcgsl_n_bpw_25_l110ae     =  0.0000000e+000   djtsswd_n_bpw_25_l110ae   =  0.0000000e+000
+djtsswgd_n_bpw_25_l110ae =  0.0000000e+000   deta0_n_bpw_25_l110ae     =  0.0000000e+000   dpeta0_n_bpw_25_l110ae    =  0.0000000e+000
+djtssws_n_bpw_25_l110ae  =  0.0000000e+000   djtsswgs_n_bpw_25_l110ae  =  0.0000000e+000
//*
include "l110ae_25_v051.mdl.scs"
//*
endsection tt
//*
section ff
include "l110ae_25_v051.lib.scs" section=setup
parameters
//*
+dtox_n_25_l110ae         = -1.6200000e-010   dxl_n_25_l110ae           = -1.5000000e-008   du0_n_25_l110ae           =  1.0946844e-003
+dvth0_n_25_l110ae        = -5.5541429e-002   drdsw_n_25_l110ae         = -7.5984540e+001   dxw_n_25_l110ae           =  2.7508053e-009
+dnlx_n_25_l110ae         = -4.4734033e-008   dk3_n_25_l110ae           = -4.7252257e-001   dpvth0_n_25_l110ae        = -8.1888582e-015
+dwwl_n_25_l110ae         = -2.6716722e-021   dvsat_n_25_l110ae         =  1.4883801e+003   dpvsat_n_25_l110ae        = -1.4704853e-010
+dcj_n_25_l110ae          = -7.8122000e-005   dcjsw_n_25_l110ae         = -1.1247000e-011   dcjswg_n_25_l110ae        = -2.1550000e-011
+dcgdo_n_25_l110ae        =  1.2500000e-012   dcgso_n_25_l110ae         =  1.2500000e-012   dags_n_25_l110ae          = -4.4996367e-002
+deta0_n_25_l110ae        = -2.4000000e-003   dcgdl_n_25_l110ae         =  2.7000000e-011   dcgsl_n_25_l110ae         =  2.7000000e-011
+dwags_n_25_l110ae        =  0.0000000e+000   dwb0_n_25_l110ae          =  0.0000000e+000   dwvsat_n_25_l110ae        =  0.0000000e+000
+db0_n_25_l110ae          = -3.9026392e-008   djtsswd_n_25_l110ae       =  1.0000000e-007   djtsswgd_n_25_l110ae      =  6.0000000e-006
+dprdsw_n_25_l110ae       =  0.0000000e+000   djtssws_n_25_l110ae       =  1.0000000e-007   djtsswgs_n_25_l110ae      =  6.0000000e-006
//*
+dtox_p_25_l110ae         = -1.1000000e-010   dxl_p_25_l110ae           = -5.0000000e-009   du0_p_25_l110ae           =  4.9388050e-004
+dvth0_p_25_l110ae        =  5.4056946e-002   drdsw_p_25_l110ae         = -4.3758708e+001   dwu0_p_25_l110ae          =  1.4521193e-011
+dlvth0_p_25_l110ae       =  1.2703258e-008   dwvth0_p_25_l110ae        =  3.1350796e-009   dpvth0_p_25_l110ae        =  2.5967959e-015
+dprdsw_p_25_l110ae       = -1.0080601e-011   dags_p_25_l110ae          = -3.5932139e-002   dlags_p_25_l110ae         = -5.4385268e-008
+dwags_p_25_l110ae        =  2.0089263e-009   dpags_p_25_l110ae         =  2.3306932e-015   dcgdo_p_25_l110ae         =  9.3000000e-012
+dcgso_p_25_l110ae        =  9.3000000e-012   dcgdl_p_25_l110ae         =  2.1710000e-011   dcgsl_p_25_l110ae         =  2.1710000e-011
+dcj_p_25_l110ae          = -9.6321000e-005   dcjsw_p_25_l110ae         = -1.0525000e-011   dcjswg_p_25_l110ae        = -3.3746000e-011
+djtsswgd_p_25_l110ae     =  2.0000000e-006   djtsswgs_p_25_l110ae      =  2.0000000e-006
//*
+dtox_n_bpw_25_l110ae     = -1.6200000e-010   dxl_n_bpw_25_l110ae       = -1.0000000e-008   dxw_n_bpw_25_l110ae       =  1.0000000e-008
+dvth0_n_bpw_25_l110ae    = -5.5322324e-002   dnlx_n_bpw_25_l110ae      = -4.5720007e-008   dk3_n_bpw_25_l110ae       = -5.7457404e-001
+dpvth0_n_bpw_25_l110ae   = -5.0487368e-015   du0_n_bpw_25_l110ae       =  1.0608897e-003   dlu0_n_bpw_25_l110ae      =  2.3513779e-010
+dwu0_n_bpw_25_l110ae     = -1.2339636e-010   dpu0_n_bpw_25_l110ae      =  4.3530652e-016   drdsw_n_bpw_25_l110ae     = -5.9000000e+001
+dags_n_bpw_25_l110ae     = -3.8029444e-002   dvsat_n_bpw_25_l110ae     =  1.1849878e+003   dwags_n_bpw_25_l110ae     = -1.4548860e-009
+dpvsat_n_bpw_25_l110ae   =  1.9671276e-010   dcj_n_bpw_25_l110ae       = -7.8122000e-005   dcjsw_n_bpw_25_l110ae     = -1.1247000e-011
+dcjswg_n_bpw_25_l110ae   = -2.1550000e-011   dcgdo_n_bpw_25_l110ae     =  1.2500000e-012   dcgso_n_bpw_25_l110ae     =  1.2500000e-012
+dcgdl_n_bpw_25_l110ae    =  2.7000000e-011   dcgsl_n_bpw_25_l110ae     =  2.7000000e-011   djtsswd_n_bpw_25_l110ae   =  1.0000000e-007
+djtsswgd_n_bpw_25_l110ae =  6.0000000e-006   deta0_n_bpw_25_l110ae     = -6.0852918e-003   dpeta0_n_bpw_25_l110ae    = -5.0675393e-016
+djtssws_n_bpw_25_l110ae  =  1.0000000e-007   djtsswgs_n_bpw_25_l110ae  =  6.0000000e-006
//*
include "l110ae_25_v051.mdl.scs"
//*
endsection ff
//*
section ss
include "l110ae_25_v051.lib.scs" section=setup
parameters
//*
+dtox_n_25_l110ae         =  1.6200000e-010   dxl_n_25_l110ae           =  1.5000000e-008   du0_n_25_l110ae           = -1.2793484e-003
+dvth0_n_25_l110ae        =  5.4670373e-002   drdsw_n_25_l110ae         =  1.1208350e+002   dxw_n_25_l110ae           = -4.3333382e-009
+dnlx_n_25_l110ae         =  5.4247906e-008   dk3_n_25_l110ae           =  4.1557227e-001   dpvth0_n_25_l110ae        =  7.7943304e-015
+dwwl_n_25_l110ae         =  1.7628178e-021   dvsat_n_25_l110ae         = -2.5903689e+003   dpvsat_n_25_l110ae        = -2.0378502e-010
+dcj_n_25_l110ae          =  7.8122000e-005   dcjsw_n_25_l110ae         =  1.1247000e-011   dcjswg_n_25_l110ae        =  2.1550000e-011
+dcgdo_n_25_l110ae        = -1.2500000e-012   dcgso_n_25_l110ae         = -1.2500000e-012   dags_n_25_l110ae          =  4.7519863e-002
+deta0_n_25_l110ae        =  2.5000000e-003   dcgdl_n_25_l110ae         = -2.7000000e-011   dcgsl_n_25_l110ae         = -2.7000000e-011
+dwags_n_25_l110ae        =  0.0000000e+000   dwb0_n_25_l110ae          =  0.0000000e+000   dwvsat_n_25_l110ae        =  0.0000000e+000
+db0_n_25_l110ae          =  5.8004424e-008   djtsswd_n_25_l110ae       = -1.0000000e-009   djtsswgd_n_25_l110ae      = -1.0000000e-007
+dprdsw_n_25_l110ae       =  6.8584745e-012   djtssws_n_25_l110ae       = -1.0000000e-009   djtsswgs_n_25_l110ae      = -1.0000000e-007
//*
+dtox_p_25_l110ae         =  1.1000000e-010   dxl_p_25_l110ae           =  5.0000000e-009   du0_p_25_l110ae           = -5.6161544e-004
+dvth0_p_25_l110ae        = -5.3461103e-002   drdsw_p_25_l110ae         =  1.1045294e+002   dwu0_p_25_l110ae          = -2.4800000e-011
+dlvth0_p_25_l110ae       = -1.3246841e-008   dwvth0_p_25_l110ae        = -3.0238606e-009   dpvth0_p_25_l110ae        = -2.6954269e-015
+dprdsw_p_25_l110ae       =  2.7529587e-011   dags_p_25_l110ae          =  3.8245188e-002   dlags_p_25_l110ae         =  4.7712216e-008
+dwags_p_25_l110ae        = -1.7024053e-009   dpags_p_25_l110ae         = -1.6648007e-014   dcgdo_p_25_l110ae         = -9.3000000e-012
+dcgso_p_25_l110ae        = -9.3000000e-012   dcgdl_p_25_l110ae         = -2.1710000e-011   dcgsl_p_25_l110ae         = -2.1710000e-011
+dcj_p_25_l110ae          =  9.6321000e-005   dcjsw_p_25_l110ae         =  1.0525000e-011   dcjswg_p_25_l110ae        =  3.3746000e-011
+djtsswgd_p_25_l110ae     = -1.9000000e-008   djtsswgs_p_25_l110ae      = -1.9000000e-008
//*
+dtox_n_bpw_25_l110ae     =  1.6200000e-010   dxl_n_bpw_25_l110ae       =  1.0000000e-008   dxw_n_bpw_25_l110ae       = -1.0000000e-008
+dvth0_n_bpw_25_l110ae    =  5.4527330e-002   dnlx_n_bpw_25_l110ae      =  5.0555336e-008   dk3_n_bpw_25_l110ae       =  4.8188535e-001
+dpvth0_n_bpw_25_l110ae   =  4.8399791e-015   du0_n_bpw_25_l110ae       = -1.2449434e-003   dlu0_n_bpw_25_l110ae      = -4.1312173e-010
+dwu0_n_bpw_25_l110ae     =  5.9316389e-011   dpu0_n_bpw_25_l110ae      = -3.7548146e-016   drdsw_n_bpw_25_l110ae     =  5.9000000e+001
+dags_n_bpw_25_l110ae     =  4.0293273e-002   dvsat_n_bpw_25_l110ae     = -2.3601530e+003   dwags_n_bpw_25_l110ae     =  1.3603733e-009
+dpvsat_n_bpw_25_l110ae   = -3.6346657e-010   dcj_n_bpw_25_l110ae       =  7.8122000e-005   dcjsw_n_bpw_25_l110ae     =  1.1247000e-011
+dcjswg_n_bpw_25_l110ae   =  2.1550000e-011   dcgdo_n_bpw_25_l110ae     = -1.2500000e-012   dcgso_n_bpw_25_l110ae     = -1.2500000e-012
+dcgdl_n_bpw_25_l110ae    = -2.7000000e-011   dcgsl_n_bpw_25_l110ae     = -2.7000000e-011   djtsswd_n_bpw_25_l110ae   = -1.0000000e-010
+djtsswgd_n_bpw_25_l110ae = -1.0000000e-008   deta0_n_bpw_25_l110ae     =  5.8527984e-003   dpeta0_n_bpw_25_l110ae    =  4.4342263e-016
+djtssws_n_bpw_25_l110ae  = -1.0000000e-010   djtsswgs_n_bpw_25_l110ae  = -1.0000000e-008
//*
include "l110ae_25_v051.mdl.scs"
//*
endsection ss
//*
section fnsp
include "l110ae_25_v051.lib.scs" section=setup
parameters
//*
+dtox_n_25_l110ae         =  0.0000000e+000   dxl_n_25_l110ae           = -1.5000000e-008   du0_n_25_l110ae           =  7.0346547e-004
+dvth0_n_25_l110ae        = -2.8357935e-002   drdsw_n_25_l110ae         = -2.5194192e+001   dxw_n_25_l110ae           =  1.5340210e-009
+dnlx_n_25_l110ae         = -1.1483355e-008   dk3_n_25_l110ae           = -2.2334804e-001   dpvth0_n_25_l110ae        = -3.8070480e-015
+dwwl_n_25_l110ae         = -9.9376761e-022   dvsat_n_25_l110ae         =  1.5752926e+003   dpvsat_n_25_l110ae        = -2.2807956e-012
+dcj_n_25_l110ae          = -7.8122000e-005   dcjsw_n_25_l110ae         = -1.1247000e-011   dcjswg_n_25_l110ae        = -2.1550000e-011
+dcgdo_n_25_l110ae        =  0.0000000e+000   dcgso_n_25_l110ae         =  0.0000000e+000   dags_n_25_l110ae          = -2.3526647e-002
+deta0_n_25_l110ae        = -3.6500000e-003   dcgdl_n_25_l110ae         =  0.0000000e+000   dcgsl_n_25_l110ae         =  0.0000000e+000
+dwags_n_25_l110ae        =  0.0000000e+000   dwb0_n_25_l110ae          =  0.0000000e+000   dwvsat_n_25_l110ae        =  0.0000000e+000
+db0_n_25_l110ae          = -2.1538398e-008   djtsswd_n_25_l110ae       =  7.5000000e-008   djtsswgd_n_25_l110ae      =  4.7000000e-006
+dprdsw_n_25_l110ae       =  0.0000000e+000   djtssws_n_25_l110ae       =  7.5000000e-008   djtsswgs_n_25_l110ae      =  4.7000000e-006
//*
+dtox_p_25_l110ae         =  0.0000000e+000   dxl_p_25_l110ae           =  5.0000000e-009   du0_p_25_l110ae           = -3.1329173e-004
+dvth0_p_25_l110ae        = -2.6844190e-002   drdsw_p_25_l110ae         =  9.2728659e+000   dwu0_p_25_l110ae          = -6.3574859e-012
+dlvth0_p_25_l110ae       = -6.0413534e-009   dwvth0_p_25_l110ae        = -1.4719195e-009   dpvth0_p_25_l110ae        = -1.3811224e-015
+dprdsw_p_25_l110ae       =  1.0129718e-011   dags_p_25_l110ae          =  1.9061263e-002   dlags_p_25_l110ae         =  3.2752082e-008
+dwags_p_25_l110ae        = -1.0000000e-009   dpags_p_25_l110ae         = -5.1548074e-015   dcgdo_p_25_l110ae         =  0.0000000e+000
+dcgso_p_25_l110ae        =  0.0000000e+000   dcgdl_p_25_l110ae         =  0.0000000e+000   dcgsl_p_25_l110ae         =  0.0000000e+000
+dcj_p_25_l110ae          =  9.6321000e-005   dcjsw_p_25_l110ae         =  1.0525000e-011   dcjswg_p_25_l110ae        =  3.3746000e-011
+djtsswgd_p_25_l110ae     = -1.9000000e-008   djtsswgs_p_25_l110ae      = -1.9000000e-008
//*
+dtox_n_bpw_25_l110ae     =  0.0000000e+000   dxl_n_bpw_25_l110ae       = -5.0000000e-009   dxw_n_bpw_25_l110ae       =  5.0000000e-009
+dvth0_n_bpw_25_l110ae    = -2.8060673e-002   dnlx_n_bpw_25_l110ae      = -2.0882452e-008   dk3_n_bpw_25_l110ae       = -2.5225204e-001
+dpvth0_n_bpw_25_l110ae   = -2.4095926e-015   du0_n_bpw_25_l110ae       =  6.8718341e-004   dlu0_n_bpw_25_l110ae      =  1.3917334e-010
+dwu0_n_bpw_25_l110ae     = -5.6222851e-011   dpu0_n_bpw_25_l110ae      =  2.4945999e-016   drdsw_n_bpw_25_l110ae     = -2.9500000e+001
+dags_n_bpw_25_l110ae     = -1.9893617e-002   dvsat_n_bpw_25_l110ae     =  1.8908809e+003   dwags_n_bpw_25_l110ae     = -6.8562649e-010
+dpvsat_n_bpw_25_l110ae   =  9.6796933e-011   dcj_n_bpw_25_l110ae       = -7.8122000e-005   dcjsw_n_bpw_25_l110ae     = -1.1247000e-011
+dcjswg_n_bpw_25_l110ae   = -2.1550000e-011   dcgdo_n_bpw_25_l110ae     =  0.0000000e+000   dcgso_n_bpw_25_l110ae     =  0.0000000e+000
+dcgdl_n_bpw_25_l110ae    =  0.0000000e+000   dcgsl_n_bpw_25_l110ae     =  0.0000000e+000   djtsswd_n_bpw_25_l110ae   =  7.5000000e-008
+djtsswgd_n_bpw_25_l110ae =  4.7000000e-006   deta0_n_bpw_25_l110ae     = -6.0457244e-003   dpeta0_n_bpw_25_l110ae    = -2.4633389e-016
+djtssws_n_bpw_25_l110ae  =  7.5000000e-008   djtsswgs_n_bpw_25_l110ae  =  4.7000000e-006
//*
include "l110ae_25_v051.mdl.scs"
//*
endsection fnsp
//*
section snfp
include "l110ae_25_v051.lib.scs" section=setup
parameters
//*
+dtox_n_25_l110ae         =  0.0000000e+000   dxl_n_25_l110ae           =  1.5000000e-008   du0_n_25_l110ae           = -7.3982193e-004
+dvth0_n_25_l110ae        =  2.8084161e-002   drdsw_n_25_l110ae         =  3.0662235e+001   dxw_n_25_l110ae           = -1.7454713e-009
+dnlx_n_25_l110ae         =  1.5976413e-008   dk3_n_25_l110ae           =  2.2072350e-001   dpvth0_n_25_l110ae        =  3.7846787e-015
+dwwl_n_25_l110ae         =  1.7430419e-021   dvsat_n_25_l110ae         = -1.8216151e+003   dpvsat_n_25_l110ae        =  9.3087134e-011
+dcj_n_25_l110ae          =  7.8122000e-005   dcjsw_n_25_l110ae         =  1.1247000e-011   dcjswg_n_25_l110ae        =  2.1550000e-011
+dcgdo_n_25_l110ae        =  0.0000000e+000   dcgso_n_25_l110ae         =  0.0000000e+000   dags_n_25_l110ae          =  2.4253558e-002
+deta0_n_25_l110ae        =  4.0500000e-003   dcgdl_n_25_l110ae         =  0.0000000e+000   dcgsl_n_25_l110ae         =  0.0000000e+000
+dwags_n_25_l110ae        =  0.0000000e+000   dwb0_n_25_l110ae          =  0.0000000e+000   dwvsat_n_25_l110ae        =  0.0000000e+000
+db0_n_25_l110ae          =  2.5576090e-008   djtsswd_n_25_l110ae       = -9.0000000e-010   djtsswgd_n_25_l110ae      = -9.0000000e-008
+dprdsw_n_25_l110ae       =  0.0000000e+000   djtssws_n_25_l110ae       = -9.0000000e-010   djtsswgs_n_25_l110ae      = -9.0000000e-008
//*
+dtox_p_25_l110ae         =  0.0000000e+000   dxl_p_25_l110ae           = -5.0000000e-009   du0_p_25_l110ae           =  2.9971677e-004
+dvth0_p_25_l110ae        =  2.7014349e-002   drdsw_p_25_l110ae         =  3.0740860e+000   dwu0_p_25_l110ae          =  2.9038150e-012
+dlvth0_p_25_l110ae       =  5.7396114e-009   dwvth0_p_25_l110ae        =  1.5940264e-009   dpvth0_p_25_l110ae        =  1.3157866e-015
+dprdsw_p_25_l110ae       = -6.1236040e-012   dags_p_25_l110ae          = -1.8447949e-002   dlags_p_25_l110ae         = -3.4330144e-008
+dwags_p_25_l110ae        =  9.7000000e-010   dpags_p_25_l110ae         =  2.0052280e-015   dcgdo_p_25_l110ae         =  0.0000000e+000
+dcgso_p_25_l110ae        =  0.0000000e+000   dcgdl_p_25_l110ae         =  0.0000000e+000   dcgsl_p_25_l110ae         =  0.0000000e+000
+dcj_p_25_l110ae          = -9.6321000e-005   dcjsw_p_25_l110ae         = -1.0525000e-011   dcjswg_p_25_l110ae        = -3.3746000e-011
+djtsswgd_p_25_l110ae     =  2.0000000e-006   djtsswgs_p_25_l110ae      =  2.0000000e-006
//*
+dtox_n_bpw_25_l110ae     =  0.0000000e+000   dxl_n_bpw_25_l110ae       =  5.0000000e-009   dxw_n_bpw_25_l110ae       = -5.0000000e-009
+dvth0_n_bpw_25_l110ae    =  2.7873255e-002   dnlx_n_bpw_25_l110ae      =  2.2105731e-008   dk3_n_bpw_25_l110ae       =  2.5907042e-001
+dpvth0_n_bpw_25_l110ae   =  2.3551067e-015   du0_n_bpw_25_l110ae       = -7.2170632e-004   dlu0_n_bpw_25_l110ae      = -1.8043805e-010
+dwu0_n_bpw_25_l110ae     =  4.1420157e-011   dpu0_n_bpw_25_l110ae      = -2.2335325e-016   drdsw_n_bpw_25_l110ae     =  2.9500000e+001
+dags_n_bpw_25_l110ae     =  2.0503854e-002   dvsat_n_bpw_25_l110ae     = -2.1110667e+003   dwags_n_bpw_25_l110ae     =  7.3034951e-010
+dpvsat_n_bpw_25_l110ae   = -1.3622256e-010   dcj_n_bpw_25_l110ae       =  7.8122000e-005   dcjsw_n_bpw_25_l110ae     =  1.1247000e-011
+dcjswg_n_bpw_25_l110ae   =  2.1550000e-011   dcgdo_n_bpw_25_l110ae     =  0.0000000e+000   dcgso_n_bpw_25_l110ae     =  0.0000000e+000
+dcgdl_n_bpw_25_l110ae    =  0.0000000e+000   dcgsl_n_bpw_25_l110ae     =  0.0000000e+000   djtsswd_n_bpw_25_l110ae   = -9.0000000e-011
+djtsswgd_n_bpw_25_l110ae = -9.0000000e-009   deta0_n_bpw_25_l110ae     =  6.1324542e-003   dpeta0_n_bpw_25_l110ae    =  3.1431239e-016
+djtssws_n_bpw_25_l110ae  = -9.0000000e-011   djtsswgs_n_bpw_25_l110ae  = -9.0000000e-009
//*
include "l110ae_25_v051.mdl.scs"
//*
endsection snfp
//*

endlibrary mylib
