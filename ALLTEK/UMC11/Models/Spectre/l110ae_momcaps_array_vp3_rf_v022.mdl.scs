simulator lang=spectre insensitive=yes
// Model: momcaps_array_vp3_rf
// RF vp3 array MOM capacitor
// Date: 2010-07-15
// Model coverage:
// nf: 10 - 40
// lf: (10 - 40) * 1e-06
// bm: 1 - 4
// ns: 3 - 6
// array: 1 - 4
// Frequency range: 0 - 0.8 * resonance (maximum 16.0 GHz)
subckt momcaps_array_vp3_rf (plus minus nwell sub)
parameters nf=20 nf_=nf/40 lf=2e-05 lf_=lf/4e-05 bm=1 ns=6 array=2  \
s0=(bm==1)*(ns==3)*(array==1) \
s1=(bm==1)*(ns==3)*(array==2) \
s2=(bm==1)*(ns==3)*(array==3) \
s3=(bm==1)*(ns==3)*(array==4) \
s4=(bm==2)*(ns==3)*(array==1) \
s5=(bm==2)*(ns==3)*(array==2) \
s6=(bm==2)*(ns==3)*(array==3) \
s7=(bm==2)*(ns==3)*(array==4) \
s8=(bm==3)*(ns==3)*(array==1) \
s9=(bm==3)*(ns==3)*(array==2) \
s10=(bm==3)*(ns==3)*(array==3) \
s11=(bm==3)*(ns==3)*(array==4) \
s12=(bm==4)*(ns==3)*(array==1) \
s13=(bm==4)*(ns==3)*(array==2) \
s14=(bm==4)*(ns==3)*(array==3) \
s15=(bm==4)*(ns==3)*(array==4) \
s16=(bm==1)*(ns==4)*(array==1) \
s17=(bm==1)*(ns==4)*(array==2) \
s18=(bm==1)*(ns==4)*(array==3) \
s19=(bm==1)*(ns==4)*(array==4) \
s20=(bm==2)*(ns==4)*(array==1) \
s21=(bm==2)*(ns==4)*(array==2) \
s22=(bm==2)*(ns==4)*(array==3) \
s23=(bm==2)*(ns==4)*(array==4) \
s24=(bm==3)*(ns==4)*(array==1) \
s25=(bm==3)*(ns==4)*(array==2) \
s26=(bm==3)*(ns==4)*(array==3) \
s27=(bm==3)*(ns==4)*(array==4) \
s28=(bm==1)*(ns==5)*(array==1) \
s29=(bm==1)*(ns==5)*(array==2) \
s30=(bm==1)*(ns==5)*(array==3) \
s31=(bm==1)*(ns==5)*(array==4) \
s32=(bm==2)*(ns==5)*(array==1) \
s33=(bm==2)*(ns==5)*(array==2) \
s34=(bm==2)*(ns==5)*(array==3) \
s35=(bm==2)*(ns==5)*(array==4) \
s36=(bm==1)*(ns==6)*(array==1) \
s37=(bm==1)*(ns==6)*(array==2) \
s38=(bm==1)*(ns==6)*(array==3) \
s39=(bm==1)*(ns==6)*(array==4) \
v0_part1=8.627921e+01*s0+2.828527e+00*s1+1.434815e+01*s2+(-1.456576e+00)*s3+(-2.144124e+02)*s4+(-2.599457e-01)*s5+8.117177e-02*s6+(-4.113818e+00)*s7+5.326010e+01*s8+4.263987e+01*s9 \
v0_part2=v0_part1+(-2.314486e+00)*s10+1.930296e+01*s11+5.244874e+01*s12+3.282001e+00*s13+1.429835e+01*s14+6.460441e+00*s15+(-5.221122e+00)*s16+(-5.703734e+00)*s17+1.705045e+01*s18+7.279290e+01*s19 \
v0_part3=v0_part2+8.361380e+00*s20+(-3.301667e+00)*s21+(-9.429685e+00)*s22+9.197205e-01*s23+6.830003e+00*s24+(-1.622451e+01)*s25+(-3.558648e+00)*s26+(-2.323376e+01)*s27+5.933417e+01*s28+8.769202e+00*s29 \
v0=v0_part3+7.912282e-02*s30+(-1.201485e+00)*s31+(-3.798043e+01)*s32+2.520810e+00*s33+2.068839e+01*s34+(-2.187536e+01)*s35+7.140183e+00*s36+1.800751e+00*s37+6.150741e-02*s38+3.633162e+00*s39 \
v1_part1=(-1.045064e+02)*s0+1.053648e-01*s1+(-8.810671e+01)*s2+1.141263e+02*s3+1.559260e+03*s4+(-4.503819e-01)*s5+4.542216e+01*s6+(-3.102432e+00)*s7+3.352913e+01*s8+(-5.102855e+01)*s9 \
v1_part2=v1_part1+(-1.630577e+01)*s10+(-1.117334e+00)*s11+(-2.313789e+00)*s12+2.704690e+01*s13+2.625799e+01*s14+4.722460e+00*s15+(-2.067904e+01)*s16+3.074101e+01*s17+(-1.231663e+01)*s18+(-5.169747e+01)*s19 \
v1_part3=v1_part2+(-1.981957e+00)*s20+6.888535e+00*s21+9.972070e-01*s22+(-1.537591e+00)*s23+(-2.457945e+01)*s24+1.854837e+01*s25+1.146745e+01*s26+7.287682e+00*s27+(-3.306208e+01)*s28+1.297790e+01*s29 \
v1=v1_part3+3.861493e+00*s30+(-1.331467e+00)*s31+1.669242e+02*s32+7.684337e+00*s33+(-3.080987e+01)*s34+2.812492e+00*s35+(-1.666925e+01)*s36+8.182247e+00*s37+(-3.728028e+00)*s38+(-9.932111e+00)*s39 \
v2_part1=(-2.075608e+01)*s0+(-4.701205e+00)*s1+5.604440e+01*s2+5.113688e-01*s3+5.322949e+00*s4+(-9.964638e-02)*s5+(-1.835507e+01)*s6+2.173775e+01*s7+(-1.038574e+02)*s8+(-1.797970e+01)*s9 \
v2_part2=v2_part1+3.535573e+01*s10+(-2.261939e+01)*s11+(-7.253738e+01)*s12+(-2.118493e+01)*s13+(-5.957393e+01)*s14+9.087653e+00*s15+1.301145e+01*s16+4.138200e+00*s17+6.705692e+01*s18+(-5.941823e+01)*s19 \
v2_part3=v2_part2+1.345674e+01*s20+7.544615e+00*s21+3.713409e+01*s22+1.581822e+00*s23+1.233316e+01*s24+2.095566e+01*s25+2.015742e+00*s26+(-2.429775e+00)*s27+(-2.979797e+01)*s28+(-4.781644e-01)*s29 \
v2=v2_part3+1.489085e+00*s30+4.880084e+00*s31+2.985289e+01*s32+(-1.309063e+01)*s33+(-1.819707e+00)*s34+4.902992e+01*s35+5.989642e+00*s36+5.686401e+00*s37+3.721828e+00*s38+1.168187e+00*s39 \
v3_part1=3.076692e+01*s0+1.064254e+01*s1+7.258870e+01*s2+(-2.908855e+01)*s3+5.816654e+01*s4+(-2.064793e+01)*s5+(-8.198391e+01)*s6+(-2.050420e+00)*s7+6.364953e-02*s8+1.877082e+01*s9 \
v3_part2=v3_part1+(-5.303567e-01)*s10+(-1.322586e+02)*s11+1.124806e+01*s12+(-1.998019e+01)*s13+4.539408e+00*s14+(-6.190726e+00)*s15+2.146694e+01*s16+(-2.332225e+01)*s17+1.141045e+01*s18+(-8.387650e+00)*s19 \
v3_part3=v3_part2+1.470243e+00*s20+(-2.828134e+00)*s21+(-2.669537e-01)*s22+3.782868e-01*s23+5.775068e+00*s24+(-1.055981e+00)*s25+(-4.919765e+00)*s26+3.292004e+01*s27+(-1.847485e+01)*s28+(-3.479867e+00)*s29 \
v3=v3_part3+(-7.282564e+00)*s30+2.875172e+00*s31+(-3.655911e+01)*s32+(-5.958329e+00)*s33+6.274404e+00*s34+1.452584e+01*s35+1.225912e+01*s36+(-8.399403e+00)*s37+4.827825e-01*s38+5.417286e+00*s39 \
v4_part1=(-4.426949e+01)*s0+(-1.472682e+01)*s1+(-4.850415e+01)*s2+(-6.447516e+01)*s3+(-1.436412e+03)*s4+2.008362e+01*s5+5.803435e+01*s6+(-5.506347e+00)*s7+(-1.719719e+01)*s8+1.718073e+01*s9 \
v4_part2=v4_part1+1.759101e+01*s10+(-2.957286e+01)*s11+(-1.557428e+00)*s12+7.786300e+00*s13+(-1.785275e+01)*s14+(-1.413896e+01)*s15+1.337772e+01*s16+1.536624e+01*s17+(-1.453832e+01)*s18+6.502521e+01*s19 \
v4_part3=v4_part2+(-4.288322e+01)*s20+6.734653e-01*s21+1.402140e+00*s22+(-6.399100e+00)*s23+1.263608e+01*s24+(-2.721545e+01)*s25+2.069158e+00*s26+4.608712e+00*s27+6.189303e+01*s28+(-4.332568e+00)*s29 \
v4=v4_part3+(-5.297055e+00)*s30+(-6.319995e-01)*s31+(-9.447793e+01)*s32+4.804252e+00*s33+1.119967e+01*s34+(-2.231597e+01)*s35+(-2.920400e+00)*s36+(-2.729863e+00)*s37+3.145266e+00*s38+7.257403e-01*s39 \
v5_part1=7.148301e+00*s0+(-3.645634e+00)*s1+3.555390e+00*s2+(-3.486117e+00)*s3+1.841268e+02*s4+7.440034e+00*s5+(-1.005993e+01)*s6+(-6.946128e+00)*s7+5.104780e+01*s8+(-1.023457e+00)*s9 \
v5_part2=v5_part1+(-2.984994e+01)*s10+1.937879e+01*s11+2.471236e+01*s12+9.989289e+00*s13+4.550242e+01*s14+(-8.304289e+00)*s15+3.204771e-01*s16+(-1.164180e+01)*s17+(-5.450908e+01)*s18+(-1.089410e+01)*s19 \
v5_part3=v5_part2+(-2.242074e+00)*s20+(-3.169803e+00)*s21+(-2.642938e+01)*s22+6.686038e+00*s23+(-1.024803e+01)*s24+7.045051e+00*s25+1.645441e-01*s26+(-1.982228e+01)*s27+(-1.311656e+02)*s28+(-7.135618e+00)*s29 \
v5=v5_part3+1.567126e+00*s30+(-1.880380e+00)*s31+(-3.454257e+00)*s32+2.404780e+00*s33+(-3.537209e+00)*s34+(-1.830581e+01)*s35+(-1.105408e+00)*s36+(-4.643955e+00)*s37+(-1.151106e+00)*s38+(-3.725361e-01)*s39 \
v6_part1=(-1.502896e+00)*s0+4.334761e-01*s1+1.001316e+00*s2+(-5.480246e-02)*s3+(-2.951261e+01)*s4+1.558055e-01*s5+(-3.150391e-01)*s6+(-3.123416e-02)*s7+1.687750e+00*s8+2.312565e+01*s9 \
v6_part2=v6_part1+(-5.581394e-03)*s10+3.230615e-01*s11+5.038231e+00*s12+(-6.419857e-01)*s13+(-2.860377e+00)*s14+(-1.092156e+00)*s15+(-3.108693e+01)*s16+(-7.142070e-02)*s17+(-2.545263e+01)*s18+4.775227e-01*s19 \
v6_part3=v6_part2+(-1.968758e-01)*s20+(-7.171178e-02)*s21+3.769305e+00*s22+(-9.543067e-01)*s23+(-2.327067e+00)*s24+(-5.821680e-01)*s25+(-4.722094e-02)*s26+(-8.469364e-01)*s27+(-1.458466e+00)*s28+4.108155e-01*s29 \
v6=v6_part3+2.473017e-01*s30+(-4.817894e-02)*s31+(-7.090469e+01)*s32+1.391178e-01*s33+7.657044e-01*s34+1.403628e+00*s35+(-2.795668e-02)*s36+7.548335e-01*s37+6.458767e-02*s38+(-3.379042e-01)*s39 \
v7_part1=5.683617e+00*s0+(-1.954638e-01)*s1+(-1.358258e+01)*s2+4.986078e-01*s3+1.325381e+02*s4+(-4.232244e+00)*s5+(-5.568445e+00)*s6+(-6.142010e-01)*s7+4.676714e-01*s8+3.742827e+00*s9 \
v7_part2=v7_part1+(-5.818946e-01)*s10+(-1.360966e+00)*s11+(-2.597135e-01)*s12+9.609808e-01*s13+1.660814e+00*s14+(-1.319260e+00)*s15+7.359776e+01*s16+1.492742e-01*s17+4.513609e+01*s18+2.621688e-01*s19 \
v7_part3=v7_part2+(-2.219268e-01)*s20+(-1.841068e-02)*s21+7.642364e-01*s22+4.538163e-01*s23+(-1.182644e+00)*s24+2.181389e+00*s25+(-7.753768e-01)*s26+1.582281e+00*s27+(-1.585129e+00)*s28+(-3.201296e-01)*s29 \
v7=v7_part3+(-2.445747e-01)*s30+2.687606e-01*s31+2.199126e+02*s32+(-2.604893e-01)*s33+(-2.349979e+00)*s34+5.333075e-01*s35+1.803079e-01*s36+(-1.491648e+00)*s37+5.446360e-02*s38+2.044331e-01*s39 \
v8_part1=(-9.894470e-01)*s0+(-1.636939e+00)*s1+1.089188e+01*s2+1.993954e+00*s3+5.033761e+01*s4+1.345395e+00*s5+5.003192e+00*s6+1.071752e-01*s7+(-2.471990e+00)*s8+(-1.228810e+01)*s9 \
v8_part2=v8_part1+1.194507e+00*s10+1.756231e-01*s11+(-3.967174e+00)*s12+8.915396e-01*s13+6.629177e+00*s14+5.681792e+00*s15+(-1.479067e+00)*s16+(-1.045247e+00)*s17+5.668330e+01*s18+1.450136e-01*s19 \
v8_part3=v8_part2+9.346205e-01*s20+1.420965e-01*s21+(-8.355039e+00)*s22+1.393818e+00*s23+6.303904e+00*s24+(-1.730056e+00)*s25+5.578278e-01*s26+(-2.125937e+00)*s27+4.888198e+00*s28+7.527878e-02*s29 \
v8=v8_part3+(-6.096712e-01)*s30+6.491344e-02*s31+(-5.028688e+01)*s32+(-2.484905e-01)*s33+5.180905e-01*s34+(-1.704148e+00)*s35+1.547166e-01*s36+(-5.397177e-01)*s37+(-2.741282e-01)*s38+5.371368e-01*s39 \
v9_part1=(-4.789690e+00)*s0+(-7.041187e-02)*s1+1.173821e+01*s2+5.568464e+00*s3+(-8.662660e+01)*s4+3.925411e+00*s5+4.213719e+00*s6+5.999912e-01*s7+(-1.210682e+00)*s8+(-4.830319e+01)*s9 \
v9_part2=v9_part1+3.176193e-01*s10+1.058144e+00*s11+(-1.522547e+01)*s12+(-2.680172e-01)*s13+2.227434e+00*s14+2.184091e+00*s15+(-4.259913e+01)*s16+3.651226e-02*s17+(-2.974068e+01)*s18+3.489421e-01*s19 \
v9_part3=v9_part2+5.383774e-01*s20+4.410317e-03*s21+3.161174e-01*s22+4.520707e-01*s23+9.033548e-01*s24+(-1.500355e+00)*s25+1.100860e+00*s26+(-2.944917e-03)*s27+2.765819e+00*s28+3.811013e-01*s29 \
v9=v9_part3+(-4.361704e-03)*s30+(-2.854722e-01)*s31+(-1.467900e+02)*s32+(-2.744242e-02)*s33+1.620414e+00*s34+(-1.685002e+00)*s35+(-1.176864e-01)*s36+6.238827e-01*s37+(-7.267435e-02)*s38+1.474088e-01*s39 \
v10_part1=3.431822e+00*s0+6.040992e-01*s1+(-8.825189e+00)*s2+(-5.711252e+00)*s3+4.290466e+01*s4+8.885402e-02*s5+7.343972e-02*s6+2.562978e-02*s7+2.312854e+00*s8+(-3.847077e+01)*s9 \
v10_part2=v10_part1+(-1.608537e-01)*s10+6.742797e-02*s11+6.259763e+00*s12+(-3.946472e-01)*s13+(-2.130928e+00)*s14+(-1.035213e+00)*s15+1.980893e+00*s16+8.038406e-01*s17+(-6.732240e+00)*s18+2.664550e-01*s19 \
v10_part3=v10_part2+(-1.553898e+00)*s20+2.602252e-01*s21+(-5.331576e-01)*s22+(-1.041271e+00)*s23+9.186977e-02*s24+1.043383e+00*s25+4.541396e-01*s26+(-8.610421e-01)*s27+(-2.808171e+00)*s28+2.025660e-01*s29 \
v10=v10_part3+3.580851e-01*s30+1.079859e-01*s31+4.742523e+01*s32+8.580470e-01*s33+(-4.679025e-01)*s34+2.130608e+00*s35+(-1.519748e-01)*s36+8.372374e-01*s37+8.394352e-02*s38+(-3.830812e-01)*s39 \
v11_part1=(-1.185501e+00)*s0+1.178151e+00*s1+(-8.326595e-01)*s2+(-8.721261e-01)*s3+(-9.942317e+01)*s4+(-4.198599e-01)*s5+(-2.112441e+00)*s6+3.302060e-01*s7+3.247868e-01*s8+1.067101e+00*s9 \
v11_part2=v11_part1+(-4.262837e-01)*s10+5.953181e-02*s11+(-1.278939e+00)*s12+(-2.396742e-01)*s13+(-3.717027e+00)*s14+(-2.969275e+00)*s15+1.037427e-01*s16+1.163791e+00*s17+(-5.794971e+01)*s18+(-6.545841e-01)*s19 \
v11_part3=v11_part2+7.001071e-01*s20+(-3.348760e-02)*s21+4.547097e+00*s22+(-2.239689e-02)*s23+(-3.345155e+00)*s24+1.764587e+00*s25+(-4.482076e-01)*s26+2.987687e+00*s27+3.878745e-01*s28+(-3.727035e-01)*s29 \
v11=v11_part3+3.953212e-01*s30+(-4.766487e-03)*s31+2.576648e+00*s32+8.332781e-02*s33+1.508421e-01*s34+(-2.431391e-01)*s35+2.568481e-01*s36+(-6.972444e-02)*s37+2.273034e-01*s38+(-9.223362e-02)*s39 \
v12_part1=1.951183e+00*s0+(-1.454241e+00)*s1+1.205339e+01*s2+(-3.343265e+00)*s3+5.680764e-01*s4+(-3.920000e+00)*s5+(-3.231317e-01)*s6+5.828993e-03*s7+(-1.613600e+00)*s8+(-8.863750e-01)*s9 \
v12_part2=v12_part1+7.174975e-01*s10+2.493165e+00*s11+2.492572e+00*s12+2.849721e+00*s13+(-3.305522e+00)*s14+(-5.655274e-01)*s15+(-2.219463e+01)*s16+1.589866e+00*s17+(-1.286926e+01)*s18+(-1.627596e+00)*s19 \
v12_part3=v12_part2+4.383237e+00*s20+(-4.026790e+00)*s21+6.814662e+00*s22+(-1.263398e+01)*s23+(-3.966850e+00)*s24+(-3.295998e+00)*s25+(-4.120562e+00)*s26+1.361893e+01*s27+(-8.017662e-01)*s28+(-8.148694e-01)*s29 \
v12=v12_part3+(-6.751182e+00)*s30+(-6.559185e+00)*s31+(-3.623123e+01)*s32+1.105837e+01*s33+(-6.187132e+00)*s34+1.265862e+01*s35+(-1.769663e+00)*s36+2.104058e+00*s37+2.059499e+00*s38+(-1.417439e+01)*s39 \
v13_part1=(-6.234820e+00)*s0+1.317862e+01*s1+(-6.679374e+01)*s2+(-3.992491e+00)*s3+(-1.314001e+01)*s4+1.430339e+01*s5+1.585882e+01*s6+4.878002e+00*s7+2.622973e+00*s8+(-2.676160e-01)*s9 \
v13_part2=v13_part1+(-4.971868e+00)*s10+1.560731e+00*s11+(-5.343577e+00)*s12+(-2.220749e+01)*s13+1.053798e+01*s14+1.194239e+01*s15+4.813071e+01*s16+(-8.486390e+00)*s17+(-1.417653e+01)*s18+2.542899e+01*s19 \
v13_part3=v13_part2+2.722305e-01*s20+1.647839e+01*s21+1.015149e+01*s22+6.059103e+01*s23+1.549816e+01*s24+1.863792e+01*s25+2.515972e+01*s26+(-6.289696e+01)*s27+(-2.166820e+00)*s28+2.308411e+01*s29 \
v13=v13_part3+(-6.712491e-01)*s30+(-1.648962e+01)*s31+4.565232e+01*s32+(-3.190980e+01)*s33+1.470345e+01*s34+(-7.497383e+01)*s35+1.204781e+00*s36+(-5.220815e+00)*s37+3.500526e+00*s38+(-7.933282e+00)*s39 \
v14_part1=(-1.037713e+01)*s0+(-4.926721e+00)*s1+(-1.296292e+01)*s2+(-1.546811e+01)*s3+3.130113e+00*s4+1.714512e+01*s5+(-3.622277e+00)*s6+(-6.897073e+00)*s7+(-3.572043e-01)*s8+(-3.168171e+00)*s9 \
v14_part2=v14_part1+(-1.679810e+01)*s10+(-1.215441e+01)*s11+(-9.899291e+00)*s12+9.419848e+00*s13+1.626434e+01*s14+(-2.260640e+01)*s15+(-1.653705e+00)*s16+2.242360e+01*s17+3.148639e+00*s18+(-4.949695e+01)*s19 \
v14_part3=v14_part2+(-1.085722e+01)*s20+1.401425e+01*s21+(-6.646081e+01)*s22+(-4.091391e+01)*s23+(-3.483721e+00)*s24+1.726856e+01*s25+2.845800e+01*s26+(-2.185502e+01)*s27+1.382224e-01*s28+(-4.616684e+01)*s29 \
v14=v14_part3+1.933176e+01*s30+1.049189e+01*s31+1.496940e+00*s32+(-3.577429e+01)*s33+(-2.738351e+01)*s34+(-2.915562e+01)*s35+7.936097e+00*s36+(-8.468597e+00)*s37+(-3.354351e+00)*s38+1.324020e+01*s39 \
v15_part1=5.516365e+00*s0+(-1.183385e+00)*s1+7.588511e+01*s2+(-3.051001e+00)*s3+1.029518e+01*s4+8.308403e-01*s5+(-5.444211e+00)*s6+5.466586e+00*s7+(-3.004108e-02)*s8+5.728856e+00*s9 \
v15_part2=v15_part1+1.355040e+01*s10+7.203676e+00*s11+2.571354e+00*s12+1.756452e+01*s13+(-5.005863e+00)*s14+(-1.312834e+01)*s15+(-2.351008e+01)*s16+1.564078e+01*s17+2.425163e+01*s18+(-1.473072e+01)*s19 \
v15_part3=v15_part2+(-2.252262e+00)*s20+1.037273e+00*s21+(-1.731314e+01)*s22+(-5.187347e+00)*s23+(-1.060619e+01)*s24+5.434264e+00*s25+(-2.477915e+01)*s26+4.415238e+01*s27+(-3.366489e+00)*s28+(-1.540502e+01)*s29 \
v15=v15_part3+7.511232e+00*s30+5.800399e+01*s31+(-8.553479e+00)*s32+1.750652e+01*s33+1.641767e+01*s34+6.230104e+01*s35+2.730903e+00*s36+1.825814e+00*s37+2.096421e+01*s38+1.538507e+01*s39 \
v16_part1=3.256169e+01*s0+6.843405e+00*s1+4.290503e+01*s2+3.012346e+01*s3+(-1.407890e+00)*s4+1.786556e+01*s5+2.815925e+01*s6+1.352674e+01*s7+1.572660e+00*s8+2.375501e+01*s9 \
v16_part2=v16_part1+6.822917e+01*s10+4.138641e+01*s11+8.188224e+00*s12+4.261711e+01*s13+3.167010e+00*s14+4.586541e+01*s15+1.659640e+00*s16+1.187238e+01*s17+1.277851e+01*s18+4.955663e+01*s19 \
v16_part3=v16_part2+3.381480e+00*s20+3.784400e+01*s21+4.404725e+01*s22+7.007218e+01*s23+3.008209e+01*s24+5.744936e-01*s25+3.440988e+01*s26+5.373362e+01*s27+2.425557e+01*s28+5.617112e+01*s29 \
v16=v16_part3+1.068441e+02*s30+1.433928e+02*s31+6.556497e+00*s32+5.564715e+01*s33+1.158914e+02*s34+1.274718e+02*s35+7.073419e+01*s36+9.120805e+00*s37+5.225269e+01*s38+2.594799e+02*s39 \
v17_part1=1.451445e+00*s0+9.971945e+00*s1+4.457331e+00*s2+3.509782e+01*s3+6.683501e+00*s4+(-1.030828e+01)*s5+(-1.031652e-02)*s6+2.324033e+00*s7+1.119027e+01*s8+3.628674e+00*s9 \
v17_part2=v17_part1+(-1.974887e+00)*s10+1.440135e+01*s11+1.535678e+01*s12+(-1.110428e-01)*s13+8.262560e+00*s14+1.790267e+01*s15+(-5.259875e-01)*s16+(-7.415151e-01)*s17+9.796518e+00*s18+6.142753e+01*s19 \
v17_part3=v17_part2+5.571749e+00*s20+3.697565e+00*s21+8.852809e+01*s22+4.532146e+01*s23+7.738755e+00*s24+(-4.354343e+00)*s25+2.259123e+00*s26+1.160681e+01*s27+(-4.678558e-01)*s28+6.112348e+01*s29 \
v17=v17_part3+9.763566e+00*s30+1.114089e+01*s31+1.434666e+01*s32+2.083873e+01*s33+(-2.573913e+00)*s34+2.505168e+01*s35+(-1.107162e+01)*s36+9.653514e+00*s37+3.378839e+01*s38+6.784050e+00*s39 \
v18_part1=2.336819e+02*s0+1.376898e+01*s1+(-7.290582e+01)*s2+4.272943e+00*s3+(-7.799786e+02)*s4+(-2.646926e+02)*s5+6.734866e+01*s6+2.948694e+00*s7+4.957251e+03*s8+(-6.506028e+00)*s9 \
v18_part2=v18_part1+(-8.186832e+01)*s10+3.863823e+01*s11+7.781609e+01*s12+4.160285e+00*s13+1.245175e+03*s14+(-1.208588e+02)*s15+(-4.472934e+00)*s16+(-8.887559e-01)*s17+1.579396e+02*s18+1.058533e+03*s19 \
v18_part3=v18_part2+8.326772e+00*s20+3.056203e+02*s21+5.668465e+02*s22+(-3.000423e+01)*s23+(-1.819501e+01)*s24+1.243961e+01*s25+4.839372e+02*s26+1.692496e+02*s27+(-1.917849e+01)*s28+1.275922e+03*s29 \
v18=v18_part3+2.772473e+01*s30+4.042605e+01*s31+2.919238e+00*s32+(-6.688925e+00)*s33+1.360063e+02*s34+1.478286e+02*s35+(-3.039810e+02)*s36+1.133326e+01*s37+1.378418e+01*s38+5.264893e-01*s39 \
v19_part1=3.520421e+02*s0+(-9.938663e+00)*s1+(-2.782658e+01)*s2+2.340834e+02*s3+9.361857e+02*s4+3.630391e+02*s5+2.004881e+01*s6+(-6.462868e+00)*s7+(-5.075893e+03)*s8+(-7.655464e+01)*s9 \
v19_part2=v19_part1+(-7.739939e+00)*s10+(-6.877095e+01)*s11+(-1.859630e+02)*s12+(-3.878606e+00)*s13+1.283306e+01*s14+(-3.288082e+01)*s15+3.124470e+01*s16+8.161476e+00*s17+1.234667e+01*s18+2.690486e+03*s19 \
v19_part3=v19_part2+(-2.017247e+01)*s20+4.632973e+00*s21+(-5.695326e+02)*s22+3.686328e+02*s23+8.069686e+01*s24+3.041118e+02*s25+2.977421e+02*s26+(-1.568612e+02)*s27+(-3.635963e+02)*s28+6.371712e+03*s29 \
v19=v19_part3+(-1.747213e+01)*s30+(-2.834185e+02)*s31+7.677760e+00*s32+1.603851e+01*s33+(-3.915013e+02)*s34+2.315960e+02*s35+(-5.507232e+03)*s36+(-1.818631e+01)*s37+2.611622e+00*s38+1.840653e+01*s39 \
v20_part1=(-1.532570e+01)*s0+(-2.935088e-01)*s1+3.805364e+02*s2+6.208715e+01*s3+(-7.412330e+02)*s4+(-2.551690e+01)*s5+1.932399e+01*s6+(-1.178696e+00)*s7+(-6.359192e+03)*s8+(-6.038763e+00)*s9 \
v20_part2=v20_part1+4.311204e+02*s10+(-8.633837e+00)*s11+4.328068e+01*s12+1.105468e+02*s13+(-7.863261e+02)*s14+6.699126e+02*s15+9.342360e+00*s16+(-3.112367e-01)*s17+(-3.556288e+00)*s18+(-2.313816e+02)*s19 \
v20_part3=v20_part2+1.903115e+01*s20+(-7.114564e+01)*s21+(-5.897551e+02)*s22+(-6.204981e+02)*s23+(-1.571342e+00)*s24+(-1.070015e+02)*s25+(-1.554633e+02)*s26+(-2.478366e+02)*s27+4.708722e+02*s28+(-6.480584e+01)*s29 \
v20=v20_part3+(-3.280215e+01)*s30+3.388089e+01*s31+(-1.122092e+01)*s32+7.641472e+00*s33+3.797872e+01*s34+(-1.876541e+02)*s35+7.951450e+03*s36+(-1.636425e+01)*s37+(-1.435828e+01)*s38+1.575277e+01*s39 \
v21_part1=(-1.468520e+02)*s0+1.696517e+01*s1+1.759206e+01*s2+(-5.789559e+00)*s3+(-3.868959e+03)*s4+2.284178e+02*s5+5.175966e+01*s6+1.582399e+00*s7+1.650541e+03*s8+(-1.351927e+00)*s9 \
v21_part2=v21_part1+(-4.202934e+00)*s10+5.627160e+01*s11+4.281859e+01*s12+1.487487e+02*s13+1.291019e+02*s14+9.288326e+01*s15+(-5.169540e+01)*s16+2.919610e+01*s17+2.282248e+01*s18+(-3.574638e+03)*s19 \
v21_part3=v21_part2+1.421201e+01*s20+(-2.823358e+01)*s21+1.401094e+02*s22+(-1.643330e+02)*s23+1.688877e+01*s24+(-2.171371e+02)*s25+(-7.359918e+01)*s26+4.459983e+00*s27+3.522830e+02*s28+8.333401e+02*s29 \
v21=v21_part3+7.667957e+00*s30+3.945109e+02*s31+(-6.392442e+00)*s32+(-5.683000e+00)*s33+3.268099e+02*s34+(-2.093200e+02)*s35+7.123999e+03*s36+1.122121e+01*s37+(-1.376192e+00)*s38+1.704973e+01*s39 \
v22_part1=1.037172e+01*s0+(-5.304206e+00)*s1+1.127272e+02*s2+(-9.584572e+02)*s3+8.508212e+03*s4+(-2.434668e-01)*s5+(-6.176501e+01)*s6+2.739529e+01*s7+(-3.169269e+02)*s8+2.440869e+00*s9 \
v22_part2=v22_part1+9.181647e+01*s10+(-1.440395e+01)*s11+6.026736e+01*s12+4.819730e+01*s13+3.603398e+00*s14+(-1.534147e+02)*s15+3.452559e+01*s16+1.234755e+02*s17+1.810741e+01*s18+6.953183e+02*s19 \
v22_part3=v22_part2+(-9.539315e+00)*s20+9.693128e+01*s21+3.256540e+02*s22+4.222614e+01*s23+(-2.436212e+00)*s24+(-4.039884e+01)*s25+(-1.557472e+03)*s26+1.703827e+02*s27+(-2.972025e+02)*s28+(-3.346198e+02)*s29 \
v22=v22_part3+(-5.639202e+00)*s30+1.713021e+02*s31+(-2.621795e+01)*s32+9.891981e+00*s33+(-1.174829e+02)*s34+2.343342e+02*s35+3.148396e+01*s36+8.947940e+00*s37+3.404495e-01*s38+(-4.582140e+01)*s39 \
v23_part1=(-3.064123e+02)*s0+(-1.586374e-01)*s1+(-1.198603e+02)*s2+8.209924e+02*s3+1.881880e+03*s4+(-1.289566e+02)*s5+4.644872e+00*s6+(-1.463200e+01)*s7+3.716032e+03*s8+(-5.931450e+01)*s9 \
v23_part2=v23_part1+(-3.579175e+02)*s10+1.651607e+01*s11+(-3.380417e+01)*s12+2.506757e+02*s13+(-3.104932e+02)*s14+(-3.664221e+02)*s15+(-2.055805e+01)*s16+6.295749e+02*s17+(-7.719327e+02)*s18+(-3.108451e+02)*s19 \
v23_part3=v23_part2+(-5.752999e+00)*s20+(-1.139926e+02)*s21+1.869638e+02*s22+5.633997e+02*s23+(-3.753835e+00)*s24+1.447096e+02*s25+1.495172e+03*s26+8.200220e+01*s27+(-3.303666e+01)*s28+(-1.365436e+03)*s29 \
v23=v23_part3+3.797422e+01*s30+1.810676e+00*s31+6.811343e+00*s32+(-1.868623e+00)*s33+3.743842e+01*s34+(-9.235456e+01)*s35+(-6.233126e+03)*s36+7.071926e+00*s37+(-7.766918e-01)*s38+1.230777e+01*s39 \
v24_part1=6.685423e+01*s0+5.262800e-01*s1+(-3.649687e+01)*s2+(-2.959400e+01)*s3+(-2.335300e+02)*s4+3.205361e+01*s5+3.427493e+01*s6+(-2.874804e-01)*s7+(-8.598120e+00)*s8+4.477851e+00*s9 \
v24_part2=v24_part1+(-5.053011e+01)*s10+(-2.923702e+01)*s11+(-4.746101e-01)*s12+5.472627e+01*s13+9.889477e+01*s14+7.099265e+00*s15+(-7.245362e-01)*s16+1.118825e+01*s17+1.383817e+00*s18+(-7.432131e+02)*s19 \
v24_part3=v24_part2+1.754115e+00*s20+2.942606e+02*s21+3.636936e+01*s22+2.502321e+00*s23+(-1.692507e+01)*s24+1.649450e+01*s25+9.613348e+00*s26+(-9.035362e+00)*s27+(-4.762600e+01)*s28+(-8.327873e+01)*s29 \
v24=v24_part3+(-1.745085e+00)*s30+(-2.081769e+01)*s31+3.950718e+00*s32+(-1.158451e-01)*s33+1.158500e+01*s34+2.777788e+01*s35+(-2.767893e+02)*s36+(-7.507922e-01)*s37+(-3.539668e-01)*s38+(-3.909433e+00)*s39 \
v25_part1=9.421938e+00*s0+6.958970e-01*s1+5.800590e+01*s2+(-3.315712e+01)*s3+(-5.375597e+02)*s4+3.085862e+00*s5+4.647087e+01*s6+5.014529e-01*s7+(-1.253580e+01)*s8+9.647942e+00*s9 \
v25_part2=v25_part1+(-8.636571e+01)*s10+1.001927e+02*s11+9.540434e+00*s12+(-4.666357e+00)*s13+3.688059e+01*s14+(-3.632532e+01)*s15+3.909715e+00*s16+6.044615e+01*s17+1.076487e+01*s18+(-2.187432e+02)*s19 \
v25_part3=v25_part2+(-2.123892e+00)*s20+(-4.542633e+00)*s21+(-1.811556e+01)*s22+8.238036e+00*s23+3.524361e+01*s24+(-3.329953e+01)*s25+(-2.033686e+01)*s26+1.967826e+01*s27+1.257097e+02*s28+(-1.533621e+03)*s29 \
v25=v25_part3+2.843423e+00*s30+(-5.924776e+00)*s31+(-2.731655e+01)*s32+(-5.507844e-01)*s33+(-4.754976e+01)*s34+1.752963e+01*s35+(-5.095319e+02)*s36+1.549900e+00*s37+(-1.309208e-01)*s38+9.270204e+00*s39 \
v26_part1=(-2.095172e+01)*s0+2.278222e-01*s1+8.867720e+00*s2+1.369711e+02*s3+1.213368e+03*s4+1.315304e+01*s5+(-1.205176e+02)*s6+1.298697e+00*s7+5.747253e+00*s8+(-1.418149e+01)*s9 \
v26_part2=v26_part1+3.193774e+02*s10+(-2.981649e+01)*s11+4.605270e+00*s12+8.149499e+00*s13+3.437261e+00*s14+1.359957e+01*s15+(-2.317633e+00)*s16+4.898315e+01*s17+(-2.047050e+00)*s18+4.214382e+03*s19 \
v26_part3=v26_part2+(-1.454252e+00)*s20+(-3.923179e+02)*s21+(-2.147603e+01)*s22+(-2.274344e+01)*s23+4.079877e+01*s24+(-2.586697e+00)*s25+1.040861e+02*s26+1.156933e+01*s27+3.943493e+01*s28+2.133483e+03*s29 \
v26=v26_part3+2.214680e+00*s30+1.829562e+01*s31+1.130790e-01*s32+2.083767e-01*s33+2.498227e+01*s34+(-3.201132e+01)*s35+6.272910e+02*s36+6.539908e-01*s37+1.678155e+00*s38+3.173685e+00*s39 \
v27_part1=(-6.484344e+01)*s0+9.565891e-01*s1+(-2.881554e+01)*s2+1.873767e+01*s3+1.676484e+02*s4+(-8.044510e+01)*s5+(-5.462543e+01)*s6+(-8.572426e-01)*s7+1.836151e+01*s8+(-2.639119e+00)*s9 \
v27_part2=v27_part1+6.173776e+01*s10+(-8.122915e+01)*s11+(-1.150527e+01)*s12+(-3.448035e+01)*s13+1.466055e+02*s14+1.734654e+01*s15+(-4.262097e+00)*s16+(-9.713450e+01)*s17+(-7.135537e+00)*s18+(-4.862004e+01)*s19 \
v27_part3=v27_part2+3.693722e-01*s20+(-1.455504e+02)*s21+6.411797e+00*s22+(-1.493173e+01)*s23+(-3.390126e+01)*s24+1.644657e+01*s25+(-7.188542e-01)*s26+(-1.226130e+01)*s27+(-9.368447e+01)*s28+1.444747e+03*s29 \
v27=v27_part3+(-1.014273e+00)*s30+1.502890e+01*s31+3.737860e+01*s32+6.392924e-01*s33+3.517996e+01*s34+(-4.037576e+01)*s35+5.608814e+01*s36+(-6.809174e-01)*s37+4.106233e-01*s38+(-5.624644e+00)*s39 \
v28_part1=4.955450e+01*s0+(-1.963398e+00)*s1+5.416322e+01*s2+3.837870e+01*s3+3.753683e+02*s4+1.935101e+02*s5+6.437674e+01*s6+9.099750e-01*s7+2.402687e+01*s8+(-3.942571e+00)*s9 \
v28_part2=v28_part1+(-2.840398e+00)*s10+4.098303e+01*s11+9.568924e+00*s12+(-1.341656e+02)*s13+(-2.490399e+02)*s14+2.110144e+01*s15+3.190399e+00*s16+6.335291e+00*s17+1.987474e+00*s18+(-3.254675e+03)*s19 \
v28_part3=v28_part2+2.035426e+00*s20+(-1.006669e+03)*s21+(-1.190231e+02)*s22+3.387801e+01*s23+2.946783e+01*s24+8.286332e+00*s25+9.488533e-02*s26+(-1.755626e+00)*s27+(-3.521896e+00)*s28+3.366498e+01*s29 \
v28=v28_part3+(-1.495476e+00)*s30+8.763690e+01*s31+4.676170e+00*s32+5.026062e-01*s33+(-1.227997e+01)*s34+1.044111e+02*s35+3.086490e+03*s36+(-7.756335e-01)*s37+(-4.104355e-01)*s38+6.393514e-01*s39 \
v29_part1=(-4.777279e+01)*s0+(-4.530553e-01)*s1+2.486435e+00*s2+3.207719e+01*s3+(-3.904494e+02)*s4+(-1.556005e+02)*s5+3.580610e+01*s6+(-1.835984e+00)*s7+(-3.797310e+01)*s8+9.124309e+00*s9 \
v29_part2=v29_part1+(-3.036897e+02)*s10+(-8.484005e-01)*s11+(-7.887396e+00)*s12+(-2.429237e+00)*s13+(-7.177115e+01)*s14+(-1.558821e+01)*s15+1.467029e+00*s16+2.791793e+01*s17+(-1.820467e+00)*s18+9.300555e+01*s19 \
v29_part3=v29_part2+(-3.643444e-01)*s20+(-5.545980e+01)*s21+5.441688e+01*s22+(-3.131664e+00)*s23+(-6.030451e+01)*s24+(-1.435956e+00)*s25+(-3.438662e+01)*s26+(-9.250562e+00)*s27+(-3.762433e+01)*s28+2.115132e+02*s29 \
v29=v29_part3+(-2.370268e-01)*s30+(-3.568634e+01)*s31+(-4.760343e-01)*s32+(-7.156459e-01)*s33+(-1.293945e+01)*s34+(-5.816953e+01)*s35+(-2.103015e+03)*s36+2.601527e-02*s37+(-1.284268e+00)*s38+(-2.790623e+00)*s39 \
v30_part1=1.063792e+00*s0+(-3.246284e-01)*s1+(-1.903403e-01)*s2+(-6.410717e-02)*s3+(-2.064497e-01)*s4+8.465535e-01*s5+5.644028e-01*s6+(-1.098888e-01)*s7+3.363572e-01*s8+5.270503e-02*s9 \
v30_part2=v30_part1+2.132049e+00*s10+(-2.073290e+00)*s11+1.547105e-01*s12+(-5.735174e-01)*s13+(-1.045496e+00)*s14+1.996057e+00*s15+(-1.155408e+00)*s16+4.645344e-01*s17+(-3.700454e-02)*s18+3.349881e+00*s19 \
v30_part3=v30_part2+(-3.512700e-01)*s20+(-5.030136e-01)*s21+2.424965e-01*s22+5.835135e-01*s23+9.614777e-01*s24+7.256537e-03*s25+1.659286e-01*s26+(-4.504904e+00)*s27+(-9.577673e-01)*s28+(-9.590867e-02)*s29 \
v30=v30_part3+(-3.309546e+00)*s30+(-1.585976e-01)*s31+(-3.328226e-01)*s32+(-1.115683e+00)*s33+3.441045e+00*s34+1.716380e-01*s35+(-1.316971e-01)*s36+1.919587e+00*s37+(-9.514603e-01)*s38+1.829864e+00*s39 \
v31_part1=(-3.016010e+00)*s0+1.206902e+00*s1+6.858880e+00*s2+2.981059e+00*s3+(-3.770189e-01)*s4+(-2.548416e+00)*s5+(-4.170516e+00)*s6+9.969557e+00*s7+(-5.364318e-01)*s8+9.893807e-02*s9 \
v31_part2=v31_part1+3.800550e+00*s10+5.787758e+00*s11+1.063993e+00*s12+1.738630e+00*s13+(-1.599212e+00)*s14+2.939837e-01*s15+3.969036e+00*s16+(-1.947605e+00)*s17+(-1.981043e-01)*s18+(-1.508422e+01)*s19 \
v31_part3=v31_part2+(-2.465863e+00)*s20+1.287179e+00*s21+(-3.211257e+00)*s22+(-1.352687e+01)*s23+(-9.358229e-01)*s24+(-2.971403e+00)*s25+(-8.401156e-01)*s26+1.351692e+01*s27+2.301985e+00*s28+7.761929e-01*s29 \
v31=v31_part3+1.933418e+00*s30+1.137884e+01*s31+3.025499e+00*s32+2.526456e+00*s33+(-1.576553e+01)*s34+1.253391e+00*s35+1.531632e+00*s36+(-6.008241e+00)*s37+(-1.653627e+00)*s38+1.049433e-01*s39 \
v32_part1=(-2.779314e+00)*s0+(-1.881332e-01)*s1+(-1.654168e+00)*s2+1.499885e-01*s3+2.561207e+00*s4+(-1.485427e+00)*s5+5.359612e-01*s6+(-1.481450e-01)*s7+(-1.563945e+00)*s8+(-3.308986e+00)*s9 \
v32_part2=v32_part1+(-9.443033e+00)*s10+1.882145e+00*s11+(-2.191080e+00)*s12+1.369852e+00*s13+3.128557e+00*s14+(-7.840356e+00)*s15+5.939229e+00*s16+(-5.652221e-01)*s17+(-7.465393e-02)*s18+(-1.775905e+00)*s19 \
v32_part3=v32_part2+(-7.917038e-02)*s20+1.907605e+00*s21+6.312029e-01*s22+3.233751e+01*s23+(-1.190067e+00)*s24+3.417506e+00*s25+5.877056e-01*s26+(-3.771160e+00)*s27+1.810664e+00*s28+2.161936e-01*s29 \
v32=v32_part3+9.776581e+00*s30+(-7.641485e-02)*s31+6.617715e+00*s32+1.244316e+01*s33+(-2.013437e+00)*s34+(-2.637212e+00)*s35+(-7.569375e-01)*s36+(-7.364601e+00)*s37+5.837963e+00*s38+(-3.459913e+00)*s39 \
v33_part1=2.269233e+00*s0+(-4.754841e+00)*s1+(-4.950790e+00)*s2+(-7.874321e-01)*s3+1.739003e-01*s4+1.708826e+00*s5+2.890326e+00*s6+(-4.324732e+00)*s7+6.897911e-03*s8+(-9.228424e-01)*s9 \
v33_part2=v33_part1+5.562043e-01*s10+(-4.495911e+00)*s11+(-5.935053e-01)*s12+(-9.454018e-01)*s13+(-5.571564e-01)*s14+(-3.586846e-01)*s15+(-2.221852e-01)*s16+1.362557e+00*s17+(-3.246291e-02)*s18+1.188068e+01*s19 \
v33_part3=v33_part2+3.468444e+00*s20+(-9.738288e-01)*s21+2.739582e+00*s22+5.753508e+00*s23+1.136074e-01*s24+2.395635e+00*s25+1.238736e+00*s26+(-7.251029e+00)*s27+4.668844e-01*s28+(-1.514439e+00)*s29 \
v33=v33_part3+(-3.990024e-01)*s30+(-1.118936e+01)*s31+(-5.252739e+00)*s32+(-8.146774e-01)*s33+1.255208e+01*s34+4.717269e-01*s35+(-1.169894e+00)*s36+4.291602e+00*s37+(-2.900890e-01)*s38+(-3.666494e+00)*s39 \
v34_part1=2.127703e+00*s0+1.528498e+01*s1+(-4.714611e-01)*s2+(-3.607627e+00)*s3+9.856364e-01*s4+4.001204e+00*s5+5.970084e+00*s6+1.345736e+01*s7+2.801783e+00*s8+6.857544e+00*s9 \
v34_part2=v34_part1+(-4.001660e+00)*s10+1.634105e+01*s11+3.004675e+00*s12+(-1.372948e+00)*s13+4.437049e+00*s14+7.918907e+00*s15+(-1.740998e-01)*s16+1.334362e+00*s17+5.549228e+00*s18+3.807252e+00*s19 \
v34_part3=v34_part2+1.313934e+01*s20+(-3.107503e-01)*s21+9.014477e+00*s22+1.606509e+01*s23+4.711856e+00*s24+6.908266e+00*s25+7.524173e-01*s26+9.895806e+00*s27+1.156795e+00*s28+1.248784e+00*s29 \
v34=v34_part3+2.970107e+01*s30+(-1.415381e+00)*s31+(-4.723261e+00)*s32+8.324519e+00*s33+1.428873e+01*s34+(-2.297119e+00)*s35+(-3.399876e-01)*s36+4.447405e+01*s37+4.243251e+01*s38+3.749774e+01*s39 \
v35_part1=2.672467e+00*s0+2.534020e-01*s1+1.129888e-01*s2+1.211064e-01*s3+(-4.296591e+00)*s4+5.562816e-02*s5+(-2.593255e-01)*s6+6.623000e-01*s7+6.496278e-01*s8+2.618797e+00*s9 \
v35_part2=v35_part1+1.092350e+01*s10+(-1.788478e+00)*s11+1.381848e+00*s12+(-2.952694e-01)*s13+(-2.247787e+00)*s14+4.872965e+00*s15+(-2.387008e+00)*s16+5.798747e-01*s17+2.517760e+00*s18+4.985048e-01*s19 \
v35_part3=v35_part2+(-5.714731e-01)*s20+(-1.555689e+00)*s21+(-2.359784e+00)*s22+(-3.541874e+01)*s23+(-7.380917e-01)*s24+(-4.664346e+00)*s25+(-5.942983e-01)*s26+1.076722e+01*s27+(-1.029967e+00)*s28+(-9.095248e-01)*s29 \
v35=v35_part3+(-1.489076e+01)*s30+6.399322e-01*s31+1.511474e-01*s32+(-5.510869e+00)*s33+(-4.130873e-01)*s34+8.373034e+00*s35+9.528733e-01*s36+6.229896e+00*s37+(-1.095626e+01)*s38+(-7.655737e+00)*s39 \
v36_part1=(-4.707198e-01)*s0+2.592831e-01*s1+(-1.013440e+00)*s2+(-6.448476e-01)*s3+(-7.750816e-02)*s4+1.487482e-01*s5+(-8.766971e-02)*s6+(-1.036987e-01)*s7+(-7.868130e-03)*s8+(-1.236924e-01)*s9 \
v36_part2=v36_part1+(-6.990336e-01)*s10+3.493409e-01*s11+(-2.589287e-01)*s12+(-7.443778e-02)*s13+3.997469e-01*s14+(-4.355357e-01)*s15+2.580592e-01*s16+(-3.427260e-01)*s17+(-2.619861e-01)*s18+(-6.598132e-01)*s19 \
v36_part3=v36_part2+(-3.173887e-01)*s20+3.882889e-01*s21+(-7.392935e-01)*s22+1.138175e+00*s23+9.971647e-02*s24+3.278671e-01*s25+3.372958e-01*s26+(-8.921321e-01)*s27+3.074119e-01*s28+7.648308e-02*s29 \
v36=v36_part3+1.401590e+00*s30+7.858066e-01*s31+(-1.487832e+00)*s32+(-1.558399e+00)*s33+(-5.334686e-01)*s34+(-1.166383e+00)*s35+2.712505e-01*s36+(-6.769280e-01)*s37+1.922294e-01*s38+9.051651e-01*s39 \
v37_part1=1.469627e+00*s0+(-1.678115e+00)*s1+4.671061e+00*s2+5.461127e-01*s3+8.870441e-02*s4+(-5.026803e-01)*s5+(-3.877488e-01)*s6+(-2.973712e+00)*s7+1.461033e-01*s8+6.260365e-01*s9 \
v37_part2=v37_part1+(-5.243262e-01)*s10+(-2.005514e+00)*s11+1.908279e-01*s12+1.685363e+00*s13+(-6.801601e-01)*s14+(-1.260710e+00)*s15+(-1.030090e+00)*s16+1.628871e+00*s17+1.584432e+00*s18+(-1.089628e-01)*s19 \
v37_part3=v37_part2+9.249311e-01*s20+(-1.658485e+00)*s21+(-1.395559e-01)*s22+(-4.324103e+00)*s23+(-1.060666e+00)*s24+(-9.631774e-01)*s25+(-2.047536e+00)*s26+2.099918e+00*s27+(-1.144395e-01)*s28+(-2.167895e+00)*s29 \
v37=v37_part3+8.072169e-02*s30+(-1.776156e+00)*s31+3.789945e+00*s32+3.906915e+00*s33+4.377869e+00*s34+7.634047e+00*s35+(-6.878868e-01)*s36+2.211670e+00*s37+(-4.562265e-01)*s38+7.329773e-01*s39 \
v38_part1=1.661021e+00*s0+3.389918e-01*s1+1.149836e+00*s2+3.281444e+00*s3+1.595296e-01*s4+(-1.435913e+00)*s5+9.716039e-02*s6+7.773405e-01*s7+4.375467e-01*s8+1.087984e+00*s9 \
v38_part2=v38_part1+4.370729e+00*s10+7.014472e-01*s11+1.420557e+00*s12+(-1.566636e+00)*s13+(-2.089003e+00)*s14+3.797176e+00*s15+(-1.723927e+00)*s16+(-2.452253e+00)*s17+5.147595e-01*s18+5.800141e+00*s19 \
v38_part3=v38_part2+7.344571e-01*s20+(-1.966146e+00)*s21+6.280699e+00*s22+(-4.647200e+00)*s23+4.376786e-01*s24+(-2.892493e+00)*s25+(-3.040304e+00)*s26+5.167401e+00*s27+(-7.074006e-01)*s28+4.233615e+00*s29 \
v38=v38_part3+(-4.344824e+00)*s30+(-1.379767e+00)*s31+3.879958e-01*s32+3.461243e-01*s33+1.824156e+00*s34+2.550252e+00*s35+(-7.611172e-01)*s36+2.561338e+00*s37+(-1.944976e+00)*s38+(-5.513055e-01)*s39 \
v39_part1=(-1.170129e+00)*s0+1.650855e+00*s1+(-6.034531e+00)*s2+(-1.627133e-01)*s3+(-1.881993e-01)*s4+(-7.376930e-01)*s5+(-5.169143e-01)*s6+7.371155e-01*s7+(-1.185642e-01)*s8+(-5.532674e-01)*s9 \
v39_part2=v39_part1+(-1.475451e+00)*s10+7.002959e-01*s11+(-5.677321e-03)*s12+(-1.414826e+00)*s13+4.987844e-01*s14+1.338381e+00*s15+(-3.791685e-01)*s16+(-2.092341e+00)*s17+(-5.248356e-01)*s18+(-8.048313e-02)*s19 \
v39_part3=v39_part2+(-9.698591e-01)*s20+1.349109e-01*s21+1.044335e+00*s22+6.605672e-01*s23+9.084390e-01*s24+(-1.254722e+00)*s25+2.165161e+00*s26+(-1.203086e+00)*s27+(-2.919036e-03)*s28+1.615501e+00*s29 \
v39=v39_part3+(-6.950476e-01)*s30+(-2.071245e+00)*s31+(-2.347157e+00)*s32+(-2.044806e+00)*s33+(-6.133320e+00)*s34+(-6.231109e+00)*s35+2.115135e-01*s36+(-1.274592e+00)*s37+(-1.225887e+00)*s38+(-6.263870e-02)*s39 \
v40_part1=3.076731e-01*s0+3.027333e+00*s1+8.475089e+00*s2+1.419778e+01*s3+5.010995e+00*s4+5.290451e+00*s5+8.816230e+00*s6+1.141166e+01*s7+3.367846e+00*s8+4.138000e+00*s9 \
v40_part2=v40_part1+7.540096e+00*s10+8.940597e+00*s11+2.707136e+00*s12+4.852433e+00*s13+1.183364e+01*s14+1.143479e+01*s15+6.091486e+00*s16+1.037409e+01*s17+1.216086e+01*s18+1.686576e+01*s19 \
v40_part3=v40_part2+1.637400e+00*s20+7.837527e+00*s21+1.052217e+01*s22+1.238536e+01*s23+1.389549e+00*s24+9.907136e+00*s25+1.309019e+01*s26+1.423375e+01*s27+4.112323e+00*s28+8.747237e+00*s29 \
v40=v40_part3+1.210553e+00*s30+1.397437e+01*s31+6.202164e+00*s32+5.636746e+00*s33+6.854824e+00*s34+1.459109e+01*s35+1.486072e+00*s36+2.659905e+00*s37+7.909501e+00*s38+(-2.722509e+00)*s39 \
v41_part1=(-8.288388e-01)*s0+(-9.980058e-01)*s1+(-3.716103e-01)*s2+(-4.376088e+00)*s3+(-1.026587e+00)*s4+1.114987e+00*s5+(-1.070846e-01)*s6+(-4.251836e-01)*s7+(-1.312944e+00)*s8+(-9.281913e-01)*s9 \
v41_part2=v41_part1+(-3.218536e+00)*s10+(-1.272632e+00)*s11+(-1.858460e+00)*s12+1.704529e-01*s13+(-5.150646e-01)*s14+(-3.110645e+00)*s15+5.758927e-01*s16+(-2.524846e-01)*s17+(-7.415342e-01)*s18+(-6.999045e+00)*s19 \
v41_part3=v41_part2+(-1.954177e-01)*s20+(-6.802947e-02)*s21+(-8.183632e+00)*s22+4.848311e+00*s23+(-4.133569e-01)*s24+1.530353e+00*s25+(-5.587037e-02)*s26+(-5.665344e+00)*s27+4.710626e-01*s28+(-6.089997e+00)*s29 \
v41=v41_part3+2.841563e+00*s30+(-1.218372e+00)*s31+(-1.365662e+00)*s32+(-4.869639e-01)*s33+9.455766e-01*s34+(-3.596631e+00)*s35+8.917044e-01*s36+(-2.579643e+00)*s37+(-2.443736e-03)*s38+1.341652e+00*s39 \
v42_part1=(-3.902464e-01)*s0+5.095491e-02*s1+(-3.913454e-01)*s2+(-1.173215e+00)*s3+(-1.131327e+00)*s4+(-1.673971e+00)*s5+5.030682e-01*s6+2.219160e+00*s7+(-3.756935e-02)*s8+1.050527e+00*s9 \
v42_part2=v42_part1+(-4.681605e-02)*s10+7.234638e-01*s11+(-6.314094e-02)*s12+(-5.433131e-01)*s13+(-1.585130e+00)*s14+(-1.705032e+00)*s15+(-4.088781e+00)*s16+(-7.072952e-01)*s17+(-3.090853e+00)*s18+(-2.985753e-01)*s19 \
v42_part3=v42_part2+(-1.548695e-01)*s20+1.445737e+00*s21+(-2.031013e-01)*s22+(-1.836177e+00)*s23+1.780369e-01*s24+(-7.323136e-01)*s25+(-8.233310e-01)*s26+4.793926e+00*s27+6.015293e-01*s28+(-6.876997e-01)*s29 \
v42=v42_part3+3.888784e+00*s30+(-2.700438e+00)*s31+(-3.439489e+01)*s32+1.127613e+00*s33+(-1.400893e+00)*s34+(-5.770113e-01)*s35+(-1.034662e+00)*s36+(-3.381370e+00)*s37+(-1.893217e+00)*s38+(-2.493336e+00)*s39 \
v43_part1=(-1.984064e+00)*s0+4.511159e-01*s1+(-9.538115e-01)*s2+(-1.365184e+01)*s3+1.329976e+00*s4+3.068453e+00*s5+(-2.995037e-01)*s6+(-7.963965e+00)*s7+(-2.032677e+00)*s8+(-2.525420e+00)*s9 \
v43_part2=v43_part1+1.949967e+00*s10+3.244989e+00*s11+(-2.983694e-01)*s12+2.562081e+00*s13+(-2.820303e+00)*s14+2.657208e+00*s15+1.904383e+01*s16+2.107079e+00*s17+7.745268e+00*s18+(-4.184953e+00)*s19 \
v43_part3=v43_part2+(-2.391406e+00)*s20+(-6.675775e-01)*s21+2.319633e+00*s22+1.956872e+01*s23+(-2.861421e+00)*s24+3.028288e+00*s25+9.650980e-01*s26+(-2.123461e+01)*s27+(-4.241549e+00)*s28+7.854043e-01*s29 \
v43=v43_part3+(-3.194927e+00)*s30+7.169694e+00*s31+9.957272e+01*s32+(-5.648246e-01)*s33+1.400602e+00*s34+(-4.997692e+00)*s35+3.671437e+00*s36+4.279062e+00*s37+1.191047e+01*s38+1.340172e+01*s39 \
v44_part1=3.912220e+00*s0+5.508321e-02*s1+1.792473e+00*s2+1.307253e+01*s3+4.205881e+00*s4+2.656522e+00*s5+(-4.348265e+00)*s6+(-2.333542e+00)*s7+2.037624e+00*s8+(-4.954857e-01)*s9 \
v44_part2=v44_part1+(-2.674608e+00)*s10+(-4.916913e+00)*s11+4.478536e-01*s12+(-6.784189e-02)*s13+8.749633e+00*s14+8.582822e+00*s15+(-6.519117e+00)*s16+1.188602e+00*s17+4.341047e+00*s18+9.831473e-02*s19 \
v44_part3=v44_part2+3.486666e+00*s20+(-3.968292e+00)*s21+(-1.131338e+00)*s22+(-4.203016e+00)*s23+2.414857e+00*s24+(-5.616971e-01)*s25+(-9.671100e-01)*s26+1.848971e+00*s27+2.448979e+00*s28+1.795735e+00*s29 \
v44=v44_part3+(-1.280165e+01)*s30+3.049517e+00*s31+9.216431e+00*s32+(-8.503938e-01)*s33+8.198843e+00*s34+5.385234e+00*s35+2.055555e-01*s36+7.715287e+00*s37+1.323701e+00*s38+(-2.239294e-01)*s39 \
v45_part1=1.988365e+00*s0+(-9.125496e-01)*s1+(-2.088975e+00)*s2+1.301715e+01*s3+(-7.310514e+00)*s4+(-1.230793e+00)*s5+3.610466e+00*s6+3.171680e+00*s7+(-7.707756e-01)*s8+(-1.949212e-01)*s9 \
v45_part2=v45_part1+(-5.816376e+00)*s10+(-1.153463e+00)*s11+(-8.747068e-01)*s12+(-1.516772e+00)*s13+1.412936e+00*s14+4.578377e-01*s15+(-1.286587e+01)*s16+(-8.225537e-01)*s17+(-1.012792e+01)*s18+1.215315e+00*s19 \
v45_part3=v45_part2+2.257852e+00*s20+(-2.732351e+00)*s21+(-6.397370e-01)*s22+(-1.908811e+01)*s23+2.325628e+00*s24+(-1.876610e+00)*s25+(-5.375927e-01)*s26+3.935940e+00*s27+1.888381e+00*s28+(-3.385032e+00)*s29 \
v45=v45_part3+(-6.142069e+00)*s30+(-6.675561e+00)*s31+(-8.431044e+01)*s32+(-1.076435e-01)*s33+(-2.999338e+00)*s34+(-3.621715e+00)*s35+(-2.475423e+00)*s36+(-3.169005e+00)*s37+(-1.085617e+01)*s38+(-1.486873e+01)*s39 \
v46_part1=1.371568e+00*s0+3.316859e+00*s1+1.037136e+01*s2+1.013605e+01*s3+1.167669e+01*s4+4.337658e+00*s5+1.722644e+00*s6+1.093298e+01*s7+5.560107e+00*s8+3.566907e+00*s9 \
v46_part2=v46_part1+9.174888e+00*s10+(-3.676073e+00)*s11+2.461828e+00*s12+2.546234e-01*s13+6.709025e+00*s14+(-1.041478e+01)*s15+1.202938e+00*s16+(-3.034727e+00)*s17+1.448547e+01*s18+6.700673e+00*s19 \
v46_part3=v46_part2+2.408885e-01*s20+5.996537e+00*s21+1.068078e+00*s22+4.874695e+00*s23+1.472296e+00*s24+(-2.132578e+00)*s25+8.101034e+00*s26+2.216281e+01*s27+7.593443e+00*s28+4.099576e+00*s29 \
v46=v46_part3+2.040645e+01*s30+5.937692e+00*s31+6.141492e+01*s32+3.162438e+00*s33+(-5.166312e-01)*s34+4.334277e+01*s35+2.496154e+00*s36+5.532458e+00*s37+3.246612e+00*s38+9.728607e-01*s39 \
v47_part1=(-3.584038e+00)*s0+(-5.154714e-02)*s1+(-9.866200e-01)*s2+(-1.188116e+01)*s3+(-7.421958e+00)*s4+(-2.098053e+00)*s5+3.963100e+00*s6+7.459197e-03*s7+(-4.421602e+00)*s8+(-6.969914e-01)*s9 \
v47_part2=v47_part1+5.166895e-01*s10+6.013597e+00*s11+(-6.480953e-01)*s12+1.472319e-01*s13+(-1.007405e+01)*s14+(-2.182023e+00)*s15+3.840964e+00*s16+1.025330e+00*s17+(-6.562202e+00)*s18+4.485020e+00*s19 \
v47_part3=v47_part2+(-2.746167e+00)*s20+1.594575e+00*s21+6.759168e-01*s22+1.063923e+00*s23+(-2.425033e+00)*s24+3.235690e+00*s25+(-1.950855e-01)*s26+(-3.595287e+00)*s27+(-5.760858e+00)*s28+(-9.571920e-01)*s29 \
v47=v47_part3+5.448558e+00*s30+(-1.881408e+00)*s31+(-6.405005e+01)*s32+(-4.866452e-01)*s33+(-4.255076e+00)*s34+(-1.937113e+01)*s35+(-4.672306e-01)*s36+(-7.728576e+00)*s37+(-1.255894e+00)*s38+6.451790e-01*s39 \
v48_part1=(-1.000000e+04)*s0+(-1.003020e+01)*s1+(-5.071119e-03)*s2+2.487996e+01*s3+(-1.000000e+04)*s4+(-2.612993e+00)*s5+(-7.976858e+00)*s6+(-3.866699e+00)*s7+1.162378e+02*s8+(-9.145604e+02)*s9 \
v48_part2=v48_part1+3.538936e+02*s10+(-3.006310e+01)*s11+8.762581e+01*s12+5.234437e+01*s13+4.461651e+00*s14+(-1.407738e+01)*s15+(-4.110594e-01)*s16+2.068075e+01*s17+3.395603e+01*s18+(-6.886046e+00)*s19 \
v48_part3=v48_part2+(-4.091146e+00)*s20+(-6.767900e+02)*s21+(-1.831386e+01)*s22+(-1.757017e+00)*s23+(-4.171363e+01)*s24+2.604036e+00*s25+3.362378e+02*s26+1.304784e+00*s27+(-7.680151e-01)*s28+1.819067e+00*s29 \
v48=v48_part3+(-6.289939e+01)*s30+2.384272e+01*s31+1.579214e+00*s32+(-3.309477e+01)*s33+(-2.647244e+01)*s34+1.038168e+01*s35+7.108812e+02*s36+1.176469e+03*s37+(-6.154033e-01)*s38+2.868428e+02*s39 \
v49_part1=(-1.000000e+04)*s0+2.461377e+00*s1+(-4.332206e-01)*s2+(-2.661014e+01)*s3+(-1.000000e+04)*s4+1.300723e+01*s5+3.456681e+01*s6+(-1.526485e+02)*s7+9.040536e+01*s8+3.417966e+03*s9 \
v49_part2=v49_part1+(-3.811150e+02)*s10+(-1.038168e+01)*s11+1.821392e+01*s12+4.286020e+00*s13+(-3.083198e+00)*s14+1.305880e+02*s15+5.168471e+00*s16+1.169016e+01*s17+(-1.041587e+02)*s18+(-1.033165e+01)*s19 \
v49_part3=v49_part2+1.502654e+00*s20+5.369674e+02*s21+(-1.039801e+02)*s22+4.204676e+00*s23+4.311836e+01*s24+1.913569e+02*s25+(-7.744181e+02)*s26+1.923713e+01*s27+(-3.279567e+00)*s28+3.242848e+02*s29 \
v49=v49_part3+1.109100e+02*s30+(-5.958114e+01)*s31+(-4.193588e-02)*s32+(-4.005030e+02)*s33+2.645679e+01*s34+(-1.140638e+01)*s35+(-2.328513e+03)*s36+(-5.779002e+02)*s37+3.014366e+01*s38+2.596951e+02*s39 \
v50_part1=(-1.000000e+04)*s0+5.008416e+01*s1+7.019729e+00*s2+(-1.948439e+01)*s3+(-1.000000e+04)*s4+3.725996e+01*s5+2.634464e+01*s6+1.824711e+02*s7+2.728853e+00*s8+(-1.974959e+03)*s9 \
v50_part2=v50_part1+(-3.580735e+02)*s10+4.281178e+01*s11+(-1.974098e+02)*s12+9.695579e+01*s13+4.200893e+01*s14+(-9.653396e+01)*s15+(-3.970629e+00)*s16+(-7.310645e+01)*s17+1.007202e+01*s18+2.530051e+01*s19 \
v50_part3=v50_part2+5.654099e+00*s20+2.451710e+02*s21+3.477992e+02*s22+1.256781e+01*s23+6.918504e+01*s24+(-7.790429e+01)*s25+4.002828e+00*s26+(-1.396640e+01)*s27+2.994443e+00*s28+(-6.034043e+01)*s29 \
v50=v50_part3+1.614634e+02*s30+3.950407e+01*s31+(-1.144031e+00)*s32+1.406978e+02*s33+(-2.230730e+01)*s34+4.191795e+00*s35+7.536071e+02*s36+(-3.274295e+03)*s37+(-4.373953e+01)*s38+(-8.810555e+01)*s39 \
v51_part1=(-1.000000e+04)*s0+1.252793e-01*s1+(-7.111288e+00)*s2+9.361245e-01*s3+(-1.000000e+04)*s4+(-1.365479e+01)*s5+(-2.015544e+01)*s6+1.054019e+02*s7+4.060622e+02*s8+1.583817e+03*s9 \
v51_part2=v51_part1+4.756291e+02*s10+9.053486e+01*s11+1.435012e+02*s12+(-8.177553e+02)*s13+(-1.233543e+01)*s14+3.048340e+02*s15+2.337614e-01*s16+8.620359e+02*s17+4.804557e+01*s18+(-1.168999e+01)*s19 \
v51_part3=v51_part2+(-9.412155e+00)*s20+4.661320e+02*s21+(-3.823445e+00)*s22+(-5.291646e+00)*s23+(-3.572737e+01)*s24+4.555589e+01*s25+3.923087e+02*s26+(-6.134919e-01)*s27+(-4.995974e+00)*s28+(-4.922841e+01)*s29 \
v51=v51_part3+4.409540e+01*s30+(-4.868200e+00)*s31+(-3.699761e-02)*s32+(-3.591122e-01)*s33+(-5.661299e+01)*s34+3.330633e+01*s35+1.282450e+03*s36+6.314263e+02*s37+(-1.024494e+02)*s38+(-8.544268e+01)*s39 \
v52_part1=(-1.000000e+04)*s0+(-2.625271e+01)*s1+1.306810e+00*s2+2.688638e+01*s3+(-1.000000e+04)*s4+(-1.239888e+01)*s5+(-5.488150e+01)*s6+(-3.944942e+01)*s7+1.754980e+02*s8+7.297576e+03*s9 \
v52_part2=v52_part1+(-3.781221e+02)*s10+1.205635e+03*s11+(-2.048488e+02)*s12+(-6.382713e+01)*s13+(-2.422119e+01)*s14+7.607995e+01*s15+(-4.086044e+00)*s16+6.068196e+01*s17+3.886106e+01*s18+1.655424e+00*s19 \
v52_part3=v52_part2+2.003767e+01*s20+1.345846e+03*s21+(-2.905996e+02)*s22+(-6.149023e+00)*s23+1.230041e+01*s24+1.464373e+02*s25+1.171318e+02*s26+(-2.013835e+01)*s27+(-1.330249e-02)*s28+7.975588e+01*s29 \
v52=v52_part3+(-2.616719e+02)*s30+4.961693e+00*s31+(-7.007964e-01)*s32+3.758300e+00*s33+2.837474e+02*s34+(-8.732170e+01)*s35+1.924176e+02*s36+(-8.550932e+02)*s37+1.935822e+02*s38+(-2.052684e+02)*s39 \
v53_part1=(-3.830350e+03)*s0+(-1.145072e+01)*s1+(-7.284685e-01)*s2+(-4.927508e+00)*s3+(-1.000000e+04)*s4+(-4.049549e+01)*s5+2.824607e+00*s6+(-8.909824e+01)*s7+(-5.147657e+02)*s8+2.060058e+02*s9 \
v53_part2=v53_part1+3.177692e+02*s10+(-3.164076e+02)*s11+1.692394e+02*s12+1.664577e+03*s13+8.908975e-01*s14+4.126530e+01*s15+(-9.136891e+00)*s16+(-7.754897e+00)*s17+(-1.788534e+01)*s18+1.519680e+02*s19 \
v53_part3=v53_part2+2.920063e-01*s20+9.280041e+02*s21+2.541663e+02*s22+(-5.621398e-01)*s23+(-5.234873e+00)*s24+(-8.844255e+00)*s25+(-6.622674e+01)*s26+1.367288e+01*s27+1.797511e+01*s28+(-7.464308e+01)*s29 \
v53=v53_part3+(-7.239626e+00)*s30+(-4.579122e+00)*s31+(-2.965049e+00)*s32+8.522466e+02*s33+(-1.761791e+01)*s34+4.714914e+01*s35+(-5.925392e+02)*s36+3.457017e+03*s37+(-3.446323e+00)*s38+8.100801e+01*s39 \
v54_part1=1.000000e+04*s0+4.740413e-01*s1+(-1.000000e+04)*s2+(-7.047841e+00)*s3+1.000000e+04*s4+(-1.000000e+04)*s5+(-9.416231e+01)*s6+(-1.193782e+01)*s7+(-4.294713e+00)*s8+(-8.501798e+02)*s9 \
v54_part2=v54_part1+(-1.189815e+02)*s10+2.346894e+02*s11+(-1.252449e+02)*s12+(-6.646353e+00)*s13+1.260398e+00*s14+(-9.465781e+01)*s15+(-9.998542e+03)*s16+(-1.051114e+02)*s17+2.669138e+01*s18+(-6.869445e+01)*s19 \
v54_part3=v54_part2+(-5.533038e+00)*s20+(-1.504416e+02)*s21+(-8.675050e+02)*s22+(-3.707491e+03)*s23+(-1.438051e+02)*s24+(-6.165780e+01)*s25+(-8.879195e+01)*s26+4.471623e+01*s27+(-9.017568e+00)*s28+(-4.047961e+03)*s29 \
v54=v54_part3+(-4.562638e+01)*s30+(-2.658901e+01)*s31+(-2.735902e+01)*s32+(-1.000000e+04)*s33+3.539994e+01*s34+(-1.000000e+04)*s35+9.465201e+02*s36+(-2.613693e+02)*s37+2.555991e+00*s38+1.153708e+01*s39 \
v55_part1=1.000000e+04*s0+(-2.728332e+00)*s1+(-1.000000e+04)*s2+(-1.443601e+01)*s3+1.000000e+04*s4+(-1.000000e+04)*s5+1.705250e+01*s6+3.467475e+02*s7+1.764246e+00*s8+1.748660e+03*s9 \
v55_part2=v55_part1+2.461602e+02*s10+4.958407e+02*s11+3.198737e+01*s12+1.127348e+01*s13+(-7.362058e+01)*s14+(-6.681611e+01)*s15+(-9.999962e+03)*s16+(-4.067343e-01)*s17+1.203951e+02*s18+5.377219e+00*s19 \
v55_part3=v55_part2+(-7.723906e+00)*s20+3.610611e+01*s21+2.999342e+03*s22+(-1.000000e+04)*s23+(-5.956355e+01)*s24+3.878080e+01*s25+(-2.020818e+02)*s26+6.815678e+01*s27+(-2.970850e+01)*s28+(-5.488638e+03)*s29 \
v55=v55_part3+9.970122e-01*s30+8.586936e+00*s31+2.587452e+01*s32+(-1.000000e+04)*s33+8.730814e+02*s34+(-1.000000e+04)*s35+(-2.208983e+03)*s36+3.482900e+02*s37+3.074629e+01*s38+1.723972e+02*s39 \
v56_part1=1.000000e+04*s0+3.837316e-01*s1+(-1.000000e+04)*s2+1.431785e+01*s3+1.000000e+04*s4+(-1.000000e+04)*s5+(-1.971333e+02)*s6+(-1.025147e+02)*s7+9.994438e-01*s8+(-2.172316e+01)*s9 \
v56_part2=v56_part1+(-5.953510e+02)*s10+(-2.799125e+02)*s11+(-4.975827e+02)*s12+(-1.244044e+01)*s13+(-1.693464e+02)*s14+2.310263e+02*s15+(-9.999646e+03)*s16+(-3.753764e+02)*s17+(-1.188745e+02)*s18+(-1.539395e+01)*s19 \
v56_part3=v56_part2+(-1.398832e+01)*s20+(-3.356890e-01)*s21+(-7.927282e+02)*s22+(-9.882332e+03)*s23+1.112411e+02*s24+(-4.029296e+00)*s25+8.418065e+01*s26+(-7.339978e+01)*s27+6.101867e+01*s28+(-5.668463e+03)*s29 \
v56=v56_part3+(-1.506756e+02)*s30+(-1.202672e+00)*s31+(-1.859264e+01)*s32+(-1.000000e+04)*s33+1.251330e+02*s34+(-1.000000e+04)*s35+(-1.331396e+01)*s36+3.342179e+02*s37+1.048193e+02*s38+(-1.108391e+02)*s39 \
v57_part1=1.000000e+04*s0+(-6.198017e+00)*s1+(-1.000000e+04)*s2+(-1.656947e+02)*s3+(-6.386283e+03)*s4+(-1.000000e+04)*s5+3.802913e+01*s6+(-3.197743e+01)*s7+1.188784e+01*s8+(-1.710852e+03)*s9 \
v57_part2=v57_part1+1.948208e+02*s10+8.393528e+02*s11+5.213443e+01*s12+5.626009e+01*s13+(-6.497292e+00)*s14+1.951246e+02*s15+1.921591e+01*s16+(-6.204925e+01)*s17+(-2.835591e+01)*s18+(-4.915455e-01)*s19 \
v57_part3=v57_part2+(-3.759287e+01)*s20+(-1.074330e+02)*s21+(-3.755048e+03)*s22+(-4.667592e+02)*s23+(-2.402589e+01)*s24+5.423559e+00*s25+(-6.353771e+01)*s26+1.118275e+02*s27+1.885778e+02*s28+(-1.387265e+03)*s29 \
v57=v57_part3+(-4.345287e+02)*s30+(-1.210125e+02)*s31+5.702199e+02*s32+(-1.000000e+04)*s33+(-1.176336e+01)*s34+(-1.000000e+04)*s35+3.741866e+03*s36+8.225483e+02*s37+5.269964e+00*s38+2.151573e+02*s39 \
v58_part1=1.000000e+04*s0+1.005768e+01*s1+(-1.000000e+04)*s2+1.456820e+02*s3+7.649630e+03*s4+(-1.000000e+04)*s5+1.121741e+02*s6+(-1.254073e+02)*s7+1.185379e+01*s8+1.150201e+03*s9 \
v58_part2=v58_part1+1.114747e+03*s10+(-5.300787e+01)*s11+2.062948e+01*s12+2.039702e+01*s13+(-3.575320e+02)*s14+5.693227e+02*s15+(-9.997642e+03)*s16+(-1.278972e+02)*s17+(-3.243569e+01)*s18+1.854038e+01*s19 \
v58_part3=v58_part2+5.590072e-01*s20+9.869634e+02*s21+2.232631e+03*s22+(-1.000000e+04)*s23+1.121122e-01*s24+1.001875e+02*s25+(-3.042740e+01)*s26+(-3.794117e+02)*s27+(-2.980534e+02)*s28+(-1.000000e+04)*s29 \
v58=v58_part3+8.077014e+02*s30+2.389663e+02*s31+(-5.478762e-01)*s32+(-1.000000e+04)*s33+5.631475e+02*s34+(-1.000000e+04)*s35+(-3.089531e+03)*s36+3.819058e+02*s37+2.065248e+02*s38+(-3.030078e+02)*s39 \
v59_part1=1.000000e+04*s0+(-1.298276e-01)*s1+(-1.000000e+04)*s2+1.070067e+00*s3+1.000000e+04*s4+(-1.000000e+04)*s5+2.316549e+02*s6+(-3.526591e+01)*s7+7.160310e+00*s8+5.709692e+02*s9 \
v59_part2=v59_part1+2.939074e+02*s10+(-3.652383e+02)*s11+9.636058e+02*s12+9.368569e+00*s13+(-4.638344e+01)*s14+(-3.669520e+02)*s15+(-9.999960e+03)*s16+(-1.607276e+02)*s17+(-3.046723e+00)*s18+2.038794e+02*s19 \
v59_part3=v59_part2+1.023426e+02*s20+9.862152e+00*s21+6.867237e+02*s22+(-9.946600e+03)*s23+3.694866e+02*s24+9.872751e+01*s25+6.029580e+02*s26+(-1.152455e+02)*s27+8.872101e+01*s28+(-1.526450e+03)*s29 \
v59=v59_part3+6.176428e+01*s30+(-7.758547e+00)*s31+(-5.393133e+03)*s32+(-1.000000e+04)*s33+(-7.793677e+02)*s34+(-1.000000e+04)*s35+9.586407e+02*s36+(-3.652099e+02)*s37+(-2.867118e+02)*s38+1.952831e+01*s39 \
v60_part1=2.865457e-01*s0+(-1.539234e-02)*s1+(-2.167046e+00)*s2+(-2.108097e+00)*s3+(-2.615250e-01)*s4+(-5.748268e-02)*s5+(-4.826276e-01)*s6+2.527559e+00*s7+3.315031e-02*s8+(-2.436397e-01)*s9 \
v60_part2=v60_part1+7.623425e-02*s10+4.532876e-01*s11+(-5.165107e-01)*s12+3.292786e-01*s13+(-4.026504e+00)*s14+(-1.646055e+00)*s15+(-1.122903e+00)*s16+(-4.195072e-01)*s17+(-8.938202e+00)*s18+2.768089e-01*s19 \
v60_part3=v60_part2+2.743889e-02*s20+2.555921e-01*s21+7.080184e-01*s22+(-5.993615e+00)*s23+4.591854e-01*s24+(-8.868333e-01)*s25+8.611254e-01*s26+1.502246e-01*s27+9.000976e-01*s28+(-1.155316e+00)*s29 \
v60=v60_part3+2.301084e+00*s30+(-8.920129e-01)*s31+(-2.072348e+01)*s32+(-2.410907e-01)*s33+(-1.860354e+00)*s34+3.793144e-02*s35+(-9.271197e-01)*s36+(-6.574574e-01)*s37+(-6.764386e-01)*s38+(-1.744112e+00)*s39 \
v61_part1=(-2.390600e+00)*s0+9.090997e-01*s1+4.290624e-01*s2+(-3.940214e+00)*s3+(-2.279649e+00)*s4+(-1.026596e+00)*s5+1.760440e+00*s6+(-3.314199e+00)*s7+(-8.123406e+00)*s8+(-7.513680e-01)*s9 \
v61_part2=v61_part1+(-2.823007e+00)*s10+2.532913e+00*s11+1.431211e+00*s12+(-1.020580e-01)*s13+1.393834e+00*s14+2.513098e+00*s15+8.208699e+00*s16+1.021078e+00*s17+1.493421e+01*s18+(-2.538949e-01)*s19 \
v61_part3=v61_part2+(-2.544860e+00)*s20+2.850581e+00*s21+3.022745e+00*s22+3.411157e+01*s23+(-3.486307e+00)*s24+3.789934e+00*s25+(-1.236300e-01)*s26+(-3.407113e+00)*s27+(-4.234209e+00)*s28+(-5.383859e-01)*s29 \
v61=v61_part3+(-7.849351e-01)*s30+9.302384e+00*s31+6.431906e+01*s32+7.986149e-01*s33+4.606676e-01*s34+(-8.113115e+00)*s35+2.889733e+00*s36+(-1.753040e-01)*s37+9.365546e+00*s38+1.714921e+01*s39 \
v62_part1=5.836430e-01*s0+1.014243e+00*s1+8.468592e+00*s2+1.737952e+01*s3+3.183601e+00*s4+6.902704e-01*s5+(-6.616523e-01)*s6+(-7.055054e+00)*s7+7.508832e+00*s8+4.316636e+00*s9 \
v62_part2=v62_part1+(-5.686919e-01)*s10+(-2.204974e+00)*s11+1.612947e+00*s12+(-1.167492e+00)*s13+1.862792e+01*s14+8.436905e+00*s15+(-2.618845e+00)*s16+3.017732e+00*s17+1.803531e+01*s18+(-1.031446e+00)*s19 \
v62_part3=v62_part2+2.634011e+00*s20+(-2.342645e+00)*s21+(-4.594449e+00)*s22+3.449727e+00*s23+1.525036e+00*s24+1.191402e-01*s25+(-6.310396e+00)*s26+4.074255e+00*s27+(-7.209024e-01)*s28+6.287066e+00*s29 \
v62=v62_part3+(-1.064773e+01)*s30+(-4.480600e+00)*s31+(-2.343222e+00)*s32+3.209003e+00*s33+1.069960e+01*s34+6.141407e+00*s35+5.268191e-01*s36+2.266545e+00*s37+(-1.263786e+00)*s38+(-7.730660e+00)*s39 \
v63_part1=2.120310e+00*s0+(-1.211690e+00)*s1+(-3.232135e-01)*s2+(-1.806837e+00)*s3+2.886558e-02*s4+2.638454e-01*s5+3.050187e+00*s6+(-9.521340e-01)*s7+(-2.553997e+00)*s8+(-6.073644e-01)*s9 \
v63_part2=v63_part1+(-3.265649e+00)*s10+(-2.776610e-01)*s11+(-2.958212e+00)*s12+(-2.677061e-01)*s13+(-5.797328e+00)*s14+1.374704e+00*s15+(-5.904707e+00)*s16+(-1.438304e+00)*s17+(-1.512030e+01)*s18+(-2.052029e-01)*s19 \
v63_part3=v63_part2+2.385146e+00*s20+(-5.710951e+00)*s21+(-2.973365e+00)*s22+(-3.524935e+01)*s23+2.852028e+00*s24+(-1.720733e+00)*s25+(-1.407179e+00)*s26+(-1.476433e+00)*s27+2.952687e+00*s28+5.033783e-02*s29 \
v63=v63_part3+(-6.658059e+00)*s30+(-1.147813e+01)*s31+(-4.623292e+01)*s32+(-1.814393e+00)*s33+(-4.120774e-01)*s34+1.354702e+00*s35+(-1.838265e+00)*s36+(-8.184735e-01)*s37+(-8.958073e+00)*s38+(-2.119359e+01)*s39 \
v64_part1=2.295926e+00*s0+3.320927e+00*s1+2.402705e+00*s2+3.006327e+01*s3+4.343504e+00*s4+1.116323e+01*s5+(-2.406210e+00)*s6+1.294639e+01*s7+2.060716e+01*s8+2.340403e+00*s9 \
v64_part2=v64_part1+1.131890e+01*s10+(-1.789230e+00)*s11+2.345392e+00*s12+3.716525e+00*s13+1.536003e+01*s14+(-1.081947e+01)*s15+3.107073e-01*s16+(-3.016934e-01)*s17+1.311559e+01*s18+1.971280e+00*s19 \
v64_part3=v64_part2+(-1.082499e-01)*s20+7.760930e+00*s21+3.940773e+00*s22+1.100083e+01*s23+8.888425e-01*s24+(-3.970760e+00)*s25+1.220136e+01*s26+8.284607e+00*s27+4.680203e+00*s28+1.556497e+00*s29 \
v64=v64_part3+1.886124e+01*s30+1.276835e+01*s31+1.247724e+01*s32+5.735295e+00*s33+(-4.649024e+00)*s34+4.179729e+01*s35+1.828687e+00*s36+1.037367e+01*s37+3.333714e+00*s38+5.647580e+00*s39 \
v65_part1=(-1.069913e+00)*s0+(-5.748505e-01)*s1+(-2.323146e+00)*s2+(-3.016487e+01)*s3+(-4.122977e+00)*s4+(-2.671587e+00)*s5+2.980807e+00*s6+3.189308e+00*s7+(-1.658413e+01)*s8+(-3.770534e+00)*s9 \
v65_part2=v65_part1+(-1.249568e+00)*s10+3.324529e+00*s11+(-1.768487e+00)*s12+7.336495e-01*s13+(-2.541680e+01)*s14+(-1.221260e+00)*s15+5.964618e-01*s16+(-6.325024e-01)*s17+(-1.595403e+01)*s18+6.338258e+00*s19 \
v65_part3=v65_part2+(-1.857004e+00)*s20+8.077576e-01*s21+2.879311e+00*s22+(-7.175863e+00)*s23+(-1.194293e+00)*s24+4.275899e+00*s25+3.256906e+00*s26+(-1.668775e+00)*s27+(-4.569978e-01)*s28+(-3.476816e+00)*s29 \
v65=v65_part3+4.590032e+00*s30+1.746767e+00*s31+(-8.885901e+00)*s32+(-3.556789e+00)*s33+(-4.420703e+00)*s34+(-2.060276e+01)*s35+(-5.656674e-01)*s36+(-3.672526e+00)*s37+1.008384e+00*s38+7.302314e+00*s39 \
v66_part1=1.158392e+02*s0+1.689270e+00*s1+(-9.405084e-01)*s2+1.382987e+00*s3+(-1.972340e+03)*s4+7.712780e+00*s5+(-3.485119e+00)*s6+4.484092e+00*s7+(-1.611560e-01)*s8+4.357702e+00*s9 \
v66_part2=v66_part1+3.949773e+03*s10+7.765317e+01*s11+(-1.356963e+01)*s12+1.097139e+01*s13+(-2.643239e-01)*s14+2.217646e+01*s15+(-9.622414e+00)*s16+1.877170e+00*s17+1.656483e+01*s18+(-1.940017e+00)*s19 \
v66_part3=v66_part2+(-4.264380e+00)*s20+8.951725e+00*s21+(-8.473824e-01)*s22+1.613174e+00*s23+(-2.118349e+00)*s24+(-1.521147e+01)*s25+4.262893e+01*s26+1.898024e+01*s27+9.818160e+01*s28+(-2.465258e+02)*s29 \
v66=v66_part3+1.352036e+01*s30+5.443659e+00*s31+(-1.923413e+00)*s32+1.264940e+01*s33+(-1.544337e+01)*s34+6.700716e+00*s35+1.162315e+03*s36+1.699869e+01*s37+(-1.041067e+02)*s38+7.584983e+01*s39 \
v67_part1=(-8.762702e+01)*s0+(-1.685827e+00)*s1+(-7.006720e-01)*s2+(-3.428899e-01)*s3+5.766825e+03*s4+1.400580e+00*s5+4.480460e+00*s6+(-2.953030e+01)*s7+(-5.691387e-01)*s8+6.936630e+00*s9 \
v67_part2=v67_part1+(-8.084750e+02)*s10+(-2.129866e+01)*s11+2.674963e+00*s12+(-2.464909e+00)*s13+1.261110e+01*s14+(-8.555976e+01)*s15+(-1.293847e+01)*s16+7.422694e+00*s17+(-1.404789e+01)*s18+7.724337e+00*s19 \
v67_part3=v67_part2+1.209542e+01*s20+6.171956e+00*s21+(-1.203716e+01)*s22+(-5.842259e-01)*s23+(-4.553346e+00)*s24+8.439288e+00*s25+(-1.836287e+02)*s26+(-9.695874e+00)*s27+4.615237e+01*s28+(-2.340841e+02)*s29 \
v67=v67_part3+2.007535e+01*s30+(-1.911979e+01)*s31+(-3.244228e+01)*s32+(-3.061734e+01)*s33+8.408887e+01*s34+(-4.255707e+00)*s35+(-2.941947e+03)*s36+6.046267e+00*s37+2.955857e+02*s38+4.353918e+02*s39 \
v68_part1=(-6.689756e+01)*s0+3.633432e+00*s1+(-2.885100e+00)*s2+(-3.489688e-04)*s3+(-2.197476e+02)*s4+(-8.595325e+00)*s5+(-1.293015e+00)*s6+2.256705e+01*s7+(-1.143560e+00)*s8+(-4.311453e+00)*s9 \
v68_part2=v68_part1+(-8.236816e+03)*s10+(-1.908109e+02)*s11+3.251693e+01*s12+(-1.457759e+01)*s13+(-6.511735e+00)*s14+(-5.942742e+01)*s15+5.494942e+01*s16+3.149801e-01*s17+(-3.201082e+01)*s18+(-9.123925e-01)*s19 \
v68_part3=v68_part2+(-3.618141e+00)*s20+(-3.822194e+01)*s21+2.894152e+01*s22+(-1.490873e+00)*s23+7.866837e+00*s24+1.038199e+00*s25+1.349426e+02*s26+(-3.854274e+01)*s27+(-2.315818e+02)*s28+(-5.916262e+01)*s29 \
v68=v68_part3+(-5.890466e+00)*s30+3.308501e+01*s31+(-3.280861e+00)*s32+(-5.251235e+00)*s33+(-6.241890e+01)*s34+3.695474e+00*s35+1.452142e+02*s36+(-6.948362e+01)*s37+5.762664e+01*s38+1.112101e+01*s39 \
v69_part1=1.441100e+01*s0+(-4.584505e+00)*s1+(-1.116976e+01)*s2+(-1.817119e+00)*s3+9.998959e+03*s4+(-6.302927e+00)*s5+(-3.841062e+00)*s6+1.853319e+01*s7+3.112713e+00*s8+(-6.545049e+00)*s9 \
v69_part2=v69_part1+4.676128e+02*s10+5.791884e-01*s11+8.310691e-01*s12+(-6.779377e+00)*s13+(-1.433042e+01)*s14+1.435158e+01*s15+(-8.009708e-01)*s16+(-1.624849e+01)*s17+(-3.203000e+01)*s18+(-6.253755e+00)*s19 \
v69_part3=v69_part2+9.239172e-01*s20+(-6.821532e+01)*s21+(-1.748247e+01)*s22+(-1.360136e+00)*s23+3.780570e+00*s24+(-6.928142e+00)*s25+7.485964e+01*s26+(-1.394474e+00)*s27+(-1.393674e+02)*s28+(-1.496382e+01)*s29 \
v69=v69_part3+(-1.065255e+01)*s30+2.109040e+00*s31+4.964951e+01*s32+(-9.082723e+00)*s33+6.145258e+01*s34+1.943386e+00*s35+1.846605e+03*s36+(-1.604067e+01)*s37+(-2.424601e+02)*s38+(-8.779399e+01)*s39 \
v70_part1=(-4.369329e+01)*s0+(-6.444406e-01)*s1+2.019006e+01*s2+1.857800e+00*s3+9.856761e+01*s4+(-7.154553e-03)*s5+2.376084e+00*s6+(-3.978621e+00)*s7+8.116678e-01*s8+2.501911e+00*s9 \
v70_part2=v70_part1+4.192597e+01*s10+3.597657e+01*s11+6.787740e+00*s12+(-3.127619e+00)*s13+9.417079e+00*s14+2.618234e+02*s15+1.029572e+02*s16+1.882141e+01*s17+6.563492e+01*s18+3.006853e+00*s19 \
v70_part3=v70_part2+4.516992e+01*s20+1.175253e+02*s21+2.580306e+01*s22+(-7.143851e-02)*s23+9.866679e+00*s24+5.727043e+01*s25+5.088637e+01*s26+8.445315e+00*s27+2.114719e+02*s28+(-3.290972e+02)*s29 \
v70=v70_part3+(-3.006347e+00)*s30+(-2.600671e+01)*s31+(-4.186285e+00)*s32+6.567418e+01*s33+1.153697e+02*s34+(-1.132703e+01)*s35+(-1.635638e+02)*s36+2.410941e+01*s37+3.088138e+01*s38+(-3.565099e+02)*s39 \
v71_part1=1.039597e+01*s0+1.970859e+00*s1+1.157065e+00*s2+2.665428e-01*s3+(-5.560574e+01)*s4+4.073993e-01*s5+7.877501e+00*s6+(-9.384248e+00)*s7+2.733746e+00*s8+(-8.816233e+00)*s9 \
v71_part2=v71_part1+4.617530e+03*s10+1.042779e+02*s11+8.077503e-01*s12+2.576983e+00*s13+2.438887e-02*s14+(-6.323799e+00)*s15+(-1.620573e+02)*s16+(-1.155441e+01)*s17+1.543026e+00*s18+1.754682e+00*s19 \
v71_part3=v71_part2+1.072450e+00*s20+(-2.621749e+00)*s21+7.500287e+00*s22+1.576706e+00*s23+1.958837e+00*s24+(-1.450610e+00)*s25+(-1.163126e+02)*s26+2.127991e+01*s27+1.987380e+01*s28+(-2.868142e+02)*s29 \
v71=v71_part3+(-9.536471e+00)*s30+(-1.599699e-01)*s31+1.477018e+01*s32+(-2.913738e+01)*s33+2.925726e+01*s34+1.728686e+00*s35+(-1.286796e+01)*s36+5.736207e+01*s37+(-9.148451e+00)*s38+(-7.648926e+01)*s39 \
v72_part1=(-4.779557e+02)*s0+1.000066e+01*s1+1.434432e+00*s2+5.972742e+01*s3+(-1.000000e+04)*s4+(-3.661686e+00)*s5+(-7.326387e+01)*s6+(-7.749252e+00)*s7+(-2.893258e+00)*s8+(-5.964825e+00)*s9 \
v72_part2=v72_part1+(-1.000000e+04)*s10+1.158077e+02*s11+(-1.272195e+00)*s12+8.196936e+00*s13+(-2.500766e+02)*s14+9.528951e+00*s15+(-1.000000e+04)*s16+1.328389e+00*s17+(-1.015106e+01)*s18+(-5.264242e+00)*s19 \
v72_part3=v72_part2+(-1.704670e+02)*s20+(-5.979063e+00)*s21+(-2.701882e+00)*s22+(-6.622727e+00)*s23+(-6.452574e+00)*s24+(-2.143059e+02)*s25+(-1.086759e+02)*s26+(-1.594258e+02)*s27+(-1.000000e+04)*s28+4.799620e+03*s29 \
v72=v72_part3+(-6.591775e+02)*s30+(-4.730186e+01)*s31+(-1.000000e+04)*s32+(-1.000000e+04)*s33+(-8.752046e+00)*s34+(-1.000000e+04)*s35+1.467008e+03*s36+(-2.097536e+01)*s37+5.737099e+02*s38+(-1.324811e+02)*s39 \
v73_part1=(-1.387624e+02)*s0+7.974286e+00*s1+(-5.092888e+00)*s2+(-2.380603e+01)*s3+(-1.000000e+04)*s4+4.628326e+01*s5+(-5.114009e+02)*s6+2.385729e+00*s7+2.259260e+01*s8+(-3.278457e+01)*s9 \
v73_part2=v73_part1+(-6.183054e+03)*s10+1.394835e+01*s11+9.333675e-03*s12+6.398603e+01*s13+(-5.529887e+01)*s14+(-4.399409e+01)*s15+(-1.000000e+04)*s16+1.114633e+01*s17+1.906990e+00*s18+(-8.622194e+01)*s19 \
v73_part3=v73_part2+7.288451e+00*s20+6.270679e+01*s21+3.187571e+01*s22+(-1.578750e+01)*s23+(-1.682692e+01)*s24+(-3.879161e+01)*s25+2.906706e+01*s26+(-2.232365e+01)*s27+(-1.000000e+04)*s28+6.187370e+03*s29 \
v73=v73_part3+(-4.769848e+03)*s30+7.873630e+01*s31+(-1.000000e+04)*s32+(-1.000000e+04)*s33+2.250068e+00*s34+(-1.000000e+04)*s35+(-3.429268e+03)*s36+3.471547e+01*s37+4.373517e+02*s38+2.363259e+01*s39 \
v74_part1=(-5.247567e+02)*s0+(-2.151400e+00)*s1+2.861472e+00*s2+2.323655e+01*s3+(-1.000000e+04)*s4+1.207095e+00*s5+(-1.520539e+02)*s6+(-1.093500e+01)*s7+1.086219e+00*s8+1.102764e+00*s9 \
v74_part2=v74_part1+(-1.000000e+04)*s10+(-2.965691e+02)*s11+1.486746e-01*s12+8.252931e+00*s13+2.618801e+02*s14+(-1.456415e+03)*s15+(-1.000000e+04)*s16+(-3.727248e+00)*s17+(-5.356484e+01)*s18+3.159342e+01*s19 \
v74_part3=v74_part2+(-1.167773e+00)*s20+(-1.305813e+02)*s21+(-1.936567e+01)*s22+1.619972e+01*s23+1.672665e+01*s24+1.561559e+01*s25+4.552659e+02*s26+2.189264e+02*s27+(-1.000000e+04)*s28+8.303937e+02*s29 \
v74=v74_part3+(-3.664893e+03)*s30+(-1.005790e+00)*s31+(-1.000000e+04)*s32+(-1.000000e+04)*s33+2.387868e+01*s34+(-1.000000e+04)*s35+(-1.596419e+03)*s36+(-3.657551e+01)*s37+2.419062e+02*s38+(-3.070934e+01)*s39 \
v75_part1=(-2.354648e+00)*s0+(-2.130280e+01)*s1+(-5.043986e+01)*s2+(-1.150295e+01)*s3+(-1.000000e+04)*s4+(-1.745238e+01)*s5+(-3.766032e+02)*s6+5.349104e+01*s7+2.330738e+01*s8+1.683105e+01*s9 \
v75_part2=v75_part1+(-4.659979e+03)*s10+3.234449e+02*s11+1.248005e+00*s12+(-2.284223e+01)*s13+(-8.765160e-01)*s14+1.368397e+02*s15+(-1.000000e+04)*s16+1.901331e+01*s17+(-3.301541e+00)*s18+6.624855e+01*s19 \
v75_part3=v75_part2+2.751596e+02*s20+(-7.782247e+01)*s21+4.221609e+01*s22+(-1.154809e+02)*s23+9.658711e+01*s24+1.294040e+00*s25+(-7.004215e+02)*s26+1.022600e+02*s27+(-1.000000e+04)*s28+2.463054e+02*s29 \
v75=v75_part3+(-9.745924e+03)*s30+4.065523e+00*s31+(-1.000000e+04)*s32+(-1.000000e+04)*s33+1.482654e+02*s34+(-9.997502e+03)*s35+7.183439e+03*s36+4.342329e+01*s37+(-3.395502e+02)*s38+1.203401e+02*s39 \
v76_part1=(-1.686060e+03)*s0+6.615231e+01*s1+4.032334e+01*s2+1.749728e+01*s3+(-1.000000e+04)*s4+(-1.201233e+02)*s5+1.469834e+03*s6+3.488522e+00*s7+2.327652e+01*s8+2.895567e+02*s9 \
v76_part2=v76_part1+(-1.000000e+04)*s10+(-1.391371e+02)*s11+1.095876e+01*s12+(-3.608095e+01)*s13+(-1.248445e+01)*s14+3.048509e+03*s15+(-1.000000e+04)*s16+1.868933e-01*s17+(-1.276243e+02)*s18+5.710177e+01*s19 \
v76_part3=v76_part2+1.473498e+01*s20+7.543222e+02*s21+8.253893e+01*s22+(-1.921777e+00)*s23+(-1.340163e+02)*s24+1.378807e+01*s25+7.985558e+02*s26+2.667822e+02*s27+(-1.000000e+04)*s28+1.154225e+03*s29 \
v76=v76_part3+(-1.507920e+03)*s30+2.016886e+01*s31+(-1.000000e+04)*s32+(-1.000000e+04)*s33+8.415009e+02*s34+(-1.000000e+04)*s35+(-1.000000e+04)*s36+4.714213e+02*s37+(-1.397436e+00)*s38+3.214734e+02*s39 \
v77_part1=(-8.286132e+03)*s0+(-4.566046e+00)*s1+4.507570e+00*s2+(-2.546313e+02)*s3+(-1.000000e+04)*s4+5.304611e+01*s5+4.321027e+01*s6+2.378879e+01*s7+2.486274e+01*s8+(-8.784958e+01)*s9 \
v77_part2=v77_part1+(-1.000000e+04)*s10+6.262709e+01*s11+2.523910e+01*s12+(-5.128063e+01)*s13+1.059287e+02*s14+7.770930e+02*s15+(-1.000000e+04)*s16+5.585574e+00*s17+1.217421e+02*s18+5.605459e+01*s19 \
v77_part3=v77_part2+(-3.290291e+00)*s20+1.063970e+02*s21+3.147268e-01*s22+1.558617e+02*s23+9.994188e+01*s24+6.166038e+02*s25+3.254928e+01*s26+1.272754e+01*s27+(-1.000000e+04)*s28+4.294481e+03*s29 \
v77=v77_part3+(-1.582842e+03)*s30+3.747941e+01*s31+(-1.000000e+04)*s32+(-1.000000e+04)*s33+(-2.382829e+02)*s34+(-1.000000e+04)*s35+6.792063e+03*s36+(-6.474919e+01)*s37+(-8.017955e+02)*s38+1.172434e+02*s39 \
v78_part1=3.046605e+02*s0+(-8.109376e+02)*s1+2.878353e+02*s2+1.000000e+04*s3+1.535779e+02*s4+1.000000e+04*s5+(-1.384931e+02)*s6+(-1.746843e+01)*s7+1.000000e+04*s8+(-1.111734e+03)*s9 \
v78_part2=v78_part1+1.000000e+04*s10+4.986755e+03*s11+1.000000e+04*s12+2.550319e+01*s13+1.000000e+04*s14+(-2.467229e+03)*s15+1.000000e+04*s16+5.298199e+02*s17+1.328179e+03*s18+4.677608e+02*s19 \
v78_part3=v78_part2+8.963697e+03*s20+1.000000e+04*s21+1.000000e+04*s22+(-7.183353e+02)*s23+6.770780e-01*s24+8.984567e+01*s25+3.355777e+03*s26+1.000000e+04*s27+9.995760e+03*s28+(-8.965629e+01)*s29 \
v78=v78_part3+1.000000e+04*s30+9.444651e+01*s31+1.000000e+04*s32+(-7.227320e+02)*s33+1.000000e+04*s34+1.996083e+03*s35+1.000000e+04*s36+1.000000e+04*s37+1.000000e+04*s38+1.358662e+03*s39 \
v79_part1=(-2.789216e+00)*s0+3.235449e+03*s1+(-2.784875e+00)*s2+1.000000e+04*s3+(-2.426710e+02)*s4+1.000000e+04*s5+6.444077e+02*s6+(-5.183386e+02)*s7+1.000000e+04*s8+(-2.107545e+01)*s9 \
v79_part2=v79_part1+1.000000e+04*s10+1.000000e+04*s11+1.000000e+04*s12+9.107462e+02*s13+1.000000e+04*s14+1.557038e+03*s15+1.000000e+04*s16+2.655866e+01*s17+8.044619e+03*s18+1.418179e+02*s19 \
v79_part3=v79_part2+9.731692e+02*s20+1.000000e+04*s21+1.000000e+04*s22+(-1.481194e+02)*s23+3.643833e+03*s24+3.187109e+02*s25+1.000000e+04*s26+5.148220e+03*s27+1.721938e+03*s28+2.224380e+01*s29 \
v79=v79_part3+1.000000e+04*s30+1.471716e+02*s31+1.000000e+04*s32+5.503300e+02*s33+1.000000e+04*s34+6.242730e+03*s35+1.000000e+04*s36+1.000000e+04*s37+1.000000e+04*s38+1.000000e+04*s39 \
v80_part1=1.267996e+02*s0+(-1.013190e+02)*s1+(-2.246280e+02)*s2+(-9.991411e+03)*s3+(-6.185377e+01)*s4+1.000000e+04*s5+(-8.628423e+01)*s6+(-9.999562e+01)*s7+9.719302e+01*s8+(-6.619401e+01)*s9 \
v80_part2=v80_part1+1.000000e+04*s10+1.269281e+03*s11+1.000000e+04*s12+1.111993e+02*s13+1.000000e+04*s14+(-9.965352e+02)*s15+1.000000e+04*s16+4.269312e+03*s17+(-8.581796e+00)*s18+(-6.351978e+02)*s19 \
v80_part3=v80_part2+6.105376e+03*s20+1.000000e+04*s21+3.125992e+02*s22+3.885008e+01*s23+5.960901e+03*s24+5.479783e+02*s25+1.000000e+04*s26+7.689271e+03*s27+(-8.081028e+03)*s28+(-2.474107e+01)*s29 \
v80=v80_part3+1.000000e+04*s30+7.093803e+00*s31+1.000000e+04*s32+(-2.008341e+03)*s33+1.000000e+04*s34+(-5.248352e+03)*s35+1.000000e+04*s36+1.000000e+04*s37+1.000000e+04*s38+1.000000e+04*s39 \
v81_part1=3.704261e+01*s0+4.939069e+02*s1+2.337139e+01*s2+1.000000e+04*s3+1.054432e+02*s4+1.000000e+04*s5+2.513784e+02*s6+2.253022e+01*s7+1.917323e+02*s8+2.613718e+03*s9 \
v81_part2=v81_part1+1.000000e+04*s10+1.000000e+04*s11+1.000000e+04*s12+2.463479e+01*s13+1.000000e+04*s14+1.000000e+04*s15+1.000000e+04*s16+7.280219e+01*s17+1.245811e+02*s18+(-1.119574e+02)*s19 \
v81_part3=v81_part2+1.219930e+02*s20+7.282083e+03*s21+1.000000e+04*s22+9.686313e+03*s23+7.344436e+02*s24+2.420866e+03*s25+9.371867e+03*s26+5.115169e+03*s27+7.700662e+03*s28+3.660466e+00*s29 \
v81=v81_part3+3.975913e+02*s30+(-1.234644e+02)*s31+1.000000e+04*s32+9.765074e+03*s33+1.000000e+04*s34+(-2.088389e+03)*s35+1.000000e+04*s36+1.000000e+04*s37+1.000000e+04*s38+1.000000e+04*s39 \
v82_part1=(-1.169279e+01)*s0+8.258906e+01*s1+(-4.594925e+01)*s2+1.000000e+04*s3+4.332025e+01*s4+1.000000e+04*s5+4.203672e+03*s6+1.448476e+03*s7+6.662325e+03*s8+(-4.382011e+03)*s9 \
v82_part2=v82_part1+1.000000e+04*s10+5.530732e+03*s11+1.000000e+04*s12+3.577359e+01*s13+1.000000e+04*s14+1.000000e+04*s15+1.000000e+04*s16+1.931113e+00*s17+(-1.384890e+03)*s18+(-1.385953e+02)*s19 \
v82_part3=v82_part2+7.961250e+02*s20+1.000000e+04*s21+1.000000e+04*s22+1.244032e+02*s23+7.042886e+02*s24+1.772566e+02*s25+1.000000e+04*s26+4.130898e+03*s27+1.666798e+03*s28+8.747441e+02*s29 \
v82=v82_part3+1.000000e+04*s30+2.221988e-01*s31+1.000000e+04*s32+7.527083e+03*s33+1.000000e+04*s34+(-8.351676e+03)*s35+1.000000e+04*s36+1.000000e+04*s37+1.000000e+04*s38+5.107833e+03*s39 \
v83_part1=1.591430e+01*s0+5.207679e+01*s1+(-3.733432e+01)*s2+(-9.991413e+03)*s3+1.497393e+01*s4+1.000000e+04*s5+6.637161e+02*s6+(-1.462494e+01)*s7+1.155254e+01*s8+1.000000e+04*s9 \
v83_part2=v83_part1+1.000000e+04*s10+2.054648e+03*s11+1.000000e+04*s12+(-6.173651e+00)*s13+1.000000e+04*s14+1.328871e+03*s15+1.000000e+04*s16+3.676914e+02*s17+(-1.276631e+03)*s18+(-1.738443e+02)*s19 \
v83_part3=v83_part2+9.943377e+03*s20+9.999981e+03*s21+1.000000e+04*s22+2.515550e+02*s23+4.529574e+03*s24+1.652404e+01*s25+5.785543e+03*s26+1.000000e+04*s27+(-9.166048e+03)*s28+1.724332e+03*s29 \
v83=v83_part3+1.000000e+04*s30+(-1.330931e+02)*s31+1.000000e+04*s32+1.665110e+02*s33+1.000000e+04*s34+(-7.450796e+03)*s35+1.000000e+04*s36+1.000000e+04*s37+1.000000e+04*s38+1.000000e+04*s39 \
v84_part1=(-3.334315e-01)*s0+(-3.439513e+00)*s1+(-1.000000e+04)*s2+(-9.998001e+03)*s3+(-1.000000e+04)*s4+(-1.000000e+04)*s5+(-2.077848e+02)*s6+1.770690e+00*s7+(-1.000000e+04)*s8+(-1.000000e+04)*s9 \
v84_part2=v84_part1+(-1.084285e+03)*s10+(-4.514905e+00)*s11+(-8.059053e+00)*s12+(-4.732781e+00)*s13+(-3.003928e+01)*s14+(-4.216050e+01)*s15+(-1.000000e+04)*s16+(-3.546635e+00)*s17+(-8.428832e+02)*s18+(-1.000000e+04)*s19 \
v84_part3=v84_part2+(-2.655511e+00)*s20+(-1.046225e+01)*s21+(-6.625902e+01)*s22+2.836948e+01*s23+(-1.092335e+02)*s24+(-1.752805e+00)*s25+1.020770e+01*s26+(-6.865711e+03)*s27+(-1.000000e+04)*s28+(-2.418693e+00)*s29 \
v84=v84_part3+(-7.440759e+00)*s30+(-5.599855e+02)*s31+(-1.382266e+02)*s32+(-1.935674e+01)*s33+(-6.430532e+02)*s34+(-1.000000e+04)*s35+4.268564e+01*s36+(-2.732139e+01)*s37+(-5.126753e+00)*s38+(-7.484359e-01)*s39 \
v85_part1=8.704835e+02*s0+1.777331e+00*s1+(-1.000000e+04)*s2+(-1.000000e+04)*s3+(-1.000000e+04)*s4+(-1.000000e+04)*s5+(-5.298477e+02)*s6+4.601112e+00*s7+(-1.000000e+04)*s8+(-9.999464e+03)*s9 \
v85_part2=v85_part1+1.942224e+01*s10+4.598472e+00*s11+(-2.567202e+00)*s12+3.584814e+00*s13+1.223714e+00*s14+1.699543e+02*s15+(-1.000000e+04)*s16+5.973588e+00*s17+(-1.671227e+03)*s18+(-1.000000e+04)*s19 \
v85_part3=v85_part2+4.231202e-01*s20+5.789122e+01*s21+6.063034e+01*s22+(-1.130593e+03)*s23+(-1.127399e+02)*s24+(-7.718873e+01)*s25+3.943765e+00*s26+(-8.025900e+03)*s27+(-1.000000e+04)*s28+4.993912e+00*s29 \
v85=v85_part3+(-5.436640e-01)*s30+(-1.002298e+03)*s31+(-5.194790e+03)*s32+4.266544e+01*s33+2.312096e+03*s34+(-1.000000e+04)*s35+(-1.306713e+02)*s36+3.518756e+02*s37+1.237129e+01*s38+(-3.084985e+00)*s39 \
v86_part1=(-9.514240e-01)*s0+(-2.564977e+00)*s1+(-1.000000e+04)*s2+(-9.997824e+03)*s3+(-1.000000e+04)*s4+(-1.000000e+04)*s5+(-5.051004e+02)*s6+3.476106e-01*s7+(-1.000000e+04)*s8+(-1.000000e+04)*s9 \
v86_part2=v86_part1+2.793260e+03*s10+5.193678e+01*s11+(-1.235483e+02)*s12+5.412896e+00*s13+(-6.451494e+00)*s14+(-4.874921e+01)*s15+(-1.000000e+04)*s16+1.405110e+00*s17+(-5.885518e+03)*s18+(-1.000000e+04)*s19 \
v86_part3=v86_part2+5.146525e+00*s20+(-2.859190e+01)*s21+(-8.430003e-01)*s22+1.086219e+00*s23+(-2.617038e+02)*s24+(-6.316560e-02)*s25+4.096822e+01*s26+(-7.345876e+03)*s27+(-1.000000e+04)*s28+(-1.884930e+01)*s29 \
v86=v86_part3+(-2.376688e+01)*s30+(-5.207391e+02)*s31+(-7.077789e+02)*s32+(-5.267155e+00)*s33+(-1.286410e+02)*s34+(-1.000000e+04)*s35+6.779150e+00*s36+(-1.544381e+02)*s37+(-1.945568e+02)*s38+(-4.192786e+00)*s39 \
v87_part1=8.937089e+00*s0+(-4.680667e+01)*s1+(-1.000000e+04)*s2+(-1.000000e+04)*s3+(-1.000000e+04)*s4+(-1.000000e+04)*s5+(-1.928928e+03)*s6+(-1.090370e-02)*s7+(-1.000000e+04)*s8+(-1.000000e+04)*s9 \
v87_part2=v87_part1+(-2.691283e+01)*s10+(-1.545074e+01)*s11+(-3.882336e+02)*s12+(-6.157455e+00)*s13+(-8.225107e-01)*s14+(-1.179023e+02)*s15+(-1.000000e+04)*s16+1.147250e+01*s17+(-3.193579e+03)*s18+(-1.000000e+04)*s19 \
v87_part3=v87_part2+3.583387e+00*s20+(-6.280418e+01)*s21+(-2.634782e+02)*s22+1.687204e+01*s23+(-5.173296e+02)*s24+(-3.161227e+00)*s25+(-4.479680e+01)*s26+(-1.577590e+03)*s27+(-1.000000e+04)*s28+(-5.719420e+00)*s29 \
v87=v87_part3+(-7.609686e+01)*s30+(-8.131593e+01)*s31+3.693133e+03*s32+(-6.142978e+01)*s33+(-2.099591e+00)*s34+(-1.000000e+04)*s35+1.134425e+01*s36+(-5.664978e+02)*s37+2.938547e+00*s38+8.706363e+00*s39 \
v88_part1=(-3.433377e+03)*s0+6.503121e+01*s1+(-1.000000e+04)*s2+(-1.000000e+04)*s3+(-1.000000e+04)*s4+(-1.000000e+04)*s5+(-4.143912e+02)*s6+(-7.797207e+00)*s7+(-1.000000e+04)*s8+(-9.981434e+03)*s9 \
v88_part2=v88_part1+2.422522e+01*s10+4.028811e+01*s11+6.584976e+02*s12+3.110854e+01*s13+4.812943e+00*s14+2.280871e+01*s15+(-1.000000e+04)*s16+3.043828e+00*s17+(-2.615204e+02)*s18+(-1.000000e+04)*s19 \
v88_part3=v88_part2+(-6.522905e+00)*s20+1.006671e+01*s21+1.013475e+03*s22+1.386723e+03*s23+(-9.981796e+01)*s24+(-4.380933e+00)*s25+(-1.791639e+01)*s26+(-2.296590e+03)*s27+(-1.000000e+04)*s28+3.623472e+01*s29 \
v88=v88_part3+1.472148e+02*s30+(-4.271134e+01)*s31+(-5.576630e+03)*s32+8.579970e+01*s33+(-2.509590e+03)*s34+(-1.000000e+04)*s35+2.104419e+02*s36+5.974455e+02*s37+6.759028e+02*s38+2.620693e+01*s39 \
v89_part1=(-4.506787e+01)*s0+(-7.321154e-01)*s1+(-1.000000e+04)*s2+(-9.998007e+03)*s3+(-1.000000e+04)*s4+(-1.000000e+04)*s5+8.329424e+02*s6+8.755338e-01*s7+(-1.000000e+04)*s8+(-1.000000e+04)*s9 \
v89_part2=v89_part1+(-1.719591e+03)*s10+(-1.053643e+01)*s11+1.437973e+01*s12+(-1.404411e+01)*s13+8.477642e+01*s14+3.952206e+01*s15+(-1.000000e+04)*s16+(-7.323329e-01)*s17+(-2.813751e+02)*s18+(-1.000000e+04)*s19 \
v89_part3=v89_part2+9.862624e-04*s20+5.200481e+01*s21+(-4.743894e+02)*s22+2.674935e+01*s23+1.287797e+03*s24+4.372412e+01*s25+8.411091e-02*s26+(-8.111796e+03)*s27+(-1.000000e+04)*s28+8.786385e+00*s29 \
v89=v89_part3+(-2.202455e+01)*s30+(-2.330977e+02)*s31+(-4.054068e+03)*s32+6.292089e+00*s33+(-6.568759e-01)*s34+(-1.000000e+04)*s35+(-1.308469e+02)*s36+(-1.489340e+02)*s37+(-6.858367e+01)*s38+(-1.253845e+00)*s39 \
v90_part1=1.991499e-02*s0+(-3.529779e-01)*s1+1.366480e-01*s2+9.476517e-02*s3+7.334995e-02*s4+9.550107e-02*s5+1.458867e-01*s6+8.586522e-01*s7+6.542833e-02*s8+8.207318e-02*s9 \
v90_part2=v90_part1+1.313478e-01*s10+6.160282e-01*s11+6.454156e-02*s12+1.119493e-01*s13+1.184916e-01*s14+5.353887e-01*s15+7.094170e-02*s16+1.735722e-01*s17+4.743309e-01*s18+7.847551e-02*s19 \
v90_part3=v90_part2+2.306823e-02*s20+6.719355e-02*s21+1.446033e-01*s22+1.419456e-01*s23+4.701482e-02*s24+1.223159e-01*s25+4.592282e-01*s26+5.246763e-01*s27+7.000577e-02*s28+1.197745e-01*s29 \
v90=v90_part3+4.494052e-01*s30+2.624697e-01*s31+7.169368e-02*s32+9.371713e-02*s33+4.606017e-01*s34+4.157366e-01*s35+6.920130e-02*s36+1.188863e-01*s37+7.427798e-02*s38+2.543758e-01*s39 \
v91_part1=4.929073e-01*s0+6.083484e-01*s1+4.487193e-02*s2+(-4.737429e-02)*s3+2.633162e-01*s4+2.360848e-01*s5+1.171166e-01*s6+1.151317e+00*s7+3.152784e-01*s8+2.537913e-01*s9 \
v91_part2=v91_part1+1.697473e-01*s10+1.010113e+00*s11+2.571695e-01*s12+4.431385e-01*s13+1.987197e-01*s14+1.316310e+00*s15+2.603842e-01*s16+5.549958e-01*s17+1.882182e+00*s18+1.015647e-02*s19 \
v91_part3=v91_part2+3.161887e-01*s20+3.332837e-01*s21+1.172778e-01*s22+(-1.108502e-02)*s23+3.496765e-01*s24+6.922197e-01*s25+6.174992e-01*s26+1.128777e+00*s27+2.601391e-01*s28+1.910463e-01*s29 \
v91=v91_part3+1.793206e+00*s30+(-3.529861e-01)*s31+2.626525e-01*s32+2.364610e-01*s33+7.019812e-01*s34+1.330813e+00*s35+2.602348e-01*s36+1.914963e-01*s37+4.379847e-01*s38+(-4.369824e-02)*s39 \
v92_part1=8.888474e-01*s0+2.766088e+00*s1+1.525509e+00*s2+2.338442e+00*s3+6.026376e-01*s4+1.073388e+00*s5+1.504076e+00*s6+(-3.354448e-01)*s7+6.030572e-01*s8+1.173310e+00*s9 \
v92_part2=v92_part1+1.602267e+00*s10+(-6.772550e-01)*s11+6.716763e-01*s12+1.012832e+00*s13+1.700770e+00*s14+(-4.354909e-01)*s15+5.928385e-01*s16+1.248606e+00*s17+(-3.224100e-01)*s18+2.336621e+00*s19 \
v92_part3=v92_part2+7.051735e-01*s20+1.075500e+00*s21+1.502137e+00*s22+2.188227e+00*s23+6.974810e-01*s24+1.015389e+00*s25+9.445127e-01*s26+(-4.873228e-01)*s27+5.898327e-01*s28+9.210213e-01*s29 \
v92=v92_part3+(-8.375556e-01)*s30+1.887164e+00*s31+5.972985e-01*s32+1.066539e+00*s33+3.859590e-01*s34+(-3.678370e-01)*s35+5.879723e-01*s36+9.187571e-01*s37+1.395011e+00*s38+1.577966e+00*s39 \
v93_part1=(-2.537018e-02)*s0+8.702339e-01*s1+7.832981e-02*s2+7.631924e-02*s3+1.176229e-02*s4+6.094281e-02*s5+9.728221e-02*s6+1.294038e+00*s7+(-3.365097e-02)*s8+5.795478e-02*s9 \
v93_part2=v93_part1+1.046343e-01*s10+(-2.909810e-02)*s11+2.047580e-02*s12+(-4.493129e-02)*s13+1.063649e-01*s14+(-1.231461e-01)*s15+1.391443e-02*s16+9.886994e-03*s17+7.101733e-01*s18+3.559407e-02*s19 \
v93_part3=v93_part2+(-5.086077e-02)*s20+(-1.351561e-02)*s21+9.643212e-02*s22+9.389151e-02*s23+(-6.962352e-02)*s24+(-9.645753e-03)*s25+3.411679e-01*s26+(-1.298229e-02)*s27+1.298666e-02*s28+6.095199e-02*s29 \
v93=v93_part3+(-6.384301e-02)*s30+2.622868e-01*s31+1.022983e-02*s32+5.894173e-02*s33+8.355968e-01*s34+2.679470e-01*s35+1.225917e-02*s36+5.973615e-02*s37+(-2.840312e-01)*s38+7.252761e-02*s39 \
v94_part1=2.613541e-01*s0+(-1.968663e-01)*s1+5.246232e+00*s2+7.190219e+00*s3+1.583873e+00*s4+3.166583e+00*s5+5.007600e+00*s6+(-2.287283e-02)*s7+1.605324e+00*s8+3.145865e+00*s9 \
v94_part2=v94_part1+4.865311e+00*s10+(-3.367373e-01)*s11+1.603247e+00*s12+1.833831e+00*s13+4.800911e+00*s14+(-6.512989e-01)*s15+1.573644e+00*s16+(-2.648723e-01)*s17+(-3.600624e-01)*s18+7.175386e+00*s19 \
v94_part3=v94_part2+1.638652e+00*s20+3.160645e+00*s21+5.008977e+00*s22+6.996810e+00*s23+5.049668e-01*s24+(-3.360818e-02)*s25+1.014462e-01*s26+(-5.058596e-01)*s27+1.575008e+00*s28+3.268766e+00*s29 \
v94=v94_part3+(-5.219565e-01)*s30+7.395831e+00*s31+1.586678e+00*s32+3.169864e+00*s33+(-4.162630e-01)*s34+4.997941e+00*s35+1.576001e+00*s36+3.270977e+00*s37+5.293223e+00*s38+7.195889e+00*s39 \
v95_part1=(-3.736524e-01)*s0+(-1.006928e-01)*s1+(-5.747551e-03)*s2+(-3.659458e-01)*s3+(-4.456738e-02)*s4+1.954552e-02*s5+8.729656e-02*s6+5.833088e-01*s7+(-4.248594e-02)*s8+(-4.806443e-02)*s9 \
v95_part2=v95_part1+5.627105e-02*s10+4.198912e-01*s11+(-8.205282e-02)*s12+(-2.025721e-01)*s13+6.788017e-03*s14+2.435544e-01*s15+(-4.403993e-02)*s16+(-7.830356e-01)*s17+2.548179e-01*s18+(-3.603984e-01)*s19 \
v95_part3=v95_part2+(-1.330688e-01)*s20+2.183636e-02*s21+8.726073e-02*s22+(-1.552927e-01)*s23+(-2.511459e-01)*s24+(-7.362264e-01)*s25+(-1.456411e-01)*s26+2.908422e-01*s27+(-4.383387e-02)*s28+1.162719e-01*s29 \
v95=v95_part3+4.008003e-01*s30+(-5.279124e-02)*s31+(-4.479846e-02)*s32+2.237341e-02*s33+(-1.913289e-01)*s34+7.442249e-01*s35+(-4.371361e-02)*s36+1.168822e-01*s37+8.953248e-02*s38+3.276231e-01*s39 \
v96_part1=1.187887e+03*s0+3.058239e+03*s1+3.644968e+03*s2+3.261218e+03*s3+5.464710e+03*s4+4.510598e+03*s5+3.790146e+03*s6+2.060443e+03*s7+5.192668e+03*s8+4.472850e+03*s9 \
v96_part2=v96_part1+3.804365e+03*s10+1.055399e+03*s11+4.919445e+03*s12+2.524997e+03*s13+3.771181e+03*s14+2.008695e+03*s15+5.577216e+03*s16+2.480974e+03*s17+2.436673e+03*s18+3.313712e+03*s19 \
v96_part3=v96_part2+4.157403e+03*s20+4.343061e+03*s21+3.830488e+03*s22+3.393493e+03*s23+5.375214e+02*s24+4.075361e+02*s25+1.532731e+03*s26+5.456116e+02*s27+5.690510e+03*s28+4.591432e+03*s29 \
v96=v96_part3+7.737098e+02*s30+3.436835e+03*s31+5.667503e+03*s32+4.627007e+03*s33+2.306990e+03*s34+7.794866e+02*s35+5.783602e+03*s36+4.649480e+03*s37+3.792202e+03*s38+3.411076e+03*s39 \
v97_part1=1.034045e+03*s0+(-1.993154e+02)*s1+(-3.015578e+03)*s2+(-3.381909e+03)*s3+(-2.389196e+03)*s4+(-2.495484e+03)*s5+(-2.762212e+03)*s6+(-2.750287e+02)*s7+(-1.564973e+03)*s8+(-2.343742e+03)*s9 \
v97_part2=v97_part1+(-2.567020e+03)*s10+2.131605e+02*s11+(-2.006238e+03)*s12+(-7.406461e+02)*s13+(-2.430815e+03)*s14+(-7.932889e+02)*s15+(-2.542388e+03)*s16+(-3.086297e+02)*s17+(-5.110223e+03)*s18+(-3.469220e+03)*s19 \
v97_part3=v97_part2+(-1.174056e+03)*s20+(-2.018442e+03)*s21+(-2.810242e+03)*s22+(-3.140256e+03)*s23+1.812225e+02*s24+4.597710e+02*s25+(-1.240983e+02)*s26+5.553741e+02*s27+(-2.654408e+03)*s28+(-2.864520e+03)*s29 \
v97=v97_part3+1.923479e+03*s30+(-3.654373e+03)*s31+(-2.589636e+03)*s32+(-2.620682e+03)*s33+1.624990e+02*s34+2.028253e+03*s35+(-2.747707e+03)*s36+(-2.931533e+03)*s37+(-3.166365e+03)*s38+(-3.588395e+03)*s39 \
v98_part1=5.785445e+02*s0+(-1.988131e+02)*s1+1.298734e+02*s2+2.368671e+03*s3+(-4.035021e+03)*s4+(-3.274102e+03)*s5+(-1.411852e+03)*s6+1.990068e+03*s7+(-3.939176e+03)*s8+(-3.423608e+03)*s9 \
v98_part2=v98_part1+(-1.999236e+03)*s10+2.039984e+03*s11+(-2.893426e+03)*s12+(-2.517940e+02)*s13+(-2.212906e+03)*s14+4.412636e+00*s15+(-4.176847e+03)*s16+1.310275e+02*s17+1.360161e+03*s18+2.373629e+03*s19 \
v98_part3=v98_part2+(-9.530865e+02)*s20+(-3.128905e+03)*s21+(-1.432580e+03)*s22+4.246178e+02*s23+8.126029e+02*s24+5.093091e+01*s25+1.186397e+03*s26+2.206399e+03*s27+(-4.268977e+03)*s28+(-2.706157e+03)*s29 \
v98=v98_part3+1.719536e+02*s30+2.250888e+03*s31+(-4.201827e+03)*s32+(-3.364888e+03)*s33+1.423198e+03*s34+1.013050e+03*s35+(-4.346321e+03)*s36+(-2.745763e+03)*s37+5.956913e+01*s38+2.340518e+03*s39 \
v99_part1=(-4.067633e+01)*s0+(-5.397826e+02)*s1+1.532655e+03*s2+1.734791e+03*s3+7.204300e+02*s4+1.187059e+03*s5+1.436852e+03*s6+(-6.321430e+02)*s7+1.016636e+02*s8+1.091743e+03*s9 \
v99_part2=v99_part1+1.353176e+03*s10+(-3.910984e+02)*s11+6.079623e+02*s12+1.496395e+02*s13+1.288976e+03*s14+(-1.969366e+02)*s15+8.311160e+02*s16+(-3.521254e+02)*s17+4.473909e+03*s18+1.785497e+03*s19 \
v99_part3=v99_part2+4.591727e+01*s20+8.997863e+02*s21+1.460720e+03*s22+1.647867e+03*s23+1.007342e+02*s24+6.154952e+02*s25+(-2.750355e+00)*s26+(-2.089241e+02)*s27+8.792079e+02*s28+1.381956e+03*s29 \
v99=v99_part3+(-1.243367e+03)*s30+1.872626e+03*s31+8.055661e+02*s32+1.246208e+03*s33+(-3.625978e+02)*s34+(-6.796670e+02)*s35+9.184368e+02*s36+1.414162e+03*s37+1.583001e+03*s38+1.840254e+03*s39 \
v100_part1=(-1.236454e+03)*s0+(-6.755864e+02)*s1+(-9.090990e+02)*s2+(-1.049300e+03)*s3+4.422707e+02*s4+(-4.547581e+02)*s5+(-8.199729e+02)*s6+(-4.653879e+02)*s7+4.879101e+02*s8+(-3.456795e+02)*s9 \
v100_part2=v100_part1+(-7.658032e+02)*s10+1.211157e+01*s11+2.343516e+02*s12+(-5.250989e+02)*s13+(-7.250768e+02)*s14+(-1.235326e+02)*s15+3.332964e+02*s16+1.866751e+02*s17+1.300958e+02*s18+(-1.057479e+03)*s19 \
v100_part3=v100_part2+(-2.560979e+01)*s20+(-6.096642e+02)*s21+(-8.215869e+02)*s22+(-9.545854e+02)*s23+5.934888e+01*s24+5.036571e+00*s25+(-6.912442e+02)*s26+8.552316e+01*s27+3.508078e+02*s28+(-6.115460e+02)*s29 \
v100=v100_part3+1.216955e+03*s30+(-9.950754e+02)*s31+4.766536e+02*s32+(-4.478129e+02)*s33+(-1.075016e+03)*s34+(-1.558453e+03)*s35+3.677996e+02*s36+(-6.092993e+02)*s37+(-8.912647e+02)*s38+(-1.062593e+03)*s39 \
v101_part1=7.212988e+02*s0+5.558523e+02*s1+1.073869e+03*s2+(-2.979325e+02)*s3+1.660841e+03*s4+2.293420e+03*s5+1.720813e+03*s6+(-4.273075e+02)*s7+1.537460e+03*s8+2.146740e+03*s9 \
v101_part2=v101_part1+1.867983e+03*s10+1.849847e+02*s11+9.290283e+02*s12+2.943129e+02*s13+1.868054e+03*s14+2.066547e+03*s15+1.940100e+03*s16+3.711926e+02*s17+1.017243e+03*s18+(-2.959041e+02)*s19 \
v101_part3=v101_part2+(-2.831322e+02)*s20+2.265946e+03*s21+1.736159e+03*s22+7.489028e+02*s23+(-2.384574e+01)*s24+7.915203e+02*s25+7.100283e+01*s26+3.394422e+02*s27+1.981246e+03*s28+2.395591e+03*s29 \
v101=v101_part3+4.411194e+02*s30+(-2.377418e+02)*s31+1.732325e+03*s32+2.346105e+03*s33+(-1.078815e+03)*s34+1.465099e+03*s35+2.014944e+03*s36+2.420549e+03*s37+1.116495e+03*s38+(-2.680317e+02)*s39 \
v102_part1=1.057431e+01*s0+1.748778e+00*s1+3.612025e+00*s2+2.558540e+00*s3+1.946738e+00*s4+2.792184e+00*s5+3.770451e+00*s6+1.358941e+01*s7+1.977296e+00*s8+2.457551e+00*s9 \
v102_part2=v102_part1+3.518524e+00*s10+(-6.469907e+00)*s11+2.028742e+00*s12+6.626963e+00*s13+3.318131e+00*s14+3.360408e-01*s15+1.914743e+00*s16+8.083379e-01*s17+1.326172e+00*s18+2.353883e+00*s19 \
v102_part3=v102_part2+1.432839e+00*s20+2.674854e+00*s21+3.716753e+00*s22+3.371443e+00*s23+6.965401e+00*s24+1.528754e+01*s25+(-6.176673e+00)*s26+1.041422e+00*s27+1.840386e+00*s28+3.320808e+00*s29 \
v102=v102_part3+(-3.498923e+00)*s30+2.520218e+00*s31+1.812794e+00*s32+2.675275e+00*s33+6.545315e+00*s34+2.641447e+00*s35+1.778971e+00*s36+3.261884e+00*s37+3.388076e+00*s38+2.462890e+00*s39 \
v103_part1=3.520409e-01*s0+3.522469e+00*s1+1.871932e+00*s2+1.075411e+00*s3+2.302130e+00*s4+3.599910e+00*s5+3.261642e+00*s6+(-3.178162e+00)*s7+2.304558e+00*s8+3.697122e+00*s9 \
v103_part2=v103_part1+4.057561e+00*s10+(-8.929042e+01)*s11+2.163895e+00*s12+(-2.335405e+00)*s13+4.412757e+00*s14+(-4.868134e+00)*s15+2.462723e+00*s16+1.063105e+00*s17+3.737051e+00*s18+1.579752e+00*s19 \
v103_part3=v103_part2+4.203621e+00*s20+3.737169e+00*s21+3.236901e+00*s22+2.441718e+00*s23+3.524939e-01*s24+1.841219e+01*s25+(-1.241802e+01)*s26+(-1.770661e+00)*s27+2.463629e+00*s28+2.892929e+00*s29 \
v103=v103_part3+4.558941e+00*s30+9.771074e-01*s31+2.309364e+00*s32+3.572045e+00*s33+7.792531e+00*s34+(-2.923813e+00)*s35+2.467320e+00*s36+2.886300e+00*s37+2.053244e+00*s38+1.075757e+00*s39 \
v104_part1=(-1.267734e+01)*s0+(-1.912199e-01)*s1+(-8.433757e+00)*s2+(-5.885098e+00)*s3+2.443543e+00*s4+(-2.451030e+00)*s5+(-7.957622e+00)*s6+(-4.368371e+01)*s7+2.476733e+00*s8+(-3.382442e-01)*s9 \
v104_part2=v104_part1+(-6.241197e+00)*s10+(-3.479786e+02)*s11+2.585356e+00*s12+(-1.277093e+01)*s13+(-4.884162e+00)*s14+(-6.966512e-02)*s15+1.921784e+00*s16+(-2.016384e+00)*s17+(-1.999765e+00)*s18+(-5.719537e+00)*s19 \
v104_part3=v104_part2+2.130158e+00*s20+(-2.373878e+00)*s21+(-7.882844e+00)*s22+(-8.006995e+00)*s23+2.889683e+00*s24+2.528442e+00*s25+(-6.846934e+00)*s26+(-4.275760e+00)*s27+1.928608e+00*s28+(-5.922692e+00)*s29 \
v104=v104_part3+(-3.905618e+00)*s30+(-5.869820e+00)*s31+2.419660e+00*s32+(-2.374386e+00)*s33+(-2.255507e+01)*s34+(-8.954816e-01)*s35+1.939207e+00*s36+(-5.848444e+00)*s37+(-8.155962e+00)*s38+(-5.859019e+00)*s39 \
v105_part1=4.160804e-01*s0+4.150419e-01*s1+(-3.274902e-01)*s2+(-2.687427e-01)*s3+(-6.991770e-01)*s4+(-7.604281e-01)*s5+(-5.291294e-01)*s6+9.881240e+00*s7+(-8.070431e-01)*s8+(-9.163304e-01)*s9 \
v105_part2=v105_part1+(-7.058817e-01)*s10+(-2.967894e+02)*s11+(-7.269179e-01)*s12+(-5.066196e-01)*s13+(-8.281044e-01)*s14+(-1.122504e+01)*s15+(-6.480302e-01)*s16+(-4.838221e-02)*s17+3.033464e+00*s18+(-6.125686e-01)*s19 \
v105_part3=v105_part2+(-1.998612e+00)*s20+(-8.603439e-01)*s21+(-5.254050e-01)*s22+(-4.557848e-01)*s23+(-6.522008e+00)*s24+2.055327e+01*s25+(-1.097443e+01)*s26+6.222734e-01*s27+(-6.549268e-01)*s28+(-5.263179e-01)*s29 \
v105=v105_part3+(-1.312866e+00)*s30+(-2.259601e-01)*s31+(-7.144131e-01)*s32+(-7.596770e-01)*s33+(-7.350152e-01)*s34+2.632270e+00*s35+(-6.602015e-01)*s36+(-5.283263e-01)*s37+(-5.098446e-01)*s38+(-2.793861e-01)*s39 \
v106_part1=(-3.093814e+00)*s0+(-6.012250e+00)*s1+(-1.779669e+00)*s2+(-9.683832e-01)*s3+5.309577e-01*s4+(-1.913804e+00)*s5+(-2.712127e+00)*s6+(-2.675273e+01)*s7+1.028753e+00*s8+(-1.017601e+00)*s9 \
v106_part2=v106_part1+(-2.812377e+00)*s10+(-1.423637e+02)*s11+1.235983e+00*s12+9.512682e+00*s13+(-2.537046e+00)*s14+(-5.046232e-02)*s15+(-3.970991e-01)*s16+2.443933e-02*s17+(-1.067621e+01)*s18+(-1.110200e+00)*s19 \
v106_part3=v106_part2+1.169169e-01*s20+(-1.938848e+00)*s21+(-2.693987e+00)*s22+(-2.158517e+00)*s23+(-1.423082e+01)*s24+(-2.531296e+02)*s25+(-6.924583e+00)*s26+(-7.701991e+01)*s27+(-3.904371e-01)*s28+(-2.265687e+00)*s29 \
v106=v106_part3+(-1.318463e+00)*s30+(-8.995285e-01)*s31+5.412944e-01*s32+(-1.896934e+00)*s33+(-1.787315e+01)*s34+(-1.096373e-01)*s35+(-3.883260e-01)*s36+(-2.256326e+00)*s37+(-1.735407e+00)*s38+(-9.453678e-01)*s39 \
v107_part1=(-1.926295e+00)*s0+(-1.419888e-02)*s1+5.724949e+00*s2+4.292258e+00*s3+(-2.631748e+00)*s4+2.850031e-01*s5+5.085495e+00*s6+3.469414e+01*s7+(-2.429662e+00)*s8+(-1.440339e+00)*s9 \
v107_part2=v107_part1+3.580479e+00*s10+(-2.171256e+02)*s11+(-2.357138e+00)*s12+4.578247e+00*s13+2.397551e+00*s14+(-4.127122e-02)*s15+(-2.550781e+00)*s16+(-7.979013e-01)*s17+(-2.485105e+01)*s18+4.233312e+00*s19 \
v107_part3=v107_part2+(-2.146258e+00)*s20+2.671441e-01*s21+5.043249e+00*s22+5.690840e+00*s23+5.957035e+00*s24+4.618254e+01*s25+(-7.112745e+01)*s26+(-8.903791e+01)*s27+(-2.536884e+00)*s28+3.174136e+00*s29 \
v107=v107_part3+(-9.100869e+00)*s30+4.265919e+00*s31+(-2.602065e+00)*s32+2.661152e-01*s33+7.090052e+00*s34+(-2.252399e-01)*s35+(-2.527574e+00)*s36+3.136607e+00*s37+5.552393e+00*s38+4.287768e+00*s39 \
_p0=v0+v1*nf_+v2*lf_+v3*nf_*nf_+v4*nf_*lf_+v5*lf_*lf_ \
_p1=0.5*(_p0+sqrt(_p0*_p0+0.001))*0.8 \
_p2=v6+v7*nf_+v8*lf_+v9*nf_*nf_+v10*nf_*lf_+v11*lf_*lf_ \
_p3=0.5*(_p2+sqrt(_p2*_p2+0.001)) \
_p4=1e-10*_p3 \
_p5=v12+v13*nf_+v14*lf_+v15*nf_*nf_+v16*nf_*lf_+v17*lf_*lf_ \
_p6=0.5*(_p5+sqrt(_p5*_p5+0.001)) \
_p7=d_cs3*1.0*1e-14*_p6*1.1 \
_p8=v18+v19*nf_+v20*lf_+v21*nf_*nf_+v22*nf_*lf_+v23*lf_*lf_ \
_p9=0.5*(_p8+sqrt(_p8*_p8+0.001))*0.8 \
_p10=v24+v25*nf_+v26*lf_+v27*nf_*nf_+v28*nf_*lf_+v29*lf_*lf_ \
_p11=0.5*(_p10+sqrt(_p10*_p10+0.001)) \
_p12=1e-10*_p11 \
_p13=v30+v31*nf_+v32*lf_+v33*nf_*nf_+v34*nf_*lf_+v35*lf_*lf_ \
_p14=0.5*(_p13+sqrt(_p13*_p13+0.001)) \
_p15=d_cs3*1.0*3e-14*_p14*1.1 \
_p16=v36+v37*nf_+v38*lf_+v39*nf_*nf_+v40*nf_*lf_+v41*lf_*lf_ \
_p17=0.5*(_p16+sqrt(_p16*_p16+0.001)) \
_p18=d_cs3*1.0*1e-13*_p17*1.1 \
_p19=v42+v43*nf_+v44*lf_+v45*nf_*nf_+v46*nf_*lf_+v47*lf_*lf_ \
_p20=0.5*(_p19+sqrt(_p19*_p19+0.001)) \
_p21=v48+v49*nf_+v50*lf_+v51*nf_*nf_+v52*nf_*lf_+v53*lf_*lf_ \
_p22=0.5*(_p21+sqrt(_p21*_p21+0.001)) \
_p23=v54+v55*nf_+v56*lf_+v57*nf_*nf_+v58*nf_*lf_+v59*lf_*lf_ \
_p24=0.5*(_p23+sqrt(_p23*_p23+0.001)) \
_p25=v60+v61*nf_+v62*lf_+v63*nf_*nf_+v64*nf_*lf_+v65*lf_*lf_ \
_p26=0.5*(_p25+sqrt(_p25*_p25+0.001)) \
_p27=v66+v67*nf_+v68*lf_+v69*nf_*nf_+v70*nf_*lf_+v71*lf_*lf_ \
_p28=0.5*(_p27+sqrt(_p27*_p27+0.001)) \
_p29=v72+v73*nf_+v74*lf_+v75*nf_*nf_+v76*nf_*lf_+v77*lf_*lf_ \
_p30=0.5*(_p29+sqrt(_p29*_p29+0.001)) \
_p31=1e-14*_p20 \
_p32=100*_p22 \
_p33=1e-15*_p24 \
_p34=1e-14*_p26 \
_p35=100*_p28 \
_p36=1e-15*_p30 \
_p37=v78+v79*nf_+v80*lf_+v81*nf_*nf_+v82*nf_*lf_+v83*lf_*lf_ \
_p38=0.5*(_p37+sqrt(_p37*_p37+0.001)) \
_p39=v84+v85*nf_+v86*lf_+v87*nf_*nf_+v88*nf_*lf_+v89*lf_*lf_ \
_p40=0.5*(_p39+sqrt(_p39*_p39+0.001)) \
_p41=100*_p38 \
_p42=1e-13*_p40 \
_p43=v90+v91*nf_+v92*lf_+v93*nf_*nf_+v94*nf_*lf_+v95*lf_*lf_ \
_p44=0.5*(_p43+sqrt(_p43*_p43+0.001)) \
_p45=1e-14*_p44 \
_p46=v96+v97*nf_+v98*lf_+v99*nf_*nf_+v100*nf_*lf_+v101*lf_*lf_ \
_p47=0.5*(_p46+sqrt(_p46*_p46+0.001)) \
_p48=v102+v103*nf_+v104*lf_+v105*nf_*nf_+v106*nf_*lf_+v107*lf_*lf_ \
_p49=0.5*(_p48+sqrt(_p48*_p48+0.001)) \
_p50=1e-15*_p49 \
nwlength=(3.8e-6+lf*array+0.6e-6*(array-1))*0.9 \
nwwidth=(3e-6+(2*nf-1)*0.2e-6)*0.9 \
nwarea=nwlength*nwwidth \
nwpj=2*(nwlength+nwwidth)
rs (plus _n1) resistor r=_p1
ls (_n1 _n2) inductor l=_p4
cs (_n2 minus) capacitor c=_p7 tc1=-3e-5 tc2=-1e-9
rs1 (_n2 _n11) resistor r=_p9
ls1 (_n11 _n21) inductor l=_p12
cs1 (_n21 minus) capacitor c=_p15 tc1=-3e-5 tc2=-1e-9
csa (plus minus) capacitor c=_p18 tc1=-3e-5 tc2=-1e-9
c_1_sub (plus _n1_1_sub) capacitor c=_p31
rs_1_sub (_n1_1_sub nwell) resistor r=_p32
cs_1_sub (_n1_1_sub nwell) capacitor c=_p33
c_2_sub (minus _n1_2_sub) capacitor c=_p34
rs_2_sub (_n1_2_sub nwell) resistor r=_p35
cs_2_sub (_n1_2_sub nwell) capacitor c=_p36
rx_1_2_sub (_n1_1_sub _n1_2_sub) resistor r=_p41
cx_1_2_sub (_n1_1_sub _n1_2_sub) capacitor c=_p42
rsw (_nsub sub) resistor r=_p47
csw1 (_nsub sub) capacitor c=_p50
dsub (_nsub nwell) nwpsub_dio_vp1 area=nwarea pj=nwpj
model nwpsub_dio_vp1 diode
+ hcomp=1.0000e+00          imax=1.00e+14             level=3
+ area=1.68e-007            perim=0.00469             tnom=25
+ is=2.05e-006              isw=5.34e-011             ik=17856
+ bv=9.662                  ibv=5.952                 ikp=595.2
+ n=1.0525                  rs=3.0891e-007
+ cjo=8.28e-005 + dcj_dionw_l110e_vp3
+ cjp=9.92e-010 + dcjp_dionw_l110e_vp3                    vj=0.588
+ vjsw=0.62                 mj=0.474                  mjsw=0.27
+ tlev=1                    tlevc=1                   trs=0.00322
+ tbv1=-0.000539            xti=5.4936                cta=0.00332
+ ctp=0.001                 eg=1.16                   pta=0.0028
+ ptp=0.001
ends momcaps_array_vp3_rf
