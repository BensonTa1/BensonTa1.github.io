simulator lang=spectre insensitive=yes
library l110ae_l_sy40k_vil_rf_v021_lib
//
section tt
include "l110ae_l_sy40k_vil_rf_v021.mdl.scs"
parameters sy_drs_1p6m0t1u=1
parameters sy_drs_sub_1p6m0t1u=1
parameters sy_dls_1p6m0t1u=1
endsection tt
//
section ff
include "l110ae_l_sy40k_vil_rf_v021.mdl.scs"
parameters sy_drs_1p6m0t1u=1.15
parameters sy_drs_sub_1p6m0t1u=0.85
parameters sy_dls_1p6m0t1u=1.05
endsection ff
//
section ss
include "l110ae_l_sy40k_vil_rf_v021.mdl.scs"
parameters sy_drs_1p6m0t1u=0.85
parameters sy_drs_sub_1p6m0t1u=1.15
parameters sy_dls_1p6m0t1u=0.95
endsection ss
//
endlibrary l110ae_l_sy40k_vil_rf_v021_lib
