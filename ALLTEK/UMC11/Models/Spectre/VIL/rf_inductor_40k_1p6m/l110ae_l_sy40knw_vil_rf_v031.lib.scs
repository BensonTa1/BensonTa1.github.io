simulator lang=spectre insensitive=yes
library l110ae_l_sy40knw_vil_rf_v031_lib
//
section tt
include "l110ae_l_sy40knw_vil_rf_v031.mdl.scs"
parameters synw_drs_1p6m0t1u=1
parameters synw_drs_sub_1p6m0t1u=1
parameters synw_dls_1p6m0t1u=1
endsection tt
//
section ff
include "l110ae_l_sy40knw_vil_rf_v031.mdl.scs"
parameters synw_drs_1p6m0t1u=1.15
parameters synw_drs_sub_1p6m0t1u=0.85
parameters synw_dls_1p6m0t1u=1.05
endsection ff
//
section ss
include "l110ae_l_sy40knw_vil_rf_v031.mdl.scs"
parameters synw_drs_1p6m0t1u=0.85
parameters synw_drs_sub_1p6m0t1u=1.15
parameters synw_dls_1p6m0t1u=0.95
endsection ss
//
endlibrary l110ae_l_sy40knw_vil_rf_v031_lib
