simulator lang=spectre insensitive=yes
// model: l_cr12k_rfvil_1p8m0t1f1u
// planar circular rf inductor, p sub, 1.2um metal8
// umc 110nm 1p8m0t1f1u rfcmos process
// date: 2011-05-13
// model coverage:(before shrinkage)
// od: (75 - 299) * 1e-06
// w: (2.23 - 9.7) * 1e-06
// s: (2.23 - 5) * 1e-06
// nt: 1.5 - 7.5
// frequency range: 100mhz - 0.8 * resonance (maximum 20.0 ghz)
subckt l_cr12k_rfvil_1p8m0t1f1u (outer inner sub)
parameters od=0.00015 od_=od/0.000299 w=6e-06 w_=w/9.99e-06 w_jump_=max(floor((w_-0.04004)/0.0700701), 1) s=2.52e-06 s_=s/5e-06 nt=3.5  \
s0=(nt==1.5) \
s1=(nt==2.5) \
s2=(nt==3.5) \
s3=(nt==4.5) \
s4=(nt==5.5) \
s5=(nt==6.5) \
s6=(nt==7.5) \
v0=(-5.374152e+00)*s0+(-4.531532e+00)*s1+(-2.052884e-01)*s2+9.241554e-01*s3+(-3.033065e+00)*s4+(-4.195430e+00)*s5+1.951328e+00*s6 \
v1=1.156120e+01*s0+1.247179e+01*s1+6.189595e+00*s2+(-4.979842e+00)*s3+1.084363e+01*s4+1.793598e+01*s5+(-2.264469e+00)*s6 \
v2=8.629943e+00*s0+3.848365e+00*s1+(-1.399160e+01)*s2+1.119810e+00*s3+3.070886e+00*s4+1.182247e+01*s5+(-8.255073e+00)*s6 \
v3=(-2.111561e+00)*s0+(-1.032174e+01)*s1+5.869203e+00*s2+1.988216e+00*s3+(-1.181686e+01)*s4+(-4.154561e+01)*s5+1.210565e+01*s6 \
v4=(-4.390029e-01)*s0+4.381106e+00*s1+(-7.619339e+00)*s2+5.189691e-01*s3+1.053230e+00*s4+3.758972e+00*s5+(-7.728045e-01)*s6 \
v5=(-8.900538e+00)*s0+(-1.328380e+01)*s1+7.106122e+00*s2+8.939274e+00*s3+(-1.602379e+01)*s4+(-1.867407e+01)*s5+(-3.373807e-01)*s6 \
v6=9.166880e-01*s0+(-3.021281e+00)*s1+(-1.433393e+01)*s2+(-7.065132e+00)*s3+6.899088e+00*s4+1.051504e+01*s5+(-1.154816e+01)*s6 \
v7=3.156044e+00*s0+7.756836e+01*s1+5.982192e+00*s2+4.219619e-01*s3+(-4.249781e+00)*s4+1.997177e+01*s5+2.786215e+00*s6 \
v8=5.517332e-01*s0+(-1.378182e+02)*s1+(-4.421445e+00)*s2+(-3.258591e+01)*s3+(-1.334018e+01)*s4+(-4.139554e+02)*s5+(-1.001022e+01)*s6 \
v9=(-6.487313e+00)*s0+(-1.736375e+02)*s1+(-7.122322e+00)*s2+(-8.127020e-01)*s3+1.592002e+01*s4+4.517069e+00*s5+(-8.942499e-01)*s6 \
v10=8.799917e-01*s0+6.614856e+01*s1+7.156945e+00*s2+1.822492e+01*s3+(-1.125913e+00)*s4+5.539313e+02*s5+1.563257e+01*s6 \
v11=(-1.110811e+00)*s0+1.829459e+02*s1+(-1.152551e+00)*s2+(-5.563710e-01)*s3+3.185087e+00*s4+1.289722e+02*s5+(-6.118135e+00)*s6 \
v12=2.202934e-01*s0+1.397760e+02*s1+(-1.650559e+00)*s2+(-9.670301e-01)*s3+(-8.421879e+00)*s4+(-7.947344e+01)*s5+(-8.471680e+00)*s6 \
v13=2.511887e+00*s0+3.089644e+01*s1+2.317166e+00*s2+2.168131e+01*s3+1.478699e+01*s4+1.233680e+01*s5+1.505142e+01*s6 \
v14=1.019753e-01*s0+(-8.683430e+00)*s1+6.910948e-01*s2+(-4.299944e-01)*s3+5.507025e-01*s4+8.025501e+00*s5+(-7.711881e-02)*s6 \
v15=5.386132e+01*s0+(-1.149409e+02)*s1+4.570368e+01*s2+(-4.535535e+00)*s3+(-1.093136e+01)*s4+4.733850e+02*s5+1.643130e+01*s6 \
v16=(-9.138914e+01)*s0+6.546952e+01*s1+(-4.153817e+01)*s2+1.628559e+02*s3+3.212044e+01*s4+(-5.743084e+02)*s5+(-2.211095e+01)*s6 \
v17=(-7.620071e-02)*s0+2.637731e+00*s1+1.252002e+00*s2+4.465302e-01*s3+4.552490e+00*s4+(-3.795799e+01)*s5+(-9.180510e+00)*s6 \
v18=4.213316e-01*s0+(-2.697905e+00)*s1+(-4.750186e-01)*s2+1.443754e-01*s3+(-1.704512e+00)*s4+1.527200e+01*s5+(-2.965021e+00)*s6 \
v19=(-3.819062e-03)*s0+(-5.857680e+00)*s1+(-1.068900e+00)*s2+(-1.013157e+00)*s3+(-3.693283e+00)*s4+8.921891e+01*s5+1.101848e+01*s6 \
v20=7.920669e-03*s0+(-3.207114e-02)*s1+1.077183e-01*s2+5.113186e-02*s3+2.971239e-01*s4+4.018730e-01*s5+8.882263e-01*s6 \
v21=(-3.760008e-02)*s0+(-1.648598e-02)*s1+(-4.809364e-02)*s2+(-5.805891e-02)*s3+(-9.746481e-02)*s4+5.784097e-01*s5+(-1.290302e-01)*s6 \
v22=1.241798e-01*s0+(-2.759475e-01)*s1+(-9.498915e-01)*s2+(-1.334731e-01)*s3+(-2.234373e+00)*s4+(-1.258628e+01)*s5+(-6.098419e+00)*s6 \
v23=1.144961e+00*s0+4.780921e+00*s1+4.903284e+00*s2+4.663769e+00*s3+9.869032e+00*s4+2.638259e+01*s5+2.065916e+01*s6 \
v24=(-2.953336e-01)*s0+2.368082e+00*s1+(-8.396679e-02)*s2+(-2.081308e+00)*s3+8.827219e-02*s4+2.423053e+01*s5+(-2.006728e+00)*s6 \
v25=4.726552e-02*s0+(-3.342753e+00)*s1+(-4.400814e-02)*s2+1.764210e+00*s3+4.556329e-01*s4+(-9.304787e+00)*s5+(-6.989994e-01)*s6 \
v26=(-8.449292e-01)*s0+(-1.925632e+01)*s1+(-2.613629e+00)*s2+(-1.341121e+00)*s3+(-6.592702e+00)*s4+(-4.739658e+01)*s5+(-1.422134e+01)*s6 \
v27=8.207339e-02*s0+(-2.434844e+00)*s1+(-3.194118e-02)*s2+1.246889e+00*s3+(-2.063548e-01)*s4+(-1.838718e+01)*s5+3.087297e+00*s6 \
v28=2.324786e-01*s0+2.188072e+01*s1+5.307263e-01*s2+(-5.392493e-01)*s3+1.958500e+00*s4+1.976523e+01*s5+5.469391e+00*s6 \
v29=3.340191e-01*s0+1.673757e+01*s1+6.140856e-01*s2+(-8.807997e-01)*s3+1.350813e+00*s4+3.547233e+01*s5+(-1.245786e-01)*s6 \
v30=(-1.230499e-01)*s0+(-1.482712e+01)*s1+(-2.952196e-02)*s2+5.026357e-01*s3+(-4.752521e-01)*s4+(-1.518631e+01)*s5+(-9.219954e-01)*s6 \
v31=(-3.214816e-02)*s0+1.330016e-03*s1+(-1.754093e-01)*s2+(-2.769965e-01)*s3+(-4.994464e-01)*s4+(-3.904924e-02)*s5+(-1.268967e+00)*s6 \
v32=(-4.336824e-02)*s0+(-4.737437e-01)*s1+(-6.330532e-01)*s2+(-1.009256e+00)*s3+(-2.094249e+00)*s4+(-3.673052e+00)*s5+(-3.400626e+00)*s6 \
v33=3.316674e-02*s0+5.342592e-02*s1+2.950398e-01*s2+4.654796e-01*s3+1.180348e+00*s4+1.772920e+00*s5+2.152255e+00*s6 \
v34=2.209848e+00*s0+6.549724e+00*s1+2.188399e+01*s2+5.737921e+01*s3+1.783060e+01*s4+(-2.117123e+01)*s5+(-3.423764e+00)*s6 \
v35=(-2.008792e+01)*s0+8.417417e+00*s1+(-8.523147e+01)*s2+(-2.754991e+01)*s3+(-8.972320e+01)*s4+(-7.460145e+01)*s5+(-1.200243e+02)*s6 \
v36=(-1.436870e-01)*s0+(-6.319429e+00)*s1+(-3.310526e+01)*s2+(-1.277436e+02)*s3+(-6.237721e+01)*s4+4.719538e+01*s5+1.266425e+01*s6 \
v37=1.341833e+01*s0+(-3.621878e+00)*s1+4.711563e+01*s2+4.992428e+01*s3+1.147680e+02*s4+3.686759e+01*s5+1.034869e+01*s6 \
v38=2.933776e+00*s0+(-1.707141e-01)*s1+3.018328e+01*s2+1.431011e+01*s3+4.734626e+00*s4+5.246304e+00*s5+6.454670e+01*s6 \
v39=4.544528e-01*s0+2.229372e+00*s1+1.974475e+01*s2+7.763891e+01*s3+1.712617e+01*s4+(-2.700197e+01)*s5+1.856426e+01*s6 \
v40=1.147203e+01*s0+2.309132e-01*s1+3.529943e+01*s2+1.141083e+01*s3+3.870202e+01*s4+4.953020e+01*s5+6.411496e+01*s6 \
v41=(-4.625702e-01)*s0+5.260379e-01*s1+(-1.213755e+00)*s2+3.895721e-01*s3+(-1.372335e+00)*s4+(-3.166625e+00)*s5+(-1.299232e+00)*s6 \
v42=(-2.822624e+01)*s0+(-4.589716e+01)*s1+(-5.109889e+01)*s2+(-7.819011e+01)*s3+1.131777e+02*s4+(-7.257854e+00)*s5+(-3.470414e+01)*s6 \
v43=1.435534e+02*s0+2.712956e+02*s1+5.326484e+01*s2+6.697859e+01*s3+(-1.938333e+02)*s4+1.205260e+00*s5+4.395227e+01*s6 \
v44=9.666346e-01*s0+7.848599e-01*s1+(-1.852558e+00)*s2+(-6.381559e-01)*s3+(-1.859218e+01)*s4+(-5.748240e+00)*s5+(-1.382204e+01)*s6 \
v45=(-5.598060e-01)*s0+(-4.861726e-01)*s1+4.112337e-02*s2+1.471385e+00*s3+4.537769e+00*s4+(-1.096631e+00)*s5+3.867328e+01*s6 \
v46=(-8.659246e-01)*s0+(-5.481163e-01)*s1+1.176892e+00*s2+(-2.162010e+00)*s3+1.248565e+01*s4+6.604814e+00*s5+(-1.847491e+01)*s6 \
v47=1.722729e-02*s0+5.496105e-02*s1+2.911985e-02*s2+1.534085e-01*s3+(-6.153010e-01)*s4+5.593409e-01*s5+(-8.644170e-01)*s6 \
v48=3.474170e-03*s0+(-5.758495e-02)*s1+1.404287e-01*s2+(-2.415412e-02)*s3+(-4.231797e-02)*s4+6.333014e-02*s5+2.668400e-01*s6 \
v49=(-8.521686e-02)*s0+(-3.058578e-01)*s1+(-1.066067e+00)*s2+(-1.791747e+00)*s3+2.838535e+00*s4+(-3.164990e+00)*s5+1.883443e+00*s6 \
v50=1.649168e+00*s0+4.522073e+00*s1+4.898425e+00*s2+1.265667e+01*s3+7.487242e+00*s4+1.510855e+01*s5+9.614033e+00*s6 \
v51=(-5.140853e-01)*s0+(-7.556793e-01)*s1+(-8.409000e-01)*s2+(-2.319836e+00)*s3+(-3.418468e+00)*s4+(-9.697562e+00)*s5+(-9.342844e+00)*s6 \
v52=6.528231e-01*s0+8.249603e-01*s1+2.740159e+00*s2+1.750427e+00*s3+5.659492e+00*s4+1.042871e+01*s5+1.523813e+01*s6 \
v53=5.011331e-01*s0+(-1.483275e+00)*s1+2.289394e+00*s2+(-6.115592e+00)*s3+(-1.062252e+01)*s4+5.985031e+00*s5+(-6.392394e+00)*s6 \
v54=3.816204e-01*s0+3.231711e-01*s1+9.349570e-01*s2+2.433912e+00*s3+6.209870e-01*s4+8.104195e+00*s5+9.412143e+00*s6 \
v55=(-1.178828e+00)*s0+(-6.440991e-01)*s1+(-4.178353e+00)*s2+(-1.875246e-01)*s3+6.092384e+00*s4+(-1.446035e+01)*s5+(-1.151589e+00)*s6 \
v56=(-8.725773e-01)*s0+(-1.416382e-01)*s1+(-4.818728e+00)*s2+(-2.004304e+00)*s3+3.962966e+00*s4+(-1.491634e+01)*s5+(-1.007605e+01)*s6 \
v57=1.035835e+00*s0+6.238168e-01*s1+3.445570e+00*s2+4.641240e+00*s3+(-3.057640e+00)*s4+1.183719e+01*s5+8.134738e-01*s6 \
v58=(-2.717505e-02)*s0+(-1.943174e-01)*s1+(-3.150131e-01)*s2+(-7.012497e-01)*s3+(-1.335405e+00)*s4+(-1.942580e+00)*s5+(-2.325234e+00)*s6 \
v59=(-1.302579e-01)*s0+(-4.976882e-01)*s1+(-9.959201e-01)*s2+(-2.598644e+00)*s3+(-3.402539e+00)*s4+(-4.805771e+00)*s5+(-6.869708e+00)*s6 \
v60=3.072500e-02*s0+2.558889e-01*s1+4.944963e-01*s2+1.416876e+00*s3+2.257648e+00*s4+3.359863e+00*s5+5.056687e+00*s6 \
v61=(-1.042985e-01)*s0+(-7.866109e-02)*s1+7.664521e-02*s2+(-7.971387e-02)*s3+1.083441e-01*s4+(-1.705679e+00)*s5+5.849323e-01*s6 \
v62=9.073069e-02*s0+2.538004e-01*s1+7.973401e-01*s2+2.969401e-01*s3+6.629338e-01*s4+(-9.086391e-01)*s5+2.015417e-01*s6 \
v63=1.748985e-01*s0+(-1.118582e+00)*s1+(-9.941053e-01)*s2+(-1.039319e+00)*s3+(-4.389321e+00)*s4+4.957551e+01*s5+(-2.748938e+00)*s6 \
v64=(-1.926139e-01)*s0+1.649689e+00*s1+(-3.017896e+00)*s2+5.568523e-01*s3+3.778995e+00*s4+(-1.157472e+02)*s5+3.399272e+00*s6 \
v65=(-5.324677e-01)*s0+5.033403e+00*s1+1.828755e-02*s2+2.298596e+00*s3+4.818567e+00*s4+(-1.241942e+02)*s5+1.685669e+00*s6 \
v66=2.617349e-03*s0+(-1.149285e+00)*s1+1.225685e+00*s2+(-3.124786e-01)*s3+(-1.399825e+00)*s4+9.125776e+01*s5+(-1.439285e+00)*s6 \
v67=9.886548e-01*s0+(-1.039998e+01)*s1+6.581324e+00*s2+(-1.511942e+00)*s3+(-1.044806e+00)*s4+3.283509e+02*s5+(-1.976144e+00)*s6 \
v68=7.926141e-01*s0+(-4.972533e+00)*s1+6.796270e-01*s2+(-1.149255e+00)*s3+(-1.148277e+00)*s4+9.713036e+01*s5+(-8.156035e-01)*s6 \
v69=(-2.365282e-01)*s0+5.789840e+00*s1+(-1.310896e+00)*s2+7.696860e-01*s3+(-1.027510e+00)*s4+(-2.608026e+02)*s5+3.744283e-01*s6 \
v70=(-1.095148e+00)*s0+9.613809e+00*s1+(-3.105328e+00)*s2+8.007714e-01*s3+(-2.790192e+00)*s4+(-2.626739e+02)*s5+1.420576e+00*s6 \
v71=3.290285e-01*s0+(-5.153004e+00)*s1+(-1.170845e-01)*s2+(-4.291632e-01)*s3+2.581594e+00*s4+2.080142e+02*s5+(-2.408169e-01)*s6 \
v72=(-3.410459e-03)*s0+1.314809e-01*s1+(-3.988505e-01)*s2+(-1.722727e-01)*s3+(-4.235618e-02)*s4+(-3.071067e+00)*s5+(-4.632303e-01)*s6 \
v73=(-3.481411e-02)*s0+(-2.433727e-02)*s1+2.683562e-01*s2+8.420222e-02*s3+2.538020e-01*s4+5.114117e+00*s5+1.314824e-01*s6 \
v74=3.695823e-02*s0+(-1.716858e-01)*s1+4.372880e-01*s2+5.887008e-02*s3+(-2.010366e-01)*s4+(-3.959932e-01)*s5+3.717781e-01*s6 \
v75=(-2.754653e-01)*s0+1.446175e-01*s1+6.908784e-02*s2+(-2.701440e-01)*s3+(-5.040414e-01)*s4+(-1.938357e-01)*s5+(-1.593762e-01)*s6 \
v76=9.493130e-01*s0+2.123163e+00*s1+3.537304e+00*s2+4.109238e+00*s3+3.810180e+00*s4+1.067365e+00*s5+4.084902e+00*s6 \
v77=1.924913e+00*s0+(-1.949857e-01)*s1+(-1.259332e+00)*s2+3.764260e-01*s3+1.559216e+00*s4+2.418830e+00*s5+7.286044e-01*s6 \
v78=3.646100e-01*s0+(-8.821460e-01)*s1+(-2.356058e+00)*s2+(-2.915489e-01)*s3+(-1.494913e+00)*s4+(-8.013683e-01)*s5+(-8.549886e-01)*s6 \
v79=1.116813e+00*s0+5.411447e+00*s1+1.024576e+01*s2+3.566448e+00*s3+6.269926e+00*s4+1.469526e+01*s5+8.253619e+00*s6 \
v80=(-2.658559e+00)*s0+(-7.192956e-01)*s1+(-2.591333e+00)*s2+(-8.866649e-01)*s3+(-2.128691e+00)*s4+(-9.489263e+00)*s5+(-6.102546e+00)*s6 \
v81=3.319092e-01*s0+(-5.034827e-01)*s1+(-4.591762e-01)*s2+(-5.568527e-01)*s3+(-4.151920e-01)*s4+(-6.611786e-01)*s5+(-5.955795e-01)*s6 \
v82=(-4.044385e-01)*s0+7.746847e-01*s1+3.250865e-01*s2+(-2.997821e-01)*s3+2.721129e+00*s4+3.040296e+00*s5+(-1.906863e-01)*s6 \
v83=(-2.247082e-02)*s0+(-8.623467e-01)*s1+(-1.490166e+00)*s2+(-4.640046e-03)*s3+(-2.661493e+00)*s4+(-2.890598e+00)*s5+1.340710e+00*s6 \
v84=2.425644e+01*s0+1.435917e+02*s1+3.419609e+00*s2+3.095157e+00*s3+1.422707e+01*s4+1.658274e+01*s5+1.358944e+01*s6 \
v85=(-5.389890e+00)*s0+(-1.093169e+01)*s1+1.114566e+00*s2+1.374866e+02*s3+(-5.390777e+00)*s4+(-2.211231e+01)*s5+(-2.091682e+01)*s6 \
v86=(-1.177811e+01)*s0+(-5.500161e+02)*s1+7.102787e+00*s2+7.645875e+01*s3+(-6.047400e+00)*s4+(-5.622190e+00)*s5+(-1.706496e+00)*s6 \
v87=(-4.450993e+00)*s0+(-2.550574e+00)*s1+3.644113e+00*s2+(-4.637528e+01)*s3+(-2.263283e+00)*s4+8.279559e+00*s5+1.102681e+01*s6 \
v88=(-9.042082e-02)*s0+4.244309e+01*s1+(-1.311888e+01)*s2+1.136199e-01*s3+5.126977e+00*s4+9.047827e+00*s5+7.929185e-01*s6 \
v89=5.368660e+00*s0+5.846567e+02*s1+4.564447e+00*s2+(-6.589847e+00)*s3+(-7.080408e-01)*s4+(-3.029631e+00)*s5+2.204678e+00*s6 \
v90=(-2.454107e+01)*s0+(-7.487750e+01)*s1+1.120075e+01*s2+2.389227e+01*s3+(-4.410854e-01)*s4+1.135149e+00*s5+2.527110e+00*s6 \
v91=1.134104e+01*s0+(-3.276511e+00)*s1+(-6.105925e+00)*s2+(-1.226350e+02)*s3+2.214448e-01*s4+(-1.465877e+00)*s5+(-3.600213e+00)*s6 \
v92=9.858190e+00*s0+1.573134e+02*s1+(-3.973607e+00)*s2+3.233153e-01*s3+1.105378e+00*s4+(-1.610633e+00)*s5+9.896385e-01*s6 \
v93=(-2.864080e+01)*s0+(-7.019512e+00)*s1+3.071203e+01*s2+3.635431e+00*s3+1.121544e+01*s4+1.269714e+01*s5+1.796151e+01*s6 \
v94=6.251089e+01*s0+8.008146e+00*s1+8.407082e+01*s2+9.950545e+01*s3+6.885955e+01*s4+9.301356e+01*s5+1.109980e+02*s6 \
v95=5.028286e+01*s0+1.168085e+02*s1+(-6.432298e+01)*s2+2.722328e+01*s3+(-2.314333e+01)*s4+(-3.824459e+01)*s5+(-2.078194e+00)*s6 \
v96=5.516708e+00*s0+(-4.198883e-01)*s1+(-4.414584e+01)*s2+(-3.943658e-01)*s3+(-1.706845e+01)*s4+2.074179e+01*s5+(-7.133852e+01)*s6 \
v97=(-7.131112e+01)*s0+(-2.684441e+01)*s1+2.709896e+01*s2+(-7.607227e+00)*s3+(-4.845872e+00)*s4+(-1.471148e+02)*s5+(-1.379447e+01)*s6 \
v98=1.591658e+01*s0+(-7.712589e+01)*s1+1.565845e+01*s2+(-1.676073e+01)*s3+2.118720e+01*s4+1.181838e+02*s5+1.771567e+01*s6 \
v99=1.151958e+01*s0+(-4.894108e+00)*s1+(-4.271189e+01)*s2+(-1.352038e+01)*s3+(-8.321987e+00)*s4+(-3.294080e+01)*s5+(-4.933337e+01)*s6 \
v100=5.340316e+00*s0+1.920737e+01*s1+1.197204e+01*s2+4.377656e+00*s3+6.943349e+00*s4+2.621362e+01*s5+(-4.943771e-01)*s6 \
v101=(-5.279402e+00)*s0+(-2.515175e+01)*s1+1.990018e+01*s2+1.384014e+01*s3+(-6.741369e+00)*s4+5.221022e+01*s5+9.887631e+01*s6 \
v102=(-3.136672e-01)*s0+(-4.826813e-01)*s1+(-2.490734e-01)*s2+(-7.037345e-01)*s3+(-5.227181e-01)*s4+(-3.226191e-01)*s5+(-5.364036e-01)*s6 \
v103=1.002915e+00*s0+2.615928e+00*s1+3.826555e+00*s2+4.217637e+00*s3+2.650023e+00*s4+(-4.876911e-01)*s5+3.362422e+00*s6 \
v104=1.156592e+00*s0+1.055341e+00*s1+(-1.204300e+00)*s2+9.976189e-01*s3+1.036635e+00*s4+2.470071e+00*s5+4.113159e-01*s6 \
v105=(-5.071537e-03)*s0+(-9.980839e-01)*s1+(-2.463368e+00)*s2+(-5.207895e-01)*s3+(-7.931382e-01)*s4+2.513131e-01*s5+(-2.290077e-01)*s6 \
v106=3.875490e-01*s0+4.386039e+00*s1+9.452877e+00*s2+4.000348e+00*s3+6.595822e+00*s4+1.486470e+01*s5+8.494555e+00*s6 \
v107=(-1.251036e+00)*s0+(-1.158352e+00)*s1+(-2.115566e+00)*s2+(-2.035931e+00)*s3+(-1.679715e+00)*s4+(-9.743599e+00)*s5+(-6.217244e+00)*s6 \
v108=1.074198e-01*s0+(-6.013870e-01)*s1+(-8.723891e-01)*s2+(-8.588638e-01)*s3+(-9.759456e-01)*s4+(-1.516010e+00)*s5+(-1.537230e+00)*s6 \
v109=1.297782e-02*s0+7.190406e-01*s1+(-1.241499e-01)*s2+(-6.320444e-01)*s3+2.133804e+00*s4+3.914537e+00*s5+1.476115e+00*s6 \
v110=(-3.498449e-02)*s0+(-7.736837e-01)*s1+(-3.094914e-01)*s2+1.780077e-01*s3+(-1.139332e+00)*s4+(-2.673328e+00)*s5+6.578251e-01*s6 \
v111=1.377266e+01*s0+1.892752e+01*s1+2.528515e+00*s2+2.211219e+03*s3+2.893914e+01*s4+1.699888e+01*s5+8.499253e+03*s6 \
v112=(-4.118323e+01)*s0+(-2.076814e+01)*s1+(-1.752249e+00)*s2+(-2.338630e+03)*s3+(-4.839333e+01)*s4+(-3.036929e+01)*s5+(-6.526196e+03)*s6 \
v113=(-2.394694e+00)*s0+(-2.869818e+00)*s1+(-1.994026e+00)*s2+2.915291e+02*s3+2.783074e+00*s4+2.240616e+01*s5+8.229609e+03*s6 \
v114=(-6.773497e+00)*s0+5.533654e+00*s1+2.055497e+01*s2+(-2.073113e+01)*s3+2.788554e+01*s4+2.510450e+01*s5+(-9.527884e+01)*s6 \
v115=5.155994e+01*s0+7.873382e+00*s1+3.749245e-01*s2+7.360966e+00*s3+(-8.241116e+00)*s4+(-3.459586e+01)*s5+(-1.080857e+03)*s6 \
v116=(-5.696670e+00)*s0+(-3.344650e+00)*s1+1.778888e+01*s2+7.859505e+03*s3+4.200995e+00*s4+8.592019e+00*s5+(-1.642474e+03)*s6 \
v117=3.723301e+00*s0+8.599442e-01*s1+4.263692e+01*s2+(-1.335164e+02)*s3+(-2.323776e-02)*s4+2.485746e+00*s5+(-5.431213e+03)*s6 \
v118=1.802044e+01*s0+(-5.838873e+00)*s1+(-6.112837e+01)*s2+(-1.217240e+02)*s3+1.693295e+00*s4+3.610105e+00*s5+(-6.745891e+02)*s6 \
v119=(-2.453949e+01)*s0+5.707911e+00*s1+6.088408e+00*s2+(-2.362485e+02)*s3+(-2.253820e+00)*s4+(-9.139048e+00)*s5+1.334572e+03*s6 \
v120=1.133707e+02*s0+6.935908e+00*s1+2.911807e+01*s2+7.715593e+00*s3+1.138808e+01*s4+(-1.457886e+00)*s5+(-5.543298e+00)*s6 \
v121=1.889427e+02*s0+(-3.643760e+01)*s1+(-4.041446e+01)*s2+(-1.124734e+01)*s3+5.783252e+00*s4+2.506315e+01*s5+1.557977e+00*s6 \
v122=(-3.157378e+02)*s0+6.247039e+01*s1+1.539008e+01*s2+(-8.787737e+00)*s3+1.254970e+01*s4+1.160516e+01*s5+(-7.117187e+00)*s6 \
v123=3.014671e+01*s0+8.280723e+00*s1+4.240469e+01*s2+4.614919e+00*s3+3.958147e+01*s4+(-8.870329e+01)*s5+(-2.166179e+01)*s6 \
v124=(-2.403230e+02)*s0+4.621077e+01*s1+5.252139e+01*s2+7.718414e+00*s3+(-2.531611e+00)*s4+2.161441e+02*s5+5.662463e+01*s6 \
v125=2.302424e+02*s0+(-5.636458e+01)*s1+(-4.968413e+01)*s2+3.363096e+00*s3+(-1.264153e+01)*s4+(-1.358622e+02)*s5+(-2.005859e+01)*s6 \
v126=8.250614e+00*s0+5.933867e-01*s1+(-1.693446e+01)*s2+9.311992e+00*s3+3.034501e+00*s4+(-3.875225e+01)*s5+(-5.232137e+00)*s6 \
v127=(-7.414094e+00)*s0+(-1.311596e+00)*s1+(-2.154931e+01)*s2+(-1.122170e+01)*s3+(-6.526068e+00)*s4+4.369078e+01*s5+7.946523e+00*s6 \
v128=3.776628e+00*s0+(-8.562381e+00)*s1+(-3.059202e+00)*s2+(-4.349265e+00)*s3+9.355516e+00*s4+1.277067e+01*s5+(-2.138155e+00)*s6 \
v129=(-1.106418e-01)*s0+(-2.789386e-01)*s1+(-5.765492e-01)*s2+1.110289e-01*s3+(-2.219922e-01)*s4+(-5.821154e-01)*s5+(-9.961109e-02)*s6 \
v130=2.261919e+00*s0+3.705893e+00*s1+3.613403e-01*s2+1.121485e+00*s3+5.043945e+00*s4+1.143943e+01*s5+5.282123e+00*s6 \
v131=2.443638e-01*s0+(-1.738753e+00)*s1+(-1.039789e+00)*s2+(-2.410059e+00)*s3+(-4.747692e+00)*s4+(-7.984930e+00)*s5+(-7.527467e+00)*s6 \
v132=(-6.946627e-02)*s0+3.299680e-01*s1+4.840736e+00*s2+1.057517e+00*s3+(-1.158637e-01)*s4+(-1.083786e+00)*s5+(-5.606284e-01)*s6 \
v133=8.194762e+00*s0+(-1.892246e-01)*s1+(-3.960187e+00)*s2+7.413942e+00*s3+9.605341e+00*s4+(-5.129764e+00)*s5+1.250196e+01*s6 \
v134=(-1.055713e+00)*s0+7.663134e-01*s1+4.967548e+00*s2+1.857293e-01*s3+(-1.003254e+00)*s4+1.396588e+01*s5+5.654540e+00*s6 \
v135=(-1.651795e-01)*s0+1.402835e+00*s1+2.632528e+00*s2+3.848830e-01*s3+(-2.486860e-01)*s4+(-9.281094e-01)*s5+(-1.050789e+00)*s6 \
v136=7.220485e-01*s0+(-1.776398e+00)*s1+1.573931e+00*s2+5.246960e+00*s3+3.067917e+00*s4+4.121511e+00*s5+1.258876e+01*s6 \
v137=(-1.107849e+00)*s0+1.161560e+00*s1+9.511132e-01*s2+(-2.542597e+00)*s3+3.087980e-01*s4+1.582493e+00*s5+(-9.513041e+00)*s6 \
v138=2.716282e+01*s0+1.592864e+01*s1+3.444593e+01*s2+7.332448e+00*s3+1.752142e+01*s4+4.022722e+02*s5+3.894619e+01*s6 \
v139=(-1.967946e+01)*s0+(-9.266143e+00)*s1+(-5.725537e+01)*s2+(-7.849712e+00)*s3+(-2.097546e+00)*s4+1.263400e+01*s5+(-3.628999e+01)*s6 \
v140=(-1.235973e+01)*s0+(-1.587216e+01)*s1+9.868446e-01*s2+(-5.663995e-01)*s3+4.057732e+01*s4+(-5.603256e+02)*s5+(-2.325713e+01)*s6 \
v141=6.771941e-01*s0+2.846002e+00*s1+2.609131e+01*s2+3.480851e+00*s3+(-1.107901e+01)*s4+(-4.020153e+02)*s5+5.658080e+00*s6 \
v142=2.637156e+01*s0+1.431478e+00*s1+2.895504e+00*s2+(-1.026373e+00)*s3+(-2.542676e+01)*s4+5.876531e+02*s5+1.755165e+01*s6 \
v143=(-1.174361e+01)*s0+9.078104e+00*s1+(-2.208488e+00)*s2+9.715310e-01*s3+(-5.579429e+00)*s4+(-2.245815e+01)*s5+2.300784e+00*s6 \
v144=1.050648e+01*s0+(-4.603501e+00)*s1+(-3.904790e+00)*s2+(-8.634444e-01)*s3+4.968554e+00*s4+(-1.964247e+02)*s5+(-3.722765e+00)*s6 \
v145=(-1.002271e+00)*s0+1.117371e+00*s1+4.295756e+00*s2+8.046778e-01*s3+(-2.211881e+00)*s4+2.076635e+02*s5+6.805762e+00*s6 \
v146=(-5.603442e+00)*s0+2.668708e+00*s1+(-8.277930e-01)*s2+7.867972e-02*s3+(-6.223772e+00)*s4+(-1.246694e+01)*s5+(-2.478333e+00)*s6 \
v147=2.936383e+01*s0+3.001549e+01*s1+(-7.907030e+00)*s2+8.054882e+00*s3+(-1.455401e+02)*s4+1.108973e+01*s5+(-1.605963e+01)*s6 \
v148=(-7.668634e-01)*s0+1.371611e+02*s1+1.781371e+01*s2+2.739884e+00*s3+(-7.889772e+01)*s4+1.219225e+01*s5+2.992127e+01*s6 \
v149=(-7.974254e+00)*s0+(-2.147178e+02)*s1+3.568985e+00*s2+(-1.590864e+01)*s3+2.501741e+02*s4+(-3.223597e+01)*s5+(-1.665418e+00)*s6 \
v150=(-3.699258e+00)*s0+6.735585e-01*s1+(-4.272794e+00)*s2+(-3.506708e+00)*s3+(-1.085989e+02)*s4+5.845897e+01*s5+4.602086e+01*s6 \
v151=3.532178e+01*s0+(-5.378901e+01)*s1+(-3.624376e+01)*s2+5.183016e+00*s3+(-3.560667e+00)*s4+(-1.029483e+02)*s5+(-1.901713e+00)*s6 \
v152=(-9.488162e+00)*s0+1.674554e+02*s1+3.461333e+01*s2+2.501753e+00*s3+(-1.860972e+01)*s4+8.697929e+01*s5+5.523572e-02*s6 \
v153=1.594318e-02*s0+1.272915e+01*s1+2.009786e+01*s2+4.816483e+00*s3+8.624633e+01*s4+3.570533e+01*s5+3.109074e+01*s6 \
v154=5.425121e+00*s0+(-6.970359e+00)*s1+4.226382e+01*s2+(-3.857232e-01)*s3+(-2.281739e+00)*s4+(-4.077094e+01)*s5+1.137265e+00*s6 \
v155=(-9.525221e+00)*s0+1.678428e+01*s1+(-4.836126e+00)*s2+(-4.799148e+00)*s3+(-1.272010e+01)*s4+(-2.276992e+01)*s5+(-6.075580e+01)*s6 \
v156=1.559283e+02*s0+(-1.558827e+00)*s1+(-1.861176e+01)*s2+4.048060e+00*s3+7.473563e+01*s4+(-5.985860e+01)*s5+4.575926e+00*s6 \
v157=2.287202e+02*s0+3.044507e+00*s1+4.119845e+00*s2+(-5.572462e+00)*s3+(-8.727456e+01)*s4+2.700969e+02*s5+(-1.613185e+01)*s6 \
v158=(-4.125507e+02)*s0+(-7.472985e+00)*s1+(-1.638488e+00)*s2+2.954428e-01*s3+(-4.727079e+01)*s4+(-3.679993e+02)*s5+2.046499e+01*s6 \
v159=(-1.154816e+01)*s0+(-3.171324e+00)*s1+2.649562e+00*s2+5.520519e-01*s3+1.568429e+01*s4+(-1.920398e+02)*s5+1.125802e+01*s6 \
v160=(-1.876142e+02)*s0+7.900868e+00*s1+(-5.763647e+00)*s2+5.428570e+00*s3+5.378791e+01*s4+4.310958e+01*s5+(-1.380479e+01)*s6 \
v161=2.419726e+02*s0+1.550708e+01*s1+1.654444e+02*s2+(-3.073857e+00)*s3+(-2.897249e+00)*s4+8.998582e+02*s5+(-4.308485e-01)*s6 \
v162=(-3.677655e+01)*s0+1.499225e-01*s1+3.097362e+01*s2+3.669733e-01*s3+3.453789e+00*s4+(-6.709643e+03)*s5+2.259650e+01*s6 \
v163=(-7.689428e+00)*s0+1.289025e+00*s1+(-8.260754e+00)*s2+1.491954e+00*s3+(-1.541958e+01)*s4+1.000000e+04*s5+(-1.631280e+01)*s6 \
v164=4.469191e+01*s0+(-2.705148e+00)*s1+(-8.098258e+01)*s2+(-3.712071e-01)*s3+2.474556e+01*s4+7.874575e+03*s5+(-7.625688e+00)*s6 \
v165=2.827768e-01*s0+4.713123e+00*s1+(-4.454148e-01)*s2+4.216025e+00*s3+1.944552e-01*s4+2.105047e-01*s5+(-1.309723e+00)*s6 \
v166=1.104764e-01*s0+(-1.293963e+00)*s1+2.916798e+00*s2+(-7.287301e-01)*s3+1.295407e+00*s4+1.130693e+00*s5+3.073801e+00*s6 \
v167=(-9.175170e-01)*s0+(-7.669148e+00)*s1+(-1.034990e+00)*s2+(-1.021513e+01)*s3+(-1.282524e+00)*s4+(-1.347170e+00)*s5+2.597201e+00*s6 \
v168=(-3.157176e-01)*s0+(-3.615326e-01)*s1+(-5.730059e-01)*s2+(-1.229432e+00)*s3+(-4.281646e-01)*s4+1.419590e+00*s5+2.782139e-01*s6 \
v169=1.294815e+00*s0+2.480628e+00*s1+(-1.672903e+00)*s2+3.107275e+00*s3+(-1.741009e-01)*s4+(-4.392225e+00)*s5+(-5.022020e+00)*s6 \
v170=(-1.315690e+00)*s0+1.861335e+00*s1+1.086702e+00*s2+5.015410e+00*s3+8.441650e-01*s4+3.378604e+00*s5+6.584578e-01*s6 \
v171=(-7.159221e-01)*s0+(-6.975052e-01)*s1+1.234254e-01*s2+(-1.368441e+00)*s3+2.356527e-01*s4+(-8.418074e-02)*s5+(-5.690935e-01)*s6 \
v172=5.240006e-01*s0+(-3.974425e-01)*s1+(-4.293008e-01)*s2+2.012340e-01*s3+(-1.165664e-01)*s4+3.664193e-01*s5+(-5.250365e-01)*s6 \
v173=4.396719e-01*s0+1.276346e+00*s1+(-7.195142e-02)*s2+1.321077e+00*s3+(-5.100901e-01)*s4+(-5.382095e-01)*s5+1.549755e+00*s6 \
v174=7.962604e+00*s0+3.974460e+00*s1+1.239816e+00*s2+(-3.423250e+01)*s3+4.676006e-01*s4+2.055979e+01*s5+2.744725e+00*s6 \
v175=(-2.595647e+00)*s0+4.674911e+00*s1+(-1.370931e+01)*s2+3.235548e+01*s3+(-5.110742e+00)*s4+(-4.064954e+01)*s5+1.486128e+01*s6 \
v176=1.330474e+01*s0+(-1.331655e+01)*s1+8.679963e+00*s2+1.699813e+01*s3+(-3.398289e+00)*s4+2.378395e-01*s5+(-4.242373e+01)*s6 \
v177=(-3.598302e+00)*s0+3.474535e-01*s1+1.117562e+01*s2+5.631331e+01*s3+4.992232e+00*s4+2.011917e+01*s5+4.586210e+00*s6 \
v178=8.832385e+00*s0+(-5.790714e+00)*s1+(-1.106323e+01)*s2+1.310519e+01*s3+(-1.457846e+01)*s4+3.916746e+00*s5+(-2.294296e+01)*s6 \
v179=(-2.486446e+01)*s0+1.024504e+01*s1+2.786996e+01*s2+2.715886e+02*s3+8.514705e+01*s4+2.826971e-02*s5+7.028004e+01*s6 \
v180=(-5.132344e+00)*s0+9.050232e-02*s1+(-1.082757e+01)*s2+2.316302e+02*s3+(-3.089020e+00)*s4+(-6.966807e+00)*s5+(-1.739355e+00)*s6 \
v181=2.295979e+00*s0+1.567834e-02*s1+5.799339e+00*s2+1.195422e+02*s3+7.106580e+00*s4+4.808978e+00*s5+7.900237e+00*s6 \
v182=2.622780e+00*s0+(-1.570104e-01)*s1+1.670187e+01*s2+1.166765e+02*s3+(-7.735690e+00)*s4+1.029893e+01*s5+(-4.205072e+00)*s6 \
v183=1.216830e+00*s0+7.237514e-01*s1+1.584555e+00*s2+(-5.269341e-02)*s3+5.613242e+00*s4+(-2.794962e-01)*s5+6.169772e+00*s6 \
v184=1.548475e+00*s0+4.941354e+00*s1+(-8.516936e-01)*s2+2.106710e+01*s3+(-2.965258e+00)*s4+(-8.210587e-01)*s5+(-1.380799e+01)*s6 \
v185=(-6.576127e+00)*s0+(-1.410140e+01)*s1+(-2.751265e+00)*s2+(-5.617132e-01)*s3+(-8.837450e+00)*s4+2.665765e+00*s5+(-1.805865e+00)*s6 \
v186=(-6.052803e-01)*s0+(-5.429271e+00)*s1+(-2.655097e-01)*s2+1.107868e+01*s3+5.548245e+00*s4+(-1.396987e+00)*s5+7.148470e+00*s6 \
v187=(-1.798205e+00)*s0+1.021933e+01*s1+1.459008e+00*s2+4.580875e+00*s3+(-1.185622e+01)*s4+(-3.679809e-01)*s5+3.206438e+00*s6 \
v188=7.455542e+00*s0+8.830004e+00*s1+8.781317e-01*s2+2.314671e+02*s3+(-2.923074e+00)*s4+(-1.080912e+00)*s5+(-1.116553e+00)*s6 \
v189=8.836759e-03*s0+(-3.821860e+00)*s1+(-2.279249e-01)*s2+6.154823e+00*s3+6.467698e+00*s4+2.083675e-01*s5+(-4.782189e-01)*s6 \
v190=(-2.668505e-01)*s0+3.450888e+00*s1+4.843745e-02*s2+(-6.723280e+01)*s3+(-9.218417e-01)*s4+1.977747e+00*s5+(-5.378092e-01)*s6 \
v191=4.403339e-01*s0+2.182016e+00*s1+1.663144e-01*s2+(-6.033565e+00)*s3+(-1.965997e+01)*s4+(-7.246343e-01)*s5+1.644402e+00*s6 \
v192=3.481002e+01*s0+9.999717e+03*s1+1.256313e+01*s2+1.532095e+00*s3+(-1.606529e+01)*s4+2.727147e+01*s5+6.053907e+01*s6 \
v193=(-9.580686e+01)*s0+1.759039e+03*s1+1.030785e+01*s2+9.310279e+00*s3+(-7.648721e+00)*s4+(-2.999884e+01)*s5+7.073718e+01*s6 \
v194=8.582390e+01*s0+9.998861e+03*s1+3.964812e+00*s2+6.764490e+00*s3+(-1.223260e+01)*s4+(-5.928759e+01)*s5+(-1.991406e+02)*s6 \
v195=5.371141e+01*s0+(-1.000000e+04)*s1+(-3.241905e+00)*s2+4.306487e-01*s3+1.084276e+00*s4+2.544360e+01*s5+(-3.484886e+01)*s6 \
v196=(-7.757108e+00)*s0+(-1.000000e+04)*s1+(-6.172541e+01)*s2+(-3.016559e+00)*s3+(-3.131166e+00)*s4+(-4.489651e+01)*s5+(-6.435440e+00)*s6 \
v197=(-5.619955e+01)*s0+1.000000e+04*s1+9.712065e+00*s2+3.032558e+00*s3+(-2.217626e+01)*s4+1.285085e+02*s5+1.020369e+02*s6 \
v198=(-7.723359e+00)*s0+2.630051e+03*s1+8.059881e+01*s2+(-1.014735e+01)*s3+1.483754e+01*s4+(-2.310690e+01)*s5+(-3.414213e+01)*s6 \
v199=8.115692e+00*s0+1.000000e+04*s1+(-7.519023e+01)*s2+(-7.594013e+00)*s3+7.261458e+00*s4+1.698478e+01*s5+(-5.315941e+01)*s6 \
v200=(-1.033778e+01)*s0+1.000000e+04*s1+(-3.251696e+01)*s2+3.258010e+00*s3+2.402950e+01*s4+2.986114e+01*s5+1.251764e+02*s6 \
v201=(-1.000000e+04)*s0+(-2.993615e+00)*s1+(-6.430351e+00)*s2+(-7.008092e-01)*s3+(-9.875723e+01)*s4+(-1.725867e+00)*s5+3.267311e+01*s6 \
v202=(-1.000000e+04)*s0+3.820984e+00*s1+7.095510e+00*s2+3.668295e+00*s3+(-3.519602e+02)*s4+1.886621e+00*s5+5.685421e+00*s6 \
v203=(-1.000000e+04)*s0+2.972775e+00*s1+1.160014e+01*s2+4.058380e-01*s3+(-3.488750e+02)*s4+3.885954e+00*s5+(-6.664451e+01)*s6 \
v204=(-1.000000e+04)*s0+5.068455e-02*s1+2.428886e+00*s2+(-6.119391e-01)*s3+(-1.280669e+03)*s4+(-1.820151e+00)*s5+(-3.553914e+01)*s6 \
v205=(-1.000000e+04)*s0+(-3.654410e+00)*s1+(-2.405878e+00)*s2+(-2.243524e+00)*s3+(-2.803670e+02)*s4+3.184689e+00*s5+(-1.284030e+01)*s6 \
v206=(-1.000000e+04)*s0+6.652677e-01*s1+(-3.730100e+00)*s2+5.751599e-01*s3+(-2.482405e+03)*s4+(-5.275950e+00)*s5+(-2.767326e+01)*s6 \
v207=(-3.522553e+03)*s0+1.119290e-01*s1+(-2.628546e+01)*s2+1.231949e-01*s3+(-3.109490e+00)*s4+8.605198e-01*s5+(-2.596038e+01)*s6 \
v208=(-4.915020e+02)*s0+1.025280e+00*s1+(-1.398767e+01)*s2+(-1.303047e+00)*s3+(-2.905510e+00)*s4+(-3.370075e+00)*s5+3.173008e+01*s6 \
v209=(-8.134888e+02)*s0+(-1.081231e+00)*s1+7.587018e+01*s2+2.065835e-01*s3+(-1.316478e+01)*s4+1.241207e+00*s5+3.986247e+01*s6 \
_p0=v0+v1*od_+v2*w_+v3*od_*w_ \
_p1=_p0+v4*(s_-0.446)+v5*(s_-0.446)*od_+v6*(s_-0.446)*w_ \
_p2=0.5*(_p1+sqrt(_p1*_p1+0.001)) \
_p3=1e-15*_p2 \
_p4=v7+v8*od_+v9*w_+v10*od_*w_+v11*od_*od_+v12*w_*w_+v13*od_/w_+v14*od_*od_/w_/w_+v15/w_jump_+v16/(w_jump_*w_jump_) \
_p5=_p4+v17*(s_-0.446)+v18*(s_-0.446)*od_+v19*(s_-0.446)*w_ \
_p6=slcr_drs_1p8m0t1f1u*0.5*(_p5+sqrt(_p5*_p5+0.001)) \
_p7=v20/od_+v21/w_+v22+v23*od_+v24*w_+v25*od_*od_+v26*od_*w_+v27*w_*w_+v28*od_*od_*w_+v29*od_*w_*w_+v30*od_*od_*w_*w_ \
_p8=_p7+v31*(s_-0.446)+v32*(s_-0.446)*od_+v33*(s_-0.446)*w_ \
_p9=0.5*(_p8+sqrt(_p8*_p8+0.001)) \
_p10=slcr_dls_1p8m0t1f1u*1e-09*_p9 \
_p11=slcr_dls_1p8m0t1f1u*1e-09*_p9 \
_p12=v34+v35*od_+v36*w_+v37*od_*w_+v38*od_*od_+v39*w_*w_+v40*od_/w_+v41*od_*od_/w_/w_+v42/w_jump_+v43/(w_jump_*w_jump_) \
_p13=_p12+v44*(s_-0.446)+v45*(s_-0.446)*od_+v46*(s_-0.446)*w_ \
_p14=slcr_drs_1p8m0t1f1u*0.5*(_p13+sqrt(_p13*_p13+0.001)) \
_p15=v47/od_+v48/w_+v49+v50*od_+v51*w_+v52*od_*od_+v53*od_*w_+v54*w_*w_+v55*od_*od_*w_+v56*od_*w_*w_+v57*od_*od_*w_*w_ \
_p16=_p15+v58*(s_-0.446)+v59*(s_-0.446)*od_+v60*(s_-0.446)*w_ \
_p17=0.5*(_p16+sqrt(_p16*_p16+0.001)) \
_p18=slcr_dls_1p8m0t1f1u*1e-09*_p17 \
_p19=v61/od_+v62/w_+v63+v64*od_+v65*w_+v66*od_*od_+v67*od_*w_+v68*w_*w_+v69*od_*od_*w_+v70*od_*w_*w_+v71*od_*od_*w_*w_ \
_p20=_p19+v72*(s_-0.446)+v73*(s_-0.446)*od_+v74*(s_-0.446)*w_ \
_p21=0.5*(atan(2*_p20)/1.5708+1) \
_p22=v75+v76*od_+v77*w_+v78*od_*od_+v79*od_*w_+v80*w_*w_ \
_p23=_p22+v81*(s_-0.446)+v82*(s_-0.446)*od_+v83*(s_-0.446)*w_ \
_p24=0.5*(_p23+sqrt(_p23*_p23+0.001)) \
_p25=v84+v85*od_+v86*w_+v87*od_*od_+v88*od_*w_+v89*w_*w_ \
_p26=_p25+v90*(s_-0.446)+v91*(s_-0.446)*od_+v92*(s_-0.446)*w_ \
_p27=0.5*(_p26+sqrt(_p26*_p26+0.001)) \
_p28=v93+v94*od_+v95*w_+v96*od_*od_+v97*od_*w_+v98*w_*w_ \
_p29=_p28+v99*(s_-0.446)+v100*(s_-0.446)*od_+v101*(s_-0.446)*w_ \
_p30=0.5*(_p29+sqrt(_p29*_p29+0.001)) \
_p31=v102+v103*od_+v104*w_+v105*od_*od_+v106*od_*w_+v107*w_*w_ \
_p32=_p31+v108*(s_-0.446)+v109*(s_-0.446)*od_+v110*(s_-0.446)*w_ \
_p33=0.5*(_p32+sqrt(_p32*_p32+0.001)) \
_p34=v111+v112*od_+v113*w_+v114*od_*od_+v115*od_*w_+v116*w_*w_ \
_p35=_p34+v117*(s_-0.446)+v118*(s_-0.446)*od_+v119*(s_-0.446)*w_ \
_p36=0.5*(_p35+sqrt(_p35*_p35+0.001)) \
_p37=v120+v121*od_+v122*w_+v123*od_*od_+v124*od_*w_+v125*w_*w_ \
_p38=_p37+v126*(s_-0.446)+v127*(s_-0.446)*od_+v128*(s_-0.446)*w_ \
_p39=0.5*(_p38+sqrt(_p38*_p38+0.001)) \
_p40=v129+v130*od_+v131*w_+v132*od_*od_+v133*od_*w_+v134*w_*w_ \
_p41=_p40+v135*(s_-0.446)+v136*(s_-0.446)*od_+v137*(s_-0.446)*w_ \
_p42=0.5*(_p41+sqrt(_p41*_p41+0.001)) \
_p43=v138+v139*od_+v140*w_+v141*od_*od_+v142*od_*w_+v143*w_*w_ \
_p44=_p43+v144*(s_-0.446)+v145*(s_-0.446)*od_+v146*(s_-0.446)*w_ \
_p45=0.5*(_p44+sqrt(_p44*_p44+0.001)) \
_p46=v147+v148*od_+v149*w_+v150*od_*od_+v151*od_*w_+v152*w_*w_ \
_p47=_p46+v153*(s_-0.446)+v154*(s_-0.446)*od_+v155*(s_-0.446)*w_ \
_p48=0.5*(_p47+sqrt(_p47*_p47+0.001)) \
_p49=1e-14*_p24 \
_p50=slcr_drs_sub_1p8m0t1f1u*100*_p27 \
_p51=1e-15*_p30 \
_p52=1e-14*_p33 \
_p53=slcr_drs_sub_1p8m0t1f1u*100*_p36 \
_p54=1e-15*_p39 \
_p55=1e-14*_p42 \
_p56=slcr_drs_sub_1p8m0t1f1u*100*_p45 \
_p57=1e-15*_p48 \
_p58=v156+v157*od_+v158*w_+v159*od_*od_+v160*od_*w_+v161*w_*w_ \
_p59=_p58+v162*(s_-0.446)+v163*(s_-0.446)*od_+v164*(s_-0.446)*w_ \
_p60=0.5*(_p59+sqrt(_p59*_p59+0.001)) \
_p61=v165+v166*od_+v167*w_+v168*od_*od_+v169*od_*w_+v170*w_*w_ \
_p62=_p61+v171*(s_-0.446)+v172*(s_-0.446)*od_+v173*(s_-0.446)*w_ \
_p63=0.5*(_p62+sqrt(_p62*_p62+0.001)) \
_p64=slcr_drs_sub_1p8m0t1f1u*100*_p60 \
_p65=1e-13*_p63 \
_p66=v174+v175*od_+v176*w_+v177*od_*od_+v178*od_*w_+v179*w_*w_ \
_p67=_p66+v180*(s_-0.446)+v181*(s_-0.446)*od_+v182*(s_-0.446)*w_ \
_p68=0.5*(_p67+sqrt(_p67*_p67+0.001)) \
_p69=v183+v184*od_+v185*w_+v186*od_*od_+v187*od_*w_+v188*w_*w_ \
_p70=_p69+v189*(s_-0.446)+v190*(s_-0.446)*od_+v191*(s_-0.446)*w_ \
_p71=0.5*(_p70+sqrt(_p70*_p70+0.001)) \
_p72=slcr_drs_sub_1p8m0t1f1u*100*_p68 \
_p73=1e-13*_p71 \
_p74=v192+v193*od_+v194*w_+v195*od_*od_+v196*od_*w_+v197*w_*w_ \
_p75=_p74+v198*(s_-0.446)+v199*(s_-0.446)*od_+v200*(s_-0.446)*w_ \
_p76=0.5*(_p75+sqrt(_p75*_p75+0.001)) \
_p77=v201+v202*od_+v203*w_+v204*od_*od_+v205*od_*w_+v206*w_*w_ \
_p78=_p77+v207*(s_-0.446)+v208*(s_-0.446)*od_+v209*(s_-0.446)*w_ \
_p79=0.5*(_p78+sqrt(_p78*_p78+0.001)) \
_p80=slcr_drs_sub_1p8m0t1f1u*100*_p76 \
_p81=1e-13*_p79
cs (outer inner) capacitor c=_p3
rs1_1 (outer n1_1) resistor r=_p6
ls1_1 (n1_1 ni_1) inductor l=_p10
rs2_1 (ni_1 n2_1) resistor r=_p6
ls2_1 (n2_1 inner) inductor l=_p11
rs1_2 (outer n1_2) resistor r=_p14
ls1_2 (n1_2 inner) inductor l=_p18
k1 mutual_inductor coupling=_p21 ind1=ls1_1 ind2=ls1_2
k2 mutual_inductor coupling=_p21 ind1=ls2_1 ind2=ls1_2
c_1_sub (outer _n1_1_sub) capacitor c=_p49
rs_1_sub (_n1_1_sub sub) resistor r=_p50
cs_1_sub (_n1_1_sub sub) capacitor c=_p51
c_2_sub (inner _n1_2_sub) capacitor c=_p52
rs_2_sub (_n1_2_sub sub) resistor r=_p53
cs_2_sub (_n1_2_sub sub) capacitor c=_p54
c_3_sub (ni_1 _n1_3_sub) capacitor c=_p55
rs_3_sub (_n1_3_sub sub) resistor r=_p56
cs_3_sub (_n1_3_sub sub) capacitor c=_p57
rx_1_2_sub (_n1_1_sub _n1_2_sub) resistor r=_p64
cx_1_2_sub (_n1_1_sub _n1_2_sub) capacitor c=_p65
rx_1_3_sub (_n1_1_sub _n1_3_sub) resistor r=_p72
cx_1_3_sub (_n1_1_sub _n1_3_sub) capacitor c=_p73
rx_2_3_sub (_n1_2_sub _n1_3_sub) resistor r=_p80
cx_2_3_sub (_n1_2_sub _n1_3_sub) capacitor c=_p81
ends l_cr12k_rfvil_1p8m0t1f1u
