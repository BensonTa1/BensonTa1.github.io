simulator lang=spectre insensitive=yes
library l110ae_l_sy12kct_vil_rf_v021_lib
//
section tt
include "l110ae_l_sy12kct_vil_rf_v021.mdl.scs"
parameters syct_drs_1p8m0t1f1u=1
parameters syct_drs_sub_1p8m0t1f1u=1
parameters syct_dls_1p8m0t1f1u=1
endsection tt
//
section ff
include "l110ae_l_sy12kct_vil_rf_v021.mdl.scs"
parameters syct_drs_1p8m0t1f1u=1.15
parameters syct_drs_sub_1p8m0t1f1u=0.85
parameters syct_dls_1p8m0t1f1u=1.05
endsection ff
//
section ss
include "l110ae_l_sy12kct_vil_rf_v021.mdl.scs"
parameters syct_drs_1p8m0t1f1u=0.85
parameters syct_drs_sub_1p8m0t1f1u=1.15
parameters syct_dls_1p8m0t1f1u=0.95
endsection ss
//
endlibrary l110ae_l_sy12kct_vil_rf_v021_lib
