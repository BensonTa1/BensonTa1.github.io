simulator lang=spectre insensitive=yes
// model: l_sqsk_rfvil_1p8m0t1f1u
// stacked inductor, p sub
// umc 110nm 1p8m rfcmos process
// date: 2011-05-11
// model coverage:(before shrinkage)
// od: (45 - 75) * 1e-06
// w: (2 - 3) * 1e-06
// s: (0.28 - 0.4) * 1e-06
// bm: 1 - 5
// ns: 2 - 6
// nt: 1.5 - 5.5
// frequency range: 100mhz - 0.8 * resonance (maximum 10.0 ghz)
subckt l_sqsk_rfvil_1p8m0t1f1u (top bottom sub)
parameters od=5e-05 od_=od/7.5e-05 w=2e-06 w_=w/3e-06 s=2.8e-07 s_=s/4e-07 bm=1 ns=4 nt=3.5  \
s0=(bm==1)*(ns==2)*(nt==1.5) \
s1=(bm==1)*(ns==2)*(nt==2.5) \
s2=(bm==1)*(ns==2)*(nt==3.5) \
s3=(bm==1)*(ns==2)*(nt==4.5) \
s4=(bm==1)*(ns==2)*(nt==5.5) \
s5=(bm==1)*(ns==4)*(nt==1.5) \
s6=(bm==1)*(ns==4)*(nt==2.5) \
s7=(bm==1)*(ns==4)*(nt==3.5) \
s8=(bm==1)*(ns==4)*(nt==4.5) \
s9=(bm==1)*(ns==4)*(nt==5.5) \
s10=(bm==1)*(ns==6)*(nt==1.5) \
s11=(bm==1)*(ns==6)*(nt==2.5) \
s12=(bm==1)*(ns==6)*(nt==3.5) \
s13=(bm==1)*(ns==6)*(nt==4.5) \
s14=(bm==1)*(ns==6)*(nt==5.5) \
s15=(bm==2)*(ns==2)*(nt==1.5) \
s16=(bm==2)*(ns==2)*(nt==2.5) \
s17=(bm==2)*(ns==2)*(nt==3.5) \
s18=(bm==2)*(ns==2)*(nt==4.5) \
s19=(bm==2)*(ns==2)*(nt==5.5) \
s20=(bm==2)*(ns==3)*(nt==1.5) \
s21=(bm==2)*(ns==3)*(nt==2.5) \
s22=(bm==2)*(ns==3)*(nt==3.5) \
s23=(bm==2)*(ns==3)*(nt==4.5) \
s24=(bm==2)*(ns==3)*(nt==5.5) \
s25=(bm==2)*(ns==4)*(nt==1.5) \
s26=(bm==2)*(ns==4)*(nt==2.5) \
s27=(bm==2)*(ns==4)*(nt==3.5) \
s28=(bm==2)*(ns==4)*(nt==4.5) \
s29=(bm==2)*(ns==4)*(nt==5.5) \
s30=(bm==2)*(ns==5)*(nt==1.5) \
s31=(bm==2)*(ns==5)*(nt==2.5) \
s32=(bm==2)*(ns==5)*(nt==3.5) \
s33=(bm==2)*(ns==5)*(nt==4.5) \
s34=(bm==2)*(ns==5)*(nt==5.5) \
s35=(bm==3)*(ns==2)*(nt==1.5) \
s36=(bm==3)*(ns==2)*(nt==2.5) \
s37=(bm==3)*(ns==2)*(nt==3.5) \
s38=(bm==3)*(ns==2)*(nt==4.5) \
s39=(bm==3)*(ns==2)*(nt==5.5) \
s40=(bm==3)*(ns==3)*(nt==1.5) \
s41=(bm==3)*(ns==3)*(nt==2.5) \
s42=(bm==3)*(ns==3)*(nt==3.5) \
s43=(bm==3)*(ns==3)*(nt==4.5) \
s44=(bm==3)*(ns==3)*(nt==5.5) \
s45=(bm==3)*(ns==4)*(nt==1.5) \
s46=(bm==3)*(ns==4)*(nt==2.5) \
s47=(bm==3)*(ns==4)*(nt==3.5) \
s48=(bm==3)*(ns==4)*(nt==4.5) \
s49=(bm==3)*(ns==4)*(nt==5.5) \
s50=(bm==4)*(ns==2)*(nt==1.5) \
s51=(bm==4)*(ns==2)*(nt==2.5) \
s52=(bm==4)*(ns==2)*(nt==3.5) \
s53=(bm==4)*(ns==2)*(nt==4.5) \
s54=(bm==4)*(ns==2)*(nt==5.5) \
s55=(bm==4)*(ns==3)*(nt==1.5) \
s56=(bm==4)*(ns==3)*(nt==2.5) \
s57=(bm==4)*(ns==3)*(nt==3.5) \
s58=(bm==4)*(ns==3)*(nt==4.5) \
s59=(bm==4)*(ns==3)*(nt==5.5) \
s60=(bm==5)*(ns==2)*(nt==1.5) \
s61=(bm==5)*(ns==2)*(nt==2.5) \
s62=(bm==5)*(ns==2)*(nt==3.5) \
s63=(bm==5)*(ns==2)*(nt==4.5) \
s64=(bm==5)*(ns==2)*(nt==5.5) \
v0_part1=(-9.048885e+00)*s0+(-1.138678e+01)*s1+4.699740e+00*s2+7.836833e+00*s3+2.765564e+01*s4+2.550848e-01*s5+9.300116e+00*s6+1.988038e+00*s7+9.466483e+00*s8 \
v0_part2=v0_part1+5.417231e+00*s9+(-1.260006e-02)*s10+3.479313e+00*s11+(-4.122543e-01)*s12+3.489014e+00*s13+1.466345e+01*s14+5.179724e+00*s15+6.574942e+00*s16+1.059656e+01*s17 \
v0_part3=v0_part2+9.597938e+00*s18+1.935503e+01*s19+3.203983e+00*s20+2.635460e+00*s21+4.497509e+00*s22+6.468785e+00*s23+1.220293e+01*s24+(-1.191088e+01)*s25+3.622948e+00*s26 \
v0_part4=v0_part3+3.982156e+00*s27+8.683443e+00*s28+1.577194e+01*s29+(-3.061400e+00)*s30+4.585231e+00*s31+2.791026e+00*s32+(-1.344268e+00)*s33+1.008379e+01*s34+1.226913e+00*s35 \
v0_part5=v0_part4+(-8.510648e+00)*s36+4.294296e+00*s37+9.138556e+00*s38+3.799281e+00*s39+6.671512e+00*s40+(-2.268396e+00)*s41+2.765340e+00*s42+(-1.844799e+00)*s43+1.129741e+01*s44 \
v0_part6=v0_part5+(-1.631885e+00)*s45+2.036174e+00*s46+1.991417e+00*s47+3.571100e+00*s48+1.434624e+01*s49+(-1.310380e+01)*s50+1.517663e+00*s51+(-9.320566e-01)*s52+8.419542e+00*s53 \
v0=v0_part6+2.209536e+01*s54+(-2.592013e+00)*s55+(-1.854718e-01)*s56+4.309207e+00*s57+4.808853e+00*s58+1.251744e+01*s59+4.517072e+00*s60+1.969546e+00*s61+4.019822e-01*s62+7.158076e+00*s63+2.228311e+01*s64 \
v1_part1=6.711567e+00*s0+1.630882e+01*s1+(-2.066597e-01)*s2+(-1.320909e+00)*s3+(-2.281901e+01)*s4+(-8.505680e-01)*s5+(-1.086686e+01)*s6+9.811866e-01*s7+(-6.511450e+00)*s8 \
v1_part2=v1_part1+(-8.519183e-01)*s9+9.183412e-01*s10+(-5.587564e+00)*s11+1.604383e+00*s12+1.305567e+00*s13+(-1.619321e+01)*s14+(-4.421789e+00)*s15+(-4.652570e+00)*s16+(-6.946746e+00)*s17 \
v1_part3=v1_part2+(-1.342925e+00)*s18+(-5.588144e+00)*s19+(-3.377043e+00)*s20+1.938029e-01*s21+(-9.576041e-01)*s22+1.693488e+00*s23+(-5.015408e+00)*s24+1.328961e+01*s25+(-2.358269e+00)*s26 \
v1_part4=v1_part3+(-4.014128e-01)*s27+(-2.881850e+00)*s28+(-9.654352e+00)*s29+4.450366e+00*s30+(-4.308999e+00)*s31+3.659480e-01*s32+8.667585e+00*s33+(-4.392627e+00)*s34+4.982632e-01*s35 \
v1_part5=v1_part4+1.155440e+01*s36+3.657855e+00*s37+1.882517e+00*s38+1.151321e+01*s39+(-4.956224e+00)*s40+8.248850e+00*s41+2.374595e+00*s42+9.433357e+00*s43+(-2.671453e+00)*s44 \
v1_part6=v1_part5+3.613880e+00*s45+8.353156e-01*s46+3.696025e+00*s47+4.561987e+00*s48+(-5.604149e+00)*s49+1.934051e+01*s50+3.022409e+00*s51+1.136177e+01*s52+4.203437e+00*s53 \
v1=v1_part6+(-1.141986e+01)*s54+6.159412e+00*s55+4.401708e+00*s56+1.627187e+00*s57+4.853590e+00*s58+(-3.418010e+00)*s59+(-1.350274e+00)*s60+2.843754e+00*s61+1.013433e+01*s62+6.613285e+00*s63+(-8.185715e+00)*s64 \
v2_part1=5.358648e+00*s0+1.504913e+01*s1+(-3.732657e+00)*s2+(-1.105435e+01)*s3+(-3.734627e+01)*s4+1.660110e+00*s5+(-1.029289e+01)*s6+(-4.363868e+00)*s7+(-1.508831e+01)*s8 \
v2_part2=v2_part1+(-9.687183e+00)*s9+6.892298e-02*s10+(-2.651304e+00)*s11+(-2.025661e+00)*s12+(-5.365601e+00)*s13+(-1.805724e+01)*s14+(-1.053276e+01)*s15+(-1.548759e+01)*s16+(-1.633700e+01)*s17 \
v2_part3=v2_part2+(-1.741412e+01)*s18+(-3.379711e+01)*s19+(-2.308333e+00)*s20+(-1.810442e+00)*s21+(-5.362017e+00)*s22+(-9.488777e+00)*s23+(-1.992671e+01)*s24+8.417843e+00*s25+(-3.986683e+00)*s26 \
v2_part4=v2_part3+(-5.167150e+00)*s27+(-1.374734e+01)*s28+(-2.483572e+01)*s29+2.981772e+00*s30+(-5.494021e+00)*s31+(-4.213907e+00)*s32+(-2.810183e-01)*s33+(-1.886034e+01)*s34+(-2.301278e+00)*s35 \
v2_part5=v2_part4+3.097375e+00*s36+(-9.791437e+00)*s37+(-1.847332e+01)*s38+(-1.804767e+01)*s39+(-1.219434e+01)*s40+2.527378e+00*s41+(-4.445496e+00)*s42+(-3.919298e+00)*s43+(-2.072054e+01)*s44 \
v2_part6=v2_part5+2.299041e+00*s45+(-2.670901e+00)*s46+(-3.955825e+00)*s47+(-1.027966e+01)*s48+(-2.513412e+01)*s49+1.576147e+01*s50+(-2.868895e+00)*s51+(-4.011199e+00)*s52+(-1.893397e+01)*s53 \
v2=v2_part6+(-3.872534e+01)*s54+(-3.890608e+00)*s55+(-4.191445e-01)*s56+(-7.570172e+00)*s57+(-1.138054e+01)*s58+(-2.345251e+01)*s59+(-6.103345e+00)*s60+(-3.721113e+00)*s61+(-6.561081e+00)*s62+(-1.833060e+01)*s63+(-4.143038e+01)*s64 \
v3_part1=7.960918e+00*s0+3.433317e+00*s1+3.468922e+01*s2+5.056162e+01*s3+8.691682e+01*s4+5.940759e+00*s5+2.761758e+01*s6+3.091828e+01*s7+4.214299e+01*s8 \
v3_part2=v3_part1+3.746402e+01*s9+6.797963e+00*s10+1.587813e+01*s11+2.089422e+01*s12+2.361618e+01*s13+4.154880e+01*s14+2.870343e+01*s15+3.852801e+01*s16+4.842396e+01*s17 \
v3_part3=v3_part2+5.387766e+01*s18+7.190227e+01*s19+9.787202e+00*s20+1.639161e+01*s21+2.830210e+01*s22+3.464968e+01*s23+5.353495e+01*s24+2.896919e-01*s25+2.063767e+01*s26 \
v3_part4=v3_part3+2.655064e+01*s27+3.917246e+01*s28+5.714708e+01*s29+2.387895e+00*s30+2.179324e+01*s31+2.147584e+01*s32+1.699891e+01*s33+4.608507e+01*s34+1.492560e+01*s35 \
v3_part5=v3_part4+2.162122e+01*s36+4.086429e+01*s37+5.628575e+01*s38+5.988561e+01*s39+2.531234e+01*s40+1.069664e+01*s41+2.877307e+01*s42+3.450163e+01*s43+5.670306e+01*s44 \
v3_part6=v3_part5+6.971673e+00*s45+1.968476e+01*s46+2.543001e+01*s47+3.932806e+01*s48+5.644632e+01*s49+(-4.640683e+00)*s50+2.657792e+01*s51+3.425372e+01*s52+5.747986e+01*s53 \
v3=v3_part6+8.815233e+01*s54+1.256230e+01*s55+1.799677e+01*s56+3.298847e+01*s57+4.372220e+01*s58+6.142189e+01*s59+2.154895e+01*s60+2.852802e+01*s61+3.825322e+01*s62+5.727669e+01*s63+8.963969e+01*s64 \
v4_part1=4.465180e+00*s0+(-1.223082e-02)*s1+8.721900e-01*s2+(-5.839252e+00)*s3+(-6.775283e-01)*s4+2.746361e-01*s5+(-7.330544e-01)*s6+(-6.646541e-01)*s7+1.193547e+00*s8 \
v4_part2=v4_part1+2.083285e+00*s9+3.544747e-02*s10+(-3.226303e-01)*s11+(-2.199588e-01)*s12+3.215720e-01*s13+(-1.200846e+00)*s14+(-2.657033e+00)*s15+4.082602e+00*s16+8.800037e-01*s17 \
v4_part3=v4_part2+8.763634e-01*s18+1.936675e+00*s19+7.853689e-01*s20+(-1.140484e+00)*s21+2.757086e-01*s22+(-5.144649e-01)*s23+6.105335e-01*s24+3.899416e+01*s25+(-2.125249e-01)*s26 \
v4_part4=v4_part3+(-7.246186e-02)*s27+(-2.192135e-01)*s28+(-8.223453e-01)*s29+4.310653e+00*s30+(-4.484910e-01)*s31+(-1.287487e+00)*s32+(-1.299256e+00)*s33+1.519515e+00*s34+2.395029e+00*s35 \
v4_part5=v4_part4+2.246509e+01*s36+(-1.670641e-01)*s37+6.110749e-01*s38+1.291233e+01*s39+(-1.218576e-01)*s40+3.561910e-01*s41+1.495893e-01*s42+1.257691e+01*s43+1.627076e-01*s44 \
v4_part6=v4_part5+4.779118e-01*s45+1.233426e-01*s46+2.912833e-01*s47+2.022473e-01*s48+(-3.694639e-01)*s49+(-8.750909e+00)*s50+1.448463e-01*s51+2.855385e-01*s52+7.022410e-02*s53 \
v4=v4_part6+3.596367e+00*s54+3.666369e+01*s55+(-7.907870e-02)*s56+(-1.922401e-01)*s57+6.658402e+00*s58+1.124296e+00*s59+(-9.090542e-01)*s60+1.423427e-01*s61+3.057023e-01*s62+1.187066e-01*s63+(-1.769608e+00)*s64 \
v5_part1=(-4.388230e+00)*s0+(-1.074583e+00)*s1+(-1.025091e+00)*s2+4.465054e+00*s3+2.460111e+00*s4+7.405266e-02*s5+6.524506e-01*s6+2.026861e+00*s7+(-2.061660e-01)*s8 \
v5_part2=v5_part1+5.498794e-01*s9+4.658486e-01*s10+7.423173e-01*s11+4.076176e+00*s12+7.805079e-01*s13+4.780911e-01*s14+7.810218e-01*s15+(-4.240539e+00)*s16+1.824503e+00*s17 \
v5_part3=v5_part2+1.958807e+00*s18+4.588693e+00*s19+(-9.193555e-01)*s20+8.039947e-01*s21+1.209760e+00*s22+2.303235e+00*s23+2.202611e+00*s24+(-2.661131e+01)*s25+9.437723e-01*s26 \
v5_part4=v5_part3+1.580561e+00*s27+9.634968e-01*s28+3.710652e+00*s29+(-7.390873e+00)*s30+1.013926e+00*s31+1.800157e+00*s32+2.248825e+00*s33+1.414810e+00*s34+(-4.219227e+00)*s35 \
v5_part5=v5_part4+(-2.034167e+01)*s36+1.367899e+00*s37+2.721794e+00*s38+(-1.809242e+00)*s39+(-8.702336e-02)*s40+7.258221e-01*s41+1.482878e+00*s42+(-3.797661e+00)*s43+3.197029e+00*s44 \
v5_part6=v5_part5+(-5.813103e-02)*s45+1.130275e+00*s46+1.490291e+00*s47+4.578541e+00*s48+3.554998e+00*s49+(-5.795270e+00)*s50+3.692507e-01*s51+1.847123e+00*s52+3.287301e+00*s53 \
v5=v5_part6+5.699206e+00*s54+(-2.551040e+01)*s55+9.336755e-01*s56+1.535320e+00*s57+(-3.072106e+00)*s58+4.044032e+00*s59+1.056253e+00*s60+5.012219e-01*s61+1.449939e+00*s62+3.873913e+00*s63+5.113382e+00*s64 \
v6_part1=(-1.244251e+00)*s0+7.976930e-01*s1+(-4.448247e-01)*s2+2.622640e+00*s3+(-2.540436e+00)*s4+(-3.221067e-01)*s5+2.027525e-01*s6+(-7.424525e-01)*s7+(-1.072290e+00)*s8 \
v6_part2=v6_part1+(-3.455857e+00)*s9+(-2.932019e-01)*s10+1.436029e-01*s11+(-3.256557e+00)*s12+(-7.295975e-01)*s13+9.871704e-01*s14+2.082135e+00*s15+(-8.386151e-01)*s16+(-2.733216e+00)*s17 \
v6_part3=v6_part2+(-2.736946e+00)*s18+(-6.786215e+00)*s19+(-2.801025e-01)*s20+7.251042e-01*s21+(-9.778544e-01)*s22+(-6.132824e-01)*s23+(-1.848327e+00)*s24+(-2.253242e+01)*s25+(-1.322865e-01)*s26 \
v6_part4=v6_part3+(-6.830194e-01)*s27+(-2.186706e-01)*s28+(-1.650679e+00)*s29+2.374496e+00*s30+2.240013e-01*s31+7.295965e-01*s32+2.227497e-01*s33+(-1.272296e+00)*s34+8.601074e-02*s35 \
v6_part5=v6_part4+(-6.819950e+00)*s36+(-1.031701e+00)*s37+(-2.746016e+00)*s38+(-1.452247e+01)*s39+2.900680e-01*s40+(-6.670373e-01)*s41+(-7.511339e-01)*s42+(-1.068991e+01)*s43+(-2.192285e+00)*s44 \
v6_part6=v6_part5+(-2.971346e-01)*s45+(-6.942890e-01)*s46+(-8.555858e-01)*s47+(-3.445477e+00)*s48+(-2.073163e+00)*s49+5.755875e+00*s50+(-4.236172e-01)*s51+(-1.554781e+00)*s52+(-2.492521e+00)*s53 \
v6=v6_part6+(-1.063056e+01)*s54+(-1.986256e+01)*s55+(-3.325175e-01)*s56+(-3.838109e-01)*s57+(-5.382322e+00)*s58+(-3.957905e+00)*s59+(-1.882742e-01)*s60+(-4.437130e-01)*s61+(-1.025087e+00)*s62+(-2.961569e+00)*s63+(-2.571442e+00)*s64 \
v7_part1=(-2.314155e+00)*s0+(-2.377778e+01)*s1+(-2.876513e+01)*s2+(-2.085013e+01)*s3+(-1.383261e+02)*s4+(-1.224839e+01)*s5+(-3.071833e+01)*s6+(-5.635991e+02)*s7+(-3.684953e+02)*s8 \
v7_part2=v7_part1+(-4.467295e+02)*s9+(-2.237735e+01)*s10+(-8.800734e+01)*s11+(-2.367300e+01)*s12+(-3.230386e+01)*s13+6.251878e+03*s14+3.463360e-02*s15+(-8.685520e+00)*s16+(-1.419600e+01)*s17 \
v7_part3=v7_part2+(-2.305886e+01)*s18+(-3.328227e+01)*s19+(-1.849003e+00)*s20+1.000000e+04*s21+(-1.722693e+01)*s22+(-1.486008e+02)*s23+3.349895e+02*s24+1.174535e+01*s25+(-2.837394e+01)*s26 \
v7_part4=v7_part3+3.547060e+01*s27+(-4.668213e+01)*s28+4.761476e+02*s29+(-1.871127e+02)*s30+(-9.012535e+00)*s31+(-3.144787e+02)*s32+(-1.505693e+02)*s33+8.981584e+01*s34+4.737948e+01*s35 \
v7_part5=v7_part4+5.332556e+02*s36+2.180617e+00*s37+(-2.349993e+01)*s38+(-8.219807e+02)*s39+(-2.595121e+00)*s40+9.511870e+03*s41+(-1.896852e+01)*s42+(-4.661295e+01)*s43+2.691402e+02*s44 \
v7_part6=v7_part5+(-1.043279e+01)*s45+(-4.819022e+00)*s46+(-1.649017e+02)*s47+(-4.292719e+02)*s48+3.320538e+02*s49+1.201917e+01*s50+(-7.232888e+01)*s51+(-9.284178e+01)*s52+(-2.323328e+01)*s53 \
v7=v7_part6+(-1.452288e+02)*s54+4.402978e+02*s55+(-3.573411e+02)*s56+3.134213e+01*s57+(-1.023076e+02)*s58+(-2.717481e+02)*s59+(-9.550883e+02)*s60+(-1.139631e+02)*s61+(-6.542110e+01)*s62+(-2.962539e+02)*s63+(-3.385824e+01)*s64 \
v8_part1=(-7.017884e+00)*s0+(-1.695340e+00)*s1+(-3.268346e+00)*s2+(-1.301109e+02)*s3+(-3.978436e+01)*s4+(-2.205746e+01)*s5+(-4.996799e+01)*s6+(-1.155388e+03)*s7+4.559275e+01*s8 \
v8_part2=v8_part1+3.723118e+02*s9+(-2.032768e+01)*s10+2.826090e+01*s11+(-1.401314e+02)*s12+1.671219e+01*s13+(-4.823641e+03)*s14+(-1.355137e+01)*s15+(-6.548892e+00)*s16+1.225104e+00*s17 \
v8_part3=v8_part2+3.030462e+00*s18+(-2.128637e+01)*s19+(-1.672161e+01)*s20+1.000000e+04*s21+4.983593e+01*s22+8.362994e+01*s23+1.293666e+03*s24+(-1.721269e+01)*s25+2.185461e+02*s26 \
v8_part4=v8_part3+(-5.421203e+01)*s27+(-1.915376e+01)*s28+7.114693e+02*s29+6.183956e+02*s30+1.812867e+00*s31+(-2.648464e+02)*s32+5.923711e+01*s33+9.215749e+02*s34+(-4.246186e+02)*s35 \
v8_part5=v8_part4+4.943260e+02*s36+(-4.748326e+01)*s37+4.218417e+00*s38+(-1.175208e+03)*s39+(-1.035137e+01)*s40+1.610740e+03*s41+(-5.001263e+00)*s42+9.697205e+00*s43+1.349747e+03*s44 \
v8_part6=v8_part5+(-4.475873e+01)*s45+(-3.183641e+01)*s46+(-2.284413e+02)*s47+1.133548e+03*s48+3.619293e+02*s49+4.643858e+02*s50+5.794152e+02*s51+(-7.085391e+01)*s52+4.060975e+00*s53 \
v8=v8_part6+9.447982e+02*s54+1.644788e+02*s55+(-4.854140e+02)*s56+1.392964e+02*s57+(-1.034557e+02)*s58+(-1.523575e+02)*s59+6.995752e+03*s60+1.505889e+03*s61+1.012567e+02*s62+(-1.190413e+02)*s63+(-1.517826e+01)*s64 \
v9_part1=(-1.101864e+00)*s0+1.615050e+01*s1+(-1.996709e+01)*s2+(-1.156130e+02)*s3+4.666100e+01*s4+7.273100e+00*s5+3.007586e+00*s6+2.238387e+02*s7+9.963873e+01*s8 \
v9_part2=v9_part1+8.473417e+01*s9+1.174840e+01*s10+(-7.028381e+01)*s11+(-1.125553e+01)*s12+(-4.841170e+01)*s13+(-7.093069e+03)*s14+(-2.465725e+00)*s15+1.698293e+00*s16+(-2.075851e+00)*s17 \
v9_part3=v9_part2+(-6.694277e-01)*s18+(-1.328535e+00)*s19+(-1.938644e+00)*s20+1.000000e+04*s21+(-6.996254e+00)*s22+(-1.078928e+02)*s23+(-6.398609e+02)*s24+(-3.015988e+01)*s25+(-6.413680e+01)*s26 \
v9_part4=v9_part3+(-1.456057e+02)*s27+3.923055e-01*s28+(-8.935279e+02)*s29+(-1.815557e+02)*s30+(-5.836106e+00)*s31+1.084346e+02*s32+(-6.660284e+01)*s33+(-5.708817e+02)*s34+1.429380e+02*s35 \
v9_part5=v9_part4+1.290294e+02*s36+(-9.263341e+01)*s37+(-4.076097e-01)*s38+(-2.154817e+02)*s39+(-1.548294e+00)*s40+9.598553e+03*s41+(-2.006127e+00)*s42+(-1.603810e+01)*s43+(-5.288864e+02)*s44 \
v9_part6=v9_part5+(-7.995042e+00)*s45+(-9.876496e+00)*s46+1.102870e+02*s47+(-5.207120e+02)*s48+(-6.205955e+02)*s49+2.758837e+02*s50+(-8.361985e+01)*s51+2.022710e+01*s52+(-6.955401e-01)*s53 \
v9=v9_part6+(-4.060873e+01)*s54+(-7.367263e+01)*s55+1.735641e+02*s56+(-1.389240e+02)*s57+2.636500e+01*s58+1.976664e+02*s59+1.108656e+03*s60+(-5.466468e+01)*s61+(-3.058704e+01)*s62+1.485972e+02*s63+(-1.158205e+01)*s64 \
v10_part1=4.085381e+00*s0+(-1.285534e+01)*s1+1.196312e+01*s2+1.909113e+02*s3+(-2.441419e+01)*s4+3.028074e+00*s5+2.634552e+01*s6+2.292785e+02*s7+(-7.148671e+01)*s8 \
v10_part2=v10_part1+(-1.138876e+02)*s9+(-4.594296e+00)*s10+1.744569e+02*s11+3.716827e+01*s12+1.635158e+01*s13+7.192152e+03*s14+8.118063e+00*s15+1.432912e+00*s16+7.160986e+00*s17 \
v10_part3=v10_part2+(-1.649408e+00)*s18+4.908565e+00*s19+9.257103e+00*s20+1.000000e+04*s21+(-4.033811e+01)*s22+1.039529e+01*s23+(-2.671328e+02)*s24+3.922920e+01*s25+(-5.025982e+01)*s26 \
v10_part4=v10_part3+1.352864e+02*s27+(-2.385907e-01)*s28+2.254270e+02*s29+(-8.252632e+02)*s30+1.007320e+01*s31+3.211576e+01*s32+1.478477e+02*s33+1.884962e+02*s34+5.988831e+02*s35 \
v10_part5=v10_part4+5.575896e+01*s36+1.554203e+02*s37+(-2.384532e+00)*s38+1.566425e+03*s39+5.108540e+00*s40+(-7.243418e+02)*s41+3.300377e+00*s42+3.222889e+01*s43+(-3.819453e+02)*s44 \
v10_part6=v10_part5+2.250881e+01*s45+3.056889e+01*s46+(-2.748608e+01)*s47+1.973999e+02*s48+2.791109e+02*s49+6.696265e+02*s50+(-1.904109e+02)*s51+7.603732e+01*s52+(-2.184408e+00)*s53 \
v10=v10_part6+4.130962e+02*s54+(-6.873422e+01)*s55+1.089309e+02*s56+6.697984e+01*s57+(-8.047614e+01)*s58+(-6.954962e+01)*s59+(-3.157422e+03)*s60+(-6.806790e+02)*s61+(-9.029768e+00)*s62+(-1.126933e+02)*s63+(-7.239828e-01)*s64 \
v11_part1=4.929780e+01*s0+9.920960e+01*s1+2.284437e+02*s2+4.645429e+02*s3+3.790822e+02*s4+1.118553e+02*s5+2.194204e+02*s6+2.120264e+03*s7+9.378183e+02*s8 \
v11_part2=v11_part1+9.159421e+02*s9+1.613811e+02*s10+5.083200e+02*s11+4.803728e+02*s12+4.619744e+02*s13+1.187763e+03*s14+4.616865e+01*s15+7.221589e+01*s16+1.230534e+02*s17 \
v11_part3=v11_part2+1.164537e+02*s18+1.763256e+02*s19+6.905618e+01*s20+1.000000e+04*s21+1.706778e+02*s22+8.975694e+02*s23+(-1.168327e+02)*s24+8.919530e+01*s25+3.414807e+02*s26 \
v11_part4=v11_part3+4.519953e+02*s27+2.784809e+02*s28+3.209240e+02*s29+2.075299e+03*s30+3.392096e+02*s31+1.024733e+03*s32+5.782875e+02*s33+3.146923e+02*s34+3.267891e+02*s35 \
v11_part5=v11_part4+3.644442e+02*s36+2.322131e+02*s37+1.161763e+02*s38+2.065100e+03*s39+6.741564e+01*s40+7.465647e+03*s41+1.381324e+02*s42+2.285463e+02*s43+(-1.596800e+02)*s44 \
v11_part6=v11_part5+2.010051e+02*s45+1.685983e+02*s46+6.713728e+02*s47+1.219504e+03*s48+2.699620e+02*s49+2.971089e+02*s50+2.560787e+02*s51+3.189974e+02*s52+1.162292e+02*s53 \
v11=v11_part6+3.679919e+02*s54+1.717463e+02*s55+1.181048e+03*s56+2.872680e+02*s57+6.194233e+02*s58+5.819644e+02*s59+(-1.787664e+02)*s60+(-2.479185e+00)*s61+2.758547e+02*s62+7.216586e+02*s63+2.108536e+02*s64 \
v12_part1=(-4.429977e-01)*s0+(-2.094860e+00)*s1+(-6.100395e+00)*s2+2.831558e+01*s3+(-2.133552e+01)*s4+(-5.362145e-01)*s5+(-5.336762e+00)*s6+6.940607e-01*s7+8.078751e+00*s8 \
v12_part2=v12_part1+5.675523e+01*s9+(-1.332805e+00)*s10+1.756151e+00*s11+(-2.903036e+01)*s12+(-3.021662e+01)*s13+(-2.861608e+01)*s14+(-6.628053e-01)*s15+(-1.061044e+00)*s16+(-4.514343e+00)*s17 \
v12_part3=v12_part2+(-5.277039e+00)*s18+(-1.227701e+01)*s19+(-3.149584e-01)*s20+6.488673e+00*s21+(-9.510771e+00)*s22+7.759256e+01*s23+(-6.138565e+01)*s24+(-1.483315e+01)*s25+(-1.458304e+00)*s26 \
v12_part4=v12_part3+(-6.582836e+00)*s27+(-9.676378e+00)*s28+(-1.318073e+01)*s29+(-9.329765e+02)*s30+(-3.893034e+00)*s31+(-3.755873e+00)*s32+(-5.498405e+00)*s33+(-3.591036e+01)*s34+(-2.423978e+00)*s35 \
v12_part5=v12_part4+3.356614e+02*s36+3.054436e+00*s37+(-5.286824e+00)*s38+3.968103e+01*s39+(-5.747730e-01)*s40+(-3.286979e+00)*s41+(-4.164480e+00)*s42+(-2.566259e+01)*s43+(-2.318257e+01)*s44 \
v12_part6=v12_part5+3.044351e+00*s45+(-4.278359e+00)*s46+(-3.023354e+01)*s47+6.714766e+01*s48+(-3.380205e+01)*s49+(-1.492131e+02)*s50+(-1.880988e+00)*s51+(-2.017942e+00)*s52+(-5.341898e+00)*s53 \
v12=v12_part6+(-6.865675e+01)*s54+6.658468e+03*s55+(-4.009675e+00)*s56+(-6.245114e+00)*s57+2.183347e+00*s58+(-1.297837e+01)*s59+(-2.669074e+00)*s60+1.536305e+00*s61+(-1.029375e+00)*s62+(-1.316653e+01)*s63+(-2.535721e+01)*s64 \
v13_part1=2.905474e-02*s0+1.450704e-01*s1+1.238332e-01*s2+(-5.894551e+01)*s3+1.025183e+00*s4+3.920112e-01*s5+3.956409e-01*s6+(-4.237032e+00)*s7+3.534993e+00*s8 \
v13_part2=v13_part1+(-4.536685e+02)*s9+(-3.231285e-03)*s10+(-2.199119e+01)*s11+1.433726e+01*s12+1.271066e+01*s13+(-1.974826e+01)*s14+2.036023e-01*s15+1.243786e-01*s16+7.809763e-01*s17 \
v13_part3=v13_part2+3.203769e-01*s18+1.557300e+00*s19+(-1.701665e-02)*s20+1.422188e+01*s21+1.446850e-01*s22+(-4.651666e+02)*s23+(-4.222462e+01)*s24+2.712826e+01*s25+(-1.561207e+00)*s26 \
v13_part4=v13_part3+(-1.621186e+00)*s27+(-3.842039e+00)*s28+(-5.361032e+00)*s29+(-2.014271e+01)*s30+(-1.694269e+00)*s31+4.578167e+00*s32+(-3.024091e+01)*s33+(-7.014064e+01)*s34+1.029259e+01*s35 \
v13_part5=v13_part4+2.783237e+00*s36+(-1.552545e+01)*s37+2.307807e-01*s38+(-2.300953e+02)*s39+1.094829e-01*s40+(-5.060334e+00)*s41+5.331412e-01*s42+8.577692e+00*s43+(-3.140398e+01)*s44 \
v13_part6=v13_part5+1.927202e-01*s45+2.822399e-01*s46+2.140659e+01*s47+(-6.148748e+00)*s48+1.244943e+01*s49+3.289637e+03*s50+(-2.990219e+00)*s51+(-1.200097e+01)*s52+3.765542e-01*s53 \
v13=v13_part6+(-1.441611e+02)*s54+(-1.422270e+03)*s55+1.972050e+00*s56+(-1.507731e+01)*s57+(-3.565703e+00)*s58+(-2.831530e+00)*s59+(-1.152791e+00)*s60+2.442274e+00*s61+(-1.453555e+01)*s62+1.583788e+01*s63+(-1.263227e+00)*s64 \
v14_part1=2.581179e-01*s0+1.177865e+00*s1+3.410492e+00*s2+(-2.802317e+00)*s3+1.246308e+01*s4+(-1.339473e-02)*s5+3.474640e+00*s6+8.006591e+00*s7+3.732783e+00*s8 \
v14_part2=v14_part1+7.083987e+01*s9+8.537631e-01*s10+(-6.641362e+00)*s11+9.742857e+00*s12+1.396409e+01*s13+2.127574e+00*s14+4.093661e-01*s15+3.225567e-01*s16+1.674436e+00*s17 \
v14_part3=v14_part2+2.960600e+00*s18+7.755768e+00*s19+1.249609e-01*s20+2.413499e+00*s21+6.864654e+00*s22+9.813980e+01*s23+7.370831e+01*s24+5.839274e+00*s25+(-3.256822e+00)*s26 \
v14_part4=v14_part3+9.832703e-01*s27+9.650274e+00*s28+(-4.357342e-01)*s29+9.977117e+02*s30+(-6.336674e+00)*s31+5.439884e+00*s32+(-6.864089e+00)*s33+2.223392e+01*s34+(-4.312986e+01)*s35 \
v14_part5=v14_part4+(-1.370796e+03)*s36+3.534026e+00*s37+3.001920e+00*s38+7.062936e+01*s39+3.223818e-01*s40+(-2.503470e+00)*s41+2.157961e+00*s42+2.123233e+01*s43+2.151301e+01*s44 \
v14_part6=v14_part5+7.807503e-01*s45+2.191097e+00*s46+(-2.376888e-01)*s47+4.550092e-01*s48+(-1.646879e+01)*s49+(-3.701293e+03)*s50+(-3.343640e+00)*s51+(-1.427693e+01)*s52+2.986288e+00*s53 \
v14=v14_part6+(-8.113619e+01)*s54+(-5.916367e+03)*s55+(-1.875494e+00)*s56+2.547244e+01*s57+(-1.591625e+00)*s58+(-8.162749e-01)*s59+(-5.787896e+00)*s60+(-4.295650e+00)*s61+7.051899e+00*s62+7.437412e+00*s63+2.946863e+01*s64 \
v15_part1=(-3.685795e-01)*s0+(-9.080405e-01)*s1+(-1.008060e+00)*s2+(-8.682276e+00)*s3+4.639000e+00*s4+(-6.930385e-01)*s5+(-2.646716e+00)*s6+4.224023e+01*s7+3.595243e+00*s8 \
v15_part2=v15_part1+(-4.283971e+01)*s9+(-2.877913e+00)*s10+(-1.561301e+01)*s11+(-8.250897e+00)*s12+(-1.859589e+01)*s13+(-6.012328e+02)*s14+(-3.870409e-01)*s15+(-1.012418e+00)*s16+(-2.112671e+00)*s17 \
v15_part3=v15_part2+(-3.947125e+00)*s18+(-9.500952e+00)*s19+(-8.798626e-01)*s20+(-2.883581e+03)*s21+(-1.899302e+00)*s22+2.839609e+01*s23+(-1.210339e+01)*s24+(-3.587784e-01)*s25+(-9.156366e+00)*s26 \
v15_part4=v15_part3+(-4.243161e+00)*s27+(-1.198256e+01)*s28+9.297730e+00*s29+8.156204e+01*s30+4.542147e+00*s31+2.896922e+00*s32+(-2.622592e+01)*s33+(-2.966476e+01)*s34+1.266817e+01*s35 \
v15_part5=v15_part4+(-1.095277e+01)*s36+(-2.451707e+00)*s37+(-3.468183e+00)*s38+3.172923e+01*s39+(-9.764049e-01)*s40+(-1.716267e+03)*s41+(-5.077318e+00)*s42+(-5.695129e-01)*s43+(-2.055892e+01)*s44 \
v15_part6=v15_part5+(-4.471311e-01)*s45+(-1.469929e+00)*s46+2.224569e+00*s47+9.578145e+01*s48+(-4.340814e+01)*s49+(-2.042992e+01)*s50+(-4.425804e+00)*s51+(-3.385553e-01)*s52+(-3.390099e+00)*s53 \
v15=v15_part6+2.509078e+01*s54+8.964700e+00*s55+2.244332e+01*s56+(-8.646861e+00)*s57+(-5.166363e+00)*s58+(-2.228084e+00)*s59+1.039749e+02*s60+(-5.000176e+00)*s61+5.000878e+00*s62+2.000318e+00*s63+(-1.054522e+00)*s64 \
v16_part1=2.279217e+00*s0+5.681239e+00*s1+1.758322e+01*s2+3.104931e+01*s3+9.466697e+00*s4+7.287555e+00*s5+2.042770e+01*s6+1.076377e+01*s7+7.152893e+01*s8 \
v16_part2=v16_part1+1.423834e+02*s9+1.691033e+01*s10+6.454898e+01*s11+8.046462e+01*s12+1.229166e+02*s13+1.054404e+03*s14+2.277630e+00*s15+5.762079e+00*s16+1.116889e+01*s17 \
v16_part3=v16_part2+2.491437e+01*s18+3.262825e+01*s19+4.892464e+00*s20+9.989047e+03*s21+1.989235e+01*s22+7.295486e+00*s23+6.807653e+01*s24+6.832233e+00*s25+3.906967e+01*s26 \
v16_part4=v16_part3+4.765179e+01*s27+5.894764e+01*s28+8.274459e+01*s29+6.489871e+01*s30+1.903042e+01*s31+5.926465e+01*s32+1.095807e+02*s33+1.638350e+02*s34+2.072843e+00*s35 \
v16_part5=v16_part4+8.724390e+01*s36+1.325113e+01*s37+2.257814e+01*s38+1.244001e+01*s39+5.036524e+00*s40+7.568996e+03*s41+3.490536e+01*s42+2.323292e+01*s43+7.702236e+01*s44 \
v16_part6=v16_part5+8.784108e+00*s45+1.800578e+01*s46+3.606749e+01*s47+(-3.031751e+01)*s48+1.396685e+02*s49+4.564363e+01*s50+1.630681e+01*s51+1.116512e+01*s52+2.171798e+01*s53 \
v16=v16_part6+1.638417e+01*s54+5.147819e+01*s55+(-9.397574e+00)*s56+3.890980e+01*s57+6.417083e+01*s58+3.788866e+01*s59+(-1.615432e+01)*s60+1.749038e+01*s61+4.917971e+00*s62+1.812132e+01*s63+1.778059e+01*s64 \
v17_part1=(-6.781415e-02)*s0+(-2.612468e-01)*s1+(-6.241279e+00)*s2+2.582078e+00*s3+(-1.058425e+01)*s4+(-1.026519e+00)*s5+(-2.928790e+00)*s6+(-6.176898e+01)*s7+(-3.324770e+01)*s8 \
v17_part2=v17_part1+9.199458e+00*s9+(-9.868575e-01)*s10+1.413748e+00*s11+(-1.392280e+01)*s12+(-2.518248e+01)*s13+7.416105e+02*s14+(-3.577695e-02)*s15+(-2.649608e-01)*s16+(-7.694719e-01)*s17 \
v17_part3=v17_part2+(-3.825337e+00)*s18+3.399656e+00*s19+(-1.289703e-01)*s20+1.272391e+01*s21+(-4.289758e+00)*s22+(-5.021772e+01)*s23+(-8.930804e+00)*s24+(-1.873465e+00)*s25+2.972508e+00*s26 \
v17_part4=v17_part3+(-1.036937e+01)*s27+(-4.529174e+00)*s28+(-5.151201e+01)*s29+(-1.019382e+02)*s30+(-1.291115e+01)*s31+(-2.701212e+01)*s32+(-8.425800e+00)*s33+(-2.129342e+01)*s34+(-1.358074e+01)*s35 \
v17_part5=v17_part4+(-2.216937e+01)*s36+(-7.774170e-01)*s37+(-3.712357e+00)*s38+(-5.465925e+01)*s39+(-3.819721e-02)*s40+(-1.781552e+01)*s41+(-5.074460e+00)*s42+(-9.699481e+00)*s43+(-1.721892e+00)*s44 \
v17_part6=v17_part5+(-1.581272e+00)*s45+(-3.742688e+00)*s46+(-1.750655e+01)*s47+(-1.323558e+02)*s48+1.187344e+01*s49+(-2.488315e+00)*s50+5.774293e+00*s51+(-3.989196e+00)*s52+(-3.491240e+00)*s53 \
v17=v17_part6+(-1.390000e+01)*s54+(-2.687970e+01)*s55+(-2.989202e+01)*s56+(-1.245024e+00)*s57+(-7.290166e+00)*s58+(-1.094402e+01)*s59+(-7.467588e+01)*s60+9.008829e+00*s61+(-8.906245e+00)*s62+(-1.071508e+01)*s63+(-5.639644e+00)*s64 \
v18_part1=(-4.796706e-01)*s0+(-1.193314e+00)*s1+(-6.354839e-01)*s2+(-1.065793e+01)*s3+7.144514e+00*s4+(-3.599720e-01)*s5+(-1.377759e+00)*s6+6.207409e+01*s7+1.007594e+01*s8 \
v18_part2=v18_part1+(-4.520781e+01)*s9+(-2.246242e+00)*s10+(-8.338929e+00)*s11+(-9.123051e+00)*s12+(-7.797372e+00)*s13+(-1.056501e+03)*s14+(-5.010342e-01)*s15+(-1.367089e+00)*s16+(-2.060365e+00)*s17 \
v18_part3=v18_part2+(-1.555447e+00)*s18+(-1.742330e+01)*s19+(-9.897472e-01)*s20+3.144629e+03*s21+(-9.833831e-01)*s22+5.419114e+01*s23+(-9.593640e+00)*s24+1.339597e+00*s25+(-9.004405e+00)*s26 \
v18_part4=v18_part3+(-1.040856e+00)*s27+(-1.430267e+01)*s28+3.051633e+01*s29+4.323704e+01*s30+1.819350e+01*s31+1.839855e+01*s32+(-1.249456e+01)*s33+(-2.384058e+01)*s34+7.003086e+00*s35 \
v18_part5=v18_part4+1.243543e+01*s36+(-1.278449e+00)*s37+(-9.376872e-01)*s38+5.595376e+01*s39+(-1.066521e+00)*s40+(-3.061477e+03)*s41+(-7.920622e-01)*s42+5.288783e+00*s43+(-1.805962e+01)*s44 \
v18_part6=v18_part5+7.854825e-01*s45+2.507195e-01*s46+1.048759e+01*s47+1.579709e+02*s48+(-5.420609e+01)*s49+1.154655e+01*s50+(-9.433130e+00)*s51+2.760513e+00*s52+(-9.525667e-01)*s53 \
v18=v18_part6+(-1.115482e+00)*s54+(-4.877431e+00)*s55+4.144196e+01*s56+(-6.487732e+00)*s57+(-2.430311e+01)*s58+(-8.278300e-01)*s59+1.147470e+01*s60+(-1.163281e+01)*s61+9.059963e+00*s62+6.463709e+00*s63+(-7.228099e-01)*s64 \
v19_part1=(-2.323825e-02)*s0+(-2.618942e-01)*s1+(-4.608795e-01)*s2+(-9.876580e-01)*s3+(-2.191405e+00)*s4+(-1.335926e-01)*s5+(-3.838042e-02)*s6+(-1.359207e+01)*s7+(-3.983233e+00)*s8 \
v19_part2=v19_part1+(-4.629963e-01)*s9+(-1.221176e-01)*s10+(-2.262963e+00)*s11+(-5.142995e+00)*s12+(-5.400419e+00)*s13+2.955035e+00*s14+6.293307e-03*s15+(-1.468302e-01)*s16+(-2.640747e-01)*s17 \
v19_part3=v19_part2+(-4.346587e-01)*s18+(-1.532162e+00)*s19+(-4.488458e-02)*s20+(-1.125127e+01)*s21+5.935699e-01*s22+(-2.281863e+00)*s23+(-2.898720e+00)*s24+3.905764e-01*s25+(-5.770930e-01)*s26 \
v19_part4=v19_part3+(-1.886328e+00)*s27+(-2.312804e-01)*s28+1.079059e+00*s29+(-4.275826e+01)*s30+1.057264e+00*s31+6.078408e-01*s32+(-1.590377e+00)*s33+(-1.153692e+01)*s34+(-1.685502e+00)*s35 \
v19_part5=v19_part4+1.042454e+01*s36+(-1.608280e+00)*s37+(-2.995506e-01)*s38+(-1.972340e+01)*s39+(-1.787943e-02)*s40+7.519381e-01*s41+(-3.111768e-01)*s42+(-7.768852e+00)*s43+2.785651e+00*s44 \
v19_part6=v19_part5+2.783208e-01*s45+(-4.455981e-01)*s46+3.249268e+00*s47+(-7.617823e+00)*s48+4.271494e+00*s49+4.578231e+01*s50+7.534554e-02*s51+3.823841e-01*s52+(-2.459457e-01)*s53 \
v19=v19_part6+(-3.187344e+01)*s54+5.276917e+01*s55+9.936740e-01*s56+(-1.452261e-01)*s57+(-6.465194e+00)*s58+(-1.047578e-01)*s59+(-7.734692e-02)*s60+2.878811e-01*s61+(-3.447014e+00)*s62+8.333355e-01*s63+(-1.135932e+00)*s64 \
v20_part1=(-3.381266e-02)*s0+1.487735e-01*s1+(-4.866492e-01)*s2+2.595176e+00*s3+(-6.730977e-01)*s4+(-5.771870e-03)*s5+(-2.221578e-01)*s6+1.628578e+01*s7+(-1.178881e+01)*s8 \
v20_part2=v20_part1+8.115619e+00*s9+(-1.797258e-01)*s10+(-1.348080e+00)*s11+1.683761e+00*s12+(-3.857956e+00)*s13+2.779776e+00*s14+(-4.357621e-02)*s15+(-1.001821e-01)*s16+(-1.543890e+00)*s17 \
v20_part3=v20_part2+(-2.752836e-01)*s18+(-1.304022e+00)*s19+(-7.106996e-02)*s20+(-6.035321e+00)*s21+(-1.281210e+00)*s22+(-1.197922e+01)*s23+(-7.501456e+00)*s24+7.072044e-01*s25+3.729364e-01*s26 \
v20_part4=v20_part3+(-3.754414e+00)*s27+(-4.229111e+00)*s28+(-7.448623e+00)*s29+(-6.105341e-02)*s30+1.936677e+00*s31+(-5.758526e+00)*s32+(-2.079911e+00)*s33+1.399418e+01*s34+(-7.772448e-01)*s35 \
v20_part5=v20_part4+(-1.334109e+02)*s36+1.473459e+00*s37+(-1.006357e+00)*s38+8.970333e-01*s39+(-7.483432e-02)*s40+1.016770e-01*s41+(-2.298356e+00)*s42+6.771493e+00*s43+(-8.218688e+00)*s44 \
v20_part6=v20_part5+7.676632e-02*s45+(-8.209901e-02)*s46+(-9.940798e+00)*s47+(-2.465952e+01)*s48+(-1.259046e+01)*s49+(-1.523020e+02)*s50+5.972241e-01*s51+(-2.432774e+00)*s52+(-1.333198e+00)*s53 \
v20=v20_part6+2.506829e+01*s54+1.518345e+00*s55+(-1.970331e+00)*s56+(-6.112479e+00)*s57+(-8.910833e+00)*s58+(-2.738101e+00)*s59+(-9.691472e-01)*s60+(-2.337075e-01)*s61+2.974665e+00*s62+(-1.255702e+00)*s63+(-1.605280e+00)*s64 \
v21_part1=2.331651e-02*s0+3.723658e-02*s1+3.407760e-01*s2+(-1.632883e+00)*s3+1.480366e+00*s4+7.350583e-02*s5+(-1.947096e-01)*s6+3.335534e+00*s7+1.219754e+01*s8 \
v21_part2=v21_part1+(-1.271369e+01)*s9+7.911342e-02*s10+3.584028e+00*s11+9.288778e-01*s12+4.658773e+00*s13+(-1.570906e+01)*s14+(-4.063447e-04)*s15+1.202078e-01*s16+1.106027e+00*s17 \
v21_part3=v21_part2+9.238117e-02*s18+2.007706e+00*s19+4.412391e-02*s20+(-1.269163e+01)*s21+(-4.744151e-01)*s22+1.219654e+01*s23+4.847774e+00*s24+(-5.430823e-01)*s25+1.576505e-01*s26 \
v21_part4=v21_part3+5.437278e+00*s27+1.476629e+00*s28+2.660936e+00*s29+3.248348e+01*s30+(-4.315301e+00)*s31+2.679365e-01*s32+(-2.471756e-01)*s33+(-7.507334e+00)*s34+5.032038e-01*s35 \
v21_part5=v21_part4+7.365694e+01*s36+8.366322e-01*s37+2.535094e-01*s38+1.049147e+01*s39+1.496119e-02*s40+3.243661e+00*s41+5.489561e-01*s42+3.225674e+00*s43+(-1.023299e+00)*s44 \
v21_part6=v21_part5+(-3.639624e-01)*s45+2.199621e-01*s46+2.345034e+00*s47+2.745037e+01*s48+1.370688e+00*s49+3.940237e+01*s50+(-9.985200e-01)*s51+8.733459e-01*s52+3.440714e-01*s53 \
v21=v21_part6+7.132348e+00*s54+(-4.552230e+01)*s55+(-2.630311e+00)*s56+3.067133e+00*s57+9.362312e+00*s58+(-4.051957e-01)*s59+(-6.614081e-01)*s60+(-5.102730e-01)*s61+7.069263e-01*s62+(-1.243779e+00)*s63+1.608863e+00*s64 \
v22_part1=3.562255e+03*s0+4.822623e+02*s1+(-4.474159e+01)*s2+(-5.845722e+01)*s3+(-5.276957e+01)*s4+5.918125e+02*s5+(-1.732976e+01)*s6+(-4.351171e+01)*s7+(-5.181987e+01)*s8 \
v22_part2=v22_part1+(-8.576294e+01)*s9+1.218370e+03*s10+(-1.313436e+01)*s11+(-3.140768e+02)*s12+(-1.011289e+03)*s13+(-3.344501e+02)*s14+6.844526e+02*s15+1.000000e+04*s16+(-1.120934e+02)*s17 \
v22_part3=v22_part2+(-1.000000e+04)*s18+(-5.404766e+02)*s19+4.340968e+03*s20+(-8.127119e+00)*s21+(-1.432187e+02)*s22+(-5.108044e+01)*s23+(-1.865477e+02)*s24+5.051887e+02*s25+(-2.450768e+01)*s26 \
v22_part4=v22_part3+(-9.527123e+01)*s27+(-9.928365e+02)*s28+(-2.432149e+02)*s29+(-3.520167e+00)*s30+(-6.057728e+01)*s31+(-3.575917e+01)*s32+(-5.375363e+01)*s33+(-2.255995e+02)*s34+(-4.269188e+00)*s35 \
v22_part5=v22_part4+(-8.470011e+00)*s36+(-2.780385e+01)*s37+(-1.000000e+04)*s38+(-2.859258e+01)*s39+7.522380e+02*s40+(-4.224223e+00)*s41+(-1.000000e+04)*s42+(-1.844701e+01)*s43+(-1.979993e+02)*s44 \
v22_part6=v22_part5+(-3.422911e+00)*s45+(-3.869592e+02)*s46+(-1.094076e+01)*s47+(-5.365587e+01)*s48+(-3.562589e+02)*s49+(-4.947755e-01)*s50+(-4.512951e+00)*s51+(-3.918892e+00)*s52+(-1.000000e+04)*s53 \
v22=v22_part6+(-5.190661e+01)*s54+1.773480e+01*s55+(-6.599532e+00)*s56+(-5.627602e+01)*s57+(-5.432537e+01)*s58+1.371184e+02*s59+(-1.021700e+00)*s60+(-4.737109e+00)*s61+(-1.651738e+01)*s62+(-2.504199e+01)*s63+(-2.421722e+02)*s64 \
v23_part1=3.798314e+03*s0+(-4.059973e+02)*s1+6.552476e+00*s2+4.767409e+01*s3+1.016214e+02*s4+(-1.786700e+02)*s5+4.257718e+02*s6+1.392771e+01*s7+1.672837e+01*s8 \
v23_part2=v23_part1+1.050748e+01*s9+(-3.775270e+03)*s10+(-1.025194e+02)*s11+3.797725e+02*s12+2.015287e+02*s13+2.235787e+02*s14+1.000000e+04*s15+1.000000e+04*s16+(-1.257078e+02)*s17 \
v23_part3=v23_part2+(-1.000000e+04)*s18+1.558162e+03*s19+2.985384e+03*s20+(-1.539775e+01)*s21+(-6.506445e+02)*s22+1.359991e+01*s23+(-2.163152e+02)*s24+(-8.180657e+02)*s25+(-6.459108e+01)*s26 \
v23_part4=v23_part3+2.082037e+01*s27+1.575854e+03*s28+(-5.378545e+01)*s29+(-2.490650e+01)*s30+(-5.964016e+01)*s31+3.435833e+01*s32+(-1.394910e+02)*s33+(-3.525171e+02)*s34+(-1.914165e+01)*s35 \
v23_part5=v23_part4+(-1.034461e+01)*s36+(-1.651084e+01)*s37+(-1.000000e+04)*s38+2.348867e+01*s39+4.716212e+02*s40+(-1.808211e+01)*s41+(-1.000000e+04)*s42+(-7.959688e+01)*s43+(-2.901190e+02)*s44 \
v23_part6=v23_part5+(-3.219339e+01)*s45+3.640514e+01*s46+3.848439e+01*s47+(-2.488798e+01)*s48+(-8.578771e+01)*s49+(-1.580315e+01)*s50+(-3.402390e+01)*s51+2.520990e+00*s52+(-1.000000e+04)*s53 \
v23=v23_part6+(-6.176722e+00)*s54+(-2.310399e+01)*s55+(-4.635501e+00)*s56+(-4.914898e+01)*s57+4.014852e+01*s58+2.353603e+02*s59+(-9.865183e+00)*s60+(-2.888925e+01)*s61+(-2.727345e+01)*s62+(-3.455894e+00)*s63+2.163790e+02*s64 \
v24_part1=1.474973e+03*s0+(-6.807479e+02)*s1+2.036353e+01*s2+2.302110e+01*s3+(-1.619282e+01)*s4+(-8.667270e+02)*s5+(-9.727210e+00)*s6+1.349454e+01*s7+(-2.915511e+00)*s8 \
v24_part2=v24_part1+(-1.484643e+01)*s9+(-1.289080e+03)*s10+(-6.505247e-01)*s11+(-3.924131e+01)*s12+5.329653e+02*s13+1.931107e+02*s14+7.209231e+02*s15+1.000000e+04*s16+3.912427e+01*s17 \
v24_part3=v24_part2+(-1.000000e+04)*s18+(-1.380329e+02)*s19+3.737308e+02*s20+(-2.996064e+00)*s21+(-7.283654e+00)*s22+7.891614e+00*s23+1.278417e+02*s24+(-2.074077e+02)*s25+8.218300e+00*s26 \
v24_part4=v24_part3+5.374183e+01*s27+(-2.916803e+02)*s28+1.614446e+02*s29+(-2.478684e+00)*s30+7.988325e+00*s31+7.904504e+00*s32+(-1.563655e+01)*s33+1.312740e+02*s34+7.597286e-01*s35 \
v24_part5=v24_part4+(-8.375314e-01)*s36+1.779348e+01*s37+(-1.000000e+04)*s38+(-6.318298e+00)*s39+6.019653e+02*s40+(-8.112003e+00)*s41+(-1.000000e+04)*s42+(-6.847322e+01)*s43+1.347157e+02*s44 \
v24_part6=v24_part5+(-2.821227e+00)*s45+2.412126e+02*s46+(-5.517609e+01)*s47+7.148081e+00*s48+2.674177e+02*s49+(-2.689759e+00)*s50+(-2.374113e+00)*s51+(-1.232813e+01)*s52+(-1.000000e+04)*s53 \
v24=v24_part6+9.731068e+00*s54+(-2.877631e+01)*s55+(-3.368899e+00)*s56+3.055669e+01*s57+(-1.675099e+01)*s58+(-3.119793e+02)*s59+(-1.717890e+00)*s60+(-2.961561e+00)*s61+4.090389e+00*s62+1.070498e+00*s63+6.675690e+01*s64 \
v25_part1=1.019092e+03*s0+8.011457e+02*s1+(-1.366610e+01)*s2+(-4.756117e+01)*s3+(-1.238302e+01)*s4+9.662769e+02*s5+(-2.467967e+02)*s6+(-1.117346e+00)*s7+(-1.010919e+01)*s8 \
v25_part2=v25_part1+(-2.355025e+01)*s9+4.003127e+03*s10+6.728710e+00*s11+5.238360e+01*s12+(-4.028500e+02)*s13+(-2.457706e+02)*s14+1.000000e+04*s15+1.000000e+04*s16+3.274029e+00*s17 \
v25_part3=v25_part2+(-1.000000e+04)*s18+(-3.949532e+02)*s19+1.264701e+03*s20+9.052096e+00*s21+5.122321e+02*s22+(-1.083130e+01)*s23+3.440163e+01*s24+9.379628e+01*s25+2.341646e+01*s26 \
v25_part4=v25_part3+(-5.098920e+01)*s27+9.854378e+01*s28+(-7.785131e+01)*s29+1.566346e+01*s30+1.920006e+01*s31+(-1.354326e+01)*s32+(-6.095660e+00)*s33+3.332264e+01*s34+7.371201e+00*s35 \
v25_part5=v25_part4+4.636024e+00*s36+(-2.359363e+01)*s37+(-1.000000e+04)*s38+(-1.731179e+01)*s39+7.612198e+01*s40+1.464037e+01*s41+(-1.000000e+04)*s42+(-9.944518e+01)*s43+7.155559e+01*s44 \
v25_part6=v25_part5+2.150667e+01*s45+(-2.822549e+02)*s46+5.693170e+01*s47+(-2.729641e+00)*s48+(-1.496880e+02)*s49+9.175460e+00*s50+1.812230e+01*s51+(-7.360600e+00)*s52+(-1.000000e+04)*s53 \
v25=v25_part6+(-1.014786e+01)*s54+3.011862e+01*s55+5.100107e+00*s56+(-5.337408e+00)*s57+3.460638e+01*s58+1.246481e+02*s59+5.601219e+00*s60+1.566458e+01*s61+6.148789e+00*s62+1.320846e+01*s63+(-5.730186e+01)*s64 \
v26_part1=3.456964e+03*s0+3.590582e+02*s1+2.031771e+02*s2+1.872021e+02*s3+2.681356e+02*s4+4.154265e+02*s5+3.657968e+02*s6+2.270891e+02*s7+3.488288e+02*s8 \
v26_part2=v26_part1+4.462339e+02*s9+1.668144e+03*s10+3.902600e+02*s11+8.071714e+02*s12+1.783880e+03*s13+5.626516e+02*s14+8.575375e+03*s15+1.606399e+03*s16+4.532836e+02*s17 \
v26_part3=v26_part2+(-1.000000e+04)*s18+5.241564e+02*s19+1.503616e+02*s20+1.080225e+02*s21+8.064182e+02*s22+2.224185e+02*s23+4.736412e+02*s24+8.374361e+02*s25+2.252121e+02*s26 \
v26_part4=v26_part3+3.262631e+02*s27+1.690541e+03*s28+5.153904e+02*s29+1.164929e+02*s30+3.633458e+02*s31+3.074764e+02*s32+6.373982e+02*s33+8.081706e+02*s34+5.567459e+01*s35 \
v26_part5=v26_part4+7.746205e+01*s36+1.662995e+02*s37+(-1.000000e+04)*s38+1.495909e+02*s39+1.537200e+03*s40+1.066234e+02*s41+(-1.000000e+04)*s42+7.543212e+02*s43+5.237184e+02*s44 \
v26_part6=v26_part5+1.604663e+02*s45+9.428704e+02*s46+2.539441e+02*s47+2.926334e+02*s48+6.700451e+02*s49+4.893014e+01*s50+9.134993e+01*s51+1.372276e+02*s52+(-1.000000e+04)*s53 \
v26=v26_part6+1.783972e+02*s54+6.787882e+01*s55+1.150362e+02*s56+2.536959e+02*s57+2.402266e+02*s58+2.213922e+02*s59+4.551559e+01*s60+8.708648e+01*s61+1.457810e+02*s62+1.485259e+02*s63+4.457553e+02*s64 \
v27_part1=(-9.293823e+00)*s0+2.474798e+00*s1+(-3.520208e+00)*s2+(-1.486317e+01)*s3+(-1.745413e+01)*s4+(-3.011430e+00)*s5+(-9.704996e-01)*s6+(-8.500021e+00)*s7+(-2.344600e+01)*s8 \
v27_part2=v27_part1+(-3.391493e+01)*s9+3.386050e+00*s10+(-7.203121e+00)*s11+5.944194e-01*s12+(-2.060622e+00)*s13+(-1.981361e+01)*s14+7.347704e+00*s15+4.933743e+00*s16+(-7.573297e+00)*s17 \
v27_part3=v27_part2+(-5.805487e+03)*s18+(-2.327355e+00)*s19+2.254984e+00*s20+(-2.155024e+00)*s21+(-1.106106e+00)*s22+(-1.771350e+01)*s23+(-1.299056e+01)*s24+(-8.479546e+02)*s25+(-4.763214e+00)*s26 \
v27_part4=v27_part3+(-1.472457e+01)*s27+(-1.104604e+02)*s28+(-2.942367e+01)*s29+2.479262e+00*s30+(-2.928069e+00)*s31+(-1.006821e+01)*s32+(-6.123048e+00)*s33+(-2.667966e+01)*s34+(-8.792495e-02)*s35 \
v27_part5=v27_part4+(-1.820714e+00)*s36+(-9.025043e+00)*s37+(-1.221924e+03)*s38+(-1.205238e+01)*s39+3.306054e-01*s40+(-1.911602e+00)*s41+(-1.249823e+03)*s42+(-1.593137e+01)*s43+(-2.220400e+01)*s44 \
v27_part6=v27_part5+(-4.349036e+00)*s45+(-4.225433e-01)*s46+(-6.584288e+00)*s47+(-1.577646e+01)*s48+(-3.046358e+01)*s49+2.047096e+00*s50+(-1.532703e+00)*s51+(-2.154650e+00)*s52+(-7.610201e+02)*s53 \
v27=v27_part6+(-6.772904e+00)*s54+(-4.531959e+01)*s55+(-2.598229e+00)*s56+(-9.902697e+00)*s57+(-2.543783e+00)*s58+(-5.630292e+01)*s59+(-4.528126e-02)*s60+(-1.921597e+00)*s61+(-5.618626e+00)*s62+(-7.052934e+00)*s63+4.720213e+01*s64 \
v28_part1=(-1.414387e+01)*s0+(-9.799973e+00)*s1+(-1.579235e+00)*s2+8.706111e+00*s3+(-1.438196e+00)*s4+2.124991e+00*s5+(-4.190821e+00)*s6+2.189560e+00*s7+4.459871e+00*s8 \
v28_part2=v28_part1+8.635168e+01*s9+(-3.683524e+00)*s10+5.301252e+00*s11+(-4.905812e+01)*s12+(-9.328080e+01)*s13+(-1.586821e+00)*s14+1.118215e+01*s15+8.485519e+00*s16+(-4.810007e+00)*s17 \
v28_part3=v28_part2+(-7.136471e+03)*s18+(-4.239453e+01)*s19+5.873842e-02*s20+(-8.999796e-01)*s21+(-1.261835e-02)*s22+3.123673e+01*s23+7.109528e+00*s24+7.855757e+00*s25+1.742137e-01*s26 \
v28_part4=v28_part3+(-2.526550e-02)*s27+(-4.452288e+01)*s28+9.740334e-02*s29+3.758303e-01*s30+3.229444e+00*s31+(-2.577839e-01)*s32+4.496003e+00*s33+1.267113e+01*s34+1.181414e-01*s35 \
v28_part5=v28_part4+2.599997e+00*s36+5.996002e+00*s37+(-2.955275e+02)*s38+3.737478e+00*s39+9.698256e-01*s40+4.224587e-01*s41+(-1.031802e+03)*s42+(-2.411711e+00)*s43+6.134502e+00*s44 \
v28_part6=v28_part5+6.692312e-01*s45+4.739374e-01*s46+(-1.037151e+01)*s47+(-3.637275e+00)*s48+(-7.419669e+00)*s49+(-3.315675e+00)*s50+(-5.829831e-02)*s51+(-5.155392e-01)*s52+(-7.821028e+02)*s53 \
v28=v28_part6+2.806322e+00*s54+5.272524e+00*s55+4.212480e-02*s56+4.449115e+00*s57+1.816753e+00*s58+7.642670e+00*s59+9.064158e-02*s60+1.278910e-02*s61+2.457374e+00*s62+(-3.352366e-01)*s63+1.487645e+01*s64 \
v29_part1=(-1.156897e+01)*s0+3.504169e+00*s1+1.133449e+00*s2+6.029401e+00*s3+1.060545e+01*s4+8.844119e-02*s5+(-4.731886e-01)*s6+2.113413e+00*s7+4.726469e+00*s8 \
v29_part2=v29_part1+5.849107e+00*s9+1.666192e+00*s10+5.691991e+00*s11+4.118982e+01*s12+2.676217e+01*s13+5.389617e+00*s14+9.146438e+00*s15+4.292301e+00*s16+8.952279e+00*s17 \
v29_part3=v29_part2+(-4.188324e+03)*s18+(-6.967849e+00)*s19+1.961811e+00*s20+1.782175e+00*s21+(-4.250693e+00)*s22+2.597412e+00*s23+3.880508e-01*s24+5.470097e+02*s25+3.415155e+00*s26 \
v29_part4=v29_part3+1.084472e+01*s27+(-1.468151e+01)*s28+1.826583e+01*s29+(-3.386688e+00)*s30+2.547561e+00*s31+5.898970e-01*s32+6.559633e+00*s33+1.464556e+01*s34+(-5.489005e-02)*s35 \
v29_part5=v29_part4+8.090385e-01*s36+2.855990e+00*s37+(-2.064187e+02)*s38+6.020416e+00*s39+4.036371e-02*s40+7.551646e-01*s41+(-9.128589e+02)*s42+(-2.982519e+01)*s43+1.202975e+01*s44 \
v29_part6=v29_part5+(-4.786894e-01)*s45+(-1.398005e-01)*s46+1.470591e+01*s47+1.370135e+01*s48+3.334877e+01*s49+1.240743e+00*s50+9.736422e-01*s51+6.290912e+00*s52+(-1.320158e+03)*s53 \
v29=v29_part6+2.012694e+00*s54+4.457539e+01*s55+1.714795e+00*s56+7.816136e-01*s57+(-8.979560e+00)*s58+5.091656e+01*s59+(-7.399617e-02)*s60+1.236181e+00*s61+2.010372e+00*s62+1.854418e+00*s63+(-1.164764e+02)*s64 \
v30_part1=2.661687e+02*s0+4.164967e+00*s1+(-6.943572e+00)*s2+(-3.202152e-01)*s3+(-1.413386e+01)*s4+(-1.618743e+01)*s5+(-7.822268e+00)*s6+(-7.473942e+00)*s7+(-1.045400e+01)*s8 \
v30_part2=v30_part1+(-5.152528e+00)*s9+(-3.003696e+01)*s10+9.148239e-01*s11+(-5.674365e-01)*s12+1.086158e+00*s13+(-2.689190e+01)*s14+(-1.794527e+03)*s15+2.120714e+03*s16+1.276994e+00*s17 \
v30_part3=v30_part2+1.000000e+04*s18+(-9.535124e+00)*s19+(-9.145760e+01)*s20+(-2.577560e+00)*s21+(-1.240409e+01)*s22+(-8.035242e+00)*s23+(-6.548404e+00)*s24+(-6.779440e+00)*s25+(-1.751872e+00)*s26 \
v30_part4=v30_part3+(-5.494723e+00)*s27+7.991526e+01*s28+(-2.283637e+01)*s29+(-2.029818e+00)*s30+(-1.174565e+01)*s31+(-1.006761e+01)*s32+8.734726e+00*s33+(-1.551490e+01)*s34+(-3.954513e-01)*s35 \
v30_part5=v30_part4+(-7.651751e-01)*s36+(-4.613008e-01)*s37+1.000000e+04*s38+(-5.464382e+00)*s39+1.014846e+02*s40+(-2.193837e+00)*s41+1.000000e+04*s42+7.290242e+00*s43+(-4.702715e+00)*s44 \
v30_part6=v30_part5+(-1.104326e+00)*s45+(-9.521615e+00)*s46+(-8.078555e+00)*s47+(-1.189447e+01)*s48+(-2.619787e-01)*s49+(-4.224936e-02)*s50+(-5.435651e-01)*s51+(-1.479100e+00)*s52+1.000000e+04*s53 \
v30=v30_part6+(-4.217876e+00)*s54+(-7.421101e-01)*s55+(-2.396229e+00)*s56+(-2.696456e+00)*s57+(-2.180453e+00)*s58+(-1.802670e+01)*s59+(-3.617840e-01)*s60+(-5.750274e-01)*s61+(-2.759187e+00)*s62+(-3.820499e+00)*s63+(-1.724870e+01)*s64 \
v31_part1=5.372777e+02*s0+2.410532e+00*s1+2.482536e+01*s2+1.237927e+01*s3+4.000887e+01*s4+2.397984e+01*s5+4.169875e+01*s6+3.834983e+01*s7+5.700205e+01*s8 \
v31_part2=v31_part1+7.034586e+01*s9+7.189864e+01*s10+3.642002e+01*s11+7.814752e+01*s12+1.387780e+02*s13+1.546347e+02*s14+4.041518e+03*s15+(-1.506147e+03)*s16+1.125702e+01*s17 \
v31_part3=v31_part2+1.000000e+04*s18+1.017722e+02*s19+6.556163e+02*s20+1.277502e+01*s21+4.708472e+01*s22+3.570135e+01*s23+4.272752e+01*s24+8.576471e+01*s25+1.985580e+01*s26 \
v31_part4=v31_part3+3.821800e+01*s27+(-1.384001e+01)*s28+9.179521e+01*s29+1.173952e+01*s30+4.955430e+01*s31+5.990255e+01*s32+6.790460e+01*s33+1.117493e+02*s34+2.345962e+00*s35 \
v31_part5=v31_part4+5.561932e+00*s36+9.042770e+00*s37+1.000000e+04*s38+2.287859e+01*s39+2.261454e+02*s40+1.220584e+01*s41+1.000000e+04*s42+3.702856e+01*s43+4.035893e+01*s44 \
v31_part6=v31_part5+9.030123e+00*s45+4.723185e+01*s46+4.271461e+01*s47+5.790453e+01*s48+6.056319e+01*s49+1.861869e+00*s50+4.981974e+00*s51+1.046644e+01*s52+1.000000e+04*s53 \
v31=v31_part6+2.069143e+01*s54+4.751931e+00*s55+1.246954e+01*s56+2.231864e+01*s57+2.534741e+01*s58+7.036836e+01*s59+2.257955e+00*s60+5.035338e+00*s61+1.186785e+01*s62+1.733138e+01*s63+4.821503e+01*s64 \
v32_part1=1.103545e+02*s0+(-7.979172e+00)*s1+(-4.280926e-01)*s2+(-4.507478e+00)*s3+3.848000e+00*s4+2.162461e+01*s5+4.033238e+00*s6+(-3.207069e+00)*s7+(-6.945956e+00)*s8 \
v32_part2=v32_part1+(-2.319676e+01)*s9+1.094125e+02*s10+(-1.261778e+01)*s11+(-4.199002e+01)*s12+(-4.327684e+01)*s13+(-2.892415e+01)*s14+(-7.202463e+01)*s15+9.943687e+03*s16+(-5.114788e+00)*s17 \
v32_part3=v32_part2+1.000000e+04*s18+(-4.390136e+00)*s19+2.358365e+02*s20+(-3.464139e-01)*s21+3.532013e+00*s22+(-1.191873e+00)*s23+(-7.653826e+00)*s24+1.863015e+00*s25+(-3.810703e+00)*s26 \
v32_part4=v32_part3+(-5.208497e+00)*s27+(-1.064265e+02)*s28+(-2.100143e+00)*s29+(-7.158175e-01)*s30+1.242790e+00*s31+(-6.293342e+00)*s32+(-3.963750e+01)*s33+(-2.416562e+01)*s34+1.863858e-03*s35 \
v32_part5=v32_part4+(-5.084725e-01)*s36+(-2.448283e+00)*s37+1.000000e+04*s38+(-6.304623e-01)*s39+(-2.010823e+02)*s40+(-7.686113e-01)*s41+1.000000e+04*s42+(-2.647382e+01)*s43+(-8.652223e+00)*s44 \
v32_part6=v32_part5+(-8.082734e-01)*s45+2.275898e+00*s46+(-2.238056e+00)*s47+(-4.780607e+00)*s48+(-2.679851e+01)*s49+(-3.810741e-01)*s50+(-5.263922e-01)*s51+(-1.040415e+00)*s52+1.000000e+04*s53 \
v32=v32_part6+(-1.923926e+00)*s54+(-3.049372e-01)*s55+(-3.838157e-01)*s56+(-3.411748e+00)*s57+(-1.158521e+01)*s58+(-2.187286e+00)*s59+(-5.045185e-02)*s60+(-5.556067e-01)*s61+4.130508e-02*s62+(-5.149624e-01)*s63+7.110164e+00*s64 \
v33_part1=4.159491e+02*s0+1.320491e+01*s1+(-7.794089e+00)*s2+9.004125e-01*s3+(-1.477787e+01)*s4+(-7.414253e+00)*s5+(-1.141662e+01)*s6+(-5.627332e+00)*s7+(-6.339862e+00)*s8 \
v33_part2=v33_part1+(-3.781957e-01)*s9+(-1.281160e+02)*s10+6.209891e+00*s11+5.258071e+01*s12+1.064178e+01*s13+(-2.202003e+01)*s14+5.763454e+03*s15+3.621336e+02*s16+3.005335e+00*s17 \
v33_part3=v33_part2+1.000000e+04*s18+(-5.544460e+01)*s19+2.021476e+02*s20+(-3.141028e+00)*s21+(-1.295495e+01)*s22+(-9.430947e+00)*s23+(-6.324759e+00)*s24+(-5.164357e+01)*s25+(-3.037773e-01)*s26 \
v33_part4=v33_part3+(-2.965983e+00)*s27+1.435148e+02*s28+(-2.810789e+01)*s29+(-1.119822e+00)*s30+(-1.432655e+01)*s31+(-8.014524e+00)*s32+1.931760e+01*s33+(-1.080183e+01)*s34+(-5.725307e-01)*s35 \
v33_part5=v33_part4+(-1.087831e+00)*s36+2.498426e-01*s37+1.000000e+04*s38+(-7.597513e+00)*s39+2.435207e+01*s40+(-2.526627e+00)*s41+1.000000e+04*s42+1.772223e+01*s43+(-5.097024e+00)*s44 \
v33_part6=v33_part5+(-7.722027e-02)*s45+(-9.521804e+00)*s46+(-7.618022e+00)*s47+(-1.241594e+01)*s48+8.661709e+00*s49+(-6.318308e-02)*s50+(-8.376608e-01)*s51+(-1.816494e+00)*s52+1.000000e+04*s53 \
v33=v33_part6+(-5.497941e+00)*s54+(-5.178089e-01)*s55+(-2.547455e+00)*s56+(-2.798320e+00)*s57+1.070700e+01*s58+(-1.968892e+01)*s59+(-4.850352e-01)*s60+(-8.233589e-01)*s61+(-3.057525e+00)*s62+(-4.714317e+00)*s63+(-1.965925e+01)*s64 \
v34_part1=(-1.364942e+01)*s0+3.969513e+00*s1+(-4.235852e-01)*s2+(-5.588973e-02)*s3+7.806937e-01*s4+5.848206e+00*s5+(-8.638650e-01)*s6+9.333138e-01*s7+2.681907e-01*s8 \
v34_part2=v34_part1+(-1.846765e+00)*s9+3.293680e+00*s10+1.362458e-01*s11+1.141610e+01*s12+9.220276e+00*s13+(-2.799310e+00)*s14+(-1.256287e+01)*s15+(-2.696340e+00)*s16+(-6.678851e-01)*s17 \
v34_part3=v34_part2+2.594840e+03*s18+8.334449e+00*s19+(-8.003766e-01)*s20+(-1.534206e-01)*s21+(-5.497040e+00)*s22+(-6.394432e-01)*s23+(-9.105832e-01)*s24+(-6.486708e+01)*s25+(-1.947494e-01)*s26 \
v34_part4=v34_part3+4.583871e-01*s27+(-1.699484e+01)*s28+(-1.195124e+00)*s29+(-5.478398e-02)*s30+(-5.216836e-01)*s31+(-1.091020e+00)*s32+(-2.026342e-03)*s33+6.989551e+00*s34+(-2.201385e-03)*s35 \
v34_part5=v34_part4+(-3.602882e-01)*s36+4.813354e-01*s37+8.390704e+02*s38+(-3.074354e-01)*s39+3.899403e-01*s40+(-2.217058e-01)*s41+5.443629e+02*s42+3.625270e+01*s43+(-2.021774e+00)*s44 \
v34_part6=v34_part5+(-2.698402e-01)*s45+1.367214e+00*s46+(-2.315458e+00)*s47+(-1.473426e-01)*s48+(-4.119798e+00)*s49+(-5.426391e-02)*s50+(-7.035952e-02)*s51+(-5.097441e-01)*s52+4.930226e+02*s53 \
v34=v34_part6+(-5.961189e-01)*s54+(-1.692772e-01)*s55+(-2.901659e-01)*s56+(-6.107276e-01)*s57+(-7.065537e-01)*s58+(-1.956516e+00)*s59+(-2.550269e-02)*s60+(-1.211337e-01)*s61+6.873656e-01*s62+(-5.980257e-01)*s63+3.800715e+00*s64 \
v35_part1=(-4.750304e+00)*s0+(-3.930336e+00)*s1+(-1.073281e+00)*s2+(-1.542860e+00)*s3+(-4.642948e+00)*s4+(-4.149222e+00)*s5+(-7.359178e-01)*s6+(-3.529948e+00)*s7+1.121184e+00*s8 \
v35_part2=v35_part1+(-1.069464e+01)*s9+(-5.663888e+00)*s10+(-7.241741e-01)*s11+(-2.392303e+01)*s12+(-1.883677e+01)*s13+(-9.261535e+00)*s14+(-1.767960e+01)*s15+(-1.501625e+00)*s16+2.487940e+00*s17 \
v35_part3=v35_part2+3.222915e+03*s18+(-2.733124e+00)*s19+(-4.457396e-01)*s20+(-3.708253e-01)*s21+(-6.022787e+00)*s22+(-5.925977e-01)*s23+(-3.765395e+00)*s24+(-2.667785e+01)*s25+(-1.941204e-01)*s26 \
v35_part4=v35_part3+(-7.723795e-03)*s27+9.932676e+00*s28+(-2.063439e+00)*s29+(-1.931770e-02)*s30+(-1.361688e+00)*s31+(-1.618632e+00)*s32+(-1.083196e+01)*s33+(-2.414377e+01)*s34+(-8.179609e-02)*s35 \
v35_part5=v35_part4+1.972417e-02*s36+(-9.480209e-01)*s37+1.247519e+03*s38+(-1.516420e+00)*s39+1.199057e+00*s40+(-2.993809e-01)*s41+6.600951e+02*s42+(-4.114446e+01)*s43+(-4.002341e+00)*s44 \
v35_part6=v35_part5+(-2.892212e-01)*s45+(-4.067841e+00)*s46+1.030070e+00*s47+(-1.718114e+00)*s48+(-3.578616e+00)*s49+4.896733e-02*s50+(-1.520623e-01)*s51+6.088832e-01*s52+1.309557e+03*s53 \
v35=v35_part6+(-1.132667e+00)*s54+(-3.923759e-01)*s55+(-3.811900e-01)*s56+(-1.143899e+00)*s57+1.208142e+00*s58+(-6.442894e+00)*s59+(-3.683108e-02)*s60+(-1.323290e-01)*s61+(-1.098622e+00)*s62+(-1.229499e+00)*s63+(-1.753720e+00)*s64 \
v36_part1=(-1.727964e+01)*s0+(-4.786330e-01)*s1+9.384116e-01*s2+6.445223e-01*s3+2.023292e+00*s4+(-3.313834e+00)*s5+1.324846e+00*s6+1.790651e-01*s7+(-3.909231e+00)*s8 \
v36_part2=v36_part1+6.674875e+00*s9+1.513804e+00*s10+(-1.105743e+00)*s11+4.297232e+00*s12+(-5.102874e+00)*s13+4.012036e+00*s14+(-1.590410e+01)*s15+(-3.464368e+00)*s16+(-2.011761e+00)*s17 \
v36_part3=v36_part2+7.244314e+01*s18+(-1.275187e+01)*s19+(-1.028356e+00)*s20+1.834792e-01*s21+7.953272e+00*s22+(-3.820006e-01)*s23+1.955116e+00*s24+7.030668e+01*s25+(-3.169452e-02)*s26 \
v36_part4=v36_part3+(-2.556212e+00)*s27+(-1.919049e+00)*s28+(-2.673429e-01)*s29+1.109278e-02*s30+1.587708e+00*s31+8.167584e-01*s32+3.613487e+00*s33+5.535212e+00*s34+2.751774e-02*s35 \
v36_part5=v36_part4+2.736904e-01*s36+(-3.181054e-01)*s37+5.100290e+02*s38+8.216865e-01*s39+1.384950e+00*s40+2.332248e-01*s41+1.715884e+01*s42+(-1.469607e+01)*s43+3.421882e+00*s44 \
v36_part6=v36_part5+3.044725e-01*s45+(-2.731986e-01)*s46+(-1.459104e-01)*s47+(-7.378501e-01)*s48+3.135459e+00*s49+2.168951e-02*s50+7.292903e-02*s51+(-1.100122e-01)*s52+1.003593e+03*s53 \
v36=v36_part6+8.423716e-01*s54+2.463106e-01*s55+4.246051e-01*s56+4.687874e-01*s57+(-3.479405e-01)*s58+5.031204e+00*s59+3.029353e-02*s60+1.098742e-01*s61+(-8.242439e-02)*s62+9.543599e-01*s63+(-4.441492e+00)*s64 \
v37_part1=(-8.402172e+00)*s0+6.939698e-01*s1+6.507543e+00*s2+1.756683e-01*s3+5.429632e-01*s4+9.327302e-01*s5+1.249751e-01*s6+4.061012e-03*s7+2.087898e-01*s8 \
v37_part2=v37_part1+5.219617e-01*s9+3.275213e-01*s10+(-9.846610e-02)*s11+(-4.182748e-03)*s12+9.683831e-02*s13+3.187100e+00*s14+4.630862e+03*s15+8.233439e+00*s16+3.206705e-01*s17 \
v37_part3=v37_part2+1.222122e-01*s18+(-1.292118e+01)*s19+(-8.326805e+02)*s20+7.049093e+02*s21+3.373992e-01*s22+2.477237e-01*s23+4.364056e-01*s24+(-1.440507e+02)*s25+1.271417e-01*s26 \
v37_part4=v37_part3+7.913411e-02*s27+5.544152e-01*s28+7.023554e-01*s29+1.842914e+01*s30+1.943364e-01*s31+2.504319e-03*s32+1.065593e-01*s33+2.173445e-01*s34+(-2.235005e+00)*s35 \
v37_part5=v37_part4+2.285886e+01*s36+2.067816e-01*s37+7.646853e-02*s38+2.833700e+00*s39+(-6.220130e+02)*s40+5.597903e+02*s41+2.038247e-01*s42+4.155337e-01*s43+5.992690e-01*s44 \
v37_part6=v37_part5+(-2.212664e-02)*s45+(-5.405047e-02)*s46+(-4.359551e-02)*s47+1.812850e-01*s48+4.571564e-01*s49+(-4.033157e+00)*s50+(-5.298056e-02)*s51+2.152155e-01*s52+4.822242e-02*s53 \
v37=v37_part6+1.036630e+00*s54+(-1.820278e+01)*s55+1.501210e-01*s56+3.617875e-01*s57+1.021654e+00*s58+4.135765e-01*s59+(-4.823381e+00)*s60+(-1.572096e-01)*s61+1.591058e-01*s62+3.923556e-01*s63+6.911487e-01*s64 \
v38_part1=(-8.005212e+00)*s0+(-1.764756e-01)*s1+(-1.501774e+01)*s2+4.808181e-01*s3+2.205319e-01*s4+(-3.698138e-01)*s5+1.295391e-01*s6+6.991764e-01*s7+4.877021e-01*s8 \
v38_part2=v38_part1+2.325657e-01*s9+(-2.385833e-01)*s10+5.897146e-01*s11+5.814807e-01*s12+5.419946e-01*s13+(-2.899170e+00)*s14+6.658995e+03*s15+4.763442e+00*s16+1.216342e-01*s17 \
v38_part3=v38_part2+(-2.287880e-03)*s18+1.013871e+01*s19+(-4.748534e+01)*s20+1.222356e+03*s21+8.725857e-02*s22+5.495837e-01*s23+3.930858e-01*s24+1.496991e+02*s25+1.382869e-01*s26 \
v38_part4=v38_part3+4.026540e-01*s27+2.747382e-01*s28+(-8.333058e-02)*s29+(-1.768526e+01)*s30+1.833638e-01*s31+5.378572e-01*s32+6.375459e-01*s33+6.972426e-01*s34+1.413448e+00*s35 \
v38_part5=v38_part4+(-2.401017e+01)*s36+4.859855e-01*s37+(-4.753443e-02)*s38+(-2.452541e+00)*s39+(-1.252685e+01)*s40+1.841535e+02*s41+(-4.355729e-02)*s42+7.219410e-01*s43+1.803215e-01*s44 \
v38_part6=v38_part5+3.449105e-01*s45+4.837428e-01*s46+5.670470e-01*s47+7.762572e-01*s48+3.361563e-01*s49+4.024437e+00*s50+5.352335e-01*s51+3.594080e-01*s52+(-5.949759e-02)*s53 \
v38=v38_part6+(-2.337083e-01)*s54+2.251262e+01*s55+4.583917e-01*s56+(-9.653177e-02)*s57+(-4.565325e-01)*s58+3.232958e-01*s59+3.325010e+00*s60+6.802350e-01*s61+4.665403e-01*s62+1.240975e-01*s63+(-1.930594e-02)*s64 \
v39_part1=(-4.886878e+02)*s0+(-2.057303e+00)*s1+(-3.605101e+00)*s2+(-1.155210e+00)*s3+(-1.425105e+00)*s4+(-2.574338e+00)*s5+(-1.174657e+00)*s6+(-1.464016e+00)*s7+(-1.408716e+00)*s8 \
v39_part2=v39_part1+(-1.783540e+00)*s9+(-2.908474e+00)*s10+(-6.691480e-01)*s11+(-1.154979e+00)*s12+(-1.293483e+00)*s13+(-5.721713e+00)*s14+(-6.947949e+03)*s15+(-3.325418e+01)*s16+(-1.311217e+00)*s17 \
v39_part3=v39_part2+6.406380e-01*s18+1.139892e+01*s19+(-4.374430e+02)*s20+(-1.129111e+03)*s21+(-1.434310e+00)*s22+(-1.578887e+00)*s23+(-1.652402e+00)*s24+(-3.012561e+01)*s25+(-1.065506e+00)*s26 \
v39_part4=v39_part3+(-9.040974e-01)*s27+(-2.571811e+00)*s28+(-2.017708e+00)*s29+(-3.492572e+01)*s30+(-1.219097e+00)*s31+(-9.306651e-01)*s32+(-1.086136e+00)*s33+(-1.438923e+00)*s34+6.683221e-01*s35 \
v39_part5=v39_part4+(-4.618984e+01)*s36+(-9.831438e-01)*s37+6.190551e-01*s38+(-5.953516e+00)*s39+(-2.074496e+02)*s40+(-9.623572e+03)*s41+5.206022e-01*s42+(-1.723295e+00)*s43+(-1.776617e+00)*s44 \
v39_part6=v39_part5+(-6.576029e-01)*s45+(-1.005940e+00)*s46+(-7.342101e-01)*s47+(-1.973455e+00)*s48+(-1.533320e+00)*s49+(-1.131372e+00)*s50+(-1.076842e+00)*s51+(-1.054474e+00)*s52+6.110767e-01*s53 \
v39=v39_part6+(-3.770098e+00)*s54+(-8.314250e+00)*s55+(-1.466494e+00)*s56+(-1.412875e+00)*s57+(-2.613434e+00)*s58+(-1.487016e+00)*s59+(-4.752115e+00)*s60+(-1.148958e+00)*s61+(-1.044664e+00)*s62+(-1.572934e+00)*s63+(-1.953444e+00)*s64 \
v40_part1=(-7.449486e+01)*s0+1.223854e+00*s1+9.957042e+00*s2+3.335521e-01*s3+6.230207e-01*s4+1.700561e+00*s5+7.062782e-01*s6+4.776105e-01*s7+5.452079e-01*s8 \
v40_part2=v40_part1+9.054225e-01*s9+2.942140e+00*s10+5.980135e-02*s11+3.762298e-01*s12+4.952203e-01*s13+5.703560e+00*s14+(-1.000000e+04)*s15+(-2.781762e+00)*s16+6.209109e-01*s17 \
v40_part3=v40_part2+(-2.898251e-01)*s18+(-8.675398e+00)*s19+(-2.905743e+02)*s20+(-1.771673e+03)*s21+7.939013e-01*s22+6.032219e-01*s23+7.844111e-01*s24+1.612905e+01*s25+5.695243e-01*s26 \
v40_part4=v40_part3+2.931130e-01*s27+1.548141e+00*s28+1.305631e+00*s29+3.247852e+01*s30+5.681314e-01*s31+2.466004e-01*s32+2.024778e-01*s33+5.079729e-01*s34+(-1.367012e-01)*s35 \
v40_part5=v40_part4+4.561335e+01*s36+1.521505e-01*s37+(-2.475727e-01)*s38+5.369354e+00*s39+(-6.125409e+00)*s40+3.510585e+03*s41+(-2.088804e-01)*s42+3.169818e-01*s43+9.911950e-01*s44 \
v40_part6=v40_part5+1.390775e-01*s45+3.134066e-01*s46+8.432499e-02*s47+8.043620e-01*s48+7.187588e-01*s49+1.310050e-01*s50+7.813493e-01*s51+3.332596e-01*s52+(-2.364412e-01)*s53 \
v40=v40_part6+3.133680e+00*s54+(-2.628982e+00)*s55+5.306288e-01*s56+9.074148e-01*s57+1.615345e+00*s58+7.426109e-01*s59+5.896265e+00*s60+7.503290e-01*s61+2.423541e-01*s62+8.488626e-01*s63+1.170756e+00*s64 \
v41_part1=1.163673e+01*s0+(-2.176782e-01)*s1+2.477657e-01*s2+(-1.287720e-01)*s3+1.133028e-01*s4+(-1.266312e-01)*s5+(-1.678916e-01)*s6+(-1.011051e-01)*s7+(-1.638052e-01)*s8 \
v41_part2=v41_part1+(-1.259692e-01)*s9+(-1.252309e-01)*s10+(-6.941296e-02)*s11+(-7.622527e-02)*s12+(-7.382783e-02)*s13+(-2.294618e-01)*s14+(-1.451371e+01)*s15+(-1.743767e+00)*s16+1.232169e-01*s17 \
v41_part3=v41_part2+7.957438e-02*s18+(-4.459659e-01)*s19+5.161661e-01*s20+3.621579e+00*s21+4.605606e-02*s22+(-2.638742e-02)*s23+1.892196e-02*s24+4.710252e+02*s25+(-1.338623e-01)*s26 \
v41_part4=v41_part3+(-1.326121e-01)*s27+(-1.667957e-01)*s28+(-3.114420e-01)*s29+(-3.845303e-01)*s30+(-1.659873e-01)*s31+(-5.957546e-02)*s32+(-1.161123e-01)*s33+(-3.754405e-01)*s34+5.295452e-01*s35 \
v41_part5=v41_part4+1.688100e+01*s36+(-2.017091e-01)*s37+5.076528e-02*s38+7.586329e-02*s39+(-6.038490e-01)*s40+5.724634e+00*s41+3.440225e-03*s42+(-3.746866e-01)*s43+(-4.846934e-02)*s44 \
v41_part6=v41_part5+(-4.524833e-02)*s45+(-8.281903e-02)*s46+(-2.232748e-02)*s47+(-2.838994e-01)*s48+(-1.193287e-01)*s49+1.163235e+01*s50+(-1.248801e-01)*s51+(-5.467296e-02)*s52+3.180587e-02*s53 \
v41=v41_part6+4.416187e-01*s54+2.628269e+01*s55+2.793114e-02*s56+1.228657e-01*s57+(-4.157830e-01)*s58+(-1.352090e-01)*s59+1.314789e+00*s60+(-2.404455e-02)*s61+(-1.355849e-01)*s62+2.297395e-02*s63+(-2.570086e-01)*s64 \
v42_part1=4.013421e+00*s0+1.339403e-01*s1+(-3.295965e-01)*s2+6.171194e-02*s3+1.390121e-01*s4+9.288376e-02*s5+8.724535e-02*s6+1.259166e-01*s7+3.885703e-02*s8 \
v42_part2=v42_part1+(-2.949396e-02)*s9+1.370487e-01*s10+2.636353e-02*s11+1.332661e-01*s12+7.671397e-02*s13+1.432145e-01*s14+(-5.005670e+00)*s15+1.014308e+00*s16+9.653884e-03*s17 \
v42_part3=v42_part2+(-3.208922e-02)*s18+4.128213e-01*s19+1.098060e+00*s20+(-1.742511e+00)*s21+2.986588e-02*s22+(-3.307465e-03)*s23+1.835797e-01*s24+(-4.898571e+02)*s25+4.721481e-02*s26 \
v42_part4=v42_part3+4.386241e-02*s27+8.323236e-02*s28+1.653786e-01*s29+4.501495e-01*s30+2.996237e-02*s31+3.896295e-02*s32+1.210531e-01*s33+3.048954e-01*s34+(-3.823355e-01)*s35 \
v42_part5=v42_part4+(-1.308779e+01)*s36+2.662011e-02*s37+(-3.049491e-02)*s38+2.001025e-02*s39+1.256858e+00*s40+2.976498e+00*s41+(-1.786026e-02)*s42+1.538789e-01*s43+2.203582e-01*s44 \
v42_part6=v42_part5+1.942877e-02*s45+2.105662e-02*s46+5.257988e-02*s47+2.920972e-01*s48+1.437437e-01*s49+(-6.357309e+00)*s50+(-2.229901e-02)*s51+(-3.641996e-04)*s52+(-3.191736e-02)*s53 \
v42=v42_part6+(-5.308255e-01)*s54+(-3.174202e+01)*s55+3.930616e-02*s56+(-3.167478e-03)*s57+3.148819e-01*s58+1.699374e-01*s59+(-1.390230e+00)*s60+(-5.980526e-03)*s61+3.101735e-02*s62+5.377093e-02*s63+1.822564e-01*s64 \
v43_part1=3.661717e+00*s0+(-1.099635e-02)*s1+(-5.146198e-02)*s2+5.577128e-02*s3+(-1.775792e-01)*s4+4.023075e-03*s5+3.783878e-02*s6+1.221084e-03*s7+1.133148e-01*s8 \
v43_part2=v43_part1+2.025465e-01*s9+(-7.783855e-03)*s10+3.414086e-02*s11+(-3.383443e-02)*s12+2.412427e-02*s13+8.865692e-02*s14+(-4.567013e+00)*s15+(-1.126697e+00)*s16+(-6.993611e-02)*s17 \
v43_part3=v43_part2+(-1.413184e-02)*s18+9.172067e-02*s19+(-3.344466e-01)*s20+1.009425e+00*s21+5.759020e-02*s22+2.389980e-02*s23+(-1.119941e-01)*s24+3.365921e+01*s25+2.570713e-02*s26 \
v43_part4=v43_part3+8.026435e-02*s27+2.436885e-01*s28+9.308489e-02*s29+(-4.826894e-01)*s30+1.000353e-01*s31+3.516044e-02*s32+5.093991e-02*s33+2.264939e-01*s34+9.495836e-02*s35 \
v43_part5=v43_part4+(-2.838201e+00)*s36+1.624815e-01*s37+(-1.712585e-02)*s38+2.179594e-02*s39+(-1.247103e+00)*s40+6.395379e+00*s41+(-1.146254e-02)*s42+2.348139e-01*s43+(-6.428454e-02)*s44 \
v43_part6=v43_part5+1.985559e-02*s45+5.274767e-02*s46+5.417849e-02*s47+2.536280e-02*s48+2.500255e-02*s49+(-4.363936e+00)*s50+1.685296e-01*s51+5.306200e-03*s52+(-1.127631e-02)*s53 \
v43=v43_part6+3.015371e-03*s54+1.592547e+01*s55+(-3.028326e-02)*s56+2.370142e-02*s57+1.809275e-01*s58+3.964821e-02*s59+4.749569e-02*s60+4.506743e-02*s61+7.509498e-02*s62+(-2.922138e-03)*s63+1.211007e-01*s64 \
v44_part1=1.565511e+00*s0+2.594461e+00*s1+2.181014e-01*s2+8.264444e-01*s3+(-2.281352e-01)*s4+8.964978e-02*s5+(-9.864714e-01)*s6+(-5.917215e-01)*s7+(-1.078894e+00)*s8 \
v44_part2=v44_part1+5.098856e-01*s9+(-4.698464e-01)*s10+(-2.568422e-01)*s11+(-4.360356e-01)*s12+(-3.481833e-01)*s13+(-4.986642e-01)*s14+(-1.179809e-02)*s15+(-3.122094e-01)*s16+(-6.585816e-01)*s17 \
v44_part3=v44_part2+5.154415e-02*s18+(-1.259587e-01)*s19+(-2.570177e-01)*s20+2.238298e-02*s21+(-2.117106e-01)*s22+4.668302e-02*s23+(-3.218898e-01)*s24+1.552650e+00*s25+(-1.855677e-01)*s26 \
v44_part4=v44_part3+(-4.256566e-02)*s27+(-3.729659e-01)*s28+(-8.198835e-01)*s29+2.968714e-01*s30+(-6.565579e-01)*s31+(-9.870127e-02)*s32+4.111541e-01*s33+(-1.752032e-01)*s34+1.108760e-01*s35 \
v44_part5=v44_part4+2.317786e-01*s36+3.143643e-01*s37+6.886153e-02*s38+(-8.973052e-01)*s39+1.781895e-02*s40+6.528474e-03*s41+9.505323e-02*s42+6.814545e-02*s43+(-7.117381e-02)*s44 \
v44_part6=v44_part5+3.996419e-01*s45+(-1.951283e-03)*s46+1.954854e-01*s47+(-5.655874e-02)*s48+(-5.411070e-01)*s49+6.657790e-01*s50+1.113557e-01*s51+9.495276e-01*s52+1.302723e-01*s53 \
v44=v44_part6+(-2.135451e-01)*s54+2.885569e-01*s55+2.676170e-01*s56+(-4.800684e-02)*s57+(-3.410833e-01)*s58+(-1.278337e-01)*s59+(-9.604216e-03)*s60+4.982705e-01*s61+6.584763e-01*s62+1.662637e-01*s63+(-2.946479e-01)*s64 \
v45_part1=4.212183e-01*s0+(-1.159976e+00)*s1+2.067536e+00*s2+1.868770e+00*s3+3.482280e+00*s4+1.582424e+00*s5+3.221123e+00*s6+3.316831e+00*s7+3.958701e+00*s8 \
v45_part2=v45_part1+2.054733e+00*s9+2.403796e+00*s10+2.441981e+00*s11+2.911628e+00*s12+2.368963e+00*s13+2.874094e+00*s14+9.276993e-01*s15+1.965260e+00*s16+2.588303e+00*s17 \
v45_part3=v45_part2+1.860971e+00*s18+1.971103e+00*s19+1.688450e+00*s20+1.428776e+00*s21+1.906403e+00*s22+1.601234e+00*s23+2.480349e+00*s24+(-9.359198e-02)*s25+1.858325e+00*s26 \
v45_part4=v45_part3+1.765872e+00*s27+2.128351e+00*s28+2.912391e+00*s29+1.039495e+00*s30+2.415949e+00*s31+1.812231e+00*s32+1.093046e+00*s33+2.111458e+00*s34+7.686377e-01*s35 \
v45_part5=v45_part4+1.446595e+00*s36+9.736720e-01*s37+1.483551e+00*s38+3.351448e+00*s39+8.892826e-01*s40+1.182098e+00*s41+1.398082e+00*s42+1.935800e+00*s43+1.841857e+00*s44 \
v45_part6=v45_part5+7.618145e-01*s45+1.421382e+00*s46+1.214961e+00*s47+1.857784e+00*s48+2.190810e+00*s49+(-5.301953e-02)*s50+9.261238e-01*s51+(-2.846192e-02)*s52+1.200286e+00*s53 \
v45=v45_part6+2.024662e+00*s54+9.762122e-01*s55+9.086160e-01*s56+1.426720e+00*s57+1.851123e+00*s58+1.781771e+00*s59+7.988218e-01*s60+4.080098e-01*s61+2.694602e-01*s62+1.053495e+00*s63+1.753582e+00*s64 \
v46_part1=(-1.576337e+00)*s0+(-4.012308e+00)*s1+(-1.791641e+00)*s2+(-2.602129e+00)*s3+(-1.771409e+00)*s4+(-6.349714e-01)*s5+6.756453e-01*s6+(-7.786038e-02)*s7+2.787316e-01*s8 \
v46_part2=v46_part1+(-1.847943e+00)*s9+4.416086e-02*s10+(-2.227430e-01)*s11+(-1.028881e-01)*s12+(-4.240948e-01)*s13+(-3.881769e-01)*s14+7.659518e-02*s15+5.005178e-02*s16+1.088009e-01*s17 \
v46_part3=v46_part2+(-7.505373e-01)*s18+(-1.012722e+00)*s19+(-6.002701e-01)*s20+(-1.098261e+00)*s21+(-4.002442e-01)*s22+(-9.452283e-01)*s23+(-5.553462e-01)*s24+(-1.406557e+00)*s25+(-1.990589e-01)*s26 \
v46_part4=v46_part3+(-5.288785e-01)*s27+(-3.502685e-01)*s28+(-2.259097e-02)*s29+(-4.904055e-01)*s30+3.948769e-01*s31+(-4.201356e-01)*s32+(-1.165007e+00)*s33+(-3.604000e-01)*s34+(-3.100146e-01)*s35 \
v46_part5=v46_part4+(-1.060679e-01)*s36+(-9.108229e-01)*s37+(-5.748122e-01)*s38+6.125061e-01*s39+(-7.021699e-03)*s40+(-8.206244e-01)*s41+(-5.547166e-01)*s42+(-3.656547e-01)*s43+(-5.973389e-01)*s44 \
v46_part6=v46_part5+(-7.476410e-01)*s45+(-3.406232e-01)*s46+(-6.682677e-01)*s47+(-4.365885e-01)*s48+4.211380e-02*s49+(-8.768889e-01)*s50+(-6.467096e-01)*s51+(-1.670088e+00)*s52+(-5.029335e-01)*s53 \
v46=v46_part6+(-4.379254e-01)*s54+(-2.371116e-01)*s55+(-6.450823e-01)*s56+(-3.212526e-01)*s57+(-8.496008e-02)*s58+(-4.810046e-01)*s59+(-1.288576e-02)*s60+(-1.031563e+00)*s61+(-1.232465e+00)*s62+(-4.955607e-01)*s63+(-1.379378e-01)*s64 \
v47_part1=2.804506e+00*s0+6.380078e+00*s1+3.599586e+00*s2+4.297271e+00*s3+3.129578e+00*s4+1.397589e+00*s5+(-3.279619e-01)*s6+2.019845e-01*s7+(-1.915805e-01)*s8 \
v47_part2=v47_part1+2.358548e+00*s9+1.383392e-01*s10+2.129669e-01*s11+(-5.641269e-02)*s12+4.325456e-01*s13+4.865968e-01*s14+(-8.084298e-03)*s15+8.450327e-01*s16+6.443870e-01*s17 \
v47_part3=v47_part2+1.667709e+00*s18+2.244751e+00*s19+1.533777e+00*s20+2.140286e+00*s21+1.214337e+00*s22+2.010979e+00*s23+1.039856e+00*s24+1.795659e+00*s25+4.499959e-01*s26 \
v47_part4=v47_part3+8.120811e-01*s27+6.694118e-01*s28+(-1.452588e-01)*s29+9.885784e-01*s30+(-3.200119e-01)*s31+6.938710e-01*s32+1.740842e+00*s33+2.507890e-01*s34+1.245545e+00*s35 \
v47_part5=v47_part4+5.015753e-01*s36+1.802355e+00*s37+1.263181e+00*s38+(-9.303334e-01)*s39+6.162656e-02*s40+1.788077e+00*s41+1.064507e+00*s42+2.017178e-01*s43+9.002860e-01*s44 \
v47_part6=v47_part5+1.133636e+00*s45+5.322676e-01*s46+9.372280e-01*s47+2.616217e-01*s48+1.527111e-02*s49+1.244234e+00*s50+1.448142e+00*s51+2.688123e+00*s52+1.077214e+00*s53 \
v47=v47_part6+5.366400e-01*s54+3.669769e-01*s55+1.132784e+00*s56+6.199518e-01*s57+(-7.449224e-02)*s58+5.421005e-01*s59+9.112252e-02*s60+1.733670e+00*s61+2.006938e+00*s62+9.531700e-01*s63+3.052576e-01*s64 \
v48_part1=(-7.521761e-01)*s0+4.730369e-02*s1+(-1.617431e-01)*s2+2.729755e-01*s3+3.770050e-02*s4+(-3.060584e-02)*s5+1.000993e-01*s6+(-6.528713e-02)*s7+(-8.767165e-02)*s8 \
v48_part2=v48_part1+(-2.010514e-01)*s9+(-3.947581e-02)*s10+2.229115e-02*s11+(-2.129820e-02)*s12+(-6.444884e-02)*s13+(-1.034577e-01)*s14+2.943350e-02*s15+(-6.607324e-01)*s16+(-2.447041e-01)*s17 \
v48_part3=v48_part2+(-8.093354e-02)*s18+(-3.069229e-01)*s19+(-1.631261e-01)*s20+(-5.370146e-03)*s21+5.731795e-02*s22+1.110196e-01*s23+(-4.781690e-02)*s24+(-5.666544e+00)*s25+1.812961e-02*s26 \
v48_part4=v48_part3+(-1.528510e-02)*s27+(-7.459177e-03)*s28+(-3.850020e-02)*s29+(-6.624690e-01)*s30+(-1.513904e-03)*s31+7.907874e-02*s32+5.684925e-03*s33+(-2.437633e-01)*s34+(-2.538974e-01)*s35 \
v48_part5=v48_part4+(-3.311913e+00)*s36+(-1.313022e-01)*s37+(-9.117433e-02)*s38+(-1.486097e+00)*s39+8.103473e-03*s40+7.765803e-03*s41+(-2.905308e-02)*s42+(-1.901319e+00)*s43+1.649993e-02*s44 \
v48_part6=v48_part5+(-5.308543e-02)*s45+(-3.370874e-02)*s46+(-8.161095e-03)*s47+(-5.852053e-02)*s48+(-1.262720e-02)*s49+(-1.485507e+00)*s50+(-1.492912e-02)*s51+(-4.335472e-02)*s52+(-2.803791e-02)*s53 \
v48=v48_part6+(-3.991620e-01)*s54+(-4.642588e+00)*s55+1.842749e-02*s56+(-2.405292e-03)*s57+(-5.515363e-01)*s58+7.623723e-02*s59+(-1.550620e-02)*s60+(-9.639446e-02)*s61+(-9.146649e-02)*s62+(-8.812146e-02)*s63+(-4.440705e-02)*s64 \
v49_part1=6.897561e-01*s0+3.697588e-01*s1+5.480428e-01*s2+1.460880e-02*s3+5.036227e-01*s4+6.095015e-02*s5+1.304398e-01*s6+1.885410e-01*s7+3.323348e-01*s8 \
v49_part2=v49_part1+2.842658e-01*s9+7.101133e-02*s10+3.352537e-02*s11+4.370760e-02*s12+1.756817e-01*s13+2.531291e-01*s14+(-2.405860e-03)*s15+8.304125e-01*s16+1.811939e-01*s17 \
v49_part3=v49_part2+2.669761e-01*s18+2.655830e-01*s19+1.908109e-01*s20+2.207499e-01*s21+1.489509e-01*s22+8.386580e-02*s23+1.852808e-01*s24+3.908162e+00*s25+4.650954e-02*s26 \
v49_part4=v49_part3+8.714613e-02*s27+2.417126e-01*s28+1.098081e-01*s29+1.200357e+00*s30+1.087746e-01*s31+3.563087e-02*s32+1.128452e-01*s33+1.524305e-01*s34+5.135161e-01*s35 \
v49_part5=v49_part4+3.346459e+00*s36+2.218873e-01*s37+2.070120e-01*s38+7.508288e-01*s39+7.588594e-03*s40+1.590712e-02*s41+1.169125e-01*s42+1.317297e+00*s43+9.908287e-02*s44 \
v49_part6=v49_part5+6.491661e-02*s45+4.590141e-02*s46+3.274414e-02*s47+2.278022e-02*s48+5.361225e-02*s49+3.487602e+00*s50+1.132496e-01*s51+1.153119e-01*s52+1.655888e-01*s53 \
v49=v49_part6+(-3.277574e-02)*s54+2.205499e+00*s55+3.683696e-02*s56+9.467421e-02*s57+8.213284e-01*s58+(-9.477950e-02)*s59+(-6.451799e-03)*s60+1.465625e-01*s61+1.519569e-01*s62+1.009125e-01*s63+8.974630e-02*s64 \
v50_part1=2.428787e-01*s0+(-2.651155e-01)*s1+(-1.232323e-01)*s2+(-1.910777e-01)*s3+(-2.980612e-01)*s4+5.676028e-03*s5+(-1.083384e-01)*s6+1.812595e-02*s7+(-1.081549e-01)*s8 \
v50_part2=v50_part1+6.961766e-02*s9+1.793471e-02*s10+(-4.715860e-02)*s11+(-9.245482e-02)*s12+(-4.234644e-02)*s13+(-4.369686e-02)*s14+(-3.475260e-02)*s15+6.701786e-02*s16+2.648129e-01*s17 \
v50_part3=v50_part2+(-2.227254e-02)*s18+2.613153e-01*s19+9.643201e-02*s20+(-1.156677e-01)*s21+(-6.687510e-02)*s22+(-1.961993e-01)*s23+(-1.117929e-01)*s24+3.267391e+00*s25+(-3.630644e-02)*s26 \
v50_part4=v50_part3+(-2.553250e-02)*s27+(-1.252468e-01)*s28+(-3.816126e-02)*s29+(-3.944178e-01)*s30+(-5.852835e-02)*s31+(-1.179559e-01)*s32+(-8.050583e-02)*s33+(-4.298132e-02)*s34+(-3.541127e-02)*s35 \
v50_part5=v50_part4+7.322082e-01*s36+7.490949e-02*s37+(-7.120343e-03)*s38+1.262149e+00*s39+(-9.184100e-03)*s40+1.800946e-02*s41+(-3.312610e-02)*s42+1.172566e+00*s43+(-8.397530e-02)*s44 \
v50_part6=v50_part5+2.382881e-02*s45+2.947111e-02*s46+(-1.958947e-02)*s47+(-1.572898e-02)*s48+(-1.288678e-02)*s49+4.621737e-01*s50+(-4.056793e-02)*s51+1.626488e-02*s52+(-6.736529e-02)*s53 \
v50=v50_part6+7.889913e-01*s54+3.848467e+00*s55+(-1.452853e-02)*s56+(-3.634458e-02)*s57+1.266245e-01*s58+3.780335e-02*s59+3.974167e-02*s60+1.647470e-02*s61+3.028865e-02*s62+5.655035e-02*s63+3.912796e-02*s64 \
v51_part1=4.398321e+01*s0+2.551826e+01*s1+1.640251e+01*s2+2.753362e+01*s3+2.108661e+01*s4+1.765009e+01*s5+1.604379e+01*s6+6.406505e+01*s7+1.093663e+02*s8 \
v51_part2=v51_part1+2.103384e+01*s9+2.018791e+01*s10+5.775676e+01*s11+1.402735e+02*s12+(-7.076546e+00)*s13+1.560738e+01*s14+(-4.835065e+03)*s15+8.211933e+00*s16+1.180960e+01*s17 \
v51_part3=v51_part2+1.576987e+01*s18+1.188403e+01*s19+1.326168e+01*s20+9.429176e+00*s21+1.172961e+01*s22+1.047169e+01*s23+1.232483e+01*s24+5.101669e+01*s25+1.284348e+01*s26 \
v51_part4=v51_part3+1.438540e+01*s27+1.106506e+01*s28+9.937804e+00*s29+2.233156e+01*s30+2.995203e+00*s31+2.483870e+01*s32+1.490559e+01*s33+6.954020e+01*s34+1.478167e+03*s35 \
v51_part5=v51_part4+8.733587e+00*s36+1.626266e+01*s37+1.996202e+01*s38+2.308894e+01*s39+(-1.234703e+00)*s40+9.436183e+00*s41+1.367184e+01*s42+1.655278e+01*s43+1.349623e+01*s44 \
v51_part6=v51_part5+1.703970e+01*s45+1.340236e+01*s46+1.770557e+01*s47+1.582558e+02*s48+6.706631e+00*s49+(-3.208577e-01)*s50+4.260156e+01*s51+4.133917e+01*s52+2.036276e+01*s53 \
v51=v51_part6+2.073713e+01*s54+1.544355e+01*s55+1.417815e+01*s56+1.072342e+01*s57+3.759960e+00*s58+1.163749e+01*s59+6.799812e+00*s60+7.041467e+02*s61+2.934144e+01*s62+2.334181e+01*s63+1.771117e+01*s64 \
v52_part1=(-1.171933e+01)*s0+(-1.848504e+01)*s1+(-8.105759e+00)*s2+(-1.648368e+01)*s3+(-1.154248e+01)*s4+(-9.089071e+00)*s5+(-2.309199e+00)*s6+(-2.874343e+01)*s7+(-6.946328e+01)*s8 \
v52_part2=v52_part1+(-1.330610e+01)*s9+4.114625e-01*s10+(-3.353950e+01)*s11+(-9.596351e+01)*s12+3.059567e+01*s13+(-7.798765e+00)*s14+(-2.023140e+03)*s15+7.742560e-01*s16+(-3.884970e+00)*s17 \
v52_part3=v52_part2+(-8.504075e+00)*s18+(-4.536481e+00)*s19+2.575297e+00*s20+(-3.075822e+00)*s21+(-5.250733e+00)*s22+(-4.253321e+00)*s23+(-5.189535e+00)*s24+(-1.332564e+01)*s25+(-5.813468e+00)*s26 \
v52_part4=v52_part3+(-7.716753e+00)*s27+(-4.807288e+00)*s28+(-2.622994e+00)*s29+(-1.145678e+01)*s30+1.760340e+01*s31+(-6.367647e+00)*s32+(-9.999891e+00)*s33+(-5.016404e+01)*s34+9.328553e-01*s35 \
v52_part5=v52_part4+4.743595e+01*s36+(-8.594305e+00)*s37+(-8.146845e+00)*s38+(-1.324386e+01)*s39+(-2.128533e+00)*s40+(-4.093345e+00)*s41+(-7.947771e+00)*s42+(-7.590612e+00)*s43+(-7.237731e+00)*s44 \
v52_part6=v52_part5+(-1.240883e+01)*s45+(-7.159832e+00)*s46+(-1.239513e+01)*s47+(-1.278125e+02)*s48+(-1.083576e-02)*s49+(-3.366496e-01)*s50+(-1.439896e+01)*s51+(-3.592577e+01)*s52+(-8.026392e+00)*s53 \
v52=v52_part6+(-6.608829e+00)*s54+(-8.189544e+00)*s55+(-9.478158e+00)*s56+(-4.850497e+00)*s57+1.079491e+01*s58+(-3.109889e+00)*s59+7.134483e+00*s60+2.363402e+03*s61+(-2.133134e+01)*s62+(-7.954093e+00)*s63+(-2.947168e+00)*s64 \
v53_part1=4.284307e+01*s0+(-7.666192e+00)*s1+1.552994e+00*s2+(-4.044505e+00)*s3+6.499151e-01*s4+6.692781e+00*s5+1.688587e+01*s6+4.704825e+01*s7+(-2.329314e+01)*s8 \
v53_part2=v53_part1+(-3.739930e+00)*s9+4.941531e+01*s10+(-1.778031e+01)*s11+(-1.049379e+01)*s12+6.090388e+01*s13+1.005551e+00*s14+(-9.917142e+02)*s15+1.484519e+01*s16+5.913851e+00*s17 \
v53_part3=v53_part2+3.325619e+00*s18+7.315160e+00*s19+1.573456e+01*s20+6.352357e-01*s21+4.514442e+00*s22+6.570384e+00*s23+4.516657e+00*s24+3.208582e+01*s25+2.103936e+00*s26 \
v53_part4=v53_part3+3.908968e-01*s27+3.747320e+00*s28+2.749047e+00*s29+(-2.177371e+00)*s30+6.233314e+01*s31+1.867073e+01*s32+(-1.505041e+00)*s33+(-1.201449e+01)*s34+6.446326e+00*s35 \
v53_part5=v53_part4+6.620066e+01*s36+1.538564e+00*s37+1.589543e+00*s38+6.363536e-01*s39+(-1.248705e+00)*s40+1.846352e+00*s41+1.216948e+00*s42+(-6.366413e-01)*s43+1.627573e+00*s44 \
v53_part6=v53_part5+(-5.107529e+00)*s45+3.707747e-02*s46+(-3.983985e+00)*s47+(-1.010140e+02)*s48+9.523259e+00*s49+(-2.177380e-01)*s50+9.516418e+00*s51+(-2.886921e+01)*s52+7.407196e+00*s53 \
v53=v53_part6+1.262588e+01*s54+4.157720e+00*s55+(-1.421878e+00)*s56+2.229059e+00*s57+1.990580e+00*s58+7.023666e-01*s59+4.614436e+00*s60+(-1.690837e+02)*s61+(-9.118250e+00)*s62+1.184117e+01*s63+1.557307e+01*s64 \
v54_part1=(-4.794658e+01)*s0+9.320200e+00*s1+(-1.207290e+00)*s2+4.645333e+00*s3+(-2.577773e-01)*s4+(-3.853998e+00)*s5+(-1.703195e+01)*s6+(-4.220954e+01)*s7+1.696219e+01*s8 \
v54_part2=v54_part1+4.297674e+00*s9+(-3.996780e+01)*s10+1.273011e+01*s11+1.162689e+01*s12+(-6.271476e+01)*s13+(-8.824253e-01)*s14+(-1.000000e+04)*s15+(-1.487687e+01)*s16+(-6.060025e+00)*s17 \
v54_part3=v54_part2+(-2.637803e+00)*s18+(-6.048216e+00)*s19+(-1.237238e+01)*s20+1.113400e+00*s21+(-3.727978e+00)*s22+(-5.284828e+00)*s23+(-4.656383e+00)*s24+(-1.672809e+01)*s25+(-2.191794e+00)*s26 \
v54_part4=v54_part3+(-6.980537e-03)*s27+(-2.794532e+00)*s28+(-3.299138e+00)*s29+3.950173e-01*s30+(-6.035877e+01)*s31+(-1.922253e+01)*s32+3.515535e+00*s33+1.082350e+01*s34+2.165709e+00*s35 \
v54_part5=v54_part4+(-1.483458e+01)*s36+3.234686e-01*s37+(-2.109645e+00)*s38+(-2.731791e+00)*s39+(-2.285866e+00)*s40+1.496896e+00*s41+(-2.404127e-01)*s42+(-2.950344e+00)*s43+(-1.397216e+00)*s44 \
v54_part6=v54_part5+7.206754e+00*s45+3.035814e-01*s46+5.489703e+00*s47+9.661515e+01*s48+(-9.367690e+00)*s49+2.415090e+00*s50+(-6.304939e-01)*s51+3.637310e+01*s52+(-5.672820e+00)*s53 \
v54=v54_part6+(-1.617536e+01)*s54+(-5.432277e+00)*s55+3.230944e+00*s56+(-2.013217e+00)*s57+(-1.068514e+01)*s58+(-2.742822e+00)*s59+2.856132e+01*s60+7.804169e+02*s61+1.599761e+01*s62+(-1.097814e+01)*s63+(-1.361303e+01)*s64 \
v55_part1=(-9.227439e+00)*s0+7.117634e-02*s1+1.584837e-02*s2+(-3.691012e+00)*s3+2.649939e-01*s4+(-1.307360e+00)*s5+5.853546e+00*s6+9.475974e+00*s7+(-7.177570e+00)*s8 \
v55_part2=v55_part1+1.018981e-01*s9+7.237207e-01*s10+(-8.003772e-01)*s11+(-1.001931e+01)*s12+4.222013e+00*s13+(-9.137528e-02)*s14+1.457896e+01*s15+(-1.950068e+00)*s16+(-3.300679e-01)*s17 \
v55_part3=v55_part2+(-1.700431e-01)*s18+(-3.540324e-01)*s19+5.772324e-01*s20+2.794356e+00*s21+2.014317e+00*s22+(-6.447470e-02)*s23+(-1.035960e+00)*s24+(-3.044241e+00)*s25+1.602820e-01*s26 \
v55_part4=v55_part3+2.704481e-01*s27+1.055568e+00*s28+(-2.161071e-01)*s29+(-1.831970e+01)*s30+4.205909e+00*s31+7.581124e+00*s32+9.930304e-01*s33+(-6.656547e+01)*s34+1.885802e+01*s35 \
v55_part5=v55_part4+(-1.845589e+02)*s36+1.031088e+00*s37+(-2.419279e+00)*s38+(-1.150888e+01)*s39+3.183207e+00*s40+3.209778e-01*s41+8.051484e-02*s42+(-1.597122e+01)*s43+8.545841e-01*s44 \
v55_part6=v55_part5+(-4.606707e-01)*s45+6.870821e-02*s46+(-9.979876e-02)*s47+(-2.901049e+01)*s48+4.727025e-01*s49+9.915516e+01*s50+(-2.153172e+00)*s51+(-1.129302e+00)*s52+1.473578e+00*s53 \
v55=v55_part6+1.528431e+01*s54+(-3.962487e+01)*s55+6.070569e-01*s56+9.846745e-01*s57+1.739774e+00*s58+1.940388e+00*s59+(-2.165520e+00)*s60+2.189805e+00*s61+(-2.895566e+00)*s62+(-8.824351e-01)*s63+(-6.696946e+00)*s64 \
v56_part1=1.288263e+01*s0+3.380377e-01*s1+(-4.010605e-03)*s2+4.437157e+00*s3+(-2.277933e-01)*s4+1.775300e-01*s5+(-6.007087e+00)*s6+(-1.039162e+01)*s7+7.063843e+00*s8 \
v56_part2=v56_part1+(-1.920589e-01)*s9+(-1.413928e+00)*s10+(-3.882043e+00)*s11+7.635880e-01*s12+(-4.035157e-01)*s13+1.210373e-01*s14+1.390178e+01*s15+2.103080e+00*s16+(-7.527511e-01)*s17 \
v56_part3=v56_part2+6.560306e-02*s18+(-8.327268e-01)*s19+1.523413e+00*s20+(-2.185597e+00)*s21+(-1.296207e+00)*s22+1.161590e-01*s23+6.419916e-01*s24+(-1.645676e+01)*s25+(-1.369538e-01)*s26 \
v56_part4=v56_part3+(-3.348224e-01)*s27+(-9.918854e-02)*s28+2.116667e-01*s29+1.781463e+01*s30+(-5.876095e-01)*s31+(-1.113182e+01)*s32+(-2.979297e-01)*s33+6.521808e+01*s34+5.907108e+01*s35 \
v56_part5=v56_part4+2.735205e+01*s36+(-1.049848e+00)*s37+1.329653e+00*s38+6.034094e+00*s39+1.635826e+00*s40+(-7.523146e-01)*s41+(-9.034330e-02)*s42+8.412493e+00*s43+(-6.262908e-01)*s44 \
v56_part6=v56_part5+2.814640e-01*s45+(-5.492777e-01)*s46+(-7.384925e-02)*s47+1.685917e+01*s48+(-5.808562e-01)*s49+(-5.407820e+01)*s50+(-6.744620e+00)*s51+(-2.839830e-01)*s52+7.561967e-01*s53 \
v56=v56_part6+(-9.487028e+00)*s54+(-2.074290e+00)*s55+(-5.425872e-01)*s56+(-8.058977e-01)*s57+(-2.333389e+00)*s58+(-3.691671e+00)*s59+(-6.783301e+00)*s60+6.859371e+00*s61+1.449536e+00*s62+(-6.652211e-01)*s63+(-6.766471e-01)*s64 \
v57_part1=3.240819e-01*s0+(-4.723551e-01)*s1+4.967396e-02*s2+(-3.083491e+00)*s3+(-2.109241e-01)*s4+(-7.828309e-01)*s5+2.037870e+00*s6+1.773723e+00*s7+(-3.607576e+00)*s8 \
v57_part2=v57_part1+2.937713e-01*s9+1.346650e+00*s10+3.752760e+00*s11+3.010982e+00*s12+(-3.733411e+00)*s13+1.473318e-01*s14+3.497200e-01*s15+1.156190e-01*s16+1.409639e+00*s17 \
v57_part3=v57_part2+9.326375e-01*s18+1.487599e+00*s19+1.121005e+00*s20+(-6.917945e-01)*s21+(-6.030404e-01)*s22+(-2.145280e-01)*s23+3.778092e-01*s24+(-3.382308e+01)*s25+(-8.348671e-02)*s26 \
v57_part4=v57_part3+3.384163e-02*s27+(-7.387938e-01)*s28+7.197089e-02*s29+9.072369e-01*s30+(-1.861002e+00)*s31+3.848512e+00*s32+(-7.334801e-01)*s33+(-2.804505e+00)*s34+2.833549e+01*s35 \
v57_part5=v57_part4+2.177011e+00*s36+(-4.655725e-01)*s37+2.170427e+00*s38+7.088663e+00*s39+8.251605e-01*s40+4.019404e-01*s41+8.696479e-02*s42+1.100545e+01*s43+(-2.880296e-01)*s44 \
v57_part6=v57_part5+2.701671e-01*s45+6.282370e-01*s46+(-7.444538e-02)*s47+9.116096e+00*s48+1.657786e-01*s49+(-1.152471e+01)*s50+5.053499e-01*s51+2.303662e+00*s52+(-1.923526e+00)*s53 \
v57=v57_part6+1.386700e+00*s54+6.527488e+01*s55+(-6.839808e-04)*s56+(-3.057810e-02)*s57+3.805236e+00*s58+8.087804e-01*s59+(-3.253846e+00)*s60+3.290335e+00*s61+2.501368e+00*s62+1.974049e+00*s63+7.506268e+00*s64 \
v58_part1=8.015181e-01*s0+(-7.086693e+00)*s1+(-8.056288e+00)*s2+3.612435e+00*s3+(-3.066256e+01)*s4+7.048281e+00*s5+2.363995e+00*s6+4.631210e+00*s7+9.804811e+00*s8 \
v58_part2=v58_part1+(-1.394110e+01)*s9+1.445999e+01*s10+(-1.260341e+00)*s11+2.103636e+01*s12+8.351953e+00*s13+7.577316e+00*s14+(-1.788012e+02)*s15+(-5.148128e+00)*s16+3.579406e-01*s17 \
v58_part3=v58_part2+1.064660e+01*s18+(-2.376752e+00)*s19+1.219353e+01*s20+(-2.288266e+01)*s21+1.796962e+01*s22+(-4.241863e+00)*s23+5.574339e+00*s24+5.860258e+00*s25+5.582232e+00*s26 \
v58_part4=v58_part3+(-7.475855e+00)*s27+(-3.290726e+01)*s28+(-8.213294e+01)*s29+6.823564e+00*s30+1.428944e+01*s31+1.527850e+00*s32+1.999030e+01*s33+(-3.842773e+00)*s34+3.373706e+00*s35 \
v58_part5=v58_part4+(-6.880979e+00)*s36+2.418244e+01*s37+1.048030e+01*s38+1.295195e+01*s39+3.344227e+02*s40+3.312041e+01*s41+2.253369e+01*s42+8.460163e-01*s43+(-3.197286e+00)*s44 \
v58_part6=v58_part5+(-3.884769e+00)*s45+1.284486e-01*s46+1.001715e+01*s47+5.891408e+00*s48+3.342924e+00*s49+1.914036e+01*s50+4.970115e+01*s51+1.103942e+01*s52+1.177526e+01*s53 \
v58=v58_part6+4.409942e+00*s54+(-3.986335e+00)*s55+(-4.239742e+00)*s56+(-8.401592e-01)*s57+3.041665e+01*s58+(-3.410658e+00)*s59+2.776053e+02*s60+2.200352e+01*s61+9.915252e+00*s62+6.551208e+00*s63+(-1.934607e+01)*s64 \
v59_part1=2.895110e+01*s0+2.104624e+01*s1+2.823661e+01*s2+1.679712e+01*s3+7.344593e+01*s4+3.153344e+01*s5+3.607174e+01*s6+1.402257e+01*s7+2.036366e+01*s8 \
v59_part2=v59_part1+6.109831e+01*s9+2.824210e+00*s10+4.202638e+01*s11+6.597753e-01*s12+2.644384e+01*s13+2.956157e+01*s14+(-4.509881e+03)*s15+2.392219e+01*s16+1.917822e+01*s17 \
v59_part3=v59_part2+3.580991e+00*s18+3.214921e+01*s19+1.678685e+01*s20+6.515682e+01*s21+1.860129e+01*s22+5.015586e+01*s23+3.279946e+01*s24+2.869072e+01*s25+3.685473e+01*s26 \
v59_part4=v59_part3+5.870769e+01*s27+5.698489e+01*s28+1.198764e+02*s29+3.912962e+01*s30+2.067950e+01*s31+4.488929e+01*s32+1.683299e+01*s33+4.510247e+01*s34+3.688086e+01*s35 \
v59_part5=v59_part4+3.626123e+01*s36+(-9.118299e+00)*s37+5.855929e+00*s38+1.386162e+01*s39+3.558148e+03*s40+1.204909e+01*s41+(-5.825985e+00)*s42+2.221914e+01*s43+3.717068e+01*s44 \
v59_part6=v59_part5+3.665214e+01*s45+3.840047e+01*s46+3.100716e+01*s47+2.190852e+01*s48+4.650184e+01*s49+1.080405e+01*s50+1.556179e+01*s51+6.066517e+00*s52+4.288428e+00*s53 \
v59=v59_part6+3.158067e+01*s54+3.493638e+01*s55+2.675494e+01*s56+3.008822e+01*s57+(-1.992896e+01)*s58+5.377642e+01*s59+1.566983e+02*s60+1.310320e+01*s61+9.477397e+00*s62+1.351574e+01*s63+5.356481e+01*s64 \
v60_part1=(-1.449471e-01)*s0+2.796459e+01*s1+7.106635e+00*s2+1.587302e+00*s3+1.569418e+01*s4+(-3.467585e+00)*s5+(-1.932813e+00)*s6+(-4.709836e+00)*s7+4.878299e+00*s8 \
v60_part2=v60_part1+1.312227e+01*s9+(-9.840525e+00)*s10+4.447367e-01*s11+(-1.880235e+01)*s12+1.590228e+01*s13+(-2.235702e+01)*s14+(-1.456685e+03)*s15+(-2.360558e+01)*s16+9.142492e+00*s17 \
v60_part3=v60_part2+(-4.442656e+00)*s18+(-1.579318e+01)*s19+(-1.190470e+01)*s20+(-2.604627e+00)*s21+(-1.251396e+01)*s22+1.172997e+00*s23+1.272202e+01*s24+(-9.560193e+00)*s25+(-2.669679e+00)*s26 \
v60_part4=v60_part3+1.828487e+01*s27+2.031077e+01*s28+8.237114e+01*s29+(-3.253952e+00)*s30+(-1.616761e+01)*s31+3.772381e+00*s32+(-2.900910e+01)*s33+1.552811e+01*s34+(-2.048426e+00)*s35 \
v60_part5=v60_part4+9.458448e-01*s36+(-1.926039e+01)*s37+(-3.569907e+00)*s38+(-2.098862e+01)*s39+1.130265e+03*s40+(-2.771397e+01)*s41+(-4.036652e+00)*s42+4.780451e-01*s43+1.704020e+01*s44 \
v60_part6=v60_part5+2.370488e+01*s45+1.716530e+01*s46+7.263134e+00*s47+(-5.542637e+00)*s48+(-1.158670e+01)*s49+1.490412e+02*s50+(-2.985906e+01)*s51+(-3.622063e+00)*s52+(-6.021819e+00)*s53 \
v60=v60_part6+(-3.038226e+00)*s54+1.128266e+01*s55+2.742810e+01*s56+5.707971e+00*s57+(-2.388345e+00)*s58+(-7.674426e+00)*s59+2.161644e+03*s60+6.644393e-01*s61+(-2.719078e+00)*s62+(-3.821925e+00)*s63+2.193455e+01*s64 \
v61_part1=1.647278e+00*s0+(-2.142403e+01)*s1+(-5.838129e+00)*s2+1.424462e-01*s3+(-2.821609e+01)*s4+1.944241e+00*s5+1.384500e+00*s6+1.420290e+00*s7+(-7.390939e+00)*s8 \
v61_part2=v61_part1+(-2.170700e+01)*s9+1.338075e+01*s10+7.615233e-01*s11+1.549456e+01*s12+(-1.502305e+01)*s13+3.490260e+01*s14+(-1.826279e+03)*s15+3.810910e+01*s16+(-9.087137e+00)*s17 \
v61_part3=v61_part2+9.695472e+00*s18+1.565971e+01*s19+1.746197e+01*s20+(-1.816423e+00)*s21+1.311817e+01*s22+(-4.534657e+00)*s23+(-1.986556e+01)*s24+1.391321e+01*s25+1.789501e+00*s26 \
v61_part4=v61_part3+(-3.233811e+01)*s27+(-1.984672e+01)*s28+(-1.293289e+02)*s29+(-1.185502e+00)*s30+6.169674e+00*s31+(-6.746353e+00)*s32+4.381844e+01*s33+(-1.142395e+01)*s34+(-1.882704e+00)*s35 \
v61_part5=v61_part4+4.441753e+00*s36+2.358724e+01*s37+6.734364e+00*s38+3.779621e+01*s39+2.029041e+03*s40+2.245421e+01*s41+1.504645e+01*s42+2.381384e+00*s43+(-2.018890e+01)*s44 \
v61_part6=v61_part5+(-2.002252e+01)*s45+(-2.041532e+01)*s46+(-1.135260e+01)*s47+(-1.292992e+00)*s48+1.393275e+01*s49+1.122798e+02*s50+(-3.322004e+01)*s51+6.512558e+00*s52+1.005130e+01*s53 \
v61=v61_part6+8.280958e+00*s54+1.989022e+00*s55+(-2.247066e+01)*s56+(-9.946276e+00)*s57+(-8.044323e+00)*s58+(-1.155325e+01)*s59+1.628469e+03*s60+(-8.695975e+00)*s61+3.325740e+00*s62+4.242940e+00*s63+(-3.711161e+01)*s64 \
v62_part1=9.772306e-01*s0+(-1.624305e+00)*s1+9.053218e-01*s2+1.186576e+01*s3+(-2.219324e+00)*s4+2.376933e-01*s5+(-1.101755e+00)*s6+5.216278e-01*s7+(-9.527643e-01)*s8 \
v62_part2=v62_part1+(-2.379028e+00)*s9+1.456672e-01*s10+4.900874e-01*s11+1.019364e+01*s12+3.305282e+00*s13+2.277201e+00*s14+1.128581e+00*s15+2.224161e+00*s16+(-2.776723e+00)*s17 \
v62_part3=v62_part2+(-1.838866e+00)*s18+3.783976e+00*s19+1.122595e+00*s20+5.350483e-01*s21+(-2.328900e+00)*s22+7.982654e+00*s23+3.058025e+01*s24+6.611114e+01*s25+(-8.036672e-01)*s26 \
v62_part4=v62_part3+(-2.747564e-01)*s27+7.601438e+00*s28+5.088130e+00*s29+4.262875e+00*s30+(-1.730713e+00)*s31+1.863000e-01*s32+(-5.016289e-01)*s33+1.919061e+01*s34+6.590131e+00*s35 \
v62_part5=v62_part4+8.117166e+01*s36+5.848847e-01*s37+8.695305e-01*s38+3.633263e+01*s39+3.209962e+00*s40+(-1.250053e+00)*s41+(-2.364035e+00)*s42+(-2.598996e+01)*s43+3.280543e+01*s44 \
v62_part6=v62_part5+2.955032e+00*s45+(-4.210941e-01)*s46+3.642421e+01*s47+7.479471e+00*s48+1.887005e+00*s49+(-1.000000e+04)*s50+(-4.266215e-01)*s51+3.207298e-02*s52+(-3.560328e-01)*s53 \
v62=v62_part6+2.227894e+00*s54+1.059005e+01*s55+(-1.725089e-01)*s56+(-5.928600e+00)*s57+(-2.977503e+00)*s58+(-2.267802e+01)*s59+(-1.144450e+00)*s60+6.396832e-01*s61+1.848887e+00*s62+(-3.995582e-01)*s63+7.711579e+00*s64 \
v63_part1=(-9.037532e-01)*s0+(-9.834068e-01)*s1+(-1.534797e+00)*s2+2.688644e+00*s3+(-9.905969e-01)*s4+3.462956e-01*s5+(-1.403032e-01)*s6+(-6.403482e-01)*s7+1.830992e+00*s8 \
v63_part2=v63_part1+2.539038e-01*s9+(-4.388358e-01)*s10+(-1.207155e+00)*s11+(-1.773805e+01)*s12+(-2.109885e+00)*s13+(-4.471456e+00)*s14+2.236255e+01*s15+(-2.480026e+00)*s16+6.303296e-01*s17 \
v63_part3=v63_part2+1.368468e+00*s18+(-6.608955e+00)*s19+(-6.820579e-01)*s20+3.735106e-01*s21+5.292526e+00*s22+(-9.625211e+00)*s23+(-5.082008e+01)*s24+(-3.215842e+01)*s25+6.486422e-01*s26 \
v63_part4=v63_part3+(-6.647857e-01)*s27+2.075140e+01*s28+(-1.006477e+01)*s29+(-1.074493e+01)*s30+(-1.001842e+00)*s31+(-1.471880e+00)*s32+9.282407e-02*s33+(-3.020471e+01)*s34+(-7.412776e+00)*s35 \
v63_part5=v63_part4+(-7.938752e+01)*s36+(-3.107079e+00)*s37+(-1.404680e+00)*s38+(-6.974563e+00)*s39+2.954239e+00*s40+1.088155e+00*s41+8.713130e-01*s42+4.286641e+01*s43+(-2.401231e+01)*s44 \
v63_part6=v63_part5+(-3.728067e+00)*s45+(-1.313311e-01)*s46+(-6.011933e+01)*s47+(-1.924369e+01)*s48+(-1.983721e+00)*s49+(-1.000000e+04)*s50+7.431357e-01*s51+(-5.700564e-01)*s52+7.317588e-02*s53 \
v63=v63_part6+1.523915e+01*s54+(-6.175355e+01)*s55+(-1.752317e+00)*s56+4.905884e+00*s57+2.119490e+01*s58+5.489545e+00*s59+(-3.451801e+00)*s60+2.099231e-01*s61+(-2.957481e+00)*s62+(-4.750034e+00)*s63+(-8.772619e+00)*s64 \
v64_part1=1.223070e-01*s0+2.518662e+00*s1+2.380221e-01*s2+(-2.082242e+01)*s3+4.268646e+00*s4+(-4.805644e-01)*s5+7.941918e-01*s6+(-1.288757e-01)*s7+3.214931e-02*s8 \
v64_part2=v64_part1+1.117614e+00*s9+(-5.979335e-02)*s10+5.335677e-01*s11+7.682902e+00*s12+(-2.372665e+00)*s13+3.433045e-01*s14+8.362403e+00*s15+(-2.733286e+00)*s16+2.738713e+00*s17 \
v64_part3=v64_part2+1.305985e+00*s18+1.122794e+00*s19+(-1.502350e+00)*s20+8.475097e-01*s21+(-2.451378e+00)*s22+(-5.231409e-01)*s23+8.665198e-02*s24+(-4.660708e+01)*s25+(-8.789795e-02)*s26 \
v64_part4=v64_part3+5.117590e-01*s27+(-2.216660e+01)*s28+4.245529e+00*s29+9.485814e+00*s30+1.576367e+00*s31+1.059882e+00*s32+1.248682e-01*s33+8.051811e+00*s34+(-2.428735e-01)*s35 \
v64_part5=v64_part4+(-2.279403e+01)*s36+4.392732e+00*s37+1.408878e-01*s38+(-3.722052e+01)*s39+1.418793e+00*s40+2.773870e-01*s41+1.763330e+00*s42+3.256310e+00*s43+(-1.778092e+01)*s44 \
v64_part6=v64_part5+(-7.350805e-01)*s45+1.026920e+00*s46+(-1.392107e-01)*s47+1.193615e+01*s48+(-1.542909e+00)*s49+(-2.140370e+03)*s50+(-7.673784e-01)*s51+5.230646e-01*s52+2.327203e-01*s53 \
v64=v64_part6+(-2.051368e+01)*s54+1.904574e+01*s55+1.418454e+00*s56+3.138567e+00*s57+5.710950e+00*s58+2.178293e+01*s59+(-3.086115e+00)*s60+1.837978e-01*s61+5.053098e-01*s62+4.667988e+00*s63+2.808980e+00*s64 \
v65_part1=1.973079e+00*s0+4.110421e+00*s1+1.611433e+00*s2+1.186265e+00*s3+2.014092e+00*s4+1.256277e+00*s5+(-2.232601e+00)*s6+9.770936e-01*s7+(-1.386153e+00)*s8 \
v65_part2=v65_part1+4.526838e+00*s9+(-1.034506e-01)*s10+5.355049e-01*s11+1.646304e+00*s12+2.635725e+00*s13+2.375826e+00*s14+(-1.283400e-02)*s15+1.148437e-01*s16+(-5.908826e-01)*s17 \
v65_part3=v65_part2+7.655402e-01*s18+8.581556e-01*s19+(-1.724236e-01)*s20+(-4.973119e-01)*s21+7.568346e-01*s22+9.682816e-01*s23+6.975352e-01*s24+1.400970e-01*s25+1.204645e-01*s26 \
v65_part4=v65_part3+7.704121e-01*s27+9.736270e-01*s28+(-1.420871e-01)*s29+1.201474e-01*s30+(-9.055446e-02)*s31+6.488186e-01*s32+1.463183e+00*s33+1.314854e-01*s34+1.048266e-01*s35 \
v65_part5=v65_part4+(-1.917821e+00)*s36+3.895931e-01*s37+2.163634e-01*s38+(-1.461759e+00)*s39+(-6.917852e-01)*s40+3.806311e-01*s41+1.636267e-01*s42+6.720244e-01*s43+2.391472e-01*s44 \
v65_part6=v65_part5+6.096618e-01*s45+1.254230e-01*s46+8.323810e-01*s47+3.217147e-01*s48+(-2.688709e-02)*s49+5.343692e-01*s50+2.377803e-01*s51+1.049121e+00*s52+9.043072e-02*s53 \
v65=v65_part6+(-1.114817e+00)*s54+2.484543e+00*s55+2.529869e-01*s56+2.330912e-01*s57+1.591333e-01*s58+(-6.444747e-01)*s59+9.963664e-03*s60+6.517170e-01*s61+9.375712e-01*s62+3.034806e-01*s63+5.193017e-01*s64 \
v66_part1=(-1.155085e-01)*s0+(-2.899381e+00)*s1+7.531454e-01*s2+1.820456e+00*s3+1.708853e+00*s4+3.877070e-01*s5+5.284563e+00*s6+1.851183e+00*s7+5.752816e+00*s8 \
v66_part2=v66_part1+(-1.239818e-01)*s9+2.378953e+00*s10+2.296572e+00*s11+1.649038e+00*s12+1.232569e+00*s13+3.293030e+00*s14+1.028926e+00*s15+1.770966e+00*s16+2.950718e+00*s17 \
v66_part3=v66_part2+1.705377e+00*s18+1.115130e+00*s19+1.627954e+00*s20+2.320017e+00*s21+1.236623e+00*s22+1.020885e+00*s23+2.192343e+00*s24+2.213008e+00*s25+1.861663e+00*s26 \
v66_part4=v66_part3+1.470011e+00*s27+1.870583e+00*s28+4.040416e+00*s29+1.443117e+00*s30+2.305183e+00*s31+1.730021e+00*s32+1.083511e+00*s33+3.764621e+00*s34+7.047813e-01*s35 \
v66_part5=v66_part4+4.304010e+00*s36+1.123070e+00*s37+1.683994e+00*s38+4.495824e+00*s39+2.602009e+00*s40+5.352083e-01*s41+1.534062e+00*s42+1.964194e+00*s43+2.104280e+00*s44 \
v66_part6=v66_part5+7.353885e-01*s45+1.504240e+00*s46+8.986111e-01*s47+1.606553e+00*s48+2.740261e+00*s49+1.732392e-01*s50+7.374005e-01*s51+(-1.167498e-02)*s52+1.570828e+00*s53 \
v66=v66_part6+3.464390e+00*s54+(-1.410442e+00)*s55+1.041599e+00*s56+1.324198e+00*s57+1.716779e+00*s58+2.824190e+00*s59+8.125463e-01*s60+2.034972e-01*s61+4.175204e-02*s62+1.044927e+00*s63+9.880618e-01*s64 \
v67_part1=(-2.047551e+00)*s0+(-6.948433e+00)*s1+(-6.156110e+00)*s2+(-6.151762e+00)*s3+(-8.670799e+00)*s4+(-3.162803e+00)*s5+(-1.639323e-01)*s6+(-4.760229e+00)*s7+(-3.215068e+00)*s8 \
v67_part2=v67_part1+(-1.164106e+01)*s9+(-1.973382e+00)*s10+(-3.456297e+00)*s11+(-5.542686e+00)*s12+(-8.140080e+00)*s13+(-9.324711e+00)*s14+9.504292e-02*s15+(-6.088427e-03)*s16+(-1.494685e+00)*s17 \
v67_part3=v67_part2+(-3.569724e+00)*s18+(-4.213771e+00)*s19+(-1.019390e+00)*s20+(-1.244668e+00)*s21+(-3.080648e+00)*s22+(-3.938018e+00)*s23+(-4.221713e+00)*s24+7.752387e-01*s25+(-1.712908e+00)*s26 \
v67_part4=v67_part3+(-2.957890e+00)*s27+(-3.950037e+00)*s28+(-3.288589e+00)*s29+(-8.891585e-01)*s30+(-1.311434e+00)*s31+(-2.868933e+00)*s32+(-4.354717e+00)*s33+(-3.689569e+00)*s34+(-3.602893e-01)*s35 \
v67_part5=v67_part4+2.533331e+00*s36+(-1.986076e+00)*s37+(-2.171584e+00)*s38+2.330373e-01*s39+7.067088e-01*s40+(-1.465172e+00)*s41+(-1.564138e+00)*s42+(-2.548272e+00)*s43+(-2.342211e+00)*s44 \
v67_part6=v67_part5+(-1.256606e+00)*s45+(-1.091778e+00)*s46+(-2.228570e+00)*s47+(-2.059185e+00)*s48+(-2.027114e+00)*s49+(-6.607240e-01)*s50+(-9.656778e-01)*s51+(-2.490808e+00)*s52+(-1.417938e+00)*s53 \
v67=v67_part6+(-2.619116e-01)*s54+(-2.837209e+00)*s55+(-9.685799e-01)*s56+(-1.394084e+00)*s57+(-1.186760e+00)*s58+(-9.220022e-01)*s59+(-3.476690e-02)*s60+(-1.354276e+00)*s61+(-2.073131e+00)*s62+(-1.277532e+00)*s63+(-1.822964e+00)*s64 \
v68_part1=4.651619e+00*s0+1.247160e+01*s1+1.252993e+01*s2+1.348226e+01*s3+1.676490e+01*s4+7.384057e+00*s5+5.213285e+00*s6+1.207729e+01*s7+1.082560e+01*s8 \
v68_part2=v68_part1+2.092002e+01*s9+6.019480e+00*s10+9.404019e+00*s11+1.304233e+01*s12+1.774715e+01*s13+1.824326e+01*s14+2.098739e-01*s15+2.155635e+00*s16+4.576850e+00*s17 \
v68_part3=v68_part2+7.681325e+00*s18+9.711390e+00*s19+2.953472e+00*s20+4.126506e+00*s21+7.059441e+00*s22+9.044921e+00*s23+9.181780e+00*s24+7.887019e-02*s25+5.052330e+00*s26 \
v68_part4=v68_part3+7.210555e+00*s27+8.534234e+00*s28+7.605185e+00*s29+3.346091e+00*s30+4.430004e+00*s31+7.100309e+00*s32+9.515839e+00*s33+8.332642e+00*s34+1.935064e+00*s35 \
v68_part5=v68_part4+(-2.228187e+00)*s36+4.502555e+00*s37+4.900843e+00*s38+1.385248e+00*s39+(-5.909500e-01)*s40+4.122433e+00*s41+3.950270e+00*s42+4.391127e+00*s43+5.283859e+00*s44 \
v68_part6=v68_part5+2.824628e+00*s45+3.235181e+00*s46+5.048401e+00*s47+5.320846e+00*s48+4.984212e+00*s49+1.119245e+00*s50+2.609377e+00*s51+4.736723e+00*s52+3.373711e+00*s53 \
v68=v68_part6+1.570616e+00*s54+3.621279e+00*s55+2.293591e+00*s56+3.016155e+00*s57+2.418778e+00*s58+2.715081e+00*s59+2.878638e-01*s60+2.746028e+00*s61+3.857540e+00*s62+2.945040e+00*s63+3.534378e+00*s64 \
v69_part1=(-8.944214e-01)*s0+(-9.177096e-02)*s1+(-1.360009e-01)*s2+(-7.361585e-02)*s3+3.203994e-01*s4+(-1.520643e-01)*s5+8.673360e-02*s6+(-1.270894e-01)*s7+(-2.929743e-02)*s8 \
v69_part2=v69_part1+(-2.671672e-01)*s9+(-1.163943e-01)*s10+(-1.535560e-01)*s11+(-2.395736e-01)*s12+1.061703e-01*s13+(-1.619854e-01)*s14+3.586265e-02*s15+(-1.108883e+00)*s16+(-2.946809e-01)*s17 \
v69_part3=v69_part2+(-1.287485e-01)*s18+(-7.909465e-01)*s19+(-2.788076e-01)*s20+(-7.835946e-01)*s21+(-1.477212e-01)*s22+(-5.077562e-02)*s23+(-1.464350e-01)*s24+(-1.011160e+01)*s25+(-5.917096e-02)*s26 \
v69_part4=v69_part3+(-1.285523e-01)*s27+(-3.363607e-01)*s28+(-1.944454e-02)*s29+(-9.535021e-01)*s30+(-4.460461e-02)*s31+8.240832e-02*s32+(-1.343805e-01)*s33+(-8.007287e-01)*s34+(-2.696449e-01)*s35 \
v69_part5=v69_part4+(-3.927316e+00)*s36+(-2.652002e-01)*s37+(-1.596413e-01)*s38+(-2.263486e+00)*s39+2.020618e-02*s40+(-7.631814e-02)*s41+(-6.796447e-02)*s42+(-1.625220e+00)*s43+(-1.432162e-01)*s44 \
v69_part6=v69_part5+(-7.542194e-02)*s45+(-7.147668e-02)*s46+(-1.317494e-01)*s47+(-9.658597e-02)*s48+(-2.901483e-02)*s49+(-2.634974e+00)*s50+(-2.307035e-02)*s51+(-1.490255e-01)*s52+(-4.106790e-02)*s53 \
v69=v69_part6+(-3.397405e-01)*s54+(-6.378339e+00)*s55+(-1.098570e-01)*s56+4.333112e-02*s57+(-1.510661e+00)*s58+2.766599e-01*s59+(-1.262772e-02)*s60+(-1.303409e-01)*s61+(-2.839355e-01)*s62+(-1.320838e-01)*s63+(-2.476913e-01)*s64 \
v70_part1=9.254372e-01*s0+8.045497e-01*s1+8.299945e-01*s2+2.018209e+00*s3+1.034513e+00*s4+2.962024e-01*s5+5.060507e-01*s6+8.988116e-01*s7+1.115032e+00*s8 \
v70_part2=v70_part1+1.420114e+00*s9+3.549391e-01*s10+6.578138e-01*s11+1.020311e+00*s12+1.181855e+00*s13+1.766912e+00*s14+(-9.118025e-03)*s15+9.927777e-01*s16+3.748408e-01*s17 \
v70_part3=v70_part2+6.124982e-01*s18+8.715651e-01*s19+2.980854e-01*s20+1.378986e+00*s21+6.579961e-01*s22+6.638350e-01*s23+9.185027e-01*s24+6.921463e+00*s25+4.384876e-01*s26 \
v70_part4=v70_part3+6.144532e-01*s27+9.623925e-01*s28+8.467638e-01*s29+1.059745e+00*s30+3.456758e-01*s31+5.529950e-01*s32+8.331335e-01*s33+1.421550e+00*s34+5.819515e-01*s35 \
v70_part5=v70_part4+3.784659e+00*s36+5.090197e-01*s37+5.019071e-01*s38+1.320835e+00*s39+3.648296e-01*s40+1.893431e-01*s41+3.662580e-01*s42+1.337836e+00*s43+5.578265e-01*s44 \
v70_part6=v70_part5+1.507348e-01*s45+2.547476e-01*s46+4.400992e-01*s47+5.529566e-01*s48+5.524535e-01*s49+4.665584e+00*s50+1.752974e-01*s51+2.832423e-01*s52+3.320773e-01*s53 \
v70=v70_part6+(-4.140632e-01)*s54+3.062323e+00*s55+2.702608e-01*s56+2.676016e-01*s57+1.568272e+00*s58+8.224256e-02*s59+(-1.426908e-03)*s60+2.062454e-01*s61+3.747602e-01*s62+3.890624e-01*s63+5.345072e-01*s64 \
v71_part1=1.414864e-01*s0+(-4.096247e-01)*s1+(-2.999256e-01)*s2+(-1.847193e+00)*s3+(-1.137311e+00)*s4+7.438535e-02*s5+(-2.757796e-01)*s6+(-3.253191e-01)*s7+(-5.714713e-01)*s8 \
v71_part2=v71_part1+(-6.598095e-01)*s9+(-1.342082e-02)*s10+(-1.068855e-01)*s11+(-2.168430e-01)*s12+(-7.449196e-01)*s13+(-1.026440e+00)*s14+(-3.977884e-02)*s15+5.884526e-01*s16+2.735922e-01*s17 \
v71_part3=v71_part2+(-1.989176e-01)*s18+3.987508e-01*s19+1.880129e-01*s20+(-9.807537e-02)*s21+(-2.054703e-01)*s22+(-2.778442e-01)*s23+(-4.311661e-01)*s24+6.639284e+00*s25+(-1.482929e-01)*s26 \
v71_part4=v71_part3+(-1.628050e-01)*s27+(-2.378826e-01)*s28+(-4.929412e-01)*s29+2.788056e-01*s30+(-8.001967e-02)*s31+(-3.424848e-01)*s32+(-3.009819e-01)*s33+3.491147e-01*s34+(-1.870483e-02)*s35 \
v71_part5=v71_part4+1.301814e+00*s36+1.338265e-03*s37+(-1.229451e-01)*s38+1.816803e+00*s39+5.509516e-02*s40+4.299465e-02*s41+(-9.214964e-02)*s42+8.185455e-01*s43+(-1.448068e-01)*s44 \
v71_part6=v71_part5+2.384045e-02*s45+(-9.027400e-03)*s46+(-8.324945e-02)*s47+(-1.786015e-01)*s48+(-2.855686e-01)*s49+1.325686e+00*s50+(-5.569596e-02)*s51+4.071639e-02*s52+(-1.546592e-01)*s53 \
v71=v71_part6+1.159175e+00*s54+5.197435e+00*s55+(-4.149294e-02)*s56+(-1.708029e-01)*s57+7.248619e-01*s58+(-2.299832e-01)*s59+3.457729e-02*s60+3.193032e-02*s61+1.122340e-01*s62+(-9.595650e-02)*s63+(-1.284276e-01)*s64 \
v72_part1=3.781866e+01*s0+2.343050e+02*s1+1.000000e+04*s2+8.471491e+01*s3+1.666240e+02*s4+8.228965e+01*s5+3.862372e+01*s6+2.361484e+01*s7+1.833032e+01*s8 \
v72_part2=v72_part1+1.000000e+04*s9+2.114507e+01*s10+2.278295e+01*s11+2.288294e+01*s12+3.504736e+01*s13+1.000000e+04*s14+(-6.389497e+03)*s15+1.197717e+02*s16+1.000000e+04*s17 \
v72_part3=v72_part2+1.757609e+03*s18+1.317763e+03*s19+1.308057e+01*s20+1.000000e+04*s21+1.000000e+04*s22+1.127022e+03*s23+1.000000e+04*s24+1.481544e+01*s25+1.000000e+04*s26 \
v72_part4=v72_part3+1.000000e+04*s27+2.421622e+03*s28+1.000000e+04*s29+7.911479e+00*s30+2.321824e+01*s31+3.154559e+01*s32+1.000000e+04*s33+2.285089e+01*s34+7.673204e+00*s35 \
v72_part5=v72_part4+2.097846e+01*s36+9.358642e+01*s37+2.375544e+01*s38+1.804737e+01*s39+1.553210e+01*s40+1.157611e+03*s41+1.000000e+04*s42+2.045275e+01*s43+1.000000e+04*s44 \
v72_part6=v72_part5+1.000000e+04*s45+1.000000e+04*s46+1.000000e+04*s47+1.168569e+01*s48+1.000000e+04*s49+(-1.446878e+00)*s50+1.152925e+01*s51+(-2.530942e+01)*s52+3.391269e+01*s53 \
v72=v72_part6+2.959296e+01*s54+4.941569e+01*s55+1.000000e+04*s56+1.000000e+04*s57+5.726821e+00*s58+1.724679e+02*s59+1.294250e+01*s60+1.522573e+01*s61+4.611652e+01*s62+2.906250e+01*s63+3.367846e+01*s64 \
v73_part1=(-2.114679e+01)*s0+1.163199e+03*s1+1.000000e+04*s2+(-5.069597e+01)*s3+(-6.046911e+01)*s4+(-4.923830e+01)*s5+(-1.420631e+01)*s6+(-1.148453e+01)*s7+(-5.795123e+00)*s8 \
v73_part2=v73_part1+1.000000e+04*s9+(-8.614401e+00)*s10+(-9.039784e+00)*s11+(-1.177710e+01)*s12+(-2.262536e+01)*s13+(-2.349955e+03)*s14+(-5.255574e+03)*s15+3.214027e+00*s16+1.000000e+04*s17 \
v73_part3=v73_part2+(-8.982577e+02)*s18+(-1.285501e+03)*s19+2.393317e+00*s20+1.000000e+04*s21+1.000000e+04*s22+(-1.096563e+01)*s23+1.000000e+04*s24+(-3.676716e+00)*s25+(-1.496340e+01)*s26 \
v73_part4=v73_part3+(-8.757720e+03)*s27+1.061601e+03*s28+(-5.674162e+01)*s29+(-1.307061e+01)*s30+(-1.090274e+01)*s31+(-1.910891e+01)*s32+(-4.265295e+03)*s33+(-1.001055e+01)*s34+(-3.102871e+00)*s35 \
v73_part5=v73_part4+(-8.631564e+00)*s36+(-6.666940e+01)*s37+(-8.000528e+00)*s38+6.720213e+01*s39+1.416369e+00*s40+1.158987e+02*s41+1.000000e+04*s42+5.138006e+01*s43+1.000000e+04*s44 \
v73_part6=v73_part5+1.000000e+04*s45+1.000000e+04*s46+(-9.561446e+02)*s47+(-1.129704e+00)*s48+(-1.282249e+03)*s49+2.128656e-01*s50+(-4.213748e+00)*s51+4.165908e+01*s52+(-1.899138e+01)*s53 \
v73=v73_part6+(-2.484173e+00)*s54+(-6.076387e+00)*s55+1.000000e+04*s56+1.000000e+04*s57+1.580126e+00*s58+(-1.545084e+02)*s59+9.917259e-01*s60+(-1.055976e+01)*s61+(-3.748476e+01)*s62+(-1.836779e+01)*s63+(-2.119410e+01)*s64 \
v74_part1=(-5.414394e+00)*s0+7.338862e+03*s1+1.000000e+04*s2+2.656185e+01*s3+7.886612e+01*s4+(-2.523088e+01)*s5+8.841944e+00*s6+2.354194e+00*s7+1.154047e+01*s8 \
v74_part2=v74_part1+1.000000e+04*s9+1.357242e+00*s10+1.041949e+01*s11+1.634082e+00*s12+(-7.744922e+00)*s13+1.000000e+04*s14+(-7.567236e+03)*s15+3.636933e+00*s16+1.000000e+04*s17 \
v74_part3=v74_part2+2.216310e+02*s18+4.707745e+02*s19+6.074434e+00*s20+1.000000e+04*s21+1.000000e+04*s22+6.188921e+02*s23+1.000000e+04*s24+1.795938e+01*s25+1.000000e+04*s26 \
v74_part4=v74_part3+8.115425e+03*s27+1.918550e+03*s28+1.000000e+04*s29+7.255394e+01*s30+5.547695e-01*s31+(-1.475996e+00)*s32+1.000000e+04*s33+4.812917e+00*s34+8.960082e+00*s35 \
v74_part5=v74_part4+(-1.062008e+00)*s36+2.952286e+01*s37+6.900169e+01*s38+1.371273e+01*s39+(-1.807749e+00)*s40+4.878989e+02*s41+1.000000e+04*s42+9.592458e+02*s43+1.000000e+04*s44 \
v74_part6=v74_part5+5.640258e+03*s45+1.000000e+04*s46+2.792081e+03*s47+1.368093e+01*s48+1.000000e+04*s49+6.097512e-01*s50+8.760245e+00*s51+1.090028e+02*s52+1.926031e+01*s53 \
v74=v74_part6+6.434706e+00*s54+1.700736e+01*s55+1.000000e+04*s56+1.000000e+04*s57+3.295514e+01*s58+1.136223e+02*s59+2.479526e+01*s60+(-2.676486e+00)*s61+(-6.436460e+00)*s62+1.183341e+01*s63+3.605700e-01*s64 \
v75_part1=1.233505e+00*s0+1.445888e+03*s1+1.000000e+04*s2+(-2.323606e+01)*s3+(-9.919245e+01)*s4+2.169556e+01*s5+(-1.240669e+01)*s6+(-3.033931e+00)*s7+(-1.179896e+01)*s8 \
v75_part2=v75_part1+1.000000e+04*s9+(-2.106461e+00)*s10+(-9.769506e+00)*s11+(-1.830255e+00)*s12+8.295371e+00*s13+(-9.538913e+03)*s14+(-6.043922e+02)*s15+(-4.290331e+01)*s16+1.000000e+04*s17 \
v75_part3=v75_part2+(-3.802138e+02)*s18+(-2.322640e+02)*s19+(-7.016666e+00)*s20+1.000000e+04*s21+1.000000e+04*s22+(-2.185982e+02)*s23+1.000000e+04*s24+(-2.047968e+01)*s25+(-8.304928e+02)*s26 \
v75_part4=v75_part3+(-6.997521e+03)*s27+3.174213e+01*s28+(-1.320049e+03)*s29+(-3.564908e+01)*s30+(-1.198235e+00)*s31+3.200612e+00*s32+(-1.000000e+04)*s33+(-5.166525e+00)*s34+(-5.755264e+00)*s35 \
v75_part5=v75_part4+(-2.749795e+00)*s36+(-9.164229e+00)*s37+(-5.717970e+01)*s38+5.593370e+01*s39+(-5.602870e+00)*s40+2.993831e+01*s41+1.000000e+04*s42+5.129938e+02*s43+1.000000e+04*s44 \
v75_part6=v75_part5+1.000000e+04*s45+1.000000e+04*s46+(-2.212348e+02)*s47+(-1.289627e+01)*s48+(-1.000000e+04)*s49+(-1.982954e-01)*s50+(-6.073066e+00)*s51+(-1.006210e+02)*s52+(-1.528908e+01)*s53 \
v75=v75_part6+(-5.264890e+00)*s54+(-1.747702e+01)*s55+1.000000e+04*s56+1.000000e+04*s57+(-1.628242e+01)*s58+(-4.061538e+01)*s59+4.844106e-01*s60+5.904274e+00*s61+1.813906e+01*s62+(-6.428988e+00)*s63+1.651055e+00*s64 \
v76_part1=(-6.189236e+00)*s0+9.356582e+00*s1+6.540335e+00*s2+8.292756e+01*s3+2.707289e+01*s4+8.027457e+00*s5+(-6.459255e+00)*s6+(-5.227427e-01)*s7+4.382296e-01*s8 \
v76_part2=v76_part1+1.000000e+04*s9+(-1.149225e-01)*s10+9.188738e-01*s11+(-8.694021e-02)*s12+(-3.408544e-01)*s13+1.100233e+01*s14+1.137849e+01*s15+5.409546e-01*s16+6.836449e+01*s17 \
v76_part3=v76_part2+(-2.733449e+03)*s18+1.333727e+01*s19+(-1.653186e-01)*s20+6.579250e+00*s21+1.703700e+03*s22+1.000000e+04*s23+1.000000e+04*s24+(-3.342424e+01)*s25+8.232729e+01*s26 \
v76_part4=v76_part3+1.000000e+04*s27+2.966387e+02*s28+6.740356e+01*s29+6.226408e+01*s30+(-4.163933e-01)*s31+(-6.059292e-01)*s32+1.792667e+01*s33+4.447254e+00*s34+4.435507e+00*s35 \
v76_part5=v76_part4+3.519297e+01*s36+1.295088e+01*s37+9.032335e+00*s38+3.478299e+02*s39+1.803259e+00*s40+7.125456e+00*s41+1.035352e+03*s42+4.820543e+03*s43+1.223518e+03*s44 \
v76_part6=v76_part5+7.012415e+01*s45+2.193911e+01*s46+8.404856e+03*s47+1.419790e+00*s48+4.254560e+02*s49+8.597470e+01*s50+4.817611e-01*s51+4.742848e+00*s52+(-1.909703e+00)*s53 \
v76=v76_part6+9.999925e+00*s54+(-3.193108e+02)*s55+1.000000e+04*s56+5.871328e+02*s57+2.429072e+00*s58+7.720055e+00*s59+(-1.820305e+00)*s60+(-8.240994e-01)*s61+2.161893e+00*s62+(-7.209384e-01)*s63+1.215449e+01*s64 \
v77_part1=4.648123e+00*s0+1.256951e+01*s1+7.798427e+00*s2+(-9.410405e+01)*s3+(-1.262075e+01)*s4+1.213363e+01*s5+6.938788e+00*s6+4.794692e-01*s7+(-6.576751e-01)*s8 \
v77_part2=v77_part1+1.000000e+04*s9+2.250812e-02*s10+1.201129e+00*s11+5.141325e-01*s12+(-4.860356e-02)*s13+2.000156e+01*s14+1.193852e+01*s15+5.979976e+00*s16+2.559639e+02*s17 \
v77_part3=v77_part2+1.534217e+03*s18+1.474366e+02*s19+(-1.827512e+00)*s20+9.657118e+00*s21+2.221203e+03*s22+(-1.000000e+04)*s23+1.000000e+04*s24+2.227466e+01*s25+(-1.302799e+01)*s26 \
v77_part4=v77_part3+1.000000e+04*s27+6.353898e+02*s28+2.648890e+00*s29+(-1.649026e+01)*s30+(-2.547837e-01)*s31+3.356750e+00*s32+2.241611e+02*s33+(-3.863268e+00)*s34+(-2.366507e+00)*s35 \
v77_part5=v77_part4+(-2.550389e+01)*s36+(-2.908607e+01)*s37+(-3.421273e+00)*s38+(-2.703499e+02)*s39+1.244950e+00*s40+5.231065e+00*s41+8.042516e+02*s42+4.005180e+03*s43+4.897186e+01*s44 \
v77_part6=v77_part5+5.148078e+01*s45+3.782134e+01*s46+(-1.000000e+04)*s47+(-4.858370e-01)*s48+7.805112e+01*s49+6.961191e+01*s50+2.570189e-01*s51+(-1.826144e+00)*s52+(-9.127441e-02)*s53 \
v77=v77_part6+(-6.143397e+01)*s54+1.517485e+02*s55+1.000000e+04*s56+1.242897e+03*s57+(-9.111694e+00)*s58+(-3.681039e+02)*s59+(-5.137662e+00)*s60+6.721217e-01*s61+(-1.710582e+00)*s62+9.284923e-01*s63+(-3.688841e+00)*s64 \
v78_part1=9.036150e-01*s0+5.304134e+00*s1+9.678412e+00*s2+3.334974e+01*s3+(-4.584324e-01)*s4+(-8.664094e+00)*s5+(-3.707808e+00)*s6+(-2.313366e-02)*s7+7.331179e-01*s8 \
v78_part2=v78_part1+1.000000e+04*s9+1.536618e-02*s10+(-2.127693e+00)*s11+(-3.039780e-01)*s12+4.675404e-01*s13+2.271648e+01*s14+7.721587e+00*s15+4.558289e+00*s16+4.903130e+02*s17 \
v78_part3=v78_part2+(-1.764436e+02)*s18+1.284895e+02*s19+1.103989e+00*s20+1.020702e+01*s21+2.111483e+03*s22+5.281239e+03*s23+1.000000e+04*s24+2.757358e+01*s25+4.669826e+01*s26 \
v78_part4=v78_part3+1.000000e+04*s27+5.995732e+02*s28+3.271891e+02*s29+(-3.489380e+01)*s30+4.598596e-01*s31+(-3.403620e+00)*s32+1.811056e+02*s33+7.470144e-01*s34+(-7.853636e-01)*s35 \
v78_part5=v78_part4+(-5.937057e+00)*s36+4.234288e+01*s37+(-8.863896e+00)*s38+7.693054e+01*s39+1.288965e+00*s40+2.530923e+00*s41+9.744522e+02*s42+1.552199e+03*s43+1.450251e+02*s44 \
v78_part6=v78_part5+2.490771e+01*s45+2.218791e+01*s46+1.000000e+04*s47+(-6.780469e-01)*s48+2.977202e+02*s49+(-3.482654e+01)*s50+3.889922e-01*s51+(-4.295980e+00)*s52+1.767233e+00*s53 \
v78=v78_part6+3.337510e+01*s54+1.587826e+02*s55+1.000000e+04*s56+1.586470e+02*s57+6.738004e+00*s58+5.903741e+02*s59+(-4.026021e-01)*s60+4.071170e-01*s61+7.999547e-01*s62+3.930285e-01*s63+(-7.663479e+00)*s64 \
v79_part1=(-1.767391e+00)*s0+5.423026e+00*s1+1.116100e+01*s2+(-3.134549e+00)*s3+3.245768e+01*s4+(-1.000000e+04)*s5+3.901726e+00*s6+(-2.284574e+00)*s7+(-1.665717e+01)*s8 \
v79_part2=v79_part1+8.570791e+00*s9+(-4.495208e+00)*s10+3.271565e+00*s11+(-1.455391e+01)*s12+(-2.077982e+01)*s13+(-2.154860e+01)*s14+(-2.243923e+03)*s15+1.131350e+01*s16+4.120632e+00*s17 \
v79_part3=v79_part2+(-5.651845e+00)*s18+1.156609e+01*s19+4.675642e+00*s20+2.640552e+01*s21+(-9.282720e+00)*s22+9.712744e+00*s23+(-6.001083e+00)*s24+3.697170e+00*s25+(-1.701499e+02)*s26 \
v79_part4=v79_part3+6.045316e+00*s27+1.722558e+01*s28+(-4.734939e-02)*s29+(-4.987337e+00)*s30+(-2.158926e-01)*s31+(-4.442597e+00)*s32+1.202634e+01*s33+(-9.955609e+00)*s34+1.137399e+01*s35 \
v79_part5=v79_part4+2.072361e+01*s36+(-1.466183e+01)*s37+(-5.224275e+00)*s38+9.298918e+02*s39+8.981914e+00*s40+4.561812e+00*s41+(-1.416325e+01)*s42+2.564160e+00*s43+(-3.897645e+00)*s44 \
v79_part6=v79_part5+1.584093e+00*s45+2.277080e+00*s46+(-1.134077e+01)*s47+(-6.715049e+00)*s48+(-3.008827e+01)*s49+1.705890e+01*s50+(-4.103643e+01)*s51+(-7.311804e+00)*s52+(-7.458156e+00)*s53 \
v79=v79_part6+(-4.952777e+00)*s54+(-5.292594e+00)*s55+6.269011e+00*s56+4.612673e+00*s57+9.673439e+00*s58+(-2.662749e+00)*s59+2.620717e+02*s60+(-2.075410e+01)*s61+(-7.731843e+00)*s62+(-4.730873e+00)*s63+1.991980e+01*s64 \
v80_part1=1.345196e+01*s0+1.306060e+01*s1+7.510211e-01*s2+1.525975e+01*s3+(-4.188128e+01)*s4+(-9.296380e+03)*s5+(-4.051741e+00)*s6+1.710812e+01*s7+2.425810e+01*s8 \
v80_part2=v80_part1+(-1.378881e+01)*s9+2.330070e+01*s10+(-3.902510e+00)*s11+2.841523e+01*s12+2.361475e+01*s13+3.646385e+01*s14+(-9.039054e+03)*s15+3.320701e+00*s16+1.115990e+01*s17 \
v80_part3=v80_part2+2.577272e+01*s18+(-6.723675e+00)*s19+2.446967e+00*s20+(-2.664492e+01)*s21+1.416911e+01*s22+(-1.102152e+01)*s23+1.247181e+01*s24+(-4.198905e+01)*s25+1.701709e+02*s26 \
v80_part4=v80_part3+(-1.077351e+01)*s27+(-6.958227e-01)*s28+2.606493e+01*s29+7.332593e+00*s30+7.928508e+00*s31+4.498677e+00*s32+(-1.155683e+02)*s33+2.915177e+01*s34+(-1.104575e+01)*s35 \
v80_part5=v80_part4+(-1.472121e+01)*s36+3.733341e+01*s37+2.636008e+01*s38+2.038199e+01*s39+1.161157e+01*s40+(-1.959294e+01)*s41+3.751835e+01*s42+1.293296e+01*s43+1.709845e+01*s44 \
v80_part6=v80_part5+1.086533e+01*s45+3.845382e+00*s46+1.719224e+01*s47+1.834960e+01*s48+4.918672e+01*s49+1.814106e+01*s50+1.719093e+01*s51+3.183412e+01*s52+3.160564e+01*s53 \
v80=v80_part6+7.404115e+01*s54+2.035209e+01*s55+1.631929e+01*s56+1.207397e+01*s57+7.609528e+00*s58+7.065450e+00*s59+2.942151e+02*s60+3.087888e+01*s61+3.286470e+01*s62+2.759210e+01*s63+(-9.636306e+00)*s64 \
v81_part1=(-1.653212e+01)*s0+(-2.261560e+01)*s1+(-9.933033e+00)*s2+(-1.422258e+00)*s3+(-2.005104e+01)*s4+(-1.000000e+04)*s5+(-3.761758e+00)*s6+3.824129e+00*s7+3.320323e+00*s8 \
v81_part2=v81_part1+(-1.111922e+01)*s9+4.083094e+00*s10+2.981314e+00*s11+1.319892e+01*s12+9.569286e+00*s13+2.432073e+01*s14+(-5.550724e+03)*s15+1.711587e+01*s16+(-1.138663e+01)*s17 \
v81_part3=v81_part2+(-5.815741e-01)*s18+1.934451e+00*s19+2.235123e-01*s20+(-6.459928e-01)*s21+5.135368e+00*s22+(-6.224380e+00)*s23+(-1.057356e+01)*s24+1.765544e+01*s25+(-1.231373e+02)*s26 \
v81_part4=v81_part3+(-1.444344e+01)*s27+(-9.249787e+00)*s28+(-1.729536e+00)*s29+1.376031e+00*s30+3.686919e+00*s31+(-1.037676e+00)*s32+3.698356e+01*s33+(-1.373405e+01)*s34+(-1.215338e+01)*s35 \
v81_part5=v81_part4+(-1.549478e+01)*s36+1.240304e+01*s37+(-1.314114e+00)*s38+(-1.426331e+03)*s39+(-1.057447e+01)*s40+(-5.004163e-01)*s41+5.068192e-01*s42+(-1.677637e+00)*s43+(-5.705560e+00)*s44 \
v81_part6=v81_part5+(-1.086672e+01)*s45+(-1.262282e+01)*s46+(-2.033139e+00)*s47+9.010271e+00*s48+4.011938e+01*s49+1.850622e+01*s50+2.664745e+01*s51+4.495685e+00*s52+1.096521e+00*s53 \
v81=v81_part6+7.405542e+00*s54+(-2.083863e-01)*s55+(-2.139796e+01)*s56+(-5.515793e+00)*s57+(-7.300298e-01)*s58+1.268262e+01*s59+3.050614e+02*s60+6.843123e+00*s61+5.076095e+00*s62+4.796245e-01*s63+(-2.005519e+01)*s64 \
v82_part1=(-1.069464e+01)*s0+1.534841e+01*s1+9.018707e+00*s2+(-3.731634e-01)*s3+3.317027e+01*s4+(-1.000000e+04)*s5+3.811630e+00*s6+(-7.584146e-01)*s7+(-2.750942e+00)*s8 \
v82_part2=v82_part1+1.816992e+01*s9+(-7.328107e+00)*s10+(-4.074597e+00)*s11+(-9.904927e+00)*s12+(-9.042972e+00)*s13+(-4.089338e+01)*s14+(-1.461338e+03)*s15+(-3.009570e+01)*s16+1.043263e+01*s17 \
v82_part3=v82_part2+(-4.742569e+00)*s18+(-1.600548e-02)*s19+(-7.711030e+00)*s20+1.443926e+00*s21+(-7.176876e+00)*s22+6.121003e+00*s23+1.320135e+01*s24+4.439743e+00*s25+1.234320e+02*s26 \
v82_part4=v82_part3+2.335363e+01*s27+6.994174e+00*s28+4.001582e+00*s29+(-2.531158e+00)*s30+3.165135e+00*s31+2.746488e+00*s32+3.417271e+01*s33+(-8.665383e+00)*s34+1.193813e+01*s35 \
v82_part5=v82_part4+8.943224e+00*s36+(-1.898880e+01)*s37+(-3.396028e+00)*s38+2.630164e+00*s39+1.181457e+01*s40+1.570638e+01*s41+(-1.109411e+01)*s42+(-2.508306e-02)*s43+4.755919e+00*s44 \
v82_part6=v82_part5+3.997230e+00*s45+1.383630e+01*s46+3.702824e+00*s47+(-2.915154e+00)*s48+(-6.677275e+01)*s49+1.039245e+01*s50+3.088976e+01*s51+(-1.247143e+01)*s52+(-7.820745e+00)*s53 \
v82=v82_part6+(-1.455860e+02)*s54+(-1.922184e+01)*s55+1.316795e+01*s56+5.511139e+00*s57+7.616797e-01*s58+(-3.735599e+00)*s59+2.536737e+02*s60+(-6.712267e+00)*s61+(-1.266153e+01)*s62+(-4.990225e+00)*s63+2.903898e+01*s64 \
v83_part1=1.265592e+01*s0+1.261273e+00*s1+(-8.760533e-01)*s2+(-1.021950e+01)*s3+2.126875e+00*s4+(-2.925834e+00)*s5+(-1.068829e+00)*s6+(-5.525279e-01)*s7+1.695021e+00*s8 \
v83_part2=v83_part1+(-1.567516e+00)*s9+(-1.632099e-01)*s10+1.761717e+00*s11+(-7.082886e+00)*s12+2.621412e-01*s13+1.574921e+00*s14+1.714930e+01*s15+(-6.397787e-01)*s16+3.228751e+00*s17 \
v83_part3=v83_part2+1.286303e+00*s18+(-4.195306e+00)*s19+(-7.795260e-01)*s20+(-2.203195e-03)*s21+1.502686e-01*s22+(-6.879088e+00)*s23+(-1.989381e+01)*s24+(-2.082109e+03)*s25+1.043983e+00*s26 \
v83_part4=v83_part3+6.675218e-02*s27+(-2.690967e+00)*s28+2.987353e-01*s29+8.245655e+00*s30+6.165000e-01*s31+1.023347e+00*s32+3.458516e+01*s33+(-9.657421e-01)*s34+(-3.714865e+00)*s35 \
v83_part5=v83_part4+(-7.270365e+01)*s36+(-2.924509e+00)*s37+(-5.456156e-01)*s38+7.792174e+00*s39+(-1.873099e-01)*s40+1.841562e+00*s41+1.659998e+00*s42+2.600329e+01*s43+(-2.191050e+01)*s44 \
v83_part6=v83_part5+(-1.164478e+00)*s45+(-2.061137e-01)*s46+(-2.633759e+01)*s47+(-3.321836e+00)*s48+(-2.231425e+00)*s49+(-2.488631e+00)*s50+3.225278e-01*s51+(-8.044651e-01)*s52+2.372292e-01*s53 \
v83=v83_part6+(-1.936572e+00)*s54+5.898450e+01*s55+(-4.085258e-01)*s56+2.549100e+00*s57+(-8.193911e+00)*s58+1.499173e+01*s59+(-2.268073e+00)*s60+(-4.975887e-01)*s61+(-2.590082e+00)*s62+1.361904e-01*s63+(-6.693848e+00)*s64 \
v84_part1=1.460432e+00*s0+7.032178e-01*s1+1.511747e+00*s2+(-1.804464e+00)*s3+4.041744e-01*s4+(-6.268073e-01)*s5+6.072882e-01*s6+7.027902e-01*s7+(-3.267022e+00)*s8 \
v84_part2=v84_part1+1.247476e+00*s9+4.040354e-01*s10+(-3.112713e-01)*s11+1.216656e+01*s12+4.352030e-01*s13+1.216503e+00*s14+1.978946e+00*s15+1.580631e+00*s16+(-2.770815e-01)*s17 \
v84_part3=v84_part2+(-1.061309e+00)*s18+5.559883e+00*s19+8.083897e-01*s20+(-1.898038e+00)*s21+(-2.301311e+00)*s22+6.424746e+00*s23+3.384797e+01*s24+1.132377e+02*s25+(-1.106270e+00)*s26 \
v84_part4=v84_part3+(-1.670579e-01)*s27+(-1.305782e+01)*s28+3.143484e-01*s29+(-1.660846e+01)*s30+4.255181e-01*s31+(-3.817675e-01)*s32+(-9.258357e+01)*s33+(-1.020491e+01)*s34+(-7.392125e-01)*s35 \
v84_part5=v84_part4+6.900741e+01*s36+4.437982e+00*s37+6.852884e-01*s38+(-2.306664e+00)*s39+(-4.012777e-02)*s40+(-3.001511e+00)*s41+(-8.866657e-01)*s42+(-2.660472e+01)*s43+1.497907e+01*s44 \
v84_part6=v84_part5+2.067487e+00*s45+8.569153e-01*s46+4.287666e+01*s47+1.112088e+01*s48+(-6.233913e-01)*s49+9.220757e+00*s50+(-1.120314e+00)*s51+1.883010e+00*s52+(-9.189978e-01)*s53 \
v84=v84_part6+(-6.904177e-01)*s54+4.198682e+01*s55+1.791386e+00*s56+(-2.180640e+00)*s57+5.286827e+00*s58+(-3.198743e+00)*s59+(-2.018785e+00)*s60+(-7.891167e-01)*s61+2.939972e+00*s62+4.648846e+00*s63+8.940296e+00*s64 \
v85_part1=8.243617e-01*s0+(-1.811281e+00)*s1+(-3.202695e-01)*s2+1.748220e+01*s3+(-3.908786e+00)*s4+(-8.234049e+00)*s5+8.063885e-01*s6+(-4.565606e-02)*s7+4.990403e-01*s8 \
v85_part2=v85_part1+1.449718e-01*s9+(-4.901977e-02)*s10+(-1.884917e+00)*s11+(-5.121028e+00)*s12+(-7.067837e-01)*s13+(-2.581555e+00)*s14+1.117045e+00*s15+1.176821e+00*s16+(-3.919231e+00)*s17 \
v85_part3=v85_part2+(-1.166945e+00)*s18+(-7.621889e-02)*s19+6.832055e-01*s20+(-2.988667e-02)*s21+1.567904e+00*s22+1.513958e+00*s23+(-4.285519e-01)*s24+2.020106e+03*s25+8.293913e-02*s26 \
v85_part4=v85_part3+3.732874e-02*s27+1.148031e+01*s28+(-4.829196e-01)*s29+4.437274e+00*s30+(-4.538569e-01)*s31+(-7.666654e-01)*s32+2.084943e+01*s33+1.361220e+01*s34+(-2.956370e+00)*s35 \
v85_part5=v85_part4+2.342382e+01*s36+(-3.241256e+00)*s37+(-2.077151e-01)*s38+1.295842e+00*s39+(-5.271381e-01)*s40+2.847592e-01*s41+(-1.261626e+00)*s42+(-1.250272e+01)*s43+1.226715e+01*s44 \
v85_part6=v85_part5+(-3.880710e-02)*s45+(-1.208766e+00)*s46+4.876658e-01*s47+(-8.268253e+00)*s48+3.951326e+00*s49+(-1.013603e+02)*s50+9.978972e-01*s51+(-1.421103e+00)*s52+3.272287e-01*s53 \
v85=v85_part6+(-3.246692e-01)*s54+(-8.355729e+01)*s55+(-1.351675e+00)*s56+(-1.906171e+00)*s57+4.119797e+00*s58+(-1.496709e+01)*s59+(-7.317649e-01)*s60+(-2.860374e-01)*s61+(-3.456560e-01)*s62+(-4.662914e+00)*s63+(-4.142649e+00)*s64 \
v86_part1=2.308089e+00*s0+1.102423e+00*s1+3.029888e+00*s2+(-2.069252e+00)*s3+3.472461e+00*s4+9.712529e+00*s5+5.878579e+00*s6+(-7.501233e+00)*s7+2.068614e+01*s8 \
v86_part2=v86_part1+2.934263e+00*s9+1.465532e+02*s10+2.541240e+01*s11+1.000000e+04*s12+1.000000e+04*s13+8.636665e+00*s14+9.401288e+02*s15+4.036348e+00*s16+1.649204e+00*s17 \
v86_part3=v86_part2+2.941385e+00*s18+3.645381e+00*s19+2.421744e-01*s20+2.902752e+00*s21+8.390763e+00*s22+6.562092e+00*s23+6.862359e+00*s24+1.059753e+00*s25+3.132253e+00*s26 \
v86_part4=v86_part3+4.520325e+00*s27+9.283918e+00*s28+1.081193e+01*s29+(-7.082561e+00)*s30+3.672892e+03*s31+2.096727e+01*s32+5.179974e+00*s33+1.269319e+02*s34+1.036936e+01*s35 \
v86_part5=v86_part4+5.853972e+00*s36+(-9.419662e-01)*s37+(-3.951387e+00)*s38+(-4.031072e+00)*s39+6.744689e+02*s40+2.623454e+00*s41+1.372425e+00*s42+7.859807e+00*s43+4.348133e+00*s44 \
v86_part6=v86_part5+2.347171e+00*s45+5.715618e-01*s46+1.386786e+00*s47+1.000000e+04*s48+1.014650e+01*s49+1.176551e+00*s50+(-1.201456e+03)*s51+(-6.660801e+00)*s52+(-1.652372e+01)*s53 \
v86=v86_part6+(-1.403271e+00)*s54+3.314376e+01*s55+1.116481e+00*s56+4.816641e+00*s57+3.424685e+01*s58+(-5.160156e+00)*s59+6.217392e+01*s60+5.232818e-02*s61+(-1.930199e+01)*s62+(-4.551320e+01)*s63+2.099753e+01*s64 \
v87_part1=(-3.042243e+01)*s0+4.569657e-01*s1+(-1.477163e+00)*s2+5.103845e+00*s3+(-2.259486e+00)*s4+(-6.479961e+00)*s5+(-1.256514e+00)*s6+(-1.445093e+02)*s7+(-4.026504e-01)*s8 \
v87_part2=v87_part1+(-9.761030e-01)*s9+1.556726e+01*s10+(-1.863076e+01)*s11+6.917135e+01*s12+1.000000e+04*s13+(-7.100509e+00)*s14+6.305777e+03*s15+(-3.235670e+00)*s16+5.000120e-01*s17 \
v87_part3=v87_part2+(-1.780914e-01)*s18+(-1.483666e+00)*s19+4.745650e-01*s20+(-8.739833e-02)*s21+(-5.581307e+00)*s22+(-3.242783e+00)*s23+(-4.206779e+00)*s24+(-2.548123e-01)*s25+(-9.934754e-01)*s26 \
v87_part4=v87_part3+(-1.896703e+00)*s27+(-5.985066e+00)*s28+(-8.400448e+00)*s29+1.447986e+01*s30+(-8.208201e+03)*s31+4.734012e-01*s32+(-1.108482e+00)*s33+(-8.344459e+00)*s34+6.243673e+01*s35 \
v87_part5=v87_part4+(-5.815165e+00)*s36+5.833759e+00*s37+1.204003e+01*s38+5.195589e+00*s39+4.889869e+02*s40+(-1.586371e+00)*s41+1.763406e+00*s42+(-6.857106e+00)*s43+(-1.119274e+00)*s44 \
v87_part6=v87_part5+5.949597e-02*s45+1.440649e+00*s46+1.559563e+00*s47+1.000000e+04*s48+(-7.708540e+00)*s49+1.319719e+00*s50+(-2.604485e+03)*s51+1.558763e+01*s52+3.203404e+01*s53 \
v87=v87_part6+2.771255e+00*s54+1.673443e+01*s55+1.509526e+00*s56+(-2.012268e+00)*s57+(-2.133710e+01)*s58+9.626249e+00*s59+6.973954e+01*s60+5.869571e-02*s61+3.290265e+01*s62+7.362146e+01*s63+(-1.433149e+01)*s64 \
v88_part1=5.379226e+00*s0+1.422594e-01*s1+(-1.609562e+00)*s2+4.734669e+00*s3+(-1.034119e+00)*s4+(-3.711951e+00)*s5+(-1.005956e+00)*s6+9.817660e+02*s7+(-6.543046e+00)*s8 \
v88_part2=v88_part1+2.750071e+00*s9+3.328599e+01*s10+(-5.008851e+00)*s11+1.000000e+04*s12+1.000000e+04*s13+(-1.735444e+00)*s14+3.087429e+03*s15+1.045996e+00*s16+(-6.870074e-01)*s17 \
v88_part3=v88_part2+(-1.667166e+00)*s18+(-6.264114e-01)*s19+1.037868e-01*s20+3.828301e+00*s21+(-4.922521e+00)*s22+(-7.894752e-01)*s23+(-2.375907e-01)*s24+9.633096e-01*s25+8.556014e-01*s26 \
v88_part4=v88_part3+1.563188e+00*s27+(-2.884420e+00)*s28+(-9.140123e-01)*s29+1.170190e+01*s30+8.907699e+02*s31+6.569259e+00*s32+4.144157e+00*s33+5.230848e+01*s34+(-5.365436e+00)*s35 \
v88_part5=v88_part4+(-6.029253e+00)*s36+2.426131e+00*s37+3.427349e+00*s38+6.449145e+00*s39+1.182555e+02*s40+3.611796e+00*s41+2.148155e+00*s42+(-5.575779e+00)*s43+3.648450e+00*s44 \
v88_part6=v88_part5+1.876686e+00*s45+3.732400e+00*s46+4.403356e+00*s47+1.000000e+04*s48+(-4.173029e+00)*s49+1.499049e+00*s50+(-1.264261e+03)*s51+7.089914e+00*s52+1.373561e+01*s53 \
v88=v88_part6+3.487087e+00*s54+3.105926e+01*s55+1.333635e+00*s56+(-1.568886e+00)*s57+(-4.145365e+00)*s58+1.658504e+01*s59+3.529830e+02*s60+4.325965e-02*s61+1.965415e+01*s62+4.218882e+01*s63+(-2.469789e+01)*s64 \
v89_part1=(-5.396368e+00)*s0+(-9.371758e-01)*s1+1.070627e+00*s2+(-6.448359e+00)*s3+8.563448e-01*s4+3.435017e+00*s5+8.198809e-01*s6+(-1.176878e+01)*s7+(-2.688383e-01)*s8 \
v89_part2=v89_part1+(-3.237577e+00)*s9+(-1.876608e-01)*s10+9.722691e+00*s11+2.016703e+03*s12+1.000000e+04*s13+2.065474e+00*s14+6.884787e+03*s15+(-1.232499e+00)*s16+(-6.419698e-02)*s17 \
v89_part3=v89_part2+5.561579e-01*s18+(-1.382780e-01)*s19+2.135920e-01*s20+(-5.349778e+00)*s21+4.649687e+00*s22+(-3.478276e-02)*s23+6.941019e-01*s24+4.874598e-01*s25+(-4.372919e-01)*s26 \
v89_part4=v89_part3+(-1.706582e+00)*s27+1.911689e+00*s28+1.360102e+00*s29+(-1.564769e+01)*s30+9.388063e+03*s31+(-1.361120e+01)*s32+(-5.375644e+00)*s33+(-4.331909e+01)*s34+7.088197e+01*s35 \
v89_part5=v89_part4+7.372094e+00*s36+(-5.192947e+00)*s37+(-8.245961e+00)*s38+(-5.575564e+00)*s39+7.757960e+02*s40+(-3.498755e+00)*s41+(-2.566096e+00)*s42+8.726240e+00*s43+(-3.449278e+00)*s44 \
v89_part6=v89_part5+(-2.377550e+00)*s45+(-3.317642e+00)*s46+(-4.921845e+00)*s47+1.000000e+04*s48+4.361906e+00*s49+1.516063e+00*s50+(-1.870652e+03)*s51+(-1.327557e+01)*s52+(-2.416730e+01)*s53 \
v89=v89_part6+(-2.113737e+00)*s54+1.446284e+01*s55+(-2.045086e+00)*s56+1.811790e+00*s57+(-2.435733e+00)*s58+(-1.692702e+01)*s59+8.011513e+01*s60+6.742825e-02*s61+(-2.976615e+01)*s62+(-6.359861e+01)*s63+2.975490e+01*s64 \
v90_part1=1.661472e+01*s0+(-1.273163e-01)*s1+1.314720e-03*s2+(-1.347563e+00)*s3+(-4.936053e-01)*s4+3.424449e-01*s5+(-2.157425e+00)*s6+2.125897e+01*s7+5.867150e+00*s8 \
v90_part2=v90_part1+(-5.199100e-01)*s9+2.334538e+01*s10+(-4.874934e+00)*s11+2.221135e+01*s12+9.039452e+02*s13+(-7.730892e-02)*s14+1.540957e+01*s15+3.841651e-02*s16+6.849522e-01*s17 \
v90_part3=v90_part2+(-4.467455e-01)*s18+(-1.024746e+00)*s19+(-1.944435e-02)*s20+(-2.459942e+00)*s21+(-2.776768e+00)*s22+(-2.444216e-01)*s23+1.042119e+00*s24+5.747560e+01*s25+(-1.854730e-01)*s26 \
v90_part4=v90_part3+(-3.412953e-01)*s27+(-1.646872e+00)*s28+5.633755e-01*s29+5.215452e+00*s30+2.785523e+00*s31+(-3.458108e-02)*s32+(-8.493584e-01)*s33+9.857300e+02*s34+(-4.494292e+01)*s35 \
v90_part5=v90_part4+2.002679e+00*s36+(-1.929241e+00)*s37+(-7.675546e-01)*s38+6.480774e+00*s39+2.892088e+00*s40+(-1.413048e-02)*s41+2.186694e-01*s42+1.181548e+01*s43+(-8.299030e-01)*s44 \
v90_part6=v90_part5+5.377180e-01*s45+1.255616e-01*s46+(-6.638790e-02)*s47+1.031183e+02*s48+(-1.394465e-01)*s49+(-1.255429e+03)*s50+(-3.497994e+00)*s51+(-1.585663e+00)*s52+1.356184e-01*s53 \
v90=v90_part6+1.307048e+00*s54+(-7.743049e+03)*s55+(-1.497614e+00)*s56+9.455873e-02*s57+(-7.727368e+00)*s58+1.346481e+00*s59+(-4.963566e+00)*s60+1.373373e+00*s61+(-3.263791e+00)*s62+5.114016e+00*s63+(-1.534205e+01)*s64 \
v91_part1=1.251665e+01*s0+6.437584e-02*s1+(-1.830015e-01)*s2+2.310853e+00*s3+4.319612e-01*s4+(-8.492871e-01)*s5+7.715532e-01*s6+5.154801e+00*s7+(-1.245418e+01)*s8 \
v91_part2=v91_part1+5.496570e-01*s9+8.063903e+00*s10+(-1.444456e+00)*s11+3.497892e+01*s12+8.615997e+02*s13+8.893877e-02*s14+1.160876e+01*s15+(-1.996536e-01)*s16+(-1.549972e-01)*s17 \
v91_part3=v91_part2+3.638116e-01*s18+6.653169e-01*s19+(-7.260770e-01)*s20+2.589662e+00*s21+1.861087e+00*s22+(-2.298398e-02)*s23+(-5.985736e-01)*s24+(-2.657038e+01)*s25+2.809968e-01*s26 \
v91_part4=v91_part3+2.998848e-01*s27+7.479109e-01*s28+(-3.409384e-01)*s29+(-2.030779e+01)*s30+(-2.791833e+00)*s31+(-1.179711e+01)*s32+2.906491e-01*s33+(-7.442100e+02)*s34+(-5.876605e+01)*s35 \
v91_part5=v91_part4+(-8.004175e-01)*s36+1.142498e+00*s37+4.232695e-01*s38+(-5.092043e-01)*s39+3.179113e+00*s40+2.281183e-01*s41+(-1.500590e-01)*s42+(-6.155684e+00)*s43+5.140955e-01*s44 \
v91_part6=v91_part5+(-3.695711e-01)*s45+3.311812e-01*s46+3.050886e-01*s47+(-1.209716e+02)*s48+3.313510e-01*s49+(-3.048224e+00)*s50+(-4.573875e+00)*s51+9.342198e-01*s52+(-1.803074e-01)*s53 \
v91=v91_part6+5.979392e+00*s54+(-1.000000e+04)*s55+1.774808e+00*s56+3.572740e-01*s57+7.705325e+00*s58+1.419427e+00*s59+(-6.490214e+00)*s60+1.795782e+00*s61+1.404704e+00*s62+8.005141e-01*s63+1.027186e+01*s64 \
v92_part1=2.092419e+01*s0+5.767999e-02*s1+6.045533e-02*s2+(-1.337952e+00)*s3+(-1.132525e-01)*s4+1.381127e-01*s5+1.593504e+00*s6+5.946026e-01*s7+2.975003e-01*s8 \
v92_part2=v92_part1+(-2.691144e-01)*s9+5.852581e+00*s10+7.944953e+00*s11+6.472824e+01*s12+1.233067e+03*s13+(-1.496105e-01)*s14+1.940645e+01*s15+1.898129e-01*s16+(-7.874604e-01)*s17 \
v92_part3=v92_part2+8.118388e-02*s18+3.693836e-01*s19+(-1.409779e+00)*s20+3.580975e-01*s21+8.222322e-01*s22+3.923820e-01*s23+(-4.482130e-01)*s24+(-3.489688e+01)*s25+(-5.846315e-02)*s26 \
v92_part4=v92_part3+9.553609e-03*s27+7.711095e-01*s28+(-3.200718e-01)*s29+1.417487e+01*s30+(-4.737290e+00)*s31+1.586975e+01*s32+5.978981e-01*s33+2.123356e+02*s34+(-4.213696e+01)*s35 \
v92_part5=v92_part4+(-1.407878e+00)*s36+2.172155e-01*s37+3.803206e-01*s38+(-7.633348e+00)*s39+2.912229e-01*s40+(-2.262986e-01)*s41+(-1.437995e-01)*s42+(-8.907196e+00)*s43+4.378039e-01*s44 \
v92_part6=v92_part5+(-2.468231e-01)*s45+(-5.633841e-01)*s46+5.776966e-02*s47+1.298370e+02*s48+(-2.373604e-01)*s49+(-1.586277e+02)*s50+(-3.279601e+00)*s51+6.963794e-01*s52+(-1.449722e-01)*s53 \
v92=v92_part6+(-7.330305e+00)*s54+(-5.501844e+03)*s55+(-2.393467e-01)*s56+(-6.382194e-01)*s57+3.609063e-01*s58+(-3.984454e+00)*s59+(-4.653671e+00)*s60+1.287628e+00*s61+2.055293e+00*s62+(-6.904009e+00)*s63+2.929407e+00*s64 \
v93_part1=9.137110e+01*s0+1.476749e+00*s1+(-5.415795e+02)*s2+(-1.975294e-01)*s3+(-1.000000e+04)*s4+(-2.036960e-01)*s5+(-3.594464e-01)*s6+2.163014e-01*s7+4.377189e-01*s8 \
v93_part2=v93_part1+3.938092e+00*s9+2.942627e-01*s10+(-4.782435e-03)*s11+6.587544e-01*s12+(-3.200643e-01)*s13+3.309195e+00*s14+1.000000e+04*s15+(-6.491342e+01)*s16+(-1.000000e+04)*s17 \
v93_part3=v93_part2+2.052518e+02*s18+(-1.000000e+04)*s19+3.093612e+00*s20+(-2.083470e+00)*s21+3.335216e-01*s22+1.888984e-01*s23+1.276973e+00*s24+(-2.954501e-01)*s25+2.205138e-01*s26 \
v93_part4=v93_part3+3.033027e-01*s27+(-3.479497e+03)*s28+(-1.000000e+04)*s29+3.525551e-01*s30+(-1.670671e-01)*s31+1.016836e-01*s32+(-2.122340e-01)*s33+(-1.473713e-02)*s34+4.829260e+01*s35 \
v93_part5=v93_part4+(-1.079964e+02)*s36+(-1.000000e+04)*s37+(-1.000000e+04)*s38+(-1.873380e-01)*s39+3.018135e+01*s40+1.119509e+00*s41+1.258334e+00*s42+(-6.067752e+01)*s43+1.363840e+00*s44 \
v93_part6=v93_part5+5.224456e-01*s45+4.470776e-01*s46+1.012614e+00*s47+6.577783e-01*s48+3.560634e-01*s49+(-9.288417e-01)*s50+3.016847e+02*s51+(-1.000000e+04)*s52+(-1.000000e+04)*s53 \
v93=v93_part6+(-5.156126e+00)*s54+5.263070e+00*s55+(-2.932101e-01)*s56+(-1.000000e+04)*s57+8.434697e+01*s58+(-9.166869e+02)*s59+3.078815e+01*s60+2.888145e+02*s61+(-1.000000e+04)*s62+(-1.000000e+04)*s63+(-1.000000e+04)*s64 \
v94_part1=6.354142e+01*s0+(-2.833046e+00)*s1+5.427654e+02*s2+(-2.156149e-01)*s3+(-1.000000e+04)*s4+1.303829e+00*s5+1.357116e+00*s6+(-7.938986e-03)*s7+2.216334e-01*s8 \
v94_part2=v94_part1+(-5.636914e+00)*s9+(-2.162764e-01)*s10+9.518769e-01*s11+(-3.547772e-01)*s12+1.131652e+00*s13+(-4.872902e+00)*s14+1.000000e+04*s15+(-9.425232e+00)*s16+(-1.000000e+04)*s17 \
v94_part3=v94_part2+(-3.419841e+02)*s18+(-1.000000e+04)*s19+2.913465e+01*s20+3.072224e+00*s21+1.206017e-01*s22+6.144380e-02*s23+(-1.568241e+00)*s24+3.338167e+00*s25+5.922809e-01*s26 \
v94_part4=v94_part3+3.457096e-01*s27+(-1.467899e+03)*s28+(-1.000000e+04)*s29+4.809326e-01*s30+7.118461e-01*s31+6.097801e-01*s32+9.813727e-01*s33+6.826206e-01*s34+(-9.115793e-01)*s35 \
v94_part5=v94_part4+1.154604e+02*s36+(-1.000000e+04)*s37+(-1.000000e+04)*s38+(-2.415041e+00)*s39+(-1.123558e+02)*s40+(-6.895778e-01)*s41+(-1.935405e+00)*s42+6.095496e+01*s43+(-2.126648e+00)*s44 \
v94_part6=v94_part5+(-3.056477e-02)*s45+6.631750e-02*s46+(-7.345596e-01)*s47+(-4.010550e-01)*s48+(-9.934985e-02)*s49+(-5.597326e-01)*s50+3.823931e+03*s51+(-1.000000e+04)*s52+(-1.000000e+04)*s53 \
v94=v94_part6+3.465968e+00*s54+4.400548e+01*s55+6.637340e-02*s56+(-1.000000e+04)*s57+(-3.111285e+01)*s58+1.326367e+01*s59+1.772476e+01*s60+1.223171e+02*s61+(-1.000000e+04)*s62+(-1.000000e+04)*s63+(-1.000000e+04)*s64 \
v95_part1=9.521496e+01*s0+8.365490e-01*s1+(-2.861452e+01)*s2+1.856784e+00*s3+(-1.000000e+04)*s4+2.026926e-01*s5+5.001141e-01*s6+(-3.020603e-01)*s7+1.010516e-01*s8 \
v95_part2=v95_part1+(-3.097976e+00)*s9+(-2.267632e-01)*s10+(-2.900456e-01)*s11+(-6.960508e-01)*s12+(-2.210827e-01)*s13+(-2.125676e+00)*s14+1.000000e+04*s15+(-1.156708e+02)*s16+(-1.000000e+04)*s17 \
v95_part3=v95_part2+(-2.034963e+02)*s18+(-3.950370e+03)*s19+3.889312e+00*s20+1.034576e+00*s21+2.579936e-02*s22+(-6.026420e-02)*s23+(-7.095237e-01)*s24+1.245388e+00*s25+(-1.179942e-01)*s26 \
v95_part4=v95_part3+(-4.288549e-02)*s27+1.431407e+03*s28+(-1.000000e+04)*s29+3.005274e-01*s30+1.178847e-01*s31+(-1.169889e-01)*s32+5.074494e-01*s33+(-1.387355e-01)*s34+(-7.082329e+00)*s35 \
v95_part5=v95_part4+(-1.079369e+01)*s36+(-1.000000e+04)*s37+(-1.000000e+04)*s38+2.601937e+00*s39+(-8.275781e+00)*s40+(-1.052537e+00)*s41+(-4.670157e-01)*s42+5.741935e+01*s43+(-8.173916e-01)*s44 \
v95_part6=v95_part5+(-1.050231e-01)*s45+1.106459e-01*s46+(-3.573413e-01)*s47+(-7.877847e-01)*s48+4.955325e-01*s49+(-8.833034e-01)*s50+1.130312e+03*s51+(-1.000000e+04)*s52+(-1.000000e+04)*s53 \
v95=v95_part6+7.176039e+00*s54+4.407111e+00*s55+1.377095e+00*s56+(-1.000000e+04)*s57+(-8.770365e+01)*s58+1.016144e+03*s59+2.927870e+01*s60+2.825307e+02*s61+(-1.000000e+04)*s62+(-1.000000e+04)*s63+(-1.000000e+04)*s64 \
v96_part1=4.722663e+01*s0+5.594223e-01*s1+2.707207e+01*s2+(-1.630968e+00)*s3+(-1.000000e+04)*s4+(-1.845137e-01)*s5+(-4.500291e-01)*s6+2.506294e-01*s7+6.035854e-03*s8 \
v96_part2=v96_part1+5.096161e+00*s9+3.745432e-01*s10+2.583773e-01*s11+6.174978e-01*s12+3.047429e-01*s13+3.754416e+00*s14+1.000000e+04*s15+6.734315e+01*s16+(-1.000000e+04)*s17 \
v96_part3=v96_part2+3.396726e+02*s18+(-6.543209e+03)*s19+6.687070e+00*s20+(-1.206140e+00)*s21+1.278540e-01*s22+4.241670e-01*s23+1.285628e+00*s24+(-3.277745e+00)*s25+1.653500e-01*s26 \
v96_part4=v96_part3+5.021380e-02*s27+2.181170e+03*s28+(-1.000000e+04)*s29+(-2.717389e-01)*s30+(-4.517492e-01)*s31+1.115073e-01*s32+(-8.262182e-01)*s33+7.629409e-02*s34+(-5.048402e-01)*s35 \
v96_part5=v96_part4+1.542390e+00*s36+(-1.000000e+04)*s37+(-1.000000e+04)*s38+(-2.075705e-01)*s39+7.455808e+01*s40+1.384091e+00*s41+1.240728e+00*s42+(-5.759700e+01)*s43+1.608647e+00*s44 \
v96_part6=v96_part5+3.720563e-01*s45+(-9.344532e-02)*s46+4.443722e-01*s47+7.052036e-01*s48+(-6.012183e-01)*s49+(-1.037404e-01)*s50+5.125268e+02*s51+(-1.000000e+04)*s52+(-1.000000e+04)*s53 \
v96=v96_part6+(-5.569359e+00)*s54+6.461603e+00*s55+(-1.147145e+00)*s56+(-1.000000e+04)*s57+(-3.702042e+01)*s58+(-2.439055e+02)*s59+3.438665e+00*s60+3.318209e+01*s61+(-1.000000e+04)*s62+(-1.000000e+04)*s63+(-1.000000e+04)*s64 \
v97_part1=2.556977e+01*s0+(-4.393762e-01)*s1+5.029285e-03*s2+(-6.635532e-02)*s3+(-1.859413e+01)*s4+(-2.918735e-02)*s5+1.804600e-01*s6+4.810709e-02*s7+(-4.309935e-02)*s8 \
v97_part2=v97_part1+6.829976e-01*s9+(-3.240338e-03)*s10+(-5.262193e-02)*s11+2.375016e-01*s12+(-8.231472e-02)*s13+1.651379e-01*s14+(-1.894243e+01)*s15+3.676557e+00*s16+(-5.425127e+02)*s17 \
v97_part3=v97_part2+1.537380e-01*s18+(-2.284180e+02)*s19+(-8.166835e-01)*s20+(-1.076397e+00)*s21+4.397865e-02*s22+1.053289e-01*s23+6.755027e-01*s24+(-8.460503e+00)*s25+6.061319e-02*s26 \
v97_part4=v97_part3+(-3.159987e-02)*s27+1.222009e+02*s28+(-8.234414e+01)*s29+(-1.594839e+00)*s30+9.587802e-03*s31+5.470012e-03*s32+(-4.382149e-02)*s33+(-3.167801e-01)*s34+(-1.416426e+01)*s35 \
v97_part5=v97_part4+3.672484e+02*s36+(-1.000000e+04)*s37+(-1.277968e+03)*s38+(-1.470714e+00)*s39+7.583758e-01*s40+(-8.266972e-02)*s41+(-7.711125e-02)*s42+1.074980e+01*s43+6.757953e-01*s44 \
v97_part6=v97_part5+(-9.450129e-02)*s45+5.791289e-02*s46+7.654479e-01*s47+7.723191e-02*s48+(-1.873431e-02)*s49+(-7.381462e+01)*s50+2.057101e+00*s51+(-6.599224e+01)*s52+(-5.853158e+02)*s53 \
v97=v97_part6+(-1.122203e+00)*s54+(-1.659193e+03)*s55+(-2.807742e-01)*s56+(-1.755126e+03)*s57+6.958141e+00*s58+(-3.541644e+02)*s59+(-1.564323e+00)*s60+4.328337e-01*s61+(-5.379078e+01)*s62+(-2.644300e+01)*s63+(-1.000000e+04)*s64 \
v98_part1=1.346126e+01*s0+1.263061e+00*s1+(-2.307665e+00)*s2+(-2.513573e+00)*s3+(-8.287156e+01)*s4+(-3.075369e-02)*s5+(-5.991732e-02)*s6+(-2.074191e-02)*s7+2.393686e-01*s8 \
v98_part2=v98_part1+(-7.051249e-01)*s9+(-1.179967e-02)*s10+3.441346e-02*s11+(-4.504517e-01)*s12+1.480033e-01*s13+(-1.050484e-01)*s14+(-9.972282e+00)*s15+4.619418e+00*s16+(-5.219327e+02)*s17 \
v98_part3=v98_part2+(-1.105910e-01)*s18+(-2.332320e+02)*s19+(-1.026124e+00)*s20+1.422658e+00*s21+(-6.418575e-02)*s22+6.902343e-02*s23+(-1.072412e+00)*s24+2.742613e+00*s25+(-3.402407e-02)*s26 \
v98_part4=v98_part3+9.812747e-02*s27+4.864798e+02*s28+(-1.304636e+02)*s29+2.803390e+00*s30+(-7.643908e-03)*s31+8.533597e-03*s32+1.928375e-02*s33+3.401904e-01*s34+(-1.422465e+01)*s35 \
v98_part5=v98_part4+(-3.723268e+02)*s36+(-1.000000e+04)*s37+(-4.249000e+02)*s38+(-2.637571e+00)*s39+4.507396e-01*s40+7.124554e-02*s41+4.411134e-02*s42+(-1.099279e+01)*s43+(-3.688498e-01)*s44 \
v98_part6=v98_part5+(-8.127078e-03)*s45+(-1.048179e-01)*s46+(-1.321934e+00)*s47+(-3.532613e-01)*s48+8.675006e-02*s49+(-7.412931e+01)*s50+2.065871e+00*s51+(-6.206084e+02)*s52+(-7.903898e+02)*s53 \
v98=v98_part6+(-7.912741e+00)*s54+(-1.417161e+03)*s55+(-8.066561e-03)*s56+(-1.880430e+03)*s57+1.716453e+01*s58+7.357380e+02*s59+(-1.570992e+00)*s60+4.346790e-01*s61+(-9.851102e+01)*s62+(-4.198762e+00)*s63+(-1.000000e+04)*s64 \
v99_part1=4.471064e+00*s0+(-5.829486e-01)*s1+3.040993e+00*s2+8.853152e-01*s3+(-1.099789e+01)*s4+6.471282e-02*s5+(-7.400516e-02)*s6+(-1.530772e-02)*s7+(-1.095013e-01)*s8 \
v99_part2=v99_part1+(-5.066346e-02)*s9+1.651349e-02*s10+4.109104e-02*s11+2.190920e-01*s12+(-7.696177e-04)*s13+(-9.217957e-02)*s14+(-3.312225e+00)*s15+6.016840e+00*s16+(-7.755223e+01)*s17 \
v99_part3=v99_part2+(-3.267601e-02)*s18+(-2.403739e+02)*s19+(-1.336537e+00)*s20+1.762885e-02*s21+3.445914e-02*s22+(-5.503697e-02)*s23+(-2.791455e-02)*s24+7.241883e+00*s25+(-7.988350e-03)*s26 \
v99_part4=v99_part3+(-2.370950e-02)*s27+1.675207e+02*s28+(-2.553277e+02)*s29+(-9.300443e-01)*s30+(-1.898460e-02)*s31+(-1.513040e-02)*s32+4.941791e-02*s33+(-6.907923e-03)*s34+(-5.422510e+01)*s35 \
v99_part5=v99_part4+6.634780e+00*s36+(-5.450775e+03)*s37+(-2.951301e+02)*s38+3.493098e+00*s39+1.193512e+00*s40+3.855962e-02*s41+6.328375e-02*s42+1.008762e-01*s43+(-4.265776e-01)*s44 \
v99_part6=v99_part5+8.058150e-02*s45+6.033727e-02*s46+1.740942e-02*s47+2.818160e-01*s48+(-2.534143e-03)*s49+(-1.124985e+03)*s50+7.875207e+00*s51+(-6.332031e+01)*s52+(-9.632438e+01)*s53 \
v99=v99_part6+7.326307e+00*s54+(-1.000000e+04)*s55+2.824265e-01*s56+(-1.063267e+03)*s57+6.538802e+00*s58+4.251320e+01*s59+(-5.988705e+00)*s60+1.657019e+00*s61+(-1.340168e+01)*s62+(-1.945226e+01)*s63+(-1.000000e+04)*s64 \
_p0=v0+v1*od_+v2*w_+v3*od_*w_ \
_p1=_p0+v4*(s_-0.7)+v5*(s_-0.7)*od_+v6*(s_-0.7)*w_ \
_p2=0.5*(_p1+sqrt(_p1*_p1+0.001)) \
_p3=1e-15*_p2 \
_p4=v7+v8*od_+v9*w_+v10*od_*w_+v11*od_/w_ \
_p5=_p4+v12*(s_-0.7)+v13*(s_-0.7)*od_+v14*(s_-0.7)*w_ \
_p6=sqsk_drs_1p8m0t1f1u*0.5*(_p5+sqrt(_p5*_p5+0.001)) \
_p7=v15+v16*od_+v17*w_+v18*od_*w_ \
_p8=_p7+v19*(s_-0.7)+v20*(s_-0.7)*od_+v21*(s_-0.7)*w_ \
_p9=0.5*(_p8+sqrt(_p8*_p8+0.001)) \
_p10=sqsk_dls_1p8m0t1f1u*1e-09*_p9 \
_p11=v22+v23*od_+v24*w_+v25*od_*w_+v26*od_/w_ \
_p12=_p11+v27*(s_-0.7)+v28*(s_-0.7)*od_+v29*(s_-0.7)*w_ \
_p13=sqsk_drs_1p8m0t1f1u*0.5*(_p12+sqrt(_p12*_p12+0.001)) \
_p14=v30+v31*od_+v32*w_+v33*od_*w_ \
_p15=_p14+v34*(s_-0.7)+v35*(s_-0.7)*od_+v36*(s_-0.7)*w_ \
_p16=0.5*(_p15+sqrt(_p15*_p15+0.001)) \
_p17=sqsk_dls_1p8m0t1f1u*1e-09*_p16 \
_p18=v37+v38*od_+v39*w_+v40*od_*w_ \
_p19=_p18+v41*(s_-0.7)+v42*(s_-0.7)*od_+v43*(s_-0.7)*w_ \
_p20=0.5*(atan(2*_p19)/1.5708+1) \
_p21=v44+v45*od_+v46*w_+v47*od_*w_ \
_p22=_p21+v48*(s_-0.7)+v49*(s_-0.7)*od_+v50*(s_-0.7)*w_ \
_p23=0.5*(_p22+sqrt(_p22*_p22+0.001)) \
_p24=v51+v52*od_+v53*w_+v54*od_*w_ \
_p25=_p24+v55*(s_-0.7)+v56*(s_-0.7)*od_+v57*(s_-0.7)*w_ \
_p26=0.5*(_p25+sqrt(_p25*_p25+0.001)) \
_p27=v58+v59*od_+v60*w_+v61*od_*w_ \
_p28=_p27+v62*(s_-0.7)+v63*(s_-0.7)*od_+v64*(s_-0.7)*w_ \
_p29=0.5*(_p28+sqrt(_p28*_p28+0.001)) \
_p30=v65+v66*od_+v67*w_+v68*od_*w_ \
_p31=_p30+v69*(s_-0.7)+v70*(s_-0.7)*od_+v71*(s_-0.7)*w_ \
_p32=0.5*(_p31+sqrt(_p31*_p31+0.001)) \
_p33=v72+v73*od_+v74*w_+v75*od_*w_ \
_p34=_p33+v76*(s_-0.7)+v77*(s_-0.7)*od_+v78*(s_-0.7)*w_ \
_p35=0.5*(_p34+sqrt(_p34*_p34+0.001)) \
_p36=v79+v80*od_+v81*w_+v82*od_*w_ \
_p37=_p36+v83*(s_-0.7)+v84*(s_-0.7)*od_+v85*(s_-0.7)*w_ \
_p38=0.5*(_p37+sqrt(_p37*_p37+0.001)) \
_p39=1e-14*_p23 \
_p40=sqsk_drs_sub_1p8m0t1f1u*100*_p26 \
_p41=1e-15*_p29 \
_p42=1e-14*_p32 \
_p43=sqsk_drs_sub_1p8m0t1f1u*100*_p35 \
_p44=1e-15*_p38 \
_p45=v86+v87*od_+v88*w_+v89*od_*w_ \
_p46=_p45+v90*(s_-0.7)+v91*(s_-0.7)*od_+v92*(s_-0.7)*w_ \
_p47=0.5*(_p46+sqrt(_p46*_p46+0.001)) \
_p48=v93+v94*od_+v95*w_+v96*od_*w_ \
_p49=_p48+v97*(s_-0.7)+v98*(s_-0.7)*od_+v99*(s_-0.7)*w_ \
_p50=0.5*(_p49+sqrt(_p49*_p49+0.001)) \
_p51=sqsk_drs_sub_1p8m0t1f1u*100*_p47 \
_p52=1e-13*_p50
cs (top bottom) capacitor c=_p3
rs1_1 (top n1_1) resistor r=_p6
ls1_1 (n1_1 bottom) inductor l=_p10
rs1_2 (top n1_2) resistor r=_p13
ls1_2 (n1_2 bottom) inductor l=_p17
k1 mutual_inductor coupling=_p20 ind1=ls1_1 ind2=ls1_2
c_1_sub (top _n1_1_sub) capacitor c=_p39
rs_1_sub (_n1_1_sub sub) resistor r=_p40
cs_1_sub (_n1_1_sub sub) capacitor c=_p41
c_2_sub (bottom _n1_2_sub) capacitor c=_p42
rs_2_sub (_n1_2_sub sub) resistor r=_p43
cs_2_sub (_n1_2_sub sub) capacitor c=_p44
rx_1_2_sub (_n1_1_sub _n1_2_sub) resistor r=_p51
cx_1_2_sub (_n1_1_sub _n1_2_sub) capacitor c=_p52
ends l_sqsk_rfvil_1p8m0t1f1u
