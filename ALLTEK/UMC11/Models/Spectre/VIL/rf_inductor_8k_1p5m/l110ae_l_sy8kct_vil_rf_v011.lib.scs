simulator lang=spectre insensitive=yes
library l110ae_l_sy8kct_vil_rf_v011_lib
//
section tt
include "l110ae_l_sy8kct_vil_rf_v011.mdl.scs"
parameters syct_drs_1p5m1t=1
parameters syct_drs_sub_1p5m1t=1
parameters syct_dls_1p5m1t=1
endsection tt
//
section ff
include "l110ae_l_sy8kct_vil_rf_v011.mdl.scs"
parameters syct_drs_1p5m1t=1.15
parameters syct_drs_sub_1p5m1t=0.85
parameters syct_dls_1p5m1t=1.05
endsection ff
//
section ss
include "l110ae_l_sy8kct_vil_rf_v011.mdl.scs"
parameters syct_drs_1p5m1t=0.85
parameters syct_drs_sub_1p5m1t=1.15
parameters syct_dls_1p5m1t=0.95
endsection ss
//
endlibrary l110ae_l_sy8kct_vil_rf_v011_lib
