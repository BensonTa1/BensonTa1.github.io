simulator lang=spectre insensitive=yes
// model: l_sqsk_rfvil_1p5m1t
// stacked inductor, p sub
// umc 110nm 1p5m rfcmos process
// date: 2012-04-19
// model coverage:(before shrinkage)
// od: (45 - 75) * 1e-06
// w: (2 - 3) * 1e-06
// s: (0.28 - 0.4) * 1e-06
// bm: 1 - 3
// ns: 2 - 4
// nt: 1.5 - 5.5
// frequency range: 100mhz - 0.8 * resonance (maximum 10.0 ghz)
subckt l_sqsk_rfvil_1p5m1t (top bottom sub)
parameters od=5e-05 od_=od/7.5e-05 w=2e-06 w_=w/3e-06 s=2.8e-07 s_=s/5e-07 bm=1 ns=4 nt=3.5  \
s0=(bm==1)*(ns==2)*(nt==1.5) \
s1=(bm==1)*(ns==2)*(nt==2.5) \
s2=(bm==1)*(ns==2)*(nt==3.5) \
s3=(bm==1)*(ns==2)*(nt==4.5) \
s4=(bm==1)*(ns==2)*(nt==5.5) \
s5=(bm==1)*(ns==4)*(nt==1.5) \
s6=(bm==1)*(ns==4)*(nt==2.5) \
s7=(bm==1)*(ns==4)*(nt==3.5) \
s8=(bm==1)*(ns==4)*(nt==4.5) \
s9=(bm==1)*(ns==4)*(nt==5.5) \
s10=(bm==2)*(ns==2)*(nt==1.5) \
s11=(bm==2)*(ns==2)*(nt==2.5) \
s12=(bm==2)*(ns==2)*(nt==3.5) \
s13=(bm==2)*(ns==2)*(nt==4.5) \
s14=(bm==2)*(ns==2)*(nt==5.5) \
s15=(bm==2)*(ns==3)*(nt==1.5) \
s16=(bm==2)*(ns==3)*(nt==2.5) \
s17=(bm==2)*(ns==3)*(nt==3.5) \
s18=(bm==2)*(ns==3)*(nt==4.5) \
s19=(bm==2)*(ns==3)*(nt==5.5) \
s20=(bm==3)*(ns==2)*(nt==1.5) \
s21=(bm==3)*(ns==2)*(nt==2.5) \
s22=(bm==3)*(ns==2)*(nt==3.5) \
s23=(bm==3)*(ns==2)*(nt==4.5) \
s24=(bm==3)*(ns==2)*(nt==5.5) \
v0_part1=(-4.127365e+00)*s0+7.917810e+00*s1+6.969875e+00*s2+2.638245e+01*s3+1.992545e+01*s4+(-4.904089e+00)*s5+7.676445e+00*s6+6.954554e+00*s7 \
v0_part2=v0_part1+1.174715e+01*s8+1.336254e+01*s9+(-1.810683e+00)*s10+5.229620e+00*s11+1.718536e+00*s12+1.625290e+01*s13+1.512173e+01*s14+4.325832e-01*s15 \
v0=v0_part2+5.945177e+00*s16+6.047419e+00*s17+8.499605e+00*s18+5.232844e+00*s19+3.306912e+00*s20+(-2.927174e+00)*s21+7.063172e+00*s22+1.138310e+01*s23+1.589483e+01*s24 \
v1_part1=4.009251e+00*s0+(-2.816844e+00)*s1+(-4.495340e+00)*s2+(-2.377197e+01)*s3+(-8.567425e+00)*s4+6.396385e+00*s5+(-8.900373e+00)*s6+(-7.751065e+00)*s7 \
v1_part2=v1_part1+(-1.136167e+01)*s8+(-1.079425e+01)*s9+4.325444e+00*s10+(-8.469093e-01)*s11+5.347059e+00*s12+(-8.029334e+00)*s13+(-2.115443e+00)*s14+(-4.230328e-01)*s15 \
v1=v1_part2+(-4.570516e+00)*s16+(-1.536007e+00)*s17+2.322436e+00*s18+4.160261e+00*s19+(-2.166382e+00)*s20+1.343388e+01*s21+5.080889e-01*s22+(-3.507995e-01)*s23+(-9.984579e-01)*s24 \
v2_part1=8.785037e+00*s0+(-7.811764e+00)*s1+(-8.656628e+00)*s2+(-3.396913e+01)*s3+(-2.780239e+01)*s4+3.033449e+00*s5+(-8.079171e+00)*s6+(-9.715705e+00)*s7 \
v2_part2=v2_part1+(-1.424357e+01)*s8+(-1.908558e+01)*s9+2.189696e+00*s10+(-1.104778e+01)*s11+(-5.553503e+00)*s12+(-2.525710e+01)*s13+(-2.804269e+01)*s14+(-2.888476e-01)*s15 \
v2=v2_part2+(-7.628330e+00)*s16+(-8.196237e+00)*s17+(-1.337848e+01)*s18+(-1.182470e+01)*s19+(-7.228275e+00)*s20+(-8.310757e-01)*s21+(-1.345093e+01)*s22+(-2.169952e+01)*s23+(-3.095990e+01)*s24 \
v3_part1=1.377692e+00*s0+2.573842e+01*s1+4.252427e+01*s2+7.811549e+01*s3+6.995698e+01*s4+7.901415e+00*s5+2.464729e+01*s6+3.978817e+01*s7 \
v3_part2=v3_part1+4.164881e+01*s8+4.917983e+01*s9+6.528089e+00*s10+3.444710e+01*s11+3.348443e+01*s12+6.171624e+01*s13+6.736236e+01*s14+7.107370e+00*s15 \
v3=v3_part2+2.445984e+01*s16+2.989709e+01*s17+4.325960e+01*s18+4.290755e+01*s19+2.554781e+01*s20+1.926965e+01*s21+4.510690e+01*s22+5.968744e+01*s23+7.283827e+01*s24 \
v4_part1=7.313885e+00*s0+(-1.217441e+00)*s1+(-1.428552e-02)*s2+(-4.527554e+00)*s3+2.252288e+00*s4+2.144954e+01*s5+(-1.250785e+00)*s6+(-2.415349e-01)*s7 \
v4_part2=v4_part1+1.660877e-01*s8+(-1.444582e-01)*s9+1.941541e+00*s10+(-1.868393e+00)*s11+1.392270e+00*s12+(-1.093127e+00)*s13+2.701510e+00*s14+3.021863e+00*s15 \
v4=v4_part2+4.724693e-01*s16+(-3.963273e-01)*s17+(-3.450701e-01)*s18+9.922007e-01*s19+(-2.036853e-01)*s20+(-1.527204e+00)*s21+(-4.855488e-01)*s22+2.042326e-01*s23+(-2.074831e-01)*s24 \
v5_part1=(-8.796972e+00)*s0+1.654827e+00*s1+(-1.204396e+00)*s2+5.536337e+00*s3+2.663032e+00*s4+(-2.908080e+01)*s5+1.806170e+00*s6+3.997338e+00*s7 \
v5_part2=v5_part1+8.577017e-01*s8+2.056733e+00*s9+(-2.645500e+00)*s10+(-6.034574e+00)*s11+1.293757e+00*s12+3.014170e+00*s13+3.922563e+00*s14+(-3.467892e-01)*s15 \
v5=v5_part2+5.475311e-02*s16+1.393242e+00*s17+5.130486e+00*s18+3.943604e-01*s19+2.961196e-01*s20+(-1.398407e+01)*s21+1.957608e+00*s22+3.966940e+00*s23+7.585319e+00*s24 \
v6_part1=(-8.752087e-01)*s0+9.285812e-01*s1+6.294610e-01*s2+(-2.837634e-01)*s3+(-6.432041e+00)*s4+(-7.237280e+00)*s5+(-7.111992e-02)*s6+(-2.469878e+00)*s7 \
v6_part2=v6_part1+(-4.578639e-01)*s8+(-1.498350e+00)*s9+(-4.105362e-01)*s10+1.428243e+00*s11+(-2.686932e+00)*s12+(-1.125595e+00)*s13+(-6.793592e+00)*s14+(-3.218201e+00)*s15 \
v6=v6_part2+(-3.751512e-01)*s16+(-8.184058e-02)*s17+(-3.052640e+00)*s18+(-5.326334e-01)*s19+(-5.055989e-01)*s20+8.218360e+00*s21+(-8.416321e-01)*s22+(-3.122950e+00)*s23+(-6.044501e+00)*s24 \
v7_part1=(-2.426972e+00)*s0+3.227680e+03*s1+(-6.229759e+02)*s2+(-7.500623e+01)*s3+(-6.723072e+00)*s4+(-1.570111e+01)*s5+(-1.707003e+01)*s6+(-3.279100e+02)*s7 \
v7_part2=v7_part1+(-8.791041e+01)*s8+2.093664e+02*s9+3.339297e+01*s10+8.814049e+01*s11+(-1.982154e+02)*s12+(-2.306973e+01)*s13+(-3.299075e+01)*s14+(-1.346073e+00)*s15 \
v7=v7_part2+(-5.568005e+01)*s16+5.167712e+01*s17+(-1.426915e+03)*s18+(-7.157636e+01)*s19+(-1.223163e+00)*s20+1.238711e+01*s21+(-2.737194e+01)*s22+3.555191e+01*s23+(-4.576251e+01)*s24 \
v8_part1=(-6.772792e+00)*s0+1.226027e+02*s1+(-1.154164e+03)*s2+(-2.024750e+02)*s3+(-2.290379e+00)*s4+(-3.089502e+00)*s5+(-8.009933e+00)*s6+8.928179e+02*s7 \
v8_part2=v8_part1+(-3.853595e+01)*s8+1.155166e+03*s9+(-6.246128e+02)*s10+1.098307e+03*s11+(-4.358603e+02)*s12+3.339295e+00*s13+4.854920e+01*s14+2.132439e+01*s15 \
v8=v8_part2+(-2.144995e+03)*s16+1.785921e+03*s17+3.947936e+03*s18+9.263131e+01*s19+(-9.139342e+00)*s20+3.979851e+02*s21+9.640203e+00*s22+(-2.106391e+01)*s23+3.583604e+01*s24 \
v9_part1=(-1.005970e+00)*s0+4.172597e+02*s1+2.698680e+02*s2+(-1.014299e+01)*s3+(-5.828271e+01)*s4+1.198334e+01*s5+(-4.039666e+00)*s6+1.515594e+02*s7 \
v9_part2=v9_part1+3.256328e+01*s8+(-5.107095e+02)*s9+(-3.471136e+01)*s10+9.484013e+01*s11+9.305564e+01*s12+(-5.910104e-01)*s13+(-3.582804e+01)*s14+(-2.161383e+00)*s15 \
v9=v9_part2+(-8.778032e+02)*s16+(-3.243270e+02)*s17+6.796473e+02*s18+7.470765e+00*s19+(-1.406272e+00)*s20+(-1.468949e+02)*s21+1.737902e+01*s22+(-7.184767e+01)*s23+(-2.875382e+00)*s24 \
v10_part1=3.967413e+00*s0+3.178804e+02*s1+2.178922e+02*s2+1.403803e+02*s3+3.927946e+01*s4+1.624293e-01*s5+1.649355e+01*s6+(-5.252832e+02)*s7 \
v10_part2=v10_part1+(-4.508066e+00)*s8+(-2.861303e+02)*s9+6.211589e+02*s10+1.486306e+02*s11+1.301351e+02*s12+(-1.832835e+00)*s13+(-5.775134e+00)*s14+(-1.274806e+01)*s15 \
v10=v10_part2+1.124682e+03*s16+(-7.074602e+02)*s17+(-2.031124e+03)*s18+(-3.754264e+01)*s19+5.135419e+00*s20+4.772644e+01*s21+(-2.701997e+01)*s22+2.873076e+01*s23+(-2.390696e+01)*s24 \
v11_part1=4.916503e+01*s0+7.691537e+02*s1+2.130583e+03*s2+4.381594e+02*s3+1.961291e+02*s4+1.147551e+02*s5+1.588725e+02*s6+3.882305e+02*s7 \
v11_part2=v11_part1+3.475901e+02*s8+5.258655e+01*s9+2.881347e+02*s10+3.439048e+02*s11+7.085595e+02*s12+1.162367e+02*s13+2.136101e+02*s14+5.266625e+01*s15 \
v11=v11_part2+3.517796e+03*s16+(-1.027608e+02)*s17+5.880670e+02*s18+2.391804e+02*s19+4.487365e+01*s20+1.722324e+02*s21+1.306157e+02*s22+2.194149e+02*s23+2.875266e+02*s24 \
v12_part1=(-5.592249e-01)*s0+1.744781e+01*s1+1.578694e+01*s2+1.635243e+02*s3+(-1.070632e+01)*s4+8.376092e+01*s5+(-4.356114e+00)*s6+(-5.864577e+01)*s7 \
v12_part2=v12_part1+(-1.686878e+01)*s8+(-8.646010e+01)*s9+(-1.481585e+00)*s10+(-5.731344e+01)*s11+(-1.399786e+01)*s12+(-6.596397e+00)*s13+1.440594e+01*s14+(-7.385957e-01)*s15 \
v12=v12_part2+1.943308e+02*s16+(-2.405861e+00)*s17+(-4.015986e+01)*s18+(-5.146378e+01)*s19+(-4.965094e-01)*s20+4.146855e+01*s21+(-2.000580e+00)*s22+(-1.156509e+01)*s23+(-3.793548e+01)*s24 \
v13_part1=5.161451e-02*s0+2.686106e+01*s1+1.377923e+00*s2+(-1.690573e+02)*s3+(-1.136725e+00)*s4+(-4.946217e+01)*s5+7.146630e-02*s6+5.758329e+01*s7 \
v13_part2=v13_part1+(-4.798395e-01)*s8+(-3.588347e+01)*s9+1.704093e+00*s10+2.755183e-02*s11+1.533146e+01*s12+5.095057e-01*s13+(-4.547606e+01)*s14+1.600237e-03*s15 \
v13=v13_part2+2.621923e-03*s16+(-3.649536e+01)*s17+(-3.731123e+01)*s18+2.272432e+01*s19+(-1.328784e-01)*s20+8.231462e+02*s21+1.414944e+00*s22+3.404436e+01*s23+1.125221e+01*s24 \
v14_part1=3.164745e-01*s0+1.328882e+01*s1+9.631334e-01*s2+(-5.882991e+01)*s3+7.944925e+00*s4+(-5.506983e+01)*s5+2.983237e+00*s6+6.672985e+01*s7 \
v14_part2=v14_part1+9.906556e+00*s8+1.123060e+02*s9+(-5.720883e+00)*s10+(-5.781293e+01)*s11+1.838703e+01*s12+3.616973e+00*s13+1.081405e+01*s14+5.023277e-01*s15 \
v14=v14_part2+5.469050e-03*s16+(-3.426810e+00)*s17+(-3.436668e+02)*s18+2.927119e+01*s19+4.536598e-01*s20+(-4.137729e+02)*s21+(-2.012522e+00)*s22+(-1.571194e+01)*s23+9.743582e+00*s24 \
v15_part1=(-3.556491e-01)*s0+2.672191e+02*s1+3.142854e+01*s2+(-2.919143e+01)*s3+(-3.316065e+00)*s4+1.034081e+00*s5+(-4.272475e+00)*s6+(-2.050031e+01)*s7 \
v15_part2=v15_part1+(-1.463802e+01)*s8+(-4.093618e+01)*s9+(-9.797504e-01)*s10+(-1.448027e+01)*s11+3.724086e+00*s12+(-4.157713e+00)*s13+(-9.914529e-01)*s14+(-8.016446e-01)*s15 \
v15=v15_part2+1.656382e+02*s16+(-1.228422e+00)*s17+(-9.725280e+00)*s18+(-8.197463e+00)*s19+(-3.605459e-01)*s20+(-1.776433e+01)*s21+(-9.359934e-01)*s22+1.212796e-01*s23+(-4.714650e+00)*s24 \
v16_part1=2.261642e+00*s0+4.760468e+01*s1+(-1.856019e+01)*s2+7.486182e+01*s3+2.063312e+01*s4+5.365545e+00*s5+2.139088e+01*s6+7.222771e+01*s7 \
v16_part2=v16_part1+7.365240e+01*s8+1.352197e+02*s9+3.751147e+00*s10+1.125283e+02*s11+7.392712e+00*s12+2.554728e+01*s13+1.887288e+01*s14+4.827854e+00*s15 \
v16=v16_part2+(-1.836982e+02)*s16+3.582972e+01*s17+7.704810e+01*s18+4.402279e+01*s19+2.246625e+00*s20+4.508214e+01*s21+9.522959e+00*s22+1.544102e+01*s23+2.742391e+01*s24 \
v17_part1=(-8.316531e-02)*s0+(-6.346173e+01)*s1+(-3.990418e+01)*s2+2.458099e+01*s3+(-2.916946e+00)*s4+(-3.253627e+00)*s5+(-7.543476e-01)*s6+5.446981e+00*s7 \
v17_part2=v17_part1+(-2.410186e+00)*s8+8.882126e+00*s9+3.078427e+00*s10+(-2.291951e+01)*s11+(-7.960012e+00)*s12+(-3.590441e+00)*s13+(-5.916144e+00)*s14+(-1.725416e-01)*s15 \
v17=v17_part2+(-1.700521e+02)*s16+(-9.684336e+00)*s17+2.769301e+00*s18+(-7.018951e+00)*s19+(-6.558705e-02)*s20+2.799385e+00*s21+(-1.836089e+00)*s22+(-5.547544e+00)*s23+(-5.319578e+00)*s24 \
v18_part1=(-4.588245e-01)*s0+8.032460e-01*s1+5.229222e+01*s2+(-5.914173e+01)*s3+(-4.591965e+00)*s4+3.034906e+00*s5+(-3.904847e+00)*s6+(-1.730776e+01)*s7 \
v18_part2=v18_part1+(-2.741505e+01)*s8+(-4.833971e+01)*s9+(-3.490612e+00)*s10+(-1.797932e+00)*s11+8.183586e+00*s12+(-2.166351e+00)*s13+(-4.168687e-01)*s14+(-9.174293e-01)*s15 \
v18=v18_part2+2.492373e+02*s16+7.354080e+00*s17+(-4.739202e+00)*s18+(-5.609665e+00)*s19+(-4.622788e-01)*s20+(-4.812144e+00)*s21+(-8.654686e-01)*s22+4.869180e-01*s23+(-2.229366e+00)*s24 \
v19_part1=(-3.227437e-02)*s0+(-2.691897e+00)*s1+1.260966e+00*s2+2.268334e+00*s3+(-8.200637e-01)*s4+3.570611e+00*s5+(-1.645594e-02)*s6+2.054125e+00*s7 \
v19_part2=v19_part1+(-2.814908e+00)*s8+6.824099e+00*s9+(-1.298534e-01)*s10+2.282029e+01*s11+2.158684e+00*s12+(-4.311626e-01)*s13+(-1.567783e+00)*s14+(-5.569512e-02)*s15 \
v19=v19_part2+(-1.761595e+01)*s16+(-7.117419e+00)*s17+1.262477e+00*s18+(-1.644167e+00)*s19+(-2.303901e-02)*s20+1.287862e+01*s21+(-4.566510e-01)*s22+(-1.134122e+00)*s23+(-9.231388e-01)*s24 \
v20_part1=(-4.144705e-02)*s0+3.505508e-01*s1+(-2.538014e+00)*s2+(-2.928294e+00)*s3+(-1.534653e+00)*s4+(-3.641111e+00)*s5+(-9.928504e-01)*s6+(-2.363663e+00)*s7 \
v20_part2=v20_part1+(-4.037989e+00)*s8+(-1.898444e+01)*s9+(-2.944059e-03)*s10+(-1.518631e+01)*s11+1.061116e+00*s12+(-1.838266e+00)*s13+(-1.061489e+00)*s14+(-8.590109e-02)*s15 \
v20=v20_part2+1.312576e+01*s16+(-3.027269e+00)*s17+8.614186e+00*s18+(-3.675723e+00)*s19+(-4.381728e-02)*s20+1.381126e+01*s21+(-3.572624e-01)*s22+(-2.712417e+00)*s23+(-4.922212e+00)*s24 \
v21_part1=3.192502e-02*s0+(-1.161213e+01)*s1+2.203817e+00*s2+(-6.406320e-01)*s3+9.320404e-01*s4+(-1.731340e+00)*s5+1.093851e-01*s6+(-5.854921e+00)*s7 \
v21_part2=v21_part1+3.678343e+00*s8+(-8.917887e-01)*s9+4.245299e-02*s10+2.591954e+00*s11+(-4.015696e+00)*s12+5.053495e-01*s13+5.966704e-01*s14+5.670636e-02*s15 \
v21=v21_part2+(-2.562546e-01)*s16+7.497656e+00*s17+(-1.702179e+01)*s18+2.430641e+00*s19+2.394082e-02*s20+(-9.030687e+00)*s21+3.669244e-01*s22+2.429970e+00*s23+3.148225e+00*s24 \
v22_part1=4.040124e+03*s0+(-1.102661e+01)*s1+(-2.054373e+01)*s2+(-5.337568e+01)*s3+(-7.499387e+02)*s4+6.404266e+01*s5+(-2.622503e+02)*s6+(-3.717341e+00)*s7 \
v22_part2=v22_part1+(-1.176218e+02)*s8+(-3.577275e+02)*s9+(-6.344157e+00)*s10+(-6.509179e+00)*s11+(-1.112835e+01)*s12+(-1.000000e+04)*s13+(-1.712171e+02)*s14+3.611657e+03*s15 \
v22=v22_part2+(-1.462422e+01)*s16+(-3.583416e+01)*s17+(-2.979658e+01)*s18+(-3.941167e+02)*s19+1.132173e+02*s20+(-1.571707e+00)*s21+2.233373e+01*s22+(-1.213227e+02)*s23+(-1.088499e+02)*s24 \
v23_part1=1.320711e+03*s0+(-2.492995e+00)*s1+8.408936e+00*s2+1.172399e+02*s3+4.538694e+02*s4+(-6.143019e+01)*s5+(-1.750242e+03)*s6+(-1.764232e+02)*s7 \
v23_part2=v23_part1+1.219591e+03*s8+(-4.238890e+02)*s9+(-5.881810e+01)*s10+(-1.827324e+01)*s11+2.086172e+01*s12+(-1.000000e+04)*s13+(-3.206904e+00)*s14+9.085241e+03*s15 \
v23=v23_part2+2.787673e+01*s16+(-3.618453e+01)*s17+3.546400e+01*s18+1.034264e+02*s19+(-3.709269e+03)*s20+(-2.679997e+01)*s21+(-1.601889e+02)*s22+3.234455e+01*s23+1.955858e+01*s24 \
v24_part1=1.518882e+03*s0+1.329202e+00*s1+3.996246e+00*s2+9.629668e+00*s3+6.525281e+02*s4+(-1.258001e+02)*s5+1.569600e+02*s6+(-3.354721e+01)*s7 \
v24_part2=v24_part1+(-4.142478e+02)*s8+2.649681e+02*s9+3.144276e+00*s10+(-1.562928e+00)*s11+(-1.634904e+00)*s12+(-1.000000e+04)*s13+9.112819e+01*s14+2.243187e+03*s15 \
v24=v24_part2+6.853771e+00*s16+1.611234e+01*s17+(-8.112058e+00)*s18+9.390724e+01*s19+2.831406e+02*s20+(-6.002464e+00)*s21+(-1.681976e+02)*s22+5.718680e+01*s23+2.297475e+01*s24 \
v25_part1=3.874766e+03*s0+8.183067e-02*s1+(-3.786022e+00)*s2+(-7.830823e+01)*s3+(-6.595698e+02)*s4+3.112324e+01*s5+3.325454e+02*s6+1.058939e+02*s7 \
v25_part2=v25_part1+(-2.708524e+02)*s8+6.107367e+01*s9+1.952126e+01*s10+8.777424e+00*s11+(-4.780886e+00)*s12+(-1.000000e+04)*s13+(-5.034038e+01)*s14+6.173248e+02*s15 \
v25=v25_part2+(-1.949818e+01)*s16+3.946869e+00*s17+(-2.200834e+01)*s18+(-2.614141e+02)*s19+8.991236e+03*s20+1.313451e+01*s21+2.798385e+02*s22+(-2.894996e+01)*s23+(-2.081974e+01)*s24 \
v26_part1=6.651923e+03*s0+8.068974e+01*s1+1.123896e+02*s2+1.796138e+02*s3+8.035287e+02*s4+4.002492e+02*s5+2.488742e+03*s6+3.452169e+02*s7 \
v26_part2=v26_part1+7.484314e+02*s8+8.385925e+02*s9+8.674154e+01*s10+7.974610e+01*s11+1.053809e+02*s12+(-1.000000e+04)*s13+4.094518e+02*s14+6.285166e+02*s15 \
v26=v26_part2+9.543292e+01*s16+1.966228e+02*s17+1.834992e+02*s18+1.088255e+03*s19+8.936565e+03*s20+8.991834e+01*s21+3.690263e+02*s22+2.565074e+02*s23+2.871262e+02*s24 \
v27_part1=7.934545e+00*s0+(-2.040314e+00)*s1+(-3.707632e+00)*s2+(-8.018550e+01)*s3+(-8.817278e+01)*s4+(-8.288785e+02)*s5+(-1.492831e+01)*s6+(-1.457894e+01)*s7 \
v27_part2=v27_part1+(-8.606438e+01)*s8+(-2.702729e+01)*s9+1.212364e-01*s10+(-2.519291e+00)*s11+(-3.667352e+00)*s12+(-8.128966e+02)*s13+(-1.001982e+02)*s14+5.690453e+00*s15 \
v27=v27_part2+(-2.760719e+00)*s16+(-8.701629e+00)*s17+(-6.932316e+00)*s18+1.552550e+02*s19+2.822813e+01*s20+(-1.592010e+01)*s21+(-3.907422e+01)*s22+(-1.027888e+01)*s23+(-1.118556e+01)*s24 \
v28_part1=1.207524e+01*s0+(-1.632493e-01)*s1+4.047560e-01*s2+6.358872e+01*s3+(-1.144001e-01)*s4+4.910302e+02*s5+(-1.611336e+01)*s6+(-8.486260e-01)*s7 \
v28_part2=v28_part1+(-6.318748e+00)*s8+2.091727e+01*s9+(-1.733749e-02)*s10+1.609790e+00*s11+(-8.841866e-02)*s12+(-4.199633e+02)*s13+1.067238e+02*s14+5.481503e+00*s15 \
v28=v28_part2+9.921699e-01*s16+9.460361e-01*s17+(-5.022775e+00)*s18+(-1.863482e+02)*s19+1.137782e+01*s20+(-1.215515e+01)*s21+(-9.517717e+00)*s22+(-3.483705e+01)*s23+(-3.489142e+00)*s24 \
v29_part1=9.876940e+00*s0+1.292418e+00*s1+4.633527e-01*s2+3.177337e+01*s3+3.586147e+01*s4+5.381736e+02*s5+(-3.929332e+00)*s6+9.807378e-01*s7 \
v29_part2=v29_part1+5.385448e+01*s8+(-1.485453e+01)*s9+(-2.133131e-01)*s10+8.731859e-01*s11+(-1.622808e+00)*s12+(-3.899078e+02)*s13+1.222540e+01*s14+1.408549e+01*s15 \
v29=v29_part2+(-7.162521e-02)*s16+6.143782e+00*s17+1.074545e+01*s18+(-6.663590e+01)*s19+5.470770e+00*s20+1.966049e+01*s21+4.575838e+01*s22+2.672121e+01*s23+1.125495e+01*s24 \
v30_part1=1.209172e+03*s0+(-1.128512e+00)*s1+(-1.932636e+00)*s2+(-5.335369e-01)*s3+(-8.887021e+00)*s4+(-5.449743e+00)*s5+8.319346e+01*s6+8.151604e-01*s7 \
v30_part2=v30_part1+(-2.027283e+02)*s8+1.731121e-01*s9+(-4.649165e-01)*s10+(-1.094526e+00)*s11+(-1.812163e+00)*s12+1.000000e+04*s13+(-7.881486e+00)*s14+1.574748e+03*s15 \
v30=v30_part2+(-2.339957e+00)*s16+(-3.137759e+00)*s17+(-6.509328e+00)*s18+2.050101e+01*s19+3.086651e+03*s20+(-2.764523e-01)*s21+(-2.966225e+00)*s22+(-4.414497e+00)*s23+(-2.491505e+00)*s24 \
v31_part1=5.120700e+02*s0+5.965258e+00*s1+1.024711e+01*s2+1.857070e+01*s3+4.014390e+01*s4+2.503136e+01*s5+(-6.686487e+01)*s6+2.817838e+01*s7 \
v31_part2=v31_part1+5.229138e+02*s8+6.279234e+01*s9+2.538356e+00*s10+6.052319e+00*s11+1.040997e+01*s12+1.000000e+04*s13+3.266086e+01*s14+3.713703e+01*s15 \
v31=v31_part2+1.236537e+01*s16+2.094883e+01*s17+3.384951e+01*s18+5.482453e+01*s19+(-2.206055e+03)*s20+5.688437e+00*s21+1.495350e+01*s22+1.947826e+01*s23+2.057623e+01*s24 \
v32_part1=(-6.084826e+01)*s0+(-1.918106e-01)*s1+(-6.104194e-01)*s2+(-4.765581e+00)*s3+(-5.757825e+00)*s4+3.149976e+00*s5+(-9.071940e+01)*s6+(-1.134747e+01)*s7 \
v32_part2=v32_part1+1.809996e+02*s8+(-2.869965e+01)*s9+9.488599e-03*s10+(-1.681060e-01)*s11+(-8.696786e-01)*s12+1.000000e+04*s13+(-2.157768e+00)*s14+7.555284e+01*s15 \
v32=v32_part2+(-4.728926e-01)*s16+(-2.601505e+00)*s17+(-3.070057e+00)*s18+(-5.731770e+01)*s19+(-2.695686e+03)*s20+(-1.103880e+00)*s21+(-4.736443e-01)*s22+(-1.140887e+00)*s23+(-4.209732e+00)*s24 \
v33_part1=2.705980e+02*s0+(-1.482159e+00)*s1+(-2.294667e+00)*s2+(-4.050343e+00)*s3+(-1.467088e+00)*s4+(-9.809681e+00)*s5+1.199620e+02*s6+4.803637e+00*s7 \
v33_part2=v33_part1+(-4.362041e+02)*s8+9.215266e+00*s9+(-6.185792e-01)*s10+(-1.575659e+00)*s11+(-1.843319e+00)*s12+1.000000e+04*s13+(-7.444748e+00)*s14+1.731055e+03*s15 \
v33=v33_part2+(-2.604018e+00)*s16+(-3.035852e+00)*s17+(-7.992054e+00)*s18+3.005494e+01*s19+2.126399e+03*s20+(-7.588666e-01)*s21+(-2.658315e-01)*s22+(-3.627597e+00)*s23+(-2.609654e+00)*s24 \
v34_part1=(-1.419556e+01)*s0+(-1.242736e-01)*s1+(-1.994163e-01)*s2+(-2.613974e+00)*s3+1.255977e+00*s4+(-1.862038e+01)*s5+(-4.752874e+00)*s6+(-3.296692e-01)*s7 \
v34_part2=v34_part1+(-2.475094e+00)*s8+(-6.799470e+00)*s9+(-2.787975e-02)*s10+(-1.523866e-01)*s11+(-8.219428e-01)*s12+5.499377e+02*s13+1.807799e-01*s14+(-1.390054e+01)*s15 \
v34=v34_part2+(-1.495665e-01)*s16+2.471497e-01*s17+(-9.648571e-01)*s18+(-2.594725e+00)*s19+(-3.278058e+00)*s20+(-1.220828e+00)*s21+8.503821e-01*s22+2.661681e-01*s23+(-6.393006e-01)*s24 \
v35_part1=(-1.997727e+01)*s0+(-1.854780e-01)*s1+(-5.854348e-01)*s2+8.877382e-02*s3+(-4.117450e+00)*s4+6.733820e+00*s5+1.727626e+00*s6+(-3.290118e-01)*s7 \
v35_part2=v35_part1+(-3.631743e+00)*s8+(-5.224692e+00)*s9+(-2.875005e-02)*s10+(-1.814760e-01)*s11+(-5.929977e-01)*s12+1.247971e+03*s13+(-6.432621e+00)*s14+(-4.101366e+00)*s15 \
v35=v35_part2+(-4.826259e-01)*s16+(-9.525933e-01)*s17+(-1.790708e+00)*s18+(-4.569895e+00)*s19+(-3.653144e+01)*s20+(-7.732147e-01)*s21+(-1.260050e+00)*s22+(-7.607862e-01)*s23+(-1.059454e+00)*s24 \
v36_part1=(-1.797102e+01)*s0+1.326008e-01*s1+1.843249e-01*s2+1.754769e+00*s3+3.822668e-01*s4+1.194312e+01*s5+4.614342e+00*s6+4.400767e-01*s7 \
v36_part2=v36_part1+(-3.145858e+00)*s8+7.168892e+00*s9+1.828654e-02*s10+1.158583e-01*s11+1.049945e+00*s12+1.098691e+03*s13+4.056041e+00*s14+(-1.584633e+01)*s15 \
v36=v36_part2+2.641274e-01*s16+(-3.078869e-01)*s17+1.161741e+00*s18+3.614734e-01*s19+(-3.010387e+01)*s20+1.277669e+00*s21+(-6.343757e-01)*s22+(-7.994358e-01)*s23+2.618612e-01*s24 \
v37_part1=(-2.502670e+00)*s0+(-6.727475e+01)*s1+7.566658e-01*s2+(-5.484017e+00)*s3+7.926785e-01*s4+(-1.695841e+00)*s5+(-3.222207e-01)*s6+(-9.171676e-03)*s7 \
v37_part2=v37_part1+(-7.388654e+00)*s8+4.464250e-01*s9+1.819785e-01*s10+(-1.408708e+01)*s11+1.791055e-01*s12+1.429017e-01*s13+4.543251e-01*s14+(-2.469061e+02)*s15 \
v37=v37_part2+1.654039e+00*s16+4.680200e-01*s17+1.466899e+00*s18+1.676272e-01*s19+6.645828e+03*s20+(-8.597576e+00)*s21+3.312543e-01*s22+2.513008e-01*s23+4.657038e-01*s24 \
v38_part1=1.751816e+02*s0+2.962964e+01*s1+6.256700e-02*s2+3.193943e+00*s3+(-1.517407e-01)*s4+2.009423e+00*s5+1.066597e+00*s6+6.799272e-01*s7 \
v38_part2=v38_part1+4.976480e+00*s8+3.068007e-01*s9+1.689293e-01*s10+6.986534e+00*s11+4.809767e-01*s12+(-4.366897e-03)*s13+2.249994e-01*s14+(-5.541145e+01)*s15 \
v38=v38_part2+(-5.280794e-01)*s16+7.850998e-02*s17+(-7.346927e-01)*s18+6.513387e-01*s19+(-6.649231e+03)*s20+1.420521e+01*s21+2.815051e-01*s22+2.852677e-01*s23+2.334361e-01*s24 \
v39_part1=(-3.591068e+02)*s0+(-1.766747e+01)*s1+(-2.842272e+00)*s2+4.637321e+00*s3+(-2.183401e+00)*s4+5.408131e-01*s5+(-1.280297e+00)*s6+(-9.629775e-01)*s7 \
v39_part2=v39_part1+6.230838e+00*s8+(-1.541638e+00)*s9+(-1.263229e+00)*s10+(-4.004902e+01)*s11+(-1.124825e+00)*s12+6.336930e-01*s13+(-1.598713e+00)*s14+(-9.325961e+01)*s15 \
v39=v39_part2+(-5.275190e+00)*s16+(-1.771523e+00)*s17+(-3.958527e+00)*s18+(-1.596154e+00)*s19+(-9.996742e+03)*s20+(-4.862363e+01)*s21+(-1.304729e+00)*s22+(-1.200951e+00)*s23+(-1.485028e+00)*s24 \
v40_part1=(-2.597041e+02)*s0+1.929427e+01*s1+1.580948e+00*s2+(-2.433619e+00)*s3+1.345701e+00*s4+(-1.411077e+00)*s5+1.931991e-01*s6+1.741071e-01*s7 \
v40_part2=v40_part1+(-3.880043e+00)*s8+7.212673e-01*s9+9.900449e-01*s10+4.514779e+01*s11+2.667044e-01*s12+(-2.998549e-01)*s13+7.723703e-01*s14+(-4.998931e+01)*s15 \
v40=v40_part2+3.517576e+00*s16+9.864008e-01*s17+3.010978e+00*s18+4.677312e-01*s19+9.997130e+03*s20+3.339699e+01*s21+4.978746e-01*s22+4.964778e-01*s23+6.610970e-01*s24 \
v41_part1=1.179346e+01*s0+1.973676e+01*s1+(-8.779950e-02)*s2+(-5.811239e-01)*s3+(-2.062680e-01)*s4+5.863537e-01*s5+(-1.102434e-01)*s6+(-2.601740e-01)*s7 \
v41_part2=v41_part1+(-2.200714e-01)*s8+(-4.253338e-02)*s9+(-7.157722e-03)*s10+4.563105e+00*s11+(-1.346920e-02)*s12+3.263913e-02*s13+8.010654e-03*s14+(-1.430774e+01)*s15 \
v41=v41_part2+(-1.073437e-01)*s16+(-1.289116e-01)*s17+(-2.281032e-01)*s18+(-7.140965e-02)*s19+1.076648e-02*s20+9.530612e+01*s21+(-1.069264e-01)*s22+(-5.590479e-02)*s23+(-1.839359e-02)*s24 \
v42_part1=4.067476e+00*s0+1.026204e+01*s1+6.530262e-03*s2+9.071509e-02*s3+1.715777e-01*s4+(-4.573490e-01)*s5+9.697864e-02*s6+9.544089e-02*s7 \
v42_part2=v42_part1+1.187980e-01*s8+1.503322e-01*s9+(-1.774490e-02)*s10+(-6.119081e+00)*s11+(-5.679647e-03)*s12+(-2.525771e-02)*s13+1.442583e-01*s14+1.534614e+01*s15 \
v42=v42_part2+1.125257e-01*s16+6.841047e-02*s17+(-1.787108e-02)*s18+9.789337e-02*s19+(-2.255039e+00)*s20+(-1.121571e+02)*s21+3.780708e-02*s22+1.250543e-01*s23+1.988191e-01*s24 \
v43_part1=3.711035e+00*s0+2.204928e+01*s1+2.064980e-01*s2+4.862165e-01*s3+5.806153e-02*s4+6.880173e-01*s5+4.477585e-02*s6+9.480493e-02*s7 \
v43_part2=v43_part1+1.604662e-01*s8+(-9.972649e-03)*s9+1.655441e-02*s10+1.573584e+00*s11+(-2.866544e-02)*s12+(-2.278014e-02)*s13+(-4.342330e-02)*s14+(-1.446580e+01)*s15 \
v43=v43_part2+2.416336e-02*s16+9.534170e-02*s17+2.664102e-01*s18+(-1.182549e-04)*s19+7.717908e+00*s20+4.278462e+01*s21+8.620566e-02*s22+1.376595e-02*s23+(-1.168715e-01)*s24 \
v44_part1=9.134464e-01*s0+(-7.497982e-01)*s1+1.673722e-01*s2+(-1.859561e+00)*s3+1.083714e-01*s4+1.070700e+00*s5+(-8.692786e-01)*s6+(-9.030831e-01)*s7 \
v44_part2=v44_part1+(-5.893341e-01)*s8+(-2.985903e-01)*s9+(-4.043335e-01)*s10+(-1.007301e+00)*s11+4.551093e-01*s12+(-1.072206e+00)*s13+1.557912e-01*s14+2.631357e-03*s15 \
v44=v44_part2+(-5.811997e-01)*s16+(-3.137141e-01)*s17+2.744010e-01*s18+3.908557e-01*s19+(-2.190669e-02)*s20+7.165787e-01*s21+(-1.856315e-01)*s22+(-3.993305e-01)*s23+9.734606e-02*s24 \
v45_part1=7.352226e-01*s0+2.249457e+00*s1+2.383813e+00*s2+5.060598e+00*s3+2.686951e+00*s4+1.719649e-01*s5+3.043154e+00*s6+3.681300e+00*s7 \
v45_part2=v45_part1+3.113795e+00*s8+2.887184e+00*s9+1.777282e+00*s10+2.460472e+00*s11+9.733656e-01*s12+3.004833e+00*s13+1.671763e+00*s14+1.582942e+00*s15 \
v45=v45_part2+2.348741e+00*s16+1.903455e+00*s17+8.811811e-01*s18+1.594026e+00*s19+8.517096e-01*s20+(-1.210679e-01)*s21+1.499482e+00*s22+1.967302e+00*s23+1.332521e+00*s24 \
v46_part1=(-2.325233e+00)*s0+(-7.688374e-01)*s1+(-1.390025e+00)*s2+5.580485e-01*s3+(-2.376320e+00)*s4+(-1.204693e+00)*s5+5.064012e-01*s6+3.117574e-01*s7 \
v46_part2=v46_part1+(-3.554398e-01)*s8+(-8.494740e-01)*s9+1.490127e-01*s10+9.259437e-01*s11+(-1.211508e+00)*s12+5.951968e-01*s13+(-1.302740e+00)*s14+(-6.855037e-01)*s15 \
v46=v46_part2+3.071916e-01*s16+(-1.392012e-01)*s17+(-1.164992e+00)*s18+(-1.312126e+00)*s19+4.931327e-02*s20+(-1.623880e+00)*s21+(-2.767490e-01)*s22+5.400066e-02*s23+(-9.224409e-01)*s24 \
v47_part1=4.011893e+00*s0+3.182777e+00*s1+2.735436e+00*s2+4.483119e-01*s3+4.288979e+00*s4+1.457746e+00*s5+(-1.726951e-01)*s6+(-3.901514e-01)*s7 \
v47_part2=v47_part1+5.909501e-01*s8+1.180621e+00*s9+6.609793e-01*s10+(-5.443151e-01)*s11+2.489735e+00*s12+2.226469e-01*s13+2.426240e+00*s14+1.493956e+00*s15 \
v47=v47_part2+1.869078e-01*s16+1.016927e+00*s17+2.620340e+00*s18+1.859461e+00*s19+(-1.464318e-02)*s20+2.769721e+00*s21+1.025277e+00*s22+4.796335e-01*s23+1.750012e+00*s24 \
v48_part1=(-1.323296e+00)*s0+2.156618e-01*s1+(-7.431934e-03)*s2+1.545818e-02*s3+(-4.329082e-01)*s4+(-2.865988e+00)*s5+1.754398e-01*s6+(-2.071527e-01)*s7 \
v48_part2=v48_part1+(-1.075241e-01)*s8+(-5.394370e-02)*s9+(-2.920327e-01)*s10+(-1.830741e-01)*s11+(-3.657784e-01)*s12+1.968029e-01*s13+(-6.388212e-01)*s14+(-5.295227e-01)*s15 \
v48=v48_part2+(-6.582555e-02)*s16+1.719727e-01*s17+1.715209e-01*s18+(-5.313457e-03)*s19+(-2.979249e-02)*s20+1.302282e+00*s21+6.605719e-02*s22+(-5.880042e-02)*s23+(-1.364003e-01)*s24 \
v49_part1=1.463965e+00*s0+2.363461e-02*s1+6.566990e-01*s2+(-2.839457e-01)*s3+7.849139e-01*s4+4.082524e+00*s5+(-2.339365e-02)*s6+4.124007e-01*s7 \
v49_part2=v49_part1+3.843043e-01*s8+3.821903e-01*s9+3.933391e-01*s10+1.619989e+00*s11+3.576915e-01*s12+2.785453e-01*s13+4.723445e-01*s14+1.246605e-01*s15 \
v49=v49_part2+2.431180e-01*s16+1.185901e-01*s17+1.506472e-01*s18+2.317862e-01*s19+(-1.530656e-02)*s20+7.230920e-01*s21+1.536684e-01*s22+1.783407e-01*s23+4.118777e-02*s24 \
v50_part1=2.491232e-01*s0+(-3.985528e-01)*s1+(-3.520128e-01)*s2+5.889632e-01*s3+6.081745e-02*s4+1.092411e+00*s5+(-8.585750e-02)*s6+(-3.728714e-02)*s7 \
v50_part2=v50_part1+(-1.220689e-01)*s8+(-1.743737e-01)*s9+4.758250e-02*s10+(-1.459984e-01)*s11+2.542846e-01*s12+(-3.738644e-01)*s13+4.009220e-01*s14+5.419986e-01*s15 \
v50=v50_part2+(-6.975497e-02)*s16+(-1.925697e-01)*s17+(-2.551804e-01)*s18+(-1.028229e-01)*s19+8.185051e-02*s20+(-8.825572e-01)*s21+(-9.179839e-02)*s22+(-4.884647e-03)*s23+1.894676e-01*s24 \
v51_part1=2.264945e+01*s0+1.113249e+01*s1+2.337653e+01*s2+2.058878e+01*s3+2.423816e+01*s4+1.949950e+01*s5+1.251877e+01*s6+8.382401e+01*s7 \
v51_part2=v51_part1+1.838182e+01*s8+2.116207e+01*s9+1.740820e+02*s10+1.684931e+00*s11+1.636039e+01*s12+7.979787e+00*s13+1.208776e+01*s14+1.592548e+01*s15 \
v51=v51_part2+1.249411e+01*s16+1.348596e+01*s17+1.810234e+01*s18+2.394496e+01*s19+2.343042e+03*s20+4.947567e+00*s21+1.781272e+01*s22+1.249754e+01*s23+2.005434e+01*s24 \
v52_part1=(-1.161193e+01)*s0+(-1.931446e+00)*s1+(-1.355120e+01)*s2+(-8.080990e+00)*s3+(-1.050828e+01)*s4+(-1.567230e+01)*s5+3.324085e+00*s6+(-2.974427e+01)*s7 \
v52_part2=v52_part1+(-8.679359e+00)*s8+(-1.170603e+01)*s9+(-7.511362e+00)*s10+6.194625e+00*s11+(-8.499193e+00)*s12+2.746420e+00*s13+(-2.391958e+00)*s14+(-4.878113e+00)*s15 \
v52=v52_part2+(-3.266251e+00)*s16+(-5.484264e+00)*s17+(-1.050146e+01)*s18+(-1.602998e+01)*s19+(-8.515397e+03)*s20+8.348566e+00*s21+(-7.355148e+00)*s22+4.134351e+00*s23+(-1.161573e+01)*s24 \
v53_part1=(-6.835747e+00)*s0+1.020739e+01*s1+(-1.959249e+00)*s2+5.576489e+00*s3+4.273338e+00*s4+(-8.684113e+00)*s5+2.706657e+01*s6+5.407474e+01*s7 \
v53_part2=v53_part1+2.252638e+00*s8+2.452876e-01*s9+1.096829e+01*s10+1.371295e+01*s11+4.750198e+00*s12+1.630599e+01*s13+1.750106e+01*s14+5.221658e-02*s15 \
v53=v53_part2+6.800945e+00*s16+6.992789e+00*s17+5.752223e+01*s18+(-5.958547e+00)*s19+1.961153e+03*s20+(-1.413873e+00)*s21+5.435682e+00*s22+1.851618e+01*s23+8.582667e+00*s24 \
v54_part1=6.840254e+00*s0+(-8.713688e+00)*s1+2.049955e+00*s2+(-5.604687e+00)*s3+(-3.543317e+00)*s4+1.026501e+01*s5+(-2.699436e+01)*s6+(-6.019702e+01)*s7 \
v54_part2=v54_part1+(-2.538397e+00)*s8+1.275652e-02*s9+(-6.118899e+01)*s10+(-1.486951e+01)*s11+(-3.096287e+00)*s12+(-1.598028e+01)*s13+(-1.372275e+01)*s14+(-1.224196e+00)*s15 \
v54=v54_part2+(-7.331731e+00)*s16+(-6.035447e+00)*s17+(-2.814418e+01)*s18+6.704354e+00*s19+2.891448e+03*s20+1.848004e+00*s21+(-3.953533e+00)*s22+(-2.088957e+01)*s23+(-2.171199e+00)*s24 \
v55_part1=(-5.278706e+00)*s0+(-1.490351e+00)*s1+1.247960e-01*s2+9.804499e-01*s3+(-1.628277e+00)*s4+1.313086e+01*s5+5.659554e+00*s6+(-9.937143e+00)*s7 \
v55_part2=v55_part1+(-1.427803e-01)*s8+3.521267e-01*s9+5.473738e+00*s10+2.391803e+01*s11+(-8.479019e-01)*s12+6.230295e+00*s13+(-6.871994e+00)*s14+(-5.640458e+00)*s15 \
v55=v55_part2+1.611055e-01*s16+2.084487e+00*s17+1.706442e+01*s18+1.223380e+00*s19+(-3.484642e+01)*s20+6.115048e+01*s21+1.101700e+00*s22+4.973523e+00*s23+1.431468e+00*s24 \
v56_part1=5.727257e+00*s0+8.195414e-01*s1+3.915334e-01*s2+(-2.546464e+00)*s3+3.260184e-01*s4+(-2.339144e+00)*s5+(-6.135585e+00)*s6+6.566536e-01*s7 \
v56_part2=v56_part1+2.762472e-01*s8+1.380643e-01*s9+2.472839e+01*s10+(-1.811103e+01)*s11+(-5.842794e-02)*s12+(-5.271284e+00)*s13+5.767902e+00*s14+1.069198e+00*s15 \
v56=v56_part2+3.478903e-01*s16+(-1.035808e+00)*s17+(-7.354875e+00)*s18+(-1.206043e+00)*s19+(-9.546899e+00)*s20+(-4.871816e+01)*s21+(-3.130812e+00)*s22+(-4.290685e+00)*s23+(-6.708378e-01)*s24 \
v57_part1=8.772174e-02*s0+(-1.718309e-01)*s1+(-4.383351e-01)*s2+2.965100e-01*s3+2.221482e+00*s4+5.091973e-01*s5+(-7.043005e-01)*s6+1.108239e+01*s7 \
v57_part2=v57_part1+(-2.879831e-02)*s8+(-4.368286e-01)*s9+1.186183e+01*s10+5.664809e-01*s11+1.320658e+00*s12+(-2.544743e+00)*s13+1.841635e+00*s14+5.166791e+00*s15 \
v57=v57_part2+(-3.891124e-01)*s16+(-1.158170e+00)*s17+(-1.120687e+01)*s18+1.005224e-01*s19+(-3.543259e+01)*s20+(-1.097886e+01)*s21+1.845949e+00*s22+1.160054e+00*s23+3.478474e+00*s24 \
v58_part1=(-2.401923e+01)*s0+4.578205e+00*s1+5.065172e+00*s2+(-3.090489e+00)*s3+(-4.653169e+00)*s4+3.759061e+01*s5+(-1.173635e-01)*s6+2.505299e+00*s7 \
v58_part2=v58_part1+8.656020e-01*s8+(-7.310842e+00)*s9+(-5.228966e+00)*s10+(-1.384686e+01)*s11+(-8.565701e+00)*s12+(-6.440667e-01)*s13+(-8.796930e+00)*s14+(-7.489123e+00)*s15 \
v58=v58_part2+2.347671e-02*s16+1.295705e+01*s17+6.893952e+00*s18+1.911903e+01*s19+9.965508e+03*s20+8.082443e+00*s21+(-2.480131e+00)*s22+2.099944e+00*s23+7.454010e+00*s24 \
v59_part1=(-5.827855e+02)*s0+7.375400e+00*s1+1.254451e+01*s2+2.718512e+01*s3+2.686813e+01*s4+8.038434e-02*s5+3.621691e+01*s6+1.644299e+01*s7 \
v59_part2=v59_part1+3.575890e+01*s8+4.755783e+01*s9+3.727365e+01*s10+3.391455e+01*s11+2.704404e+01*s12+1.717697e+01*s13+2.650385e+01*s14+(-3.876569e+01)*s15 \
v59=v59_part2+2.565916e+01*s16+2.886230e+01*s17+1.227665e+01*s18+8.571435e+00*s19+9.911433e+03*s20+2.047219e+01*s21+2.000282e+01*s22+1.790457e+01*s23+1.083238e+01*s24 \
v60_part1=(-1.407056e+03)*s0+(-6.201071e+00)*s1+(-3.230368e+00)*s2+(-2.523049e-01)*s3+(-8.125558e+00)*s4+6.431940e+00*s5+(-2.005315e+00)*s6+(-2.874942e+00)*s7 \
v60_part2=v60_part1+(-2.442033e+00)*s8+3.877329e+00*s9+(-4.405234e+01)*s10+1.729289e+01*s11+2.090385e+01*s12+8.090991e+00*s13+8.281470e+00*s14+9.134500e+00*s15 \
v60=v60_part2+3.003080e+00*s16+(-8.911703e+00)*s17+(-9.003689e+00)*s18+1.293947e+01*s19+9.913326e+03*s20+8.336939e+00*s21+1.093220e+01*s22+5.268108e+00*s23+(-1.858965e+01)*s24 \
v61_part1=5.583836e+01*s0+1.655226e+01*s1+4.301881e+00*s2+(-2.161421e+00)*s3+1.418677e+01*s4+(-2.052599e+01)*s5+1.887284e+00*s6+(-2.275889e+00)*s7 \
v61_part2=v61_part1+2.688309e+00*s8+(-6.418855e+00)*s9+4.414208e+01*s10+(-2.277030e+01)*s11+(-2.142679e+01)*s12+(-6.594970e+00)*s13+(-3.974630e+00)*s14+6.082084e+01*s15 \
v61=v61_part2+8.109412e+00*s16+1.664026e+00*s17+7.123711e+00*s18+(-2.145618e+01)*s19+9.841853e+03*s20+(-2.211089e+01)*s21+(-1.085438e+01)*s22+(-8.873497e+00)*s23+2.570678e+01*s24 \
v62_part1=2.030852e-01*s0+7.731337e-02*s1+(-5.296635e-01)*s2+4.674182e-01*s3+6.263669e-01*s4+(-2.260903e+02)*s5+5.492518e+00*s6+1.428357e+00*s7 \
v62_part2=v62_part1+(-7.417632e-01)*s8+2.593144e+00*s9+4.629353e+00*s10+(-8.432426e+00)*s11+(-8.699701e+00)*s12+1.246682e-01*s13+(-4.742191e+00)*s14+(-4.071603e+00)*s15 \
v62=v62_part2+5.334089e+00*s16+8.431357e-01*s17+(-2.719516e+00)*s18+(-4.626984e+00)*s19+(-2.454881e+01)*s20+(-1.339834e+02)*s21+5.169764e+00*s22+(-5.420319e+00)*s23+(-2.309813e+00)*s24 \
v63_part1=(-2.044100e+01)*s0+1.249509e+01*s1+3.586034e-01*s2+(-5.787476e+00)*s3+(-1.374246e+00)*s4+2.097617e+02*s5+(-5.073931e+00)*s6+(-3.071985e+00)*s7 \
v63_part2=v63_part1+(-4.022915e+00)*s8+(-1.829546e+00)*s9+(-2.006206e+00)*s10+2.892321e+01*s11+3.752893e+00*s12+1.523411e+00*s13+2.623791e+00*s14+3.320721e-01*s15 \
v63=v63_part2+8.120942e-01*s16+(-1.466070e+01)*s17+(-1.260736e+00)*s18+7.743949e-02*s19+(-3.314166e+01)*s20+1.803330e+02*s21+(-5.366233e+00)*s22+(-8.133144e-01)*s23+(-2.906651e+01)*s24 \
v64_part1=1.504793e+00*s0+(-1.883155e+01)*s1+3.953002e-01*s2+3.916904e+00*s3+7.292986e-01*s4+6.853099e+01*s5+(-5.951127e-01)*s6+9.438994e-01*s7 \
v64_part2=v64_part1+3.900394e+00*s8+(-2.048741e+00)*s9+(-3.037830e+00)*s10+(-5.636870e+00)*s11+6.491191e+00*s12+(-1.918655e+00)*s13+2.349165e+00*s14+5.412988e+00*s15 \
v64=v64_part2+(-6.548917e+00)*s16+8.663936e+00*s17+4.026033e+00*s18+6.444545e+00*s19+(-3.349102e+01)*s20+(-1.535189e+01)*s21+(-9.510391e-01)*s22+7.103110e+00*s23+2.532451e+01*s24 \
v65_part1=1.639733e+00*s0+(-9.296697e-01)*s1+1.014032e+00*s2+(-2.501812e+00)*s3+1.878947e+00*s4+(-3.265625e-01)*s5+(-2.001614e+00)*s6+2.570022e-01*s7 \
v65_part2=v65_part1+(-4.914748e-01)*s8+2.347872e+00*s9+(-3.211377e-01)*s10+(-8.259503e-01)*s11+1.884882e-01*s12+(-1.133975e+00)*s13+9.248593e-01*s14+1.127125e-01*s15 \
v65=v65_part2+9.373563e-01*s16+1.675681e-01*s17+6.618843e-01*s18+9.766928e-01*s19+(-1.162017e-02)*s20+1.630974e-01*s21+1.439811e-01*s22+(-2.435572e-01)*s23+2.601293e-01*s24 \
v66_part1=(-3.774315e-01)*s0+2.209582e+00*s1+1.778373e+00*s2+6.544049e+00*s3+1.601430e+00*s4+3.134886e+00*s5+4.787911e+00*s6+2.686516e+00*s7 \
v66_part2=v66_part1+4.789099e+00*s8+2.493071e+00*s9+1.669882e+00*s10+2.193594e+00*s11+1.592209e+00*s12+3.700275e+00*s13+1.715175e+00*s14+1.611155e+00*s15 \
v66=v66_part2+7.051422e-01*s16+2.171743e+00*s17+1.769767e+00*s18+2.261343e+00*s19+8.913807e-01*s20+3.816854e-01*s21+1.367545e+00*s22+2.062410e+00*s23+1.727216e+00*s24 \
v67_part1=(-3.772360e+00)*s0+(-1.482622e+00)*s1+(-5.130770e+00)*s2+(-2.232442e+00)*s3+(-9.134149e+00)*s4+(-5.520774e-01)*s5+(-5.968401e-01)*s6+(-4.061503e+00)*s7 \
v67_part2=v67_part1+(-4.445213e+00)*s8+(-9.114458e+00)*s9+(-7.588561e-02)*s10+5.685274e-01*s11+(-2.414794e+00)*s12+(-1.624749e+00)*s13+(-4.612733e+00)*s14+(-9.750638e-01)*s15 \
v67=v67_part2+(-2.728950e+00)*s16+(-2.234511e+00)*s17+(-3.248992e+00)*s18+(-4.321623e+00)*s19+4.755782e-02*s20+(-8.614849e-01)*s21+(-1.641953e+00)*s22+(-1.485723e+00)*s23+(-2.344354e+00)*s24 \
v68_part1=7.205629e+00*s0+6.945649e+00*s1+1.091504e+01*s2+8.329047e+00*s3+1.757173e+01*s4+3.133785e+00*s5+5.981630e+00*s6+1.124499e+01*s7 \
v68_part2=v68_part1+1.206311e+01*s8+1.781142e+01*s9+1.830834e+00*s10+1.637914e+00*s11+6.226878e+00*s12+5.624409e+00*s13+9.321985e+00*s14+2.643698e+00*s15 \
v68=v68_part2+6.014908e+00*s16+5.896251e+00*s17+7.911211e+00*s18+8.911112e+00*s19+2.362417e-01*s20+3.030751e+00*s21+4.113680e+00*s22+4.270039e+00*s23+5.397743e+00*s24 \
v69_part1=(-1.430019e+00)*s0+5.766760e-01*s1+(-4.664815e-02)*s2+5.827481e-01*s3+(-5.879896e-01)*s4+(-3.475280e+00)*s5+2.389300e-01*s6+(-1.866100e-01)*s7 \
v69_part2=v69_part1+2.098971e-01*s8+(-1.286508e-01)*s9+(-4.325258e-01)*s10+1.833826e-01*s11+(-1.459543e-01)*s12+2.219966e-01*s13+(-1.101898e+00)*s14+(-7.226521e-01)*s15 \
v69=v69_part2+(-8.330477e-02)*s16+3.053694e-02*s17+(-4.427535e-01)*s18+(-4.004682e-01)*s19+4.977483e-02*s20+1.621728e-01*s21+(-1.426626e-01)*s22+1.225552e-01*s23+1.567608e-02*s24 \
v70_part1=1.861703e+00*s0+(-5.251444e-01)*s1+1.228745e+00*s2+3.333966e-01*s3+1.455653e+00*s4+3.494459e+00*s5+6.127968e-01*s6+1.062145e+00*s7 \
v70_part2=v70_part1+1.584250e+00*s8+1.895385e+00*s9+5.260634e-01*s10+1.193030e+00*s11+4.468922e-01*s12+7.799263e-01*s13+1.190886e+00*s14+1.922897e-01*s15 \
v70=v70_part2+4.650763e-01*s16+7.644214e-01*s17+1.019798e+00*s18+1.134761e+00*s19+(-4.388450e-03)*s20+1.661932e+00*s21+6.064563e-01*s22+4.620961e-01*s23+8.313577e-01*s24 \
v71_part1=(-2.132304e-02)*s0+(-6.013312e-02)*s1+(-6.926647e-01)*s2+(-4.766477e-01)*s3+(-3.558446e-01)*s4+1.138344e+00*s5+(-4.836182e-01)*s6+(-3.084745e-01)*s7 \
v71_part2=v71_part1+(-1.300625e+00)*s8+(-1.188331e+00)*s9+1.088130e-01*s10+7.105844e-02*s11+9.417320e-02*s12+(-7.100862e-01)*s13+3.386310e-01*s14+7.436252e-01*s15 \
v71=v71_part2+(-1.058771e-01)*s16+(-5.386981e-01)*s17+(-7.886102e-02)*s18+(-2.521350e-01)*s19+(-2.315678e-02)*s20+1.876241e-01*s21+(-1.295964e-01)*s22+(-4.402385e-01)*s23+(-6.604874e-01)*s24 \
v72_part1=7.144877e+02*s0+9.313806e+01*s1+1.000000e+04*s2+7.903082e+01*s3+1.079733e+02*s4+4.692999e+03*s5+6.209477e+01*s6+2.539988e+01*s7 \
v72_part2=v72_part1+4.439568e+01*s8+1.000000e+04*s9+1.262441e+01*s10+4.923002e+01*s11+1.000000e+04*s12+3.892093e+02*s13+2.531394e+02*s14+1.002008e+03*s15 \
v72=v72_part2+1.000000e+04*s16+1.000000e+04*s17+2.866889e+01*s18+2.408489e+03*s19+3.990604e+03*s20+3.051927e+00*s21+5.605592e+01*s22+4.850609e+01*s23+9.000045e+01*s24 \
v73_part1=(-5.359611e+01)*s0+2.261288e+02*s1+(-7.224839e+03)*s2+(-6.962586e+00)*s3+(-7.134310e+01)*s4+(-3.070139e+02)*s5+(-3.294814e+01)*s6+(-1.185478e+01)*s7 \
v73_part2=v73_part1+(-3.764363e+01)*s8+(-3.484797e+03)*s9+(-2.401632e+00)*s10+3.092933e+01*s11+1.000000e+04*s12+(-3.239930e+02)*s13+(-2.039257e+02)*s14+(-7.535299e+01)*s15 \
v73=v73_part2+4.187150e+02*s16+1.000000e+04*s17+(-1.232450e+01)*s18+(-7.991806e+02)*s19+4.353460e+03*s20+(-6.606976e+00)*s21+(-2.668016e+01)*s22+(-3.184754e+01)*s23+(-5.424702e+01)*s24 \
v74_part1=1.742396e+00*s0+6.574226e+01*s1+1.000000e+04*s2+1.193480e+02*s3+1.476531e+01*s4+4.064753e+02*s5+(-9.176132e+00)*s6+4.244210e+00*s7 \
v74_part2=v74_part1+1.000000e+04*s8+1.000000e+04*s9+1.173505e+01*s10+1.088823e+02*s11+1.000000e+04*s12+(-7.201359e+01)*s13+(-1.641103e+02)*s14+8.306906e+01*s15 \
v74=v74_part2+5.335141e+02*s16+1.000000e+04*s17+4.213694e+00*s18+6.132015e+01*s19+1.165298e+03*s20+2.550439e+01*s21+6.402205e+01*s22+3.599327e+01*s23+(-5.555206e+00)*s24 \
v75_part1=(-1.503936e+01)*s0+1.139246e+02*s1+(-6.055199e+03)*s2+(-1.379178e+02)*s3+(-1.179811e+01)*s4+(-3.896464e+03)*s5+5.215246e+00*s6+(-4.608693e+00)*s7 \
v75_part2=v75_part1+(-1.053523e+02)*s8+(-9.027658e+03)*s9+(-1.179758e+01)*s10+2.130382e+02*s11+1.000000e+04*s12+7.709490e+01*s13+1.540111e+02*s14+(-2.976505e+01)*s15 \
v75=v75_part2+1.000000e+04*s16+1.000000e+04*s17+(-5.940277e+00)*s18+(-2.529348e+01)*s19+3.180495e+03*s20+(-3.684565e+00)*s21+(-4.827713e+01)*s22+(-2.445748e+01)*s23+(-1.744067e-01)*s24 \
v76_part1=1.097982e+01*s0+2.456636e+01*s1+1.378578e+01*s2+6.576780e+01*s3+1.382036e+00*s4+(-1.000000e+04)*s5+(-4.329001e+00)*s6+1.297837e-01*s7 \
v76_part2=v76_part1+2.702203e+01*s8+1.334930e+03*s9+(-4.400720e+00)*s10+1.873417e+01*s11+1.000000e+04*s12+(-1.094023e+02)*s13+2.088581e+01*s14+(-2.515930e+01)*s15 \
v76=v76_part2+8.529960e+02*s16+3.415601e+03*s17+(-1.263921e+00)*s18+6.353143e+03*s19+(-2.268502e+01)*s20+2.976189e+02*s21+4.053109e+01*s22+(-2.038042e+01)*s23+(-4.997392e+01)*s24 \
v77_part1=(-7.660303e+00)*s0+1.803509e+01*s1+1.619294e+00*s2+(-5.021432e+01)*s3+5.639968e+00*s4+8.218717e+03*s5+5.232258e+00*s6+(-4.899136e-02)*s7 \
v77_part2=v77_part1+(-6.908372e+01)*s8+9.800221e+02*s9+3.284289e+00*s10+1.650383e+01*s11+1.000000e+04*s12+7.166312e+01*s13+(-2.875601e+01)*s14+(-7.612166e+00)*s15 \
v77=v77_part2+1.185720e+03*s16+1.609086e+03*s17+6.787125e-01*s18+(-6.328816e+03)*s19+(-4.859051e+01)*s20+(-2.791483e+02)*s21+(-7.362037e-01)*s22+2.439748e+01*s23+2.279910e+01*s24 \
v78_part1=1.936838e+00*s0+8.725836e+00*s1+(-1.568060e+01)*s2+7.052199e+00*s3+(-1.209137e+01)*s4+4.965997e+03*s5+6.845061e-01*s6+(-1.944994e-01)*s7 \
v78_part2=v78_part1+1.294820e+02*s8+4.741597e+02*s9+1.467678e+00*s10+1.912325e+01*s11+1.000000e+04*s12+1.059941e+02*s13+7.655334e+00*s14+(-2.044638e+00)*s15 \
v78=v78_part2+1.342805e+03*s16+2.544051e+03*s17+7.677279e-01*s18+1.584272e+03*s19+(-4.585149e+01)*s20+3.290734e+01*s21+(-3.349578e+01)*s22+(-1.014916e+01)*s23+1.378109e+01*s24 \
v79_part1=1.634316e+00*s0+4.953349e+00*s1+(-2.703514e+00)*s2+9.005328e+00*s3+6.835465e+00*s4+(-7.555474e+00)*s5+7.267892e+00*s6+3.105425e-01*s7 \
v79_part2=v79_part1+(-6.051886e+00)*s8+(-7.647868e+01)*s9+9.057202e+00*s10+2.062046e+01*s11+1.291486e+01*s12+8.377580e+00*s13+1.273152e+01*s14+1.451192e+01*s15 \
v79=v79_part2+7.091301e+00*s16+(-8.570244e+00)*s17+5.621648e+00*s18+(-1.536011e+01)*s19+9.917124e+03*s20+(-1.493847e+01)*s21+8.621782e+00*s22+3.672889e+00*s23+(-1.709160e+00)*s24 \
v80_part1=2.897833e+01*s0+1.386325e+01*s1+1.620261e+01*s2+(-1.829728e+00)*s3+2.950268e+00*s4+1.044705e+01*s5+(-8.287071e+00)*s6+1.289563e+01*s7 \
v80_part2=v80_part1+8.551608e+00*s8+(-3.852727e+01)*s9+(-5.919879e+00)*s10+(-5.771601e+00)*s11+2.698128e+00*s12+8.480329e+00*s13+3.195025e+00*s14+6.454652e+01*s15 \
v80=v80_part2+2.723710e+00*s16+8.054588e+00*s17+8.641820e+00*s18+2.782249e+01*s19+9.863077e+03*s20+3.097368e+01*s21+1.024846e+01*s22+1.259029e+01*s23+1.983383e+01*s24 \
v81_part1=4.143667e+00*s0+(-6.794506e-03)*s1+1.543605e+00*s2+(-6.922518e+00)*s3+4.237513e+00*s4+(-1.158643e+01)*s5+(-5.212383e+00)*s6+1.156961e+00*s7 \
v81_part2=v81_part1+6.159690e+00*s8+(-2.376477e+00)*s9+4.296395e+01*s10+(-2.167777e+01)*s11+(-2.344653e+01)*s12+(-1.631509e+01)*s13+(-1.319211e+01)*s14+(-8.855888e+00)*s15 \
v81=v81_part2+(-7.238459e+00)*s16+6.313144e+00*s17+(-2.015589e+00)*s18+(-9.156345e+00)*s19+9.912471e+03*s20+1.154686e+01*s21+(-1.486546e+01)*s22+(-1.117595e+01)*s23+1.095470e+01*s24 \
v82_part1=(-5.078037e+00)*s0+(-1.056758e+01)*s1+(-2.532019e+00)*s2+9.698113e+00*s3+(-1.013399e+01)*s4+2.032151e+01*s5+6.115629e+00*s6+3.766948e+00*s7 \
v82_part2=v82_part1+(-8.782827e+00)*s8+(-1.636760e+01)*s9+(-4.647367e+01)*s10+2.655384e+01*s11+2.213554e+01*s12+1.404396e+01*s13+8.372688e+00*s14+(-6.221359e+01)*s15 \
v82=v82_part2+(-2.518183e+00)*s16+(-3.712581e+00)*s17+3.643234e+00*s18+1.160285e+01*s19+9.870253e+03*s20+(-7.358476e+00)*s21+1.199019e+01*s22+1.222231e+01*s23+(-1.951373e+01)*s24 \
v83_part1=1.761501e+00*s0+(-2.584662e+00)*s1+1.944114e-01*s2+(-1.767643e+00)*s3+1.509331e-01*s4+1.094922e+02*s5+(-5.799914e+00)*s6+(-1.160710e+00)*s7 \
v83_part2=v83_part1+2.385080e+00*s8+(-1.433909e+03)*s9+(-2.963400e+00)*s10+8.185751e+00*s11+8.078364e+00*s12+(-1.564161e+00)*s13+4.397345e+00*s14+6.639385e+00*s15 \
v83=v83_part2+(-3.671897e+00)*s16+9.210476e-01*s17+(-1.012361e-02)*s18+1.917760e+00*s19+(-4.247870e+01)*s20+9.373918e+01*s21+(-6.526522e+00)*s22+4.418933e+00*s23+2.180050e+00*s24 \
v84_part1=(-1.808901e+00)*s0+(-7.255603e+00)*s1+(-3.935310e-01)*s2+6.336038e+00*s3+1.588217e-01*s4+(-1.063597e+02)*s5+5.264596e+00*s6+2.588617e+00*s7 \
v84_part2=v84_part1+1.523378e+00*s8+(-7.256184e+02)*s9+4.916570e-01*s10+(-3.126125e+01)*s11+(-3.354260e+00)*s12+(-9.756754e-01)*s13+(-4.003483e+00)*s14+(-8.570551e-02)*s15 \
v84=v84_part2+(-1.586053e+00)*s16+1.045443e+01*s17+1.971521e+00*s18+4.311239e-01*s19+(-6.801866e+00)*s20+(-1.549335e+02)*s21+5.555003e+00*s22+9.207683e-02*s23+2.306847e+01*s24 \
v85_part1=(-8.293899e-02)*s0+1.635693e+01*s1+(-4.066920e-02)*s2+(-3.221285e+00)*s3+(-9.045634e-01)*s4+(-4.454697e+01)*s5+7.210152e-01*s6+(-8.705161e-01)*s7 \
v85_part2=v85_part1+(-3.969695e+00)*s8+(-8.038547e+02)*s9+2.553436e+00*s10+4.962942e+00*s11+(-6.441255e+00)*s12+2.896926e+00*s13+(-1.159582e+00)*s14+(-8.549959e+00)*s15 \
v85=v85_part2+5.029220e+00*s16+(-8.004244e+00)*s17+(-1.751719e+00)*s18+(-4.017328e+00)*s19+(-3.683035e+01)*s20+2.409553e+01*s21+1.776424e+00*s22+(-5.678895e+00)*s23+(-2.099401e+01)*s24 \
v86_part1=(-1.419114e+01)*s0+2.457343e+00*s1+1.122544e+00*s2+4.602157e+00*s3+2.521172e+00*s4+1.129779e+01*s5+9.370657e-01*s6+6.994583e+01*s7 \
v86_part2=v86_part1+3.728504e+00*s8+4.536781e+00*s9+5.961509e+01*s10+4.877712e+00*s11+2.592495e-01*s12+2.754965e+00*s13+4.457974e+00*s14+9.993900e+02*s15 \
v86=v86_part2+9.519904e+00*s16+8.983009e+00*s17+9.949651e+03*s18+3.391697e+00*s19+(-7.927722e+02)*s20+8.625403e+00*s21+3.534198e+00*s22+(-6.731236e+00)*s23+4.008517e+00*s24 \
v87_part1=(-6.057156e+02)*s0+(-1.262663e+00)*s1+5.843886e-01*s2+(-3.000878e+00)*s3+2.775428e-01*s4+2.460345e+00*s5+2.865919e+00*s6+(-3.168587e+00)*s7 \
v87_part2=v87_part1+(-1.826693e+00)*s8+(-2.647357e+00)*s9+6.686934e+01*s10+(-4.326122e+00)*s11+2.536386e+00*s12+8.493497e-01*s13+(-6.249700e-01)*s14+7.511581e+02*s15 \
v87=v87_part2+(-8.200222e+00)*s16+(-5.065768e+00)*s17+6.189247e+03*s18+7.407949e-01*s19+(-2.174879e+03)*s20+(-3.164298e+00)*s21+1.160717e+00*s22+1.552945e+01*s23+9.934229e-01*s24 \
v88_part1=(-1.726387e+02)*s0+9.151961e-01*s1+1.559859e-02*s2+(-3.591596e+00)*s3+(-4.710822e-01)*s4+6.367427e+00*s5+3.846358e+00*s6+2.781686e+02*s7 \
v88_part2=v88_part1+1.777342e+00*s8+4.072071e-01*s9+4.928374e+01*s10+1.849036e+00*s11+4.320965e-01*s12+(-3.135082e+00)*s13+(-2.734118e+00)*s14+(-5.839226e+02)*s15 \
v88=v88_part2+(-8.418731e+00)*s16+(-6.186459e+00)*s17+9.964009e+03*s18+4.600499e+00*s19+9.959026e+02*s20+1.108146e+01*s21+(-3.783563e+00)*s22+5.474605e+00*s23+(-3.602358e-01)*s24 \
v89_part1=(-7.835159e+02)*s0+(-1.594176e+00)*s1+(-6.180110e-01)*s2+3.383432e+00*s3+(-1.138160e+00)*s4+(-1.332538e+01)*s5+(-3.626700e+00)*s6+(-7.128000e+01)*s7 \
v89_part2=v89_part1+(-2.045342e+00)*s8+(-8.238420e-01)*s9+7.681792e+01*s10+(-3.746962e-01)*s11+(-1.918922e+00)*s12+1.520410e+00*s13+1.080576e+00*s14+1.306118e+03*s15 \
v89=v89_part2+9.918814e+00*s16+4.872554e+00*s17+9.950446e+03*s18+(-5.353082e+00)*s19+(-7.933630e+03)*s20+(-1.472810e+01)*s21+1.274407e+00*s22+(-1.068560e+01)*s23+(-2.087580e+00)*s24 \
v90_part1=(-1.408547e+01)*s0+2.415874e+00*s1+(-2.255844e-01)*s2+(-6.726911e-01)*s3+(-3.882052e-01)*s4+(-4.087181e+01)*s5+(-1.437810e+00)*s6+(-2.094151e+02)*s7 \
v90_part2=v90_part1+5.179434e-02*s8+(-5.197130e-01)*s9+(-1.878959e+01)*s10+(-2.183087e+00)*s11+1.550793e+00*s12+2.193488e-01*s13+(-2.077901e-02)*s14+(-2.366609e+01)*s15 \
v90=v90_part2+1.797540e-01*s16+(-3.085179e+00)*s17+7.416515e+03*s18+(-2.042699e+00)*s19+1.196802e+01*s20+(-7.069067e+01)*s21+(-2.935541e+00)*s22+8.179288e-01*s23+2.211168e+00*s24 \
v91_part1=(-1.061125e+01)*s0+(-2.300423e+00)*s1+(-1.199369e-01)*s2+1.075975e+00*s3+1.620505e-01*s4+1.440235e+01*s5+2.027796e+00*s6+5.333598e+01*s7 \
v91_part2=v91_part1+(-4.024121e-02)*s8+1.443480e-01*s9+(-2.456872e+01)*s10+1.577765e+00*s11+(-1.067040e+00)*s12+(-1.241664e+00)*s13+(-4.984595e-01)*s14+(-4.800459e+00)*s15 \
v91=v91_part2+(-6.696865e-01)*s16+2.248611e+00*s17+1.499972e+03*s18+1.653530e+00*s19+8.433634e+00*s20+5.076204e+01*s21+1.109289e+00*s22+1.306456e+00*s23+6.628835e+00*s24 \
v92_part1=(-1.773891e+01)*s0+(-2.842152e-02)*s1+2.016577e-01*s2+(-6.614635e-01)*s3+(-1.918574e-02)*s4+1.063750e+01*s5+(-8.463757e-01)*s6+2.125778e+02*s7 \
v92_part2=v92_part1+(-2.224236e-01)*s8+2.547755e-01*s9+(-1.761648e+01)*s10+(-2.612631e+00)*s11+(-8.779723e-01)*s12+7.025462e-01*s13+5.692047e-02*s14+(-1.539950e+01)*s15 \
v92=v92_part2+2.806851e-01*s16+8.429926e-01*s17+6.686450e+03*s18+3.054764e-01*s19+3.145151e-01*s20+1.758895e+01*s21+1.995073e+00*s22+(-2.070769e+00)*s23+(-7.855008e+00)*s24 \
v93_part1=(-3.702560e+02)*s0+(-8.532275e+00)*s1+(-1.000000e+04)*s2+(-3.521440e+01)*s3+(-1.000000e+04)*s4+4.167539e-01*s5+(-2.455719e-01)*s6+7.331831e-02*s7 \
v93_part2=v93_part1+1.701300e+00*s8+4.106181e+00*s9+4.681880e+01*s10+(-3.089055e+01)*s11+(-1.186119e+01)*s12+(-1.000000e+04)*s13+(-3.845440e+00)*s14+8.681086e+03*s15 \
v93=v93_part2+(-2.992910e-01)*s16+(-2.671165e-01)*s17+(-9.971307e-02)*s18+1.149794e+00*s19+7.096019e+03*s20+(-1.966622e+02)*s21+(-1.000000e+04)*s22+(-1.000000e+04)*s23+(-8.329757e+00)*s24 \
v94_part1=(-2.965637e+02)*s0+(-1.294927e+01)*s1+(-1.000000e+04)*s2+3.717443e+01*s3+(-1.000000e+04)*s4+(-8.492501e-02)*s5+1.365071e+00*s6+3.224116e-01*s7 \
v94_part2=v94_part1+(-1.995137e+00)*s8+(-5.831756e+00)*s9+2.821364e+01*s10+1.008253e+01*s11+1.304940e+01*s12+(-1.000000e+04)*s13+2.114285e+00*s14+1.000000e+04*s15 \
v94=v94_part2+5.320911e-01*s16+9.823290e-01*s17+1.100310e-01*s18+(-1.531784e+00)*s19+1.000000e+04*s20+2.007660e+02*s21+(-1.000000e+04)*s22+(-1.000000e+04)*s23+9.562264e+00*s24 \
v95_part1=(-6.306696e+02)*s0+5.084136e+00*s1+(-1.000000e+04)*s2+(-2.415497e+01)*s3+(-1.000000e+04)*s4+(-2.818523e-02)*s5+3.483087e-01*s6+(-1.523563e-01)*s7 \
v95_part2=v95_part1+(-1.223551e+00)*s8+(-3.008045e+00)*s9+4.452341e+01*s10+(-8.054531e+00)*s11+1.412060e+01*s12+(-1.000000e+04)*s13+5.349045e+00*s14+8.720800e+03*s15 \
v95=v95_part2+5.140944e-01*s16+6.826415e-01*s17+(-3.331893e-02)*s18+(-3.655877e-02)*s19+(-1.851470e+03)*s20+(-1.825290e+01)*s21+(-1.000000e+04)*s22+(-1.000000e+04)*s23+9.898489e+00*s24 \
v96_part1=(-5.081902e+02)*s0+(-3.028195e+00)*s1+(-1.000000e+04)*s2+2.165900e+01*s3+(-1.000000e+04)*s4+(-2.510581e-02)*s5+(-2.885454e-01)*s6+(-7.936212e-02)*s7 \
v96_part2=v96_part1+2.369893e+00*s8+5.146428e+00*s9+5.229095e+00*s10+1.194424e+01*s11+(-1.566614e+01)*s12+(-1.000000e+04)*s13+(-3.835753e+00)*s14+9.279658e+03*s15 \
v96=v96_part2+1.542601e-01*s16+(-7.264228e-01)*s17+1.237465e-01*s18+4.833887e-01*s19+1.000000e+04*s20+1.284210e+01*s21+(-1.000000e+04)*s22+(-1.000000e+04)*s23+(-1.157499e+01)*s24 \
v97_part1=(-2.167730e+01)*s0+1.432066e+01*s1+(-1.442362e+01)*s2+(-1.000000e+04)*s3+(-1.000000e+04)*s4+(-2.912874e+00)*s5+4.633722e-01*s6+4.219579e-02*s7 \
v97_part2=v97_part1+3.329564e-01*s8+(-1.775573e-01)*s9+(-5.921749e+00)*s10+7.654640e+00*s11+3.146843e+00*s12+(-2.896195e+01)*s13+6.899991e-01*s14+2.587617e+01*s15 \
v97=v97_part2+1.678917e-01*s16+2.934978e-01*s17+(-1.517670e-02)*s18+(-3.014055e-01)*s19+1.003767e+01*s20+8.313971e+02*s21+(-1.000000e+04)*s22+(-1.000000e+04)*s23+(-7.611417e-01)*s24 \
v98_part1=(-1.141206e+01)*s0+2.395577e+00*s1+(-9.032619e+00)*s2+9.998932e+03*s3+(-1.000000e+04)*s4+3.641539e+00*s5+(-3.941338e-01)*s6+(-1.229330e-01)*s7 \
v98_part2=v98_part1+(-2.028510e-01)*s8+1.001829e-01*s9+(-5.946994e+00)*s10+1.238078e+01*s11+(-2.234713e+00)*s12+(-2.302367e+02)*s13+1.331103e+00*s14+7.200943e+00*s15 \
v98=v98_part2+5.360667e-02*s16+(-7.546534e-01)*s17+(-4.419623e-02)*s18+2.893702e-01*s19+3.995981e+01*s20+(-8.378116e+02)*s21+(-1.000000e+04)*s22+(-6.652573e+03)*s23+6.491020e-02*s24 \
v99_part1=(-3.790437e+00)*s0+4.964609e+00*s1+(-2.575183e+01)*s2+1.964577e+00*s3+(-1.000000e+04)*s4+1.605508e+00*s5+(-3.337886e-02)*s6+6.910821e-02*s7 \
v99_part2=v99_part1+(-1.643397e-01)*s8+2.142405e-01*s9+(-2.267025e+01)*s10+4.641919e+01*s11+(-1.414498e+00)*s12+(-1.207147e+03)*s13+(-1.780783e+00)*s14+2.476882e+01*s15 \
v99=v99_part2+(-1.557295e-01)*s16+2.686231e-01*s17+4.925105e-02*s18+1.418261e-01*s19+1.279611e+01*s20+9.929076e+00*s21+(-1.000000e+04)*s22+(-1.000000e+04)*s23+8.076357e-01*s24 \
_p0=v0+v1*od_+v2*w_+v3*od_*w_ \
_p1=_p0+v4*(s_-0.56)+v5*(s_-0.56)*od_+v6*(s_-0.56)*w_ \
_p2=0.5*(_p1+sqrt(_p1*_p1+0.001)) \
_p3=1e-15*_p2 \
_p4=v7+v8*od_+v9*w_+v10*od_*w_+v11*od_/w_ \
_p5=_p4+v12*(s_-0.56)+v13*(s_-0.56)*od_+v14*(s_-0.56)*w_ \
_p6=sqsk_drs_1p5m1t*0.5*(_p5+sqrt(_p5*_p5+0.001)) \
_p7=v15+v16*od_+v17*w_+v18*od_*w_ \
_p8=_p7+v19*(s_-0.56)+v20*(s_-0.56)*od_+v21*(s_-0.56)*w_ \
_p9=0.5*(_p8+sqrt(_p8*_p8+0.001)) \
_p10=sqsk_dls_1p5m1t*1e-09*_p9 \
_p11=v22+v23*od_+v24*w_+v25*od_*w_+v26*od_/w_ \
_p12=_p11+v27*(s_-0.56)+v28*(s_-0.56)*od_+v29*(s_-0.56)*w_ \
_p13=sqsk_drs_1p5m1t*0.5*(_p12+sqrt(_p12*_p12+0.001)) \
_p14=v30+v31*od_+v32*w_+v33*od_*w_ \
_p15=_p14+v34*(s_-0.56)+v35*(s_-0.56)*od_+v36*(s_-0.56)*w_ \
_p16=0.5*(_p15+sqrt(_p15*_p15+0.001)) \
_p17=sqsk_dls_1p5m1t*1e-09*_p16 \
_p18=v37+v38*od_+v39*w_+v40*od_*w_ \
_p19=_p18+v41*(s_-0.56)+v42*(s_-0.56)*od_+v43*(s_-0.56)*w_ \
_p20=0.5*(atan(2*_p19)/1.5708+1) \
_p21=v44+v45*od_+v46*w_+v47*od_*w_ \
_p22=_p21+v48*(s_-0.56)+v49*(s_-0.56)*od_+v50*(s_-0.56)*w_ \
_p23=0.5*(_p22+sqrt(_p22*_p22+0.001)) \
_p24=v51+v52*od_+v53*w_+v54*od_*w_ \
_p25=_p24+v55*(s_-0.56)+v56*(s_-0.56)*od_+v57*(s_-0.56)*w_ \
_p26=0.5*(_p25+sqrt(_p25*_p25+0.001)) \
_p27=v58+v59*od_+v60*w_+v61*od_*w_ \
_p28=_p27+v62*(s_-0.56)+v63*(s_-0.56)*od_+v64*(s_-0.56)*w_ \
_p29=0.5*(_p28+sqrt(_p28*_p28+0.001)) \
_p30=v65+v66*od_+v67*w_+v68*od_*w_ \
_p31=_p30+v69*(s_-0.56)+v70*(s_-0.56)*od_+v71*(s_-0.56)*w_ \
_p32=0.5*(_p31+sqrt(_p31*_p31+0.001)) \
_p33=v72+v73*od_+v74*w_+v75*od_*w_ \
_p34=_p33+v76*(s_-0.56)+v77*(s_-0.56)*od_+v78*(s_-0.56)*w_ \
_p35=0.5*(_p34+sqrt(_p34*_p34+0.001)) \
_p36=v79+v80*od_+v81*w_+v82*od_*w_ \
_p37=_p36+v83*(s_-0.56)+v84*(s_-0.56)*od_+v85*(s_-0.56)*w_ \
_p38=0.5*(_p37+sqrt(_p37*_p37+0.001)) \
_p39=1e-14*_p23 \
_p40=sqsk_drs_sub_1p5m1t*100*_p26 \
_p41=1e-15*_p29 \
_p42=1e-14*_p32 \
_p43=sqsk_drs_sub_1p5m1t*100*_p35 \
_p44=1e-15*_p38 \
_p45=v86+v87*od_+v88*w_+v89*od_*w_ \
_p46=_p45+v90*(s_-0.56)+v91*(s_-0.56)*od_+v92*(s_-0.56)*w_ \
_p47=0.5*(_p46+sqrt(_p46*_p46+0.001)) \
_p48=v93+v94*od_+v95*w_+v96*od_*w_ \
_p49=_p48+v97*(s_-0.56)+v98*(s_-0.56)*od_+v99*(s_-0.56)*w_ \
_p50=0.5*(_p49+sqrt(_p49*_p49+0.001)) \
_p51=sqsk_drs_sub_1p5m1t*100*_p47 \
_p52=1e-13*_p50
cs (top bottom) capacitor c=_p3
rs1_1 (top n1_1) resistor r=_p6
ls1_1 (n1_1 bottom) inductor l=_p10
rs1_2 (top n1_2) resistor r=_p13
ls1_2 (n1_2 bottom) inductor l=_p17
k1 mutual_inductor coupling=_p20 ind1=ls1_1 ind2=ls1_2
c_1_sub (top _n1_1_sub) capacitor c=_p39
rs_1_sub (_n1_1_sub sub) resistor r=_p40
cs_1_sub (_n1_1_sub sub) capacitor c=_p41
c_2_sub (bottom _n1_2_sub) capacitor c=_p42
rs_2_sub (_n1_2_sub sub) resistor r=_p43
cs_2_sub (_n1_2_sub sub) capacitor c=_p44
rx_1_2_sub (_n1_1_sub _n1_2_sub) resistor r=_p51
cx_1_2_sub (_n1_1_sub _n1_2_sub) capacitor c=_p52
ends l_sqsk_rfvil_1p5m1t
