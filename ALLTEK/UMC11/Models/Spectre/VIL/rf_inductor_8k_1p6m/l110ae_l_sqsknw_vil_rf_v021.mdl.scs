simulator lang=spectre insensitive=yes
// model: lnw_sqsk_rfvil_1p6m0t1f
// stacked inductor, n well
// umc 110nm 1p6m rfcmos process
// date: 2010-10-29
// model coverage:(before shrinkage)
// od: (45 - 75) * 1e-06
// w: (2 - 3) * 1e-06
// s: (0.28 - 0.4) * 1e-06
// bm: 1 - 4
// ns: 2 - 4
// nt: 1.5 - 5.5
// frequency range: 100mhz - 0.8 * resonance (maximum 10.0 ghz)
subckt lnw_sqsk_rfvil_1p6m0t1f (top bottom nwell sub)
parameters od=5e-05 od_=od/7.5e-05 w=2e-06 w_=w/3e-06 s=2.8e-07 s_=s/4e-07 bm=1 ns=4 nt=3.5  \
s0=(bm==1)*(ns==2)*(nt==1.5) \
s1=(bm==1)*(ns==2)*(nt==2.5) \
s2=(bm==1)*(ns==2)*(nt==3.5) \
s3=(bm==1)*(ns==2)*(nt==4.5) \
s4=(bm==1)*(ns==2)*(nt==5.5) \
s5=(bm==1)*(ns==4)*(nt==1.5) \
s6=(bm==1)*(ns==4)*(nt==2.5) \
s7=(bm==1)*(ns==4)*(nt==3.5) \
s8=(bm==1)*(ns==4)*(nt==4.5) \
s9=(bm==1)*(ns==4)*(nt==5.5) \
s10=(bm==2)*(ns==2)*(nt==1.5) \
s11=(bm==2)*(ns==2)*(nt==2.5) \
s12=(bm==2)*(ns==2)*(nt==3.5) \
s13=(bm==2)*(ns==2)*(nt==4.5) \
s14=(bm==2)*(ns==2)*(nt==5.5) \
s15=(bm==2)*(ns==3)*(nt==1.5) \
s16=(bm==2)*(ns==3)*(nt==2.5) \
s17=(bm==2)*(ns==3)*(nt==3.5) \
s18=(bm==2)*(ns==3)*(nt==4.5) \
s19=(bm==2)*(ns==3)*(nt==5.5) \
s20=(bm==2)*(ns==4)*(nt==1.5) \
s21=(bm==2)*(ns==4)*(nt==2.5) \
s22=(bm==2)*(ns==4)*(nt==3.5) \
s23=(bm==2)*(ns==4)*(nt==4.5) \
s24=(bm==2)*(ns==4)*(nt==5.5) \
s25=(bm==3)*(ns==2)*(nt==1.5) \
s26=(bm==3)*(ns==2)*(nt==2.5) \
s27=(bm==3)*(ns==2)*(nt==3.5) \
s28=(bm==3)*(ns==2)*(nt==4.5) \
s29=(bm==3)*(ns==2)*(nt==5.5) \
s30=(bm==3)*(ns==3)*(nt==1.5) \
s31=(bm==3)*(ns==3)*(nt==2.5) \
s32=(bm==3)*(ns==3)*(nt==3.5) \
s33=(bm==3)*(ns==3)*(nt==4.5) \
s34=(bm==3)*(ns==3)*(nt==5.5) \
s35=(bm==4)*(ns==2)*(nt==1.5) \
s36=(bm==4)*(ns==2)*(nt==2.5) \
s37=(bm==4)*(ns==2)*(nt==3.5) \
s38=(bm==4)*(ns==2)*(nt==4.5) \
s39=(bm==4)*(ns==2)*(nt==5.5) \
v0_part1=3.267604e+00*s0+9.997355e+00*s1+4.442515e+00*s2+2.007202e+01*s3+1.162536e+01*s4+(-2.428888e+00)*s5+(-6.655940e-01)*s6+2.307206e+00*s7+1.789316e+01*s8+1.102262e+01*s9 \
v0_part2=v0_part1+2.827289e-01*s10+4.217928e-01*s11+4.658288e-01*s12+1.795227e+01*s13+1.780625e+01*s14+(-2.472810e-01)*s15+1.135123e+00*s16+4.103517e+00*s17+(-4.617079e+00)*s18+1.511396e+01*s19 \
v0_part3=v0_part2+(-4.784787e+00)*s20+4.988677e+00*s21+2.571040e+00*s22+9.141228e+00*s23+1.318891e+01*s24+4.341123e+00*s25+(-2.741424e+00)*s26+7.026492e+00*s27+1.024949e+01*s28+2.544990e+01*s29 \
v0=v0_part3+2.113473e+00*s30+1.764077e+00*s31+4.839987e+00*s32+6.353847e+00*s33+1.385894e+01*s34+(-1.408149e+00)*s35+1.132106e+00*s36+(-7.797919e-01)*s37+1.176860e+01*s38+2.221787e+01*s39 \
v1_part1=(-3.853541e+00)*s0+(-9.586904e+00)*s1+(-2.026983e+00)*s2+(-1.841086e+01)*s3+(-1.059995e+00)*s4+2.491371e+00*s5+1.556711e+00*s6+(-9.885270e-01)*s7+(-2.258885e+01)*s8+(-8.028899e+00)*s9 \
v1_part2=v1_part1+(-8.736206e-01)*s10+2.963946e+00*s11+6.286314e+00*s12+(-1.635176e+01)*s13+(-6.854393e+00)*s14+(-3.567651e-01)*s15+1.296697e+00*s16+(-1.738807e+00)*s17+1.408216e+01*s18+(-1.133047e+01)*s19 \
v1_part3=v1_part2+5.679951e+00*s20+(-4.840493e+00)*s21+1.219398e+00*s22+(-5.024491e+00)*s23+(-8.064098e+00)*s24+(-3.307741e+00)*s25+7.375511e+00*s26+6.059101e-01*s27+(-1.433393e+00)*s28+(-1.703813e+01)*s29 \
v1=v1_part3+(-1.019930e+00)*s30+1.089504e+00*s31+(-8.494948e-01)*s32+1.233713e-02*s33+(-7.342036e+00)*s34+3.942487e+00*s35+3.805227e+00*s36+1.057382e+01*s37+(-3.524155e+00)*s38+(-1.091925e+01)*s39 \
v2_part1=(-6.789926e+00)*s0+(-1.817419e+01)*s1+(-8.307019e+00)*s2+(-2.633753e+01)*s3+(-2.350503e+01)*s4+1.295371e+00*s5+1.150829e+00*s6+(-4.433337e+00)*s7+(-2.352985e+01)*s8+(-1.822732e+01)*s9 \
v2_part2=v2_part1+(-3.541402e+00)*s10+(-7.664355e+00)*s11+(-6.343818e+00)*s12+(-2.659993e+01)*s13+(-3.177472e+01)*s14+4.103348e-01*s15+(-2.905213e+00)*s16+(-5.899020e+00)*s17+1.555314e+00*s18+(-2.537421e+01)*s19 \
v2_part3=v2_part2+4.966330e+00*s20+(-6.088380e+00)*s21+(-5.506511e+00)*s22+(-1.544516e+01)*s23+(-2.318391e+01)*s24+(-1.059605e+01)*s25+(-3.646126e+00)*s26+(-1.478149e+01)*s27+(-1.953946e+01)*s28+(-4.133893e+01)*s29 \
v2=v2_part3+(-2.554775e+00)*s30+(-3.784387e+00)*s31+(-7.416963e+00)*s32+(-1.236672e+01)*s33+(-2.409688e+01)*s34+(-1.851167e+00)*s35+(-1.125691e+01)*s36+(-5.164372e+00)*s37+(-2.235931e+01)*s38+(-3.805119e+01)*s39 \
v3_part1=2.130843e+01*s0+4.578463e+01*s1+4.506384e+01*s2+7.221151e+01*s3+6.936863e+01*s4+7.449890e+00*s5+1.313602e+01*s6+2.533374e+01*s7+5.668268e+01*s8+4.736483e+01*s9 \
v3_part2=v3_part1+1.936198e+01*s10+3.126650e+01*s11+3.548961e+01*s12+7.060191e+01*s13+7.430994e+01*s14+9.393795e+00*s15+1.892919e+01*s16+3.051658e+01*s17+2.288794e+01*s18+6.327459e+01*s19 \
v3_part3=v3_part2+4.632507e+00*s20+2.441461e+01*s21+2.720736e+01*s22+4.358835e+01*s23+5.550938e+01*s24+2.487240e+01*s25+2.855321e+01*s26+4.689325e+01*s27+5.997077e+01*s28+9.094786e+01*s29 \
v3=v3_part3+1.258379e+01*s30+2.250216e+01*s31+3.354142e+01*s32+4.418421e+01*s33+6.286810e+01*s34+1.663965e+01*s35+3.659065e+01*s36+3.717840e+01*s37+6.671660e+01*s38+8.672080e+01*s39 \
v4_part1=(-3.584018e-01)*s0+5.935366e-01*s1+4.408892e-01*s2+5.204192e-01*s3+(-7.391886e-01)*s4+6.053916e-01*s5+3.760581e-02*s6+5.518252e-01*s7+1.572046e+00*s8+(-2.575714e-01)*s9 \
v4_part2=v4_part1+(-2.484720e-01)*s10+(-2.862302e-02)*s11+2.905405e+00*s12+(-3.481093e-01)*s13+(-1.660464e-01)*s14+(-1.045025e-01)*s15+1.153229e+00*s16+8.331287e-02*s17+(-5.602305e-01)*s18+5.022384e-01*s19 \
v4_part3=v4_part2+4.674169e-01*s20+(-1.501626e-02)*s21+(-5.770406e-01)*s22+(-4.251910e-01)*s23+(-3.241394e-01)*s24+(-9.633492e-01)*s25+8.634198e-01*s26+7.012272e+00*s27+(-3.767707e+00)*s28+(-8.941705e-01)*s29 \
v4=v4_part3+1.446233e-01*s30+1.578002e+00*s31+1.476131e-01*s32+5.974937e-01*s33+(-3.613309e-02)*s34+(-2.976543e-01)*s35+(-3.744018e-01)*s36+(-8.232709e-01)*s37+(-5.577216e-01)*s38+(-7.422824e-01)*s39 \
v5_part1=(-6.710134e-01)*s0+(-4.762798e-01)*s1+9.966007e-01*s2+1.990218e+00*s3+4.388213e+00*s4+(-8.797930e-01)*s5+3.557511e-02*s6+6.034180e-01*s7+1.399454e+00*s8+1.192687e+00*s9 \
v5_part2=v5_part1+(-4.545926e-01)*s10+(-3.239856e-01)*s11+(-1.856958e+00)*s12+2.317777e+00*s13+3.881890e+00*s14+(-9.213666e-02)*s15+(-1.601694e+00)*s16+3.283645e-01*s17+1.699131e+00*s18+1.735006e+00*s19 \
v5_part3=v5_part2+(-4.476977e-01)*s20+7.862096e-01*s21+1.238045e+00*s22+1.338357e+00*s23+2.815470e+00*s24+9.582072e-01*s25+(-1.967147e-01)*s26+2.883958e+00*s27+2.808541e+00*s28+5.731982e+00*s29 \
v5=v5_part3+1.928908e-02*s30+(-1.265674e+00)*s31+1.429529e+00*s32+9.718527e-01*s33+2.855171e+00*s34+(-9.676522e-01)*s35+8.218860e-01*s36+2.037004e+00*s37+1.391713e+00*s38+5.014322e+00*s39 \
v6_part1=3.679694e-01*s0+(-6.959855e-01)*s1+(-2.027391e+00)*s2+(-3.030039e+00)*s3+(-4.216334e+00)*s4+2.215843e-01*s5+(-7.156290e-02)*s6+(-1.095586e+00)*s7+(-2.926155e+00)*s8+(-9.182848e-01)*s9 \
v6_part2=v6_part1+2.709980e-01*s10+4.303812e-01*s11+(-1.603878e+00)*s12+(-1.572423e+00)*s13+(-3.553791e+00)*s14+1.379469e-01*s15+1.172838e+00*s16+1.928967e-01*s17+(-1.374000e-01)*s18+(-1.567385e+00)*s19 \
v6_part3=v6_part2+(-1.443723e-02)*s20+(-2.825730e-01)*s21+1.885583e-01*s22+(-1.327842e-01)*s23+(-1.588400e+00)*s24+(-2.333076e-01)*s25+(-5.057081e-01)*s26+(-1.186420e+01)*s27+3.002568e+00*s28+(-3.837451e+00)*s29 \
v6=v6_part3+(-1.637717e-01)*s30+(-4.096362e-01)*s31+(-6.670545e-01)*s32+(-5.134075e-01)*s33+(-1.583255e+00)*s34+8.250280e-01*s35+(-1.085762e-01)*s36+(-3.433691e-01)*s37+(-1.487711e-01)*s38+(-3.486119e+00)*s39 \
v7_part1=(-2.605080e+00)*s0+(-1.155748e+01)*s1+(-2.373913e+03)*s2+(-4.417474e+01)*s3+(-5.845697e+03)*s4+1.974764e+03*s5+7.373645e+00*s6+(-4.711511e+01)*s7+(-8.263619e+01)*s8+(-1.166703e+02)*s9 \
v7_part2=v7_part1+(-3.003345e-01)*s10+(-5.864938e+00)*s11+(-1.421119e+01)*s12+(-6.963472e+01)*s13+(-3.604356e+01)*s14+3.711852e+01*s15+3.651299e+03*s16+(-2.221347e+01)*s17+(-1.952069e+01)*s18+(-1.378337e+02)*s19 \
v7_part3=v7_part2+1.817834e+03*s20+(-7.276153e+00)*s21+(-2.176314e+01)*s22+(-1.325259e+02)*s23+(-1.125768e+02)*s24+(-8.958528e-01)*s25+(-7.550354e+00)*s26+(-1.780319e+01)*s27+5.562991e+00*s28+(-1.842805e+02)*s29 \
v7=v7_part3+(-3.445871e+00)*s30+2.635881e+02*s31+(-4.775459e+01)*s32+(-8.169503e+01)*s33+(-5.560710e+01)*s34+(-6.871325e-01)*s35+(-5.874815e+00)*s36+3.457853e+02*s37+(-2.036983e+01)*s38+(-6.288599e+01)*s39 \
v8_part1=(-6.081454e+00)*s0+(-6.959015e+00)*s1+(-6.526966e+03)*s2+(-3.168545e+02)*s3+(-1.000000e+04)*s4+1.683868e+03*s5+(-1.153059e+01)*s6+1.456319e+00*s7+2.258575e-01*s8+(-1.658509e+02)*s9 \
v8_part2=v8_part1+(-1.211826e+01)*s10+(-9.811809e+00)*s11+(-5.193877e+00)*s12+(-8.508428e+01)*s13+1.017286e+01*s14+1.233273e+02*s15+1.605506e+02*s16+(-8.323769e+01)*s17+3.976018e+01*s18+(-5.877119e+01)*s19 \
v8_part3=v8_part2+(-2.492771e+03)*s20+(-2.969139e+01)*s21+(-1.589520e+02)*s22+1.990924e+02*s23+1.086109e+01*s24+(-1.015793e+01)*s25+(-1.124528e+00)*s26+(-3.228786e+00)*s27+7.018157e+01*s28+(-3.967090e+02)*s29 \
v8=v8_part3+(-1.566466e+01)*s30+5.870455e+02*s31+(-1.995716e+02)*s32+(-2.515390e+00)*s33+(-3.639236e+02)*s34+(-1.019747e+01)*s35+(-9.340288e+00)*s36+4.324049e+02*s37+(-7.381967e+01)*s38+1.011641e+02*s39 \
v9_part1=(-7.576084e-01)*s0+1.227739e+00*s1+(-1.000000e+04)*s2+(-3.291045e+01)*s3+(-1.000000e+04)*s4+8.761115e+02*s5+(-2.136748e+01)*s6+1.094524e+01*s7+1.107033e+01*s8+2.731873e+00*s9 \
v9_part2=v9_part1+(-2.222283e+00)*s10+(-1.782260e+00)*s11+(-1.489345e+00)*s12+2.339002e+01*s13+6.109422e-01*s14+3.644214e+01*s15+1.439829e+02*s16+1.052076e+00*s17+(-1.757913e+01)*s18+5.069461e+01*s19 \
v9_part3=v9_part2+4.483416e+01*s20+(-9.266515e+00)*s21+(-7.107718e+00)*s22+(-1.239074e+02)*s23+2.391745e+01*s24+(-1.703486e+00)*s25+(-1.926905e+00)*s26+2.059681e+00*s27+(-5.108901e+01)*s28+1.760552e+02*s29 \
v9=v9_part3+(-1.332319e+00)*s30+(-1.003348e+03)*s31+9.855989e+00*s32+2.706127e+01*s33+(-8.318404e+00)*s34+(-1.961354e+00)*s35+(-1.698890e+00)*s36+1.529830e+01*s37+(-2.935168e+00)*s38+(-8.030389e+00)*s39 \
v10_part1=3.383179e+00*s0+3.104591e+00*s1+(-1.000000e+04)*s2+1.900321e+02*s3+(-1.000000e+04)*s4+3.500181e+03*s5+1.468619e+01*s6+(-3.106299e+00)*s7+(-2.032250e+01)*s8+2.683740e+00*s9 \
v10_part2=v10_part1+7.221190e+00*s10+5.663557e+00*s11+3.532024e+00*s12+1.331607e+01*s13+(-6.192190e+00)*s14+4.718256e+01*s15+5.713313e+02*s16+9.087930e+00*s17+(-1.547989e+01)*s18+(-2.077629e+01)*s19 \
v10_part3=v10_part2+1.353257e+02*s20+1.032177e+01*s21+6.649511e+01*s22+2.983850e+01*s23+(-8.181188e+01)*s24+5.862717e+00*s25+9.555003e-01*s26+(-9.387049e-01)*s27+1.116035e+01*s28+5.752530e+02*s29 \
v10=v10_part3+8.294623e+00*s30+1.812746e+01*s31+7.371867e+01*s32+1.748709e+01*s33+1.340590e+02*s34+6.115310e+00*s35+5.259157e+00*s36+(-2.018600e+02)*s37+2.953248e+01*s38+(-5.699799e+00)*s39 \
v11_part1=4.889407e+01*s0+8.270864e+01*s1+(-6.110757e+03)*s2+4.220423e+02*s3+(-1.000000e+04)*s4+5.100981e+03*s5+1.802091e+02*s6+2.485991e+02*s7+3.256270e+02*s8+6.470528e+02*s9 \
v11_part2=v11_part1+4.578297e+01*s10+7.222933e+01*s11+9.740780e+01*s12+2.587566e+02*s13+1.398993e+02*s14+2.461394e+02*s15+9.310137e+02*s16+2.551396e+02*s17+1.938395e+02*s18+3.905404e+02*s19 \
v11_part3=v11_part2+1.981133e+03*s20+1.728718e+02*s21+2.968663e+02*s22+7.194166e+02*s23+4.578271e+02*s24+4.515443e+01*s25+7.237830e+01*s26+9.987865e+01*s27+1.626297e+02*s28+4.799967e+02*s29 \
v11=v11_part3+7.428474e+01*s30+2.164430e+03*s31+3.808061e+02*s32+3.772379e+02*s33+5.295166e+02*s34+4.492216e+01*s35+7.186767e+01*s36+2.692765e+02*s37+1.747660e+02*s38+2.142988e+02*s39 \
v12_part1=(-3.903611e-01)*s0+(-1.804588e+00)*s1+(-1.438247e+02)*s2+(-7.093068e+00)*s3+(-1.000000e+04)*s4+8.781542e-01*s5+(-5.004081e+00)*s6+(-1.004381e+01)*s7+(-2.750154e+00)*s8+(-2.820831e+01)*s9 \
v12_part2=v12_part1+(-3.166465e-01)*s10+(-1.282013e+00)*s11+(-2.466001e+00)*s12+(-9.215259e+00)*s13+(-8.413030e+00)*s14+1.001451e+00*s15+(-9.544266e+03)*s16+(-5.916516e+00)*s17+(-6.060996e+00)*s18+(-2.377481e+01)*s19 \
v12_part3=v12_part2+(-1.902678e-01)*s20+(-3.740550e+00)*s21+(-3.532795e+00)*s22+(-2.265800e+00)*s23+(-3.787449e+01)*s24+(-2.753708e-01)*s25+(-1.538704e+00)*s26+(-5.410299e+00)*s27+9.051251e+00*s28+(-2.342328e+01)*s29 \
v12=v12_part3+(-6.224726e-01)*s30+(-2.245537e+00)*s31+(-3.342170e+00)*s32+(-5.761621e+00)*s33+2.300069e-01*s34+(-3.207110e-01)*s35+(-1.325472e+00)*s36+(-5.741896e+00)*s37+(-2.708448e+00)*s38+(-1.692893e+01)*s39 \
v13_part1=2.419959e-02*s0+3.585525e-02*s1+(-4.266179e+01)*s2+8.199297e+00*s3+(-1.000000e+04)*s4+4.219353e+00*s5+3.940067e+00*s6+7.686028e-02*s7+1.151036e+01*s8+3.558010e+00*s9 \
v13_part2=v13_part1+(-2.006170e-03)*s10+(-1.177150e-01)*s11+(-7.076754e-01)*s12+1.152022e+00*s13+1.257214e-01*s14+3.779369e+00*s15+1.000000e+04*s16+(-4.729488e-01)*s17+(-1.221351e+00)*s18+3.747165e-01*s19 \
v13_part3=v13_part2+9.004607e-01*s20+2.105963e-01*s21+8.644117e-02*s22+(-6.266068e+00)*s23+1.969135e+00*s24+(-9.876915e-02)*s25+5.452147e-01*s26+(-3.653952e-01)*s27+1.333823e+01*s28+9.130222e+00*s29 \
v13=v13_part3+1.132964e-01*s30+(-2.683744e+00)*s31+1.102411e+00*s32+7.606492e+00*s33+(-4.209074e-01)*s34+(-1.322898e-03)*s35+6.204886e-03*s36+(-5.131067e+00)*s37+(-5.358449e-01)*s38+(-3.659420e-01)*s39 \
v14_part1=2.245603e-01*s0+1.141342e+00*s1+(-2.296319e+02)*s2+(-1.102388e+00)*s3+(-2.366759e+03)*s4+7.886163e+00*s5+(-4.038950e+00)*s6+5.685487e+00*s7+(-6.785218e+00)*s8+1.910761e+01*s9 \
v14_part2=v14_part1+1.705340e-01*s10+7.874559e-01*s11+1.742342e+00*s12+5.651617e+00*s13+4.984368e+00*s14+4.057732e-02*s15+(-5.996741e+03)*s16+4.140485e+00*s17+1.408715e+00*s18+1.689219e+01*s19 \
v14_part3=v14_part2+(-5.875826e+00)*s20+2.184936e+00*s21+4.372396e-01*s22+(-9.180689e-02)*s23+2.500463e+01*s24+2.106603e-01*s25+5.807367e-01*s26+4.489752e+00*s27+8.772818e+00*s28+(-5.238954e+01)*s29 \
v14=v14_part3+4.059144e-01*s30+(-3.807706e+00)*s31+3.990650e+00*s32+3.673866e+00*s33+(-2.531811e+00)*s34+1.758693e-01*s35+7.356097e-01*s36+(-1.017751e+00)*s37+2.205268e+00*s38+(-5.625018e-01)*s39 \
v15_part1=(-3.716277e-01)*s0+(-9.380744e-01)*s1+1.000000e+04*s2+4.348027e+00*s3+1.000000e+04*s4+5.861729e+02*s5+5.484421e-01*s6+(-8.530737e+00)*s7+(-5.794717e+00)*s8+(-1.206770e+01)*s9 \
v15_part2=v15_part1+(-3.647872e-01)*s10+(-1.023154e+00)*s11+(-2.094266e+00)*s12+1.339566e-01*s13+(-5.089676e+00)*s14+4.147416e-01*s15+(-4.465363e+01)*s16+(-2.652324e+00)*s17+(-3.922642e-01)*s18+(-1.339844e+00)*s19 \
v15_part3=v15_part2+(-2.303088e+01)*s20+(-2.911833e+00)*s21+(-6.172161e+00)*s22+(-9.056553e+00)*s23+(-9.799467e+00)*s24+(-3.840893e-01)*s25+(-1.092829e+00)*s26+(-2.196136e+00)*s27+(-2.715554e+00)*s28+(-2.368121e+01)*s29 \
v15=v15_part3+(-7.440191e-01)*s30+2.414507e+01*s31+(-5.437930e-01)*s32+(-1.450326e+01)*s33+(-1.501499e+00)*s34+(-3.745262e-01)*s35+(-1.061897e+00)*s36+4.208056e+00*s37+(-1.902312e+00)*s38+(-8.198286e+00)*s39 \
v16_part1=2.284359e+00*s0+5.703603e+00*s1+1.000000e+04*s2+5.928611e+00*s3+1.000000e+04*s4+1.159832e+02*s5+1.574922e+01*s6+4.035983e+01*s7+4.769491e+01*s8+8.119694e+01*s9 \
v16_part2=v16_part1+2.274595e+00*s10+5.749463e+00*s11+1.052782e+01*s12+1.066472e+01*s13+3.025670e+01*s14+8.656431e+00*s15+5.613175e+02*s16+2.058890e+01*s17+2.619926e+01*s18+3.318279e+01*s19 \
v16_part3=v16_part2+1.143913e+02*s20+1.872875e+01*s21+3.710193e+01*s22+6.975660e+01*s23+7.100737e+01*s24+2.309716e+00*s25+5.939224e+00*s26+1.071130e+01*s27+1.785630e+01*s28+5.548730e+01*s29 \
v16=v16_part3+4.966453e+00*s30+4.398301e+00*s31+1.919385e+01*s32+5.220766e+01*s33+3.551461e+01*s34+2.279939e+00*s35+5.870388e+00*s36+9.296154e+01*s37+1.386346e+01*s38+3.063510e+01*s39 \
v17_part1=(-6.464293e-02)*s0+(-3.540029e-01)*s1+1.000000e+04*s2+(-8.539336e+00)*s3+1.000000e+04*s4+(-1.745653e+02)*s5+(-6.890007e+00)*s6+(-1.493318e+00)*s7+(-1.059525e+01)*s8+(-1.552747e+01)*s9 \
v17_part2=v17_part1+(-6.766530e-02)*s10+(-2.478148e-01)*s11+(-4.846650e-01)*s12+(-4.620400e+00)*s13+(-5.419923e+00)*s14+1.793955e+00*s15+(-1.691602e+02)*s16+(-3.402392e+00)*s17+(-1.083752e+01)*s18+(-1.371980e+01)*s19 \
v17_part3=v17_part2+2.659535e+00*s20+(-1.659364e+00)*s21+(-4.170578e+00)*s22+(-1.334725e+01)*s23+(-1.467402e+01)*s24+(-5.628828e-02)*s25+(-1.890359e-01)*s26+(-3.861002e-01)*s27+(-3.877260e+00)*s28+2.069210e+01*s29 \
v17=v17_part3+(-1.990138e-01)*s30+1.840739e+01*s31+(-5.935955e+00)*s32+3.638060e-01*s33+(-1.063020e+01)*s34+(-6.059807e-02)*s35+(-2.168471e-01)*s36+(-3.397062e+01)*s37+(-2.224490e+00)*s38+(-1.026982e+00)*s39 \
v18_part1=(-4.820464e-01)*s0+(-1.252088e+00)*s1+1.000000e+04*s2+7.244390e+00*s3+1.000000e+04*s4+9.027116e+02*s5+4.610597e+00*s6+(-8.840202e+00)*s7+(-3.412980e+00)*s8+(-1.042121e+01)*s9 \
v18_part2=v18_part1+(-4.805803e-01)*s10+(-1.372076e+00)*s11+(-2.857760e+00)*s12+1.691037e+00*s13+(-1.693454e+00)*s14+(-3.905990e+00)*s15+5.057019e+01*s16+(-1.945864e+00)*s17+3.237631e+00*s18+3.546999e+00*s19 \
v18_part3=v18_part2+1.556161e+00*s20+(-2.010313e+00)*s21+(-6.579217e+00)*s22+2.927763e+00*s23+(-8.137177e+00)*s24+(-4.964679e-01)*s25+(-1.465062e+00)*s26+(-3.002881e+00)*s27+(-1.136325e-01)*s28+(-3.423094e+01)*s29 \
v18=v18_part3+(-1.092537e+00)*s30+6.677629e+00*s31+1.470503e+00*s32+(-1.219896e+01)*s33+(-2.130807e+00)*s34+(-4.823949e-01)*s35+(-1.453226e+00)*s36+(-3.397143e+00)*s37+(-2.329096e+00)*s38+(-7.033471e+00)*s39 \
v19_part1=(-2.358386e-02)*s0+(-1.046036e-01)*s1+2.329314e+02*s2+(-7.212871e-01)*s3+1.000000e+04*s4+(-2.266337e+00)*s5+4.248786e-01*s6+(-7.456381e-01)*s7+(-7.922929e-01)*s8+(-1.663812e+00)*s9 \
v19_part2=v19_part1+(-2.308031e-02)*s10+(-9.897268e-02)*s11+(-3.119554e-01)*s12+(-2.636361e-01)*s13+(-5.687106e-01)*s14+7.319127e-01*s15+8.100559e+01*s16+4.176658e-01*s17+(-1.363903e+00)*s18+(-3.618275e-01)*s19 \
v19_part3=v19_part2+(-1.281602e+00)*s20+(-1.539051e-01)*s21+(-3.238772e-01)*s22+9.542292e-01*s23+(-1.933744e+00)*s24+(-2.070912e-02)*s25+(-8.450668e-02)*s26+(-8.042707e-02)*s27+(-7.191931e-01)*s28+2.140057e+00*s29 \
v19=v19_part3+(-3.809770e-02)*s30+(-7.105129e-01)*s31+(-1.314663e-01)*s32+(-1.731812e+00)*s33+(-3.076038e-01)*s34+(-2.096483e-02)*s35+(-1.000522e-01)*s36+(-9.909762e-01)*s37+(-2.350768e-01)*s38+(-4.093701e-01)*s39 \
v20_part1=(-3.302291e-02)*s0+(-1.380553e-01)*s1+6.582126e+01*s2+(-3.267579e-01)*s3+1.000000e+04*s4+(-4.711778e+00)*s5+(-2.600365e+00)*s6+(-3.013239e-01)*s7+(-2.521003e+00)*s8+(-8.463388e+00)*s9 \
v20_part2=v20_part1+(-3.717611e-02)*s10+(-1.357866e-01)*s11+(-2.806588e-01)*s12+(-7.476317e-01)*s13+(-8.269985e-01)*s14+(-1.997999e-01)*s15+(-1.767103e+03)*s16+(-2.859224e+00)*s17+(-1.186989e+00)*s18+(-3.777375e+00)*s19 \
v20_part3=v20_part2+(-2.449551e+00)*s20+(-6.219340e-01)*s21+(-2.006184e+00)*s22+(-2.542716e-02)*s23+(-5.603799e+00)*s24+(-4.107884e-02)*s25+(-1.467014e-01)*s26+(-4.145583e-01)*s27+(-3.535186e-01)*s28+(-4.972021e+00)*s29 \
v20=v20_part3+(-4.987380e-02)*s30+(-3.297157e-01)*s31+(-1.330539e+00)*s32+(-1.994681e+00)*s33+(-4.105633e+00)*s34+(-3.033441e-02)*s35+(-1.478994e-01)*s36+(-5.957789e+00)*s37+(-1.396386e+00)*s38+(-2.034203e+00)*s39 \
v21_part1=2.282823e-02*s0+1.013335e-01*s1+1.042831e+02*s2+3.909688e-01*s3+8.683127e+03*s4+(-6.254236e+00)*s5+1.476557e+00*s6+2.704438e-01*s7+1.133280e+00*s8+4.320199e+00*s9 \
v21_part2=v21_part1+2.656955e-02*s10+9.490621e-02*s11+2.817421e-01*s12+3.184300e-01*s13+2.976086e-01*s14+(-7.418425e-01)*s15+6.945990e+02*s16+9.789422e-01*s17+1.040974e+00*s18+1.343233e+00*s19 \
v21_part3=v21_part2+3.598824e-01*s20+1.780285e-01*s21+7.425240e-01*s22+(-1.214861e+00)*s23+2.859636e+00*s24+2.682309e-02*s25+9.194864e-02*s26+1.521562e-01*s27+1.419879e+00*s28+(-3.792987e-01)*s29 \
v21=v21_part3+1.957726e-02*s30+(-6.926535e+00)*s31+5.228565e-01*s32+2.087675e+00*s33+1.924092e+00*s34+1.829686e-02*s35+1.046164e-01*s36+(-3.806035e-01)*s37+7.242942e-01*s38+6.576126e-01*s39 \
v22_part1=2.189156e+03*s0+7.741408e+03*s1+(-1.333225e+01)*s2+(-9.063647e+01)*s3+(-4.048437e+01)*s4+(-7.328293e+00)*s5+(-3.213782e+02)*s6+(-9.651410e+01)*s7+(-7.830104e+02)*s8+(-2.160586e+02)*s9 \
v22_part2=v22_part1+9.228588e+03*s10+7.180747e+03*s11+1.000000e+04*s12+(-4.756490e+01)*s13+(-1.000000e+04)*s14+(-4.653856e+00)*s15+(-8.184951e+00)*s16+(-2.851297e+01)*s17+(-5.935272e+02)*s18+(-5.705999e+01)*s19 \
v22_part3=v22_part2+(-6.605560e+00)*s20+(-2.087348e+02)*s21+1.866017e+02*s22+(-8.838915e+01)*s23+(-1.376233e+02)*s24+(-2.205001e+03)*s25+4.802655e+02*s26+4.357286e+03*s27+(-1.187498e+02)*s28+(-8.897058e+01)*s29 \
v22=v22_part3+2.463566e+02*s30+(-9.947918e+00)*s31+(-3.465117e+01)*s32+(-8.080896e+01)*s33+(-9.482541e+01)*s34+3.120647e+03*s35+(-7.109395e+03)*s36+(-2.496597e+01)*s37+(-2.182002e+00)*s38+(-1.035802e+02)*s39 \
v23_part1=4.705969e+03*s0+(-1.000000e+04)*s1+(-3.861845e-01)*s2+3.133572e+02*s3+1.367451e+01*s4+(-4.665101e+00)*s5+2.364759e+01*s6+(-2.031614e+02)*s7+2.300365e+02*s8+1.019072e+02*s9 \
v23_part2=v23_part1+1.000000e+04*s10+1.085617e+03*s11+6.487182e+03*s12+7.310171e+01*s13+(-1.000000e+04)*s14+(-3.235513e+01)*s15+(-1.751080e+01)*s16+(-1.631926e+02)*s17+(-4.776671e+02)*s18+2.830870e+02*s19 \
v23_part3=v23_part2+(-3.771995e+00)*s20+3.503509e+02*s21+3.194866e+02*s22+(-1.720474e+01)*s23+(-3.897332e+02)*s24+9.878945e+02*s25+(-4.818504e+02)*s26+2.137461e+03*s27+(-8.310701e+01)*s28+(-1.333173e+02)*s29 \
v23=v23_part3+6.423990e+01*s30+(-1.063654e+01)*s31+1.532201e+02*s32+(-2.461892e+01)*s33+2.326305e+02*s34+1.000000e+04*s35+8.426831e+03*s36+1.280507e+00*s37+1.278267e+03*s38+(-1.557539e+02)*s39 \
v24_part1=1.000000e+04*s0+6.664968e+03*s1+(-2.757494e+00)*s2+5.487020e+01*s3+1.300319e-01*s4+9.727099e-01*s5+1.744248e+02*s6+(-1.714685e+02)*s7+9.416729e+02*s8+(-4.698271e+01)*s9 \
v24_part2=v24_part1+4.234682e+03*s10+4.788617e+03*s11+6.135248e+03*s12+2.650227e+01*s13+(-1.000000e+04)*s14+(-1.257003e+00)*s15+(-4.684164e+00)*s16+(-1.292054e+02)*s17+2.585504e+02*s18+(-8.276458e+00)*s19 \
v24_part3=v24_part2+(-2.245396e+00)*s20+(-1.526900e+01)*s21+(-9.253107e+02)*s22+3.102671e+01*s23+(-2.512607e+02)*s24+(-1.420954e+02)*s25+5.173769e+02*s26+8.072224e+03*s27+6.530727e+01*s28+3.708450e+01*s29 \
v24=v24_part3+(-2.351370e+02)*s30+(-9.128886e-01)*s31+(-2.167631e+01)*s32+(-1.726635e+00)*s33+(-1.717591e+02)*s34+1.787683e+03*s35+2.118106e+03*s36+4.444917e+00*s37+(-5.485813e+02)*s38+2.720690e+01*s39 \
v25_part1=9.431423e+02*s0+(-1.069882e+03)*s1+1.528760e+00*s2+(-2.000744e+02)*s3+(-7.303033e+00)*s4+5.929101e-01*s5+(-9.223491e+01)*s6+1.550237e+02*s7+(-1.197829e+02)*s8+1.968759e+02*s9 \
v25_part2=v25_part1+4.494049e+03*s10+1.539403e+02*s11+7.874002e+02*s12+2.919261e+01*s13+(-1.000000e+04)*s14+1.474838e+01*s15+1.170723e+01*s16+4.036703e+02*s17+1.678834e+02*s18+2.877440e+01*s19 \
v25_part3=v25_part2+3.348685e+00*s20+1.938495e+02*s21+1.765325e+03*s22+(-2.062967e+01)*s23+7.629154e+02*s24+4.624335e+03*s25+(-2.212166e+02)*s26+3.570603e+02*s27+(-1.121929e+01)*s28+2.489031e+01*s29 \
v25=v25_part3+1.150080e+02*s30+6.200875e+00*s31+(-3.061242e+01)*s32+(-3.521131e+00)*s33+2.890918e+02*s34+1.707457e+03*s35+3.214552e+03*s36+(-4.795993e+00)*s37+2.829411e+02*s38+3.233136e+01*s39 \
v26_part1=1.000000e+04*s0+1.853501e+03*s1+1.011333e+02*s2+1.407743e+02*s3+1.558358e+02*s4+9.115567e+01*s5+7.258130e+02*s6+1.169190e+03*s7+1.384470e+03*s8+6.225684e+02*s9 \
v26_part2=v26_part1+1.000000e+04*s10+2.540820e+03*s11+2.221041e+03*s12+2.293416e+02*s13+(-1.000000e+04)*s14+8.863527e+01*s15+1.109903e+02*s16+3.992893e+02*s17+1.402075e+03*s18+4.262079e+02*s19 \
v26_part3=v26_part2+8.889492e+01*s20+6.329495e+02*s21+3.227863e+02*s22+3.625582e+02*s23+8.905912e+02*s24+1.000000e+04*s25+1.064484e+03*s26+(-3.383864e+03)*s27+3.355369e+02*s28+2.945698e+02*s29 \
v26=v26_part3+5.336346e+02*s30+1.096945e+02*s31+2.010661e+02*s32+3.667070e+02*s33+3.276601e+02*s34+1.000000e+04*s35+1.000000e+04*s36+1.116417e+02*s37+(-3.878280e+01)*s38+4.083308e+02*s39 \
v27_part1=5.234941e-01*s0+(-4.427411e-01)*s1+(-3.410996e+00)*s2+(-1.622904e+01)*s3+(-8.458086e+00)*s4+(-1.574173e-01)*s5+(-2.363617e+01)*s6+(-1.046628e+00)*s7+(-1.429357e+02)*s8+(-2.894537e+01)*s9 \
v27_part2=v27_part1+1.242519e+00*s10+1.946331e+00*s11+2.841987e+01*s12+(-8.909168e+00)*s13+(-6.607956e+02)*s14+(-6.794175e-01)*s15+3.347543e+00*s16+(-1.122052e+01)*s17+(-1.690941e+00)*s18+(-1.655115e+01)*s19 \
v27_part3=v27_part2+(-4.069188e-01)*s20+2.483618e-01*s21+(-2.396422e+01)*s22+(-5.508712e+00)*s23+(-9.811646e+00)*s24+(-1.642409e+00)*s25+(-1.326067e+01)*s26+1.053842e+03*s27+(-3.176489e+01)*s28+(-3.352388e+00)*s29 \
v27=v27_part3+(-1.588800e+00)*s30+(-1.624716e+00)*s31+(-9.427657e+00)*s32+(-2.627230e+01)*s33+(-3.019174e+01)*s34+2.057867e+00*s35+(-4.260659e+00)*s36+(-1.334797e+00)*s37+6.122712e+00*s38+(-1.048072e+00)*s39 \
v28_part1=8.628361e-01*s0+(-7.400029e+00)*s1+1.416331e-02*s2+(-6.621724e+00)*s3+2.795002e+00*s4+(-7.327960e-01)*s5+(-4.277134e+00)*s6+3.686283e-01*s7+(-2.492303e+02)*s8+(-1.481603e+01)*s9 \
v28_part2=v28_part1+5.317520e+00*s10+(-8.562130e-02)*s11+1.013811e+00*s12+(-2.729355e+00)*s13+(-5.941420e+02)*s14+(-1.403269e-01)*s15+2.411235e-01*s16+(-4.434961e-01)*s17+(-7.236602e+00)*s18+(-5.868920e+00)*s19 \
v28_part3=v28_part2+(-1.820586e-01)*s20+(-6.769195e+00)*s21+(-9.314521e+00)*s22+(-4.653795e+00)*s23+(-5.410173e+00)*s24+(-7.028900e+00)*s25+(-5.675074e+01)*s26+8.602809e+01*s27+(-1.981618e+01)*s28+2.063670e+00*s29 \
v28=v28_part3+(-6.799475e+00)*s30+(-4.959610e-01)*s31+(-2.520670e+00)*s32+(-7.518713e+00)*s33+(-1.685776e+01)*s34+7.340947e-02*s35+(-1.519888e-01)*s36+(-5.097570e-01)*s37+(-9.430283e+01)*s38+(-8.636137e-04)*s39 \
v29_part1=3.174699e+00*s0+(-8.975284e-02)*s1+2.087929e+00*s2+1.251655e+01*s3+3.366521e+00*s4+3.131651e-01*s5+5.494417e+01*s6+(-3.564782e-02)*s7+(-7.419277e+00)*s8+4.127048e+00*s9 \
v29_part2=v29_part1+6.449468e-02*s10+1.842576e+00*s11+2.690488e+01*s12+1.274205e-02*s13+(-1.277679e+03)*s14+5.041395e-01*s15+(-2.216388e+00)*s16+1.837047e+00*s17+(-2.285762e-02)*s18+(-2.931225e-01)*s19 \
v29_part3=v29_part2+2.806381e-01*s20+1.289157e-02*s21+(-7.769879e+00)*s22+(-2.199168e-01)*s23+(-2.676606e-01)*s24+(-8.525152e-02)*s25+(-6.883135e-01)*s26+2.283045e+03*s27+1.864407e+01*s28+(-9.140001e-01)*s29 \
v29=v29_part3+(-8.246889e-02)*s30+1.060200e+00*s31+1.296896e-02*s32+2.031821e+01*s33+1.321215e-02*s34+1.948167e+00*s35+(-3.639312e+00)*s36+(-7.815620e-03)*s37+(-3.968319e+01)*s38+1.137313e+00*s39 \
v30_part1=7.661513e+03*s0+1.586561e+02*s1+(-3.235892e+00)*s2+(-8.103811e+00)*s3+(-4.649974e+00)*s4+(-1.256308e+00)*s5+(-1.780782e+01)*s6+3.441457e+01*s7+5.641120e+01*s8+(-2.085465e+01)*s9 \
v30_part2=v30_part1+1.434376e+03*s10+1.664845e+03*s11+(-1.099314e+02)*s12+(-1.225158e+01)*s13+1.000000e+04*s14+(-6.973381e-01)*s15+(-2.433698e+00)*s16+(-6.876101e+00)*s17+(-6.461418e+01)*s18+(-6.537092e+01)*s19 \
v30_part3=v30_part2+(-1.114627e+00)*s20+1.097344e+00*s21+(-5.600512e+01)*s22+(-9.216354e+00)*s23+(-3.587809e+01)*s24+(-1.677032e+03)*s25+2.969307e+01*s26+8.481780e+02*s27+(-6.575807e-01)*s28+(-3.838223e+00)*s29 \
v30=v30_part3+(-1.851226e+01)*s30+(-2.230236e+00)*s31+(-6.520415e+00)*s32+2.789428e-01*s33+(-1.912758e+01)*s34+4.188316e+03*s35+(-8.585775e+03)*s36+(-2.271698e+00)*s37+(-7.972951e+00)*s38+8.216434e-01*s39 \
v31_part1=(-6.763528e+03)*s0+4.114346e+02*s1+2.933366e+01*s2+2.563500e+01*s3+3.227426e+01*s4+7.877448e+00*s5+5.287950e+01*s6+1.380200e+01*s7+4.031311e+01*s8+1.059338e+02*s9 \
v31_part2=v31_part1+2.066507e+03*s10+1.966414e+01*s11+(-4.620705e+00)*s12+3.232612e+01*s13+1.000000e+04*s14+4.572068e+00*s15+1.261342e+01*s16+3.391936e+01*s17+1.511952e+02*s18+1.410791e+02*s19 \
v31_part3=v31_part2+7.797783e+00*s20+4.295485e+01*s21+1.133202e+02*s22+6.113198e+01*s23+1.442931e+02*s24+(-1.000000e+04)*s25+1.349201e+02*s26+(-7.531522e+00)*s27+1.342359e+01*s28+2.054675e+01*s29 \
v31=v31_part3+7.826364e+01*s30+1.260963e+01*s31+2.918864e+01*s32+2.667247e+01*s33+7.276148e+01*s34+(-1.944502e+01)*s35+3.571106e+00*s36+1.131569e+01*s37+3.393733e+01*s38+1.528139e+01*s39 \
v32_part1=8.650645e+02*s0+(-7.666718e+02)*s1+(-5.783877e+00)*s2+1.705276e+00*s3+(-7.461140e+00)*s4+(-4.683635e-01)*s5+1.657185e+01*s6+(-5.624855e+01)*s7+(-5.974269e+01)*s8+(-1.291160e+01)*s9 \
v32_part2=v32_part1+8.133762e+02*s10+4.376956e+01*s11+1.555465e+03*s12+8.929702e+00*s13+1.000000e+04*s14+(-1.615497e-01)*s15+(-5.180755e-01)*s16+(-4.219205e-02)*s17+5.256629e+01*s18+6.676599e+01*s19 \
v32_part3=v32_part2+(-5.576605e-01)*s20+(-3.972643e+00)*s21+8.066595e+01*s22+(-1.008305e+01)*s23+(-3.368400e-01)*s24+(-3.556752e+03)*s25+(-9.121674e+01)*s26+(-9.071801e+02)*s27+(-3.403137e+00)*s28+(-1.988282e+00)*s29 \
v32=v32_part3+2.024606e+01*s30+(-8.352041e-01)*s31+(-7.091156e-01)*s32+(-1.027772e+01)*s33+(-4.202770e+00)*s34+3.799972e+03*s35+(-9.572034e+02)*s36+(-3.656630e-01)*s37+4.416773e+00*s38+(-7.174685e+00)*s39 \
v33_part1=(-9.421471e+01)*s0+5.162155e+02*s1+1.442776e+00*s2+(-8.094285e+00)*s3+3.901710e-01*s4+(-1.166164e+00)*s5+(-2.731725e+01)*s6+6.277447e+01*s7+3.088596e+01*s8+(-1.615925e+01)*s9 \
v33_part2=v33_part1+1.092964e+03*s10+8.564884e+02*s11+(-4.336167e+02)*s12+(-1.657171e+01)*s13+1.000000e+04*s14+(-8.102018e-01)*s15+(-2.884275e+00)*s16+(-5.256920e+00)*s17+(-9.780491e+01)*s18+(-1.122178e+02)*s19 \
v33_part3=v33_part2+(-1.042597e+00)*s20+(-1.164022e+01)*s21+(-8.806520e+01)*s22+(-8.549656e+00)*s23+(-4.408469e+01)*s24+(-1.000000e+04)*s25+3.101226e+01*s26+1.724831e+02*s27+(-2.923941e-01)*s28+(-5.658858e+00)*s29 \
v33=v33_part3+(-6.399782e+01)*s30+(-2.565128e+00)*s31+(-4.602532e+00)*s32+2.610646e+00*s33+(-1.328812e+01)*s34+1.937592e+03*s35+1.840070e+03*s36+(-3.264461e+00)*s37+(-1.108758e+01)*s38+1.950850e+00*s39 \
v34_part1=(-2.929794e-01)*s0+(-2.394450e+00)*s1+(-4.249492e-01)*s2+3.134623e-01*s3+(-7.076223e-01)*s4+1.234583e-02*s5+(-2.161506e+00)*s6+7.269357e-03*s7+(-7.043091e+01)*s8+(-1.667511e+00)*s9 \
v34_part2=v34_part1+(-4.663752e+00)*s10+(-6.117456e+00)*s11+(-5.080435e+01)*s12+2.677392e-01*s13+4.887859e+02*s14+(-2.502225e-02)*s15+2.863385e-01*s16+(-5.603015e-01)*s17+3.644126e+00*s18+9.391395e-01*s19 \
v34_part3=v34_part2+(-1.140808e-01)*s20+8.943675e-01*s21+8.427282e-01*s22+(-1.628421e+00)*s23+2.362272e+00*s24+(-3.005404e+00)*s25+(-3.371353e+01)*s26+(-7.519651e+02)*s27+(-5.954046e-01)*s28+(-6.939531e-01)*s29 \
v34=v34_part3+(-2.178071e+00)*s30+(-5.400512e-01)*s31+(-1.862003e-01)*s32+(-2.466271e-01)*s33+1.017935e+00*s34+(-8.458623e+00)*s35+(-4.205819e-01)*s36+(-2.364870e-01)*s37+3.512164e+00*s38+(-1.255955e-02)*s39 \
v35_part1=(-1.835442e+00)*s0+(-1.146747e+01)*s1+(-5.230843e-01)*s2+(-2.228176e+00)*s3+(-1.264646e+00)*s4+(-1.840815e-01)*s5+1.431347e+01*s6+(-6.361548e+00)*s7+3.439106e+01*s8+(-4.217475e+00)*s9 \
v35_part2=v35_part1+(-1.688467e+01)*s10+3.317805e-01*s11+(-1.030522e+01)*s12+(-1.742597e+00)*s13+1.357814e+03*s14+(-7.530394e-02)*s15+(-8.005732e-01)*s16+1.782290e+00*s17+(-1.592133e+01)*s18+(-3.944766e+00)*s19 \
v35_part3=v35_part2+(-1.370945e-01)*s20+(-3.629882e+00)*s21+(-5.724909e+00)*s22+(-6.839531e-01)*s23+(-1.441044e+01)*s24+(-1.088078e+01)*s25+(-4.454991e+00)*s26+3.331889e+02*s27+3.427041e-01*s28+(-5.595501e-01)*s29 \
v35=v35_part3+(-1.681434e+00)*s30+(-2.287265e-03)*s31+(-1.162587e+00)*s32+(-2.702030e+00)*s33+(-5.758869e+00)*s34+(-1.715758e+00)*s35+1.820773e+00*s36+(-3.637817e-01)*s37+(-3.424630e-01)*s38+(-1.727415e+00)*s39 \
v36_part1=(-2.917814e+00)*s0+5.118291e+00*s1+8.318404e-02*s2+5.397421e-01*s3+5.769070e-01*s4+3.310190e-02*s5+(-1.021556e+01)*s6+7.048929e-01*s7+3.799609e+01*s8+3.772459e-01*s9 \
v36_part2=v36_part1+(-1.962145e+01)*s10+(-3.980622e+00)*s11+(-3.305834e+01)*s12+5.873276e-02*s13+1.236867e+03*s14+2.182820e-02*s15+1.715769e-01*s16+(-3.369101e+00)*s17+4.946187e+00*s18+2.619306e-02*s19 \
v36_part3=v36_part2+1.280977e-01*s20+1.726503e-01*s21+(-3.237862e+00)*s22+1.793132e-01*s23+2.763130e+00*s24+(-1.264441e+01)*s25+2.704660e+01*s26+2.457567e+02*s27+(-8.461317e-01)*s28+5.318066e-01*s29 \
v36=v36_part3+4.026291e+00*s30+3.636399e-01*s31+(-1.438341e-01)*s32+5.732219e-01*s33+(-7.907099e-01)*s34+(-5.504018e+00)*s35+(-2.736722e-01)*s36+2.669818e-01*s37+(-6.248056e+00)*s38+4.746626e-01*s39 \
v37_part1=(-4.166362e+00)*s0+(-3.173716e+03)*s1+7.436446e-01*s2+3.088854e-01*s3+3.295122e-02*s4+(-2.025439e+01)*s5+1.474944e-01*s6+3.847635e-01*s7+(-9.155388e-01)*s8+5.496742e-01*s9 \
v37_part2=v37_part1+5.045926e+00*s10+1.465108e+02*s11+(-5.681284e-02)*s12+7.212095e-01*s13+(-3.329397e-02)*s14+2.556140e-02*s15+(-1.852416e+01)*s16+3.378656e-01*s17+1.379558e+00*s18+1.412468e+00*s19 \
v37_part3=v37_part2+1.326644e+01*s20+(-2.837841e-02)*s21+1.085138e+00*s22+3.626984e-01*s23+5.365583e-01*s24+1.134045e+02*s25+(-4.229114e+02)*s26+3.212398e+02*s27+3.695709e-01*s28+1.760013e+00*s29 \
v37=v37_part3+(-7.056712e+00)*s30+4.867177e+00*s31+2.889688e-01*s32+5.272274e-01*s33+3.528872e-01*s34+(-3.951241e+00)*s35+3.904138e+02*s36+(-1.845121e+01)*s37+4.950423e-01*s38+4.515106e-01*s39 \
v38_part1=9.859407e-02*s0+8.559324e+03*s1+(-4.612297e-02)*s2+4.431584e-01*s3+3.454538e-03*s4+2.180903e+01*s5+2.701561e-01*s6+1.563731e-01*s7+2.080655e+00*s8+1.542719e-01*s9 \
v38_part2=v38_part1+4.704405e+01*s10+1.539788e+02*s11+(-5.563980e-01)*s12+5.448662e-02*s13+(-1.005445e-03)*s14+2.387678e-01*s15+1.993412e+01*s16+1.875700e-01*s17+(-9.573573e-01)*s18+(-6.784685e-01)*s19 \
v38_part3=v38_part2+(-1.351168e+01)*s20+5.248911e-01*s21+(-6.158839e-01)*s22+2.310879e-01*s23+1.750629e-01*s24+1.000000e+04*s25+1.911477e+02*s26+(-3.247951e+02)*s27+3.194610e-01*s28+(-1.445825e+00)*s29 \
v38=v38_part3+5.071651e+00*s30+(-4.726565e+00)*s31+2.740326e-01*s32+6.998304e-02*s33+4.708938e-01*s34+2.575121e+00*s35+1.051918e+02*s36+1.334172e+01*s37+3.289360e-01*s38+3.010894e-01*s39 \
v39_part1=(-1.407847e-01)*s0+(-7.157646e+03)*s1+8.351836e-01*s2+(-1.049610e+00)*s3+8.506211e-01*s4+(-3.999160e+01)*s5+(-1.149459e+00)*s6+(-1.739207e+00)*s7+(-5.643310e-01)*s8+(-1.715634e+00)*s9 \
v39_part2=v39_part1+(-9.509838e+02)*s10+(-7.625088e+02)*s11+(-1.811684e+00)*s12+(-1.626207e+00)*s13+7.961890e-01*s14+(-1.061283e+00)*s15+(-2.403772e+01)*s16+(-1.222481e+00)*s17+(-3.510597e+00)*s18+(-2.955143e+00)*s19 \
v39_part3=v39_part2+(-2.658305e+01)*s20+(-1.011882e+00)*s21+(-2.728972e+00)*s22+(-1.525389e+00)*s23+(-1.760389e+00)*s24+(-1.626480e+03)*s25+(-1.989238e+02)*s26+(-7.077075e+02)*s27+(-1.178956e+00)*s28+(-3.316012e+00)*s29 \
v39=v39_part3+5.619073e+00*s30+(-1.259528e+01)*s31+(-1.059241e+00)*s32+(-1.460474e+00)*s33+(-1.527812e+00)*s34+(-2.237973e+01)*s35+(-1.104815e+02)*s36+(-2.523216e+01)*s37+(-2.045203e+00)*s38+(-1.388072e+00)*s39 \
v40_part1=8.164520e-01*s0+(-6.700127e+03)*s1+(-2.915271e-01)*s2+2.218200e-01*s3+(-3.780815e-01)*s4+3.406212e+01*s5+4.819252e-01*s6+9.217694e-01*s7+(-5.211331e-01)*s8+9.428858e-01*s9 \
v40_part2=v40_part1+(-1.000000e+04)*s10+9.342702e+01*s11+1.256749e+00*s12+9.211819e-01*s13+(-3.700446e-01)*s14+9.650074e-01*s15+1.844404e+01*s16+6.095695e-01*s17+2.668996e+00*s18+2.408299e+00*s19 \
v40_part3=v40_part2+2.530261e+01*s20+5.016932e-01*s21+2.221317e+00*s22+7.329475e-01*s23+1.051034e+00*s24+(-2.242486e+03)*s25+2.846760e+02*s26+7.110144e+02*s27+3.986296e-01*s28+3.275004e+00*s29 \
v40=v40_part3+(-3.907989e+00)*s30+1.157536e+01*s31+3.987377e-01*s32+7.448683e-01*s33+7.690963e-01*s34+(-1.759463e+00)*s35+3.130667e+02*s36+2.822151e+01*s37+1.182558e+00*s38+5.954386e-01*s39 \
v41_part1=1.403239e-01*s0+4.525950e+00*s1+7.928619e-02*s2+(-5.725108e-02)*s3+5.742991e-02*s4+(-1.683071e+00)*s5+(-1.848574e-01)*s6+(-1.379935e-01)*s7+5.125841e-01*s8+(-1.228494e-01)*s9 \
v41_part2=v41_part1+2.963778e+00*s10+6.753283e+00*s11+(-2.838763e+00)*s12+(-1.313562e-01)*s13+8.605446e-02*s14+(-1.386680e-01)*s15+9.590684e+01*s16+(-1.342591e-01)*s17+2.736569e-02*s18+(-3.247225e-01)*s19 \
v41_part3=v41_part2+1.899420e-01*s20+(-1.026398e-01)*s21+(-1.240589e-01)*s22+(-2.388756e-01)*s23+(-1.379055e-01)*s24+4.299996e+00*s25+3.529745e+01*s26+4.402736e+02*s27+(-6.010423e-02)*s28+(-2.251989e-01)*s29 \
v41=v41_part3+(-2.171584e-01)*s30+1.328774e+00*s31+(-7.558664e-02)*s32+(-3.129347e-02)*s33+(-2.334048e-01)*s34+2.210525e+00*s35+(-3.219537e+00)*s36+3.571574e+00*s37+(-4.053010e-01)*s38+(-1.538867e-01)*s39 \
v42_part1=1.589006e-01*s0+1.527307e+00*s1+(-3.672866e-02)*s2+9.773348e-02*s3+(-5.225417e-02)*s4+(-3.486908e-02)*s5+8.964573e-02*s6+8.278150e-02*s7+(-4.546242e-01)*s8+1.427174e-01*s9 \
v42_part2=v42_part1+1.000143e+00*s10+1.879336e+00*s11+3.202184e+00*s12+1.182202e-01*s13+(-4.688983e-02)*s14+3.197149e-02*s15+(-1.009344e+02)*s16+9.636074e-02*s17+3.496659e-03*s18+2.874899e-01*s19 \
v42_part3=v42_part2+(-4.370734e-02)*s20+9.460803e-02*s21+1.276618e-01*s22+1.086065e-01*s23+2.197148e-01*s24+(-9.742955e-01)*s25+1.191132e+01*s26+(-4.412020e+02)*s27+(-1.025191e-02)*s28+1.343802e-01*s29 \
v42=v42_part3+1.260977e-01*s30+(-1.163335e+00)*s31+5.373808e-02*s32+8.315386e-02*s33+2.498599e-01*s34+1.168541e+00*s35+(-8.959480e-01)*s36+(-3.887246e+00)*s37+2.893277e-01*s38+1.384863e-01*s39 \
v43_part1=(-2.452995e+00)*s0+1.909796e+01*s1+(-1.758870e-02)*s2+(-4.474289e-04)*s3+1.372570e-02*s4+2.311538e+00*s5+8.842576e-03*s6+1.351970e-02*s7+(-1.598044e-01)*s8+4.992400e-02*s9 \
v43_part2=v43_part1+(-1.890532e+01)*s10+6.464282e+00*s11+2.667445e-01*s12+5.866952e-02*s13+(-6.841439e-03)*s14+1.281303e-01*s15+1.679900e+01*s16+1.910982e-01*s17+6.613141e-02*s18+1.231246e-01*s19 \
v43_part3=v43_part2+8.719016e-02*s20+6.679144e-02*s21+1.398863e-01*s22+3.278040e-02*s23+1.261571e-02*s24+1.814451e+01*s25+1.489431e+02*s26+2.062861e+00*s27+3.685469e-02*s28+7.209580e-02*s29 \
v43=v43_part3+7.238377e-02*s30+(-3.787946e-01)*s31+5.335558e-02*s32+(-5.100743e-04)*s33+6.802756e-02*s34+(-9.197440e+00)*s35+(-3.081759e+00)*s36+6.674132e-01*s37+3.897110e-01*s38+5.813199e-02*s39 \
v44_part1=(-1.313506e-02)*s0+1.539655e-01*s1+4.118444e-01*s2+(-2.025761e-01)*s3+2.742527e-01*s4+7.586078e-02*s5+5.715173e-03*s6+3.446264e-02*s7+(-2.305924e-01)*s8+(-3.135035e-01)*s9 \
v44_part2=v44_part1+(-5.922399e-01)*s10+(-6.597218e-02)*s11+8.537205e-02*s12+2.583023e-02*s13+(-7.915972e-02)*s14+8.674661e-02*s15+(-3.993197e-01)*s16+5.424463e-02*s17+2.368688e-01*s18+5.543621e-01*s19 \
v44_part3=v44_part2+(-1.199345e-01)*s20+(-6.387967e-02)*s21+2.981259e-01*s22+(-1.211706e+00)*s23+(-4.237251e-02)*s24+1.338372e-02*s25+2.694171e-02*s26+(-3.758846e-03)*s27+8.929182e-02*s28+(-8.167018e-02)*s29 \
v44=v44_part3+1.921184e-02*s30+1.588483e-01*s31+(-4.663049e-03)*s32+1.861657e-01*s33+4.727287e-02*s34+1.683608e-01*s35+(-5.008321e-02)*s36+7.942124e-01*s37+2.798162e-02*s38+(-9.307054e-02)*s39 \
v45_part1=1.621794e+00*s0+1.833840e+00*s1+1.824438e+00*s2+2.810600e+00*s3+2.742274e+00*s4+1.570484e+00*s5+1.929240e+00*s6+2.073799e+00*s7+2.615550e+00*s8+2.918309e+00*s9 \
v45_part2=v45_part1+2.075783e+00*s10+1.584706e+00*s11+1.591051e+00*s12+1.882884e+00*s13+2.226555e+00*s14+1.287314e+00*s15+2.079232e+00*s16+1.728712e+00*s17+1.609726e+00*s18+1.303623e+00*s19 \
v45_part3=v45_part2+1.526920e+00*s20+1.639224e+00*s21+1.291561e+00*s22+3.379022e+00*s23+1.909416e+00*s24+1.124259e+00*s25+1.248991e+00*s26+1.463819e+00*s27+1.503775e+00*s28+1.825305e+00*s29 \
v45=v45_part3+1.184438e+00*s30+1.178125e+00*s31+1.536327e+00*s32+1.426254e+00*s33+1.665805e+00*s34+8.518087e-01*s35+1.223415e+00*s36+2.863361e-01*s37+1.425638e+00*s38+1.607010e+00*s39 \
v46_part1=(-5.153576e-02)*s0+(-5.135618e-01)*s1+(-1.333951e+00)*s2+(-1.128121e+00)*s3+(-1.957599e+00)*s4+(-2.474482e-01)*s5+(-4.675707e-01)*s6+(-6.206458e-01)*s7+(-5.988366e-01)*s8+(-7.917624e-01)*s9 \
v46_part2=v46_part1+6.166163e-01*s10+(-1.350886e-01)*s11+(-6.714533e-01)*s12+(-8.047610e-01)*s13+(-9.095295e-01)*s14+(-2.599659e-01)*s15+7.811966e-02*s16+(-6.504132e-01)*s17+(-1.057466e+00)*s18+(-1.507196e+00)*s19 \
v46_part3=v46_part2+5.130880e-03*s20+(-2.841947e-01)*s21+(-8.268927e-01)*s22+8.405308e-01*s23+(-6.552179e-01)*s24+(-1.091758e-01)*s25+(-2.507863e-01)*s26+(-4.991228e-01)*s27+(-6.929336e-01)*s28+(-6.512460e-01)*s29 \
v46=v46_part3+(-1.879951e-01)*s30+(-5.140792e-01)*s31+(-5.094282e-01)*s32+(-7.544528e-01)*s33+(-7.539194e-01)*s34+(-2.883566e-01)*s35+(-1.802212e-01)*s36+(-1.408620e+00)*s37+(-5.285765e-01)*s38+(-5.356354e-01)*s39 \
v47_part1=1.083295e+00*s0+1.674865e+00*s1+2.762119e+00*s2+2.622104e+00*s3+3.390342e+00*s4+6.231924e-01*s5+9.462211e-01*s6+1.134412e+00*s7+1.008027e+00*s8+1.200039e+00*s9 \
v47_part2=v47_part1+(-3.074307e-01)*s10+7.935042e-01*s11+1.487207e+00*s12+1.603223e+00*s13+1.620677e+00*s14+7.688171e-01*s15+3.609860e-01*s16+1.199016e+00*s17+1.635737e+00*s18+2.197253e+00*s19 \
v47_part3=v47_part2+2.255555e-01*s20+5.387481e-01*s21+1.178846e+00*s22+(-1.132015e+00)*s23+8.366863e-01*s24+5.589032e-01*s25+7.423147e-01*s26+9.937212e-01*s27+1.195201e+00*s28+1.084447e+00*s29 \
v47=v47_part3+5.597394e-01*s30+9.295529e-01*s31+8.645003e-01*s32+1.082777e+00*s33+9.942829e-01*s34+6.617163e-01*s35+5.345554e-01*s36+2.005077e+00*s37+8.143239e-01*s38+8.039218e-01*s39 \
v48_part1=6.895295e-03*s0+(-3.119509e-02)*s1+1.153710e-02*s2+(-6.946506e-02)*s3+1.015287e-01*s4+(-2.135760e-02)*s5+(-4.850169e-02)*s6+(-4.403765e-02)*s7+(-1.058003e-01)*s8+(-1.213340e-01)*s9 \
v48_part2=v48_part1+2.725558e-03*s10+(-1.468132e-01)*s11+(-3.780350e-02)*s12+(-3.529521e-02)*s13+(-5.600140e-02)*s14+(-1.154947e-02)*s15+3.997929e-02*s16+(-2.420126e-02)*s17+(-9.292948e-02)*s18+(-1.091588e-01)*s19 \
v48_part3=v48_part2+(-6.932580e-02)*s20+(-1.421436e-02)*s21+(-1.213555e-01)*s22+(-1.644519e-02)*s23+(-1.426787e-01)*s24+1.424344e-02*s25+(-5.673486e-02)*s26+(-1.067024e-01)*s27+9.259962e-03*s28+(-5.768485e-02)*s29 \
v48=v48_part3+1.463523e-02*s30+(-3.749529e-03)*s31+(-2.634088e-02)*s32+(-6.526330e-02)*s33+(-3.412011e-02)*s34+(-1.968748e-02)*s35+6.404772e-03*s36+(-1.204411e-01)*s37+(-4.903798e-02)*s38+(-1.364263e-02)*s39 \
v49_part1=1.289699e-01*s0+2.660559e-01*s1+2.946275e-01*s2+5.218069e-01*s3+4.233048e-01*s4+(-2.197976e-02)*s5+1.551489e-01*s6+2.257064e-01*s7+2.596868e-01*s8+3.994600e-01*s9 \
v49_part2=v49_part1+1.018453e-01*s10+2.771422e-01*s11+2.179080e-01*s12+2.611414e-01*s13+3.156067e-01*s14+7.124334e-02*s15+1.606314e-01*s16+1.667372e-01*s17+2.170731e-01*s18+2.788083e-01*s19 \
v49_part3=v49_part2+1.390516e-01*s20+7.726362e-02*s21+1.238185e-01*s22+1.405691e-01*s23+1.740431e-01*s24+6.599789e-02*s25+1.658103e-01*s26+1.918320e-01*s27+1.580141e-01*s28+2.093624e-01*s29 \
v49=v49_part3+4.575252e-02*s30+7.969979e-02*s31+1.126561e-01*s32+1.630150e-01*s33+1.414913e-01*s34+6.712961e-02*s35+7.312017e-02*s36+1.723401e-01*s37+1.183996e-01*s38+1.316869e-01*s39 \
v50_part1=(-1.503362e-02)*s0+(-5.295514e-02)*s1+(-4.472463e-02)*s2+(-1.614496e-01)*s3+(-2.845608e-01)*s4+1.052941e-01*s5+(-1.190668e-02)*s6+(-6.246290e-02)*s7+(-3.317248e-03)*s8+(-1.037545e-01)*s9 \
v50_part2=v50_part1+(-3.421290e-02)*s10+(-1.034812e-02)*s11+(-5.088982e-02)*s12+(-8.669024e-02)*s13+(-1.050537e-01)*s14+(-8.450737e-03)*s15+(-1.256937e-01)*s16+(-7.036271e-02)*s17+(-3.360671e-02)*s18+(-7.009286e-02)*s19 \
v50_part3=v50_part2+(-1.120737e-02)*s20+(-1.675089e-02)*s21+7.014553e-02*s22+(-5.966028e-02)*s23+4.467579e-02*s24+(-3.568004e-02)*s25+(-1.011502e-02)*s26+1.655527e-02*s27+(-9.119857e-02)*s28+(-5.151952e-02)*s29 \
v50=v50_part3+(-2.852701e-02)*s30+(-3.459005e-02)*s31+(-4.017003e-02)*s32+(-4.649295e-02)*s33+(-7.358947e-02)*s34+(-7.303565e-03)*s35+(-2.710988e-02)*s36+3.352160e-02*s37+(-3.139409e-03)*s38+(-5.805046e-02)*s39 \
v51_part1=(-1.223979e+01)*s0+(-5.644655e+00)*s1+3.186142e+00*s2+(-1.791523e+01)*s3+1.566819e+01*s4+2.145977e+00*s5+1.334922e+01*s6+2.248659e+01*s7+(-3.941452e-01)*s8+(-1.133390e+01)*s9 \
v51_part2=v51_part1+(-8.961268e-03)*s10+4.329179e+00*s11+3.236248e+00*s12+(-5.975892e+03)*s13+6.249741e+00*s14+(-1.388678e-01)*s15+5.195111e+00*s16+(-9.307303e-01)*s17+(-2.361815e+00)*s18+(-5.202318e+00)*s19 \
v51_part3=v51_part2+2.249903e+00*s20+(-2.317055e+01)*s21+8.227442e+00*s22+(-6.922094e+00)*s23+1.928973e+00*s24+4.599256e+00*s25+5.826421e-01*s26+2.182511e+00*s27+1.129988e+01*s28+4.345172e+00*s29 \
v51=v51_part3+1.618784e+00*s30+2.481693e-01*s31+(-9.459856e-01)*s32+9.348105e+00*s33+2.846167e+00*s34+2.035350e+00*s35+1.980078e+00*s36+5.174968e+00*s37+5.495786e+00*s38+3.347895e+00*s39 \
v52_part1=2.783961e+01*s0+1.544080e+01*s1+(-1.570986e+00)*s2+3.753098e+01*s3+(-1.222934e+01)*s4+5.823491e+00*s5+(-1.106208e+01)*s6+(-1.950566e+01)*s7+6.340314e+00*s8+2.770596e+01*s9 \
v52_part2=v52_part1+1.500893e+00*s10+(-2.299155e+00)*s11+(-1.443398e+00)*s12+1.000000e+04*s13+(-4.068803e+00)*s14+4.194046e+00*s15+(-3.165270e+00)*s16+4.339779e+00*s17+6.151192e+00*s18+7.165649e+00*s19 \
v52_part3=v52_part2+1.643839e+00*s20+8.219539e+01*s21+(-5.894240e+00)*s22+1.887907e+01*s23+3.365205e+00*s24+(-2.432588e+00)*s25+6.483761e-01*s26+(-1.032060e+00)*s27+(-9.350584e+00)*s28+(-1.521687e+00)*s29 \
v52=v52_part3+1.768447e+00*s30+2.415677e+00*s31+4.725238e+00*s32+(-7.712178e+00)*s33+(-1.302847e+00)*s34+(-8.047353e-01)*s35+(-4.569383e-01)*s36+(-2.603453e+00)*s37+(-1.849890e+00)*s38+2.491439e-01*s39 \
v53_part1=8.228372e+00*s0+(-3.308960e+00)*s1+1.136066e+01*s2+2.570177e+00*s3+1.213034e+01*s4+(-6.906650e+00)*s5+8.321458e-01*s6+(-1.179559e+00)*s7+(-1.644131e+00)*s8+(-1.433255e+00)*s9 \
v53_part2=v53_part1+5.306359e+00*s10+(-2.898491e-01)*s11+2.977219e-01*s12+(-6.003084e+03)*s13+6.012698e-01*s14+(-8.546207e-01)*s15+5.554255e+00*s16+1.328159e+00*s17+2.553466e+00*s18+2.016977e+01*s19 \
v53_part3=v53_part2+5.088727e+00*s20+(-2.292182e+03)*s21+(-3.279824e+00)*s22+(-1.072100e+01)*s23+6.200246e+00*s24+1.341370e+02*s25+1.550277e+00*s26+(-8.114056e-01)*s27+(-6.626095e+00)*s28+1.733815e+00*s29 \
v53=v53_part3+(-2.386418e+00)*s30+2.047584e-01*s31+3.453042e-02*s32+1.258843e+00*s33+7.304327e-01*s34+(-4.264839e-01)*s35+1.277233e-01*s36+(-1.068731e+00)*s37+3.569713e+00*s38+9.292069e-01*s39 \
v54_part1=(-1.665197e+01)*s0+5.389191e+00*s1+(-1.064449e+01)*s2+(-4.756028e+00)*s3+(-1.255308e+01)*s4+1.164640e+01*s5+(-9.276167e-01)*s6+9.446823e-01*s7+1.206101e+00*s8+1.298470e+00*s9 \
v54_part2=v54_part1+(-4.044837e+00)*s10+6.896863e-01*s11+(-3.511975e-01)*s12+1.000000e+04*s13+(-4.680164e-01)*s14+5.826837e-01*s15+(-5.819096e+00)*s16+(-2.321600e+00)*s17+(-4.230938e+00)*s18+(-2.033777e+01)*s19 \
v54_part3=v54_part2+(-4.854826e+00)*s20+3.813814e+03*s21+3.359721e+00*s22+3.194284e+01*s23+(-7.888190e+00)*s24+(-7.136980e+00)*s25+(-1.484739e+00)*s26+1.019041e+00*s27+8.192149e+00*s28+(-1.474727e+00)*s29 \
v54=v54_part3+2.102222e+00*s30+(-8.007328e-01)*s31+1.979187e-01*s32+(-9.465790e-01)*s33+(-1.144105e+00)*s34+3.323398e-01*s35+(-2.039568e-01)*s36+3.785550e-02*s37+(-3.830206e+00)*s38+(-2.136590e+00)*s39 \
v55_part1=5.125047e-01*s0+4.106890e-01*s1+1.351292e+01*s2+2.211463e+00*s3+(-1.136425e+01)*s4+(-6.450941e-01)*s5+1.259683e+00*s6+(-3.001582e-01)*s7+1.912302e+00*s8+5.779833e+00*s9 \
v55_part2=v55_part1+(-6.317887e-01)*s10+2.724548e-01*s11+4.005364e-01*s12+(-6.694177e+01)*s13+7.751113e-01*s14+1.562986e-01*s15+(-7.327626e+00)*s16+(-5.941701e-02)*s17+2.254347e-01*s18+3.255781e+00*s19 \
v55_part3=v55_part2+1.543732e-01*s20+(-4.678001e+00)*s21+(-5.176718e+00)*s22+8.658237e+00*s23+2.747383e+00*s24+1.569281e+01*s25+9.310908e-01*s26+5.843023e-01*s27+(-8.552824e-01)*s28+6.329210e-01*s29 \
v55=v55_part3+3.942017e-02*s30+6.813621e-01*s31+(-1.633492e-02)*s32+(-5.324970e-01)*s33+(-7.231396e-02)*s34+1.402214e-01*s35+(-1.799560e-01)*s36+(-8.678765e-01)*s37+(-3.697530e-01)*s38+(-1.772685e+00)*s39 \
v56_part1=(-1.357117e+00)*s0+(-3.920971e-01)*s1+(-1.310054e+01)*s2+(-3.723874e+00)*s3+1.018300e+01*s4+1.209643e+00*s5+(-1.111317e+00)*s6+4.735673e-01*s7+(-5.410271e+00)*s8+(-1.130364e+01)*s9 \
v56_part2=v56_part1+6.529657e-01*s10+4.076539e-01*s11+(-1.658776e+00)*s12+1.132360e+02*s13+4.118780e-01*s14+(-8.888788e-01)*s15+6.529439e+00*s16+3.122329e-01*s17+(-5.607422e-01)*s18+(-3.616455e+00)*s19 \
v56_part3=v56_part2+7.949753e-02*s20+1.357371e+01*s21+2.227079e+00*s22+8.860942e+00*s23+(-1.468408e+00)*s24+(-1.454757e+01)*s25+(-7.512856e-01)*s26+(-6.478147e-01)*s27+(-1.104328e+00)*s28+1.869051e-01*s29 \
v56=v56_part3+1.345169e-01*s30+(-1.029875e+00)*s31+9.202291e-02*s32+2.483220e-02*s33+9.836959e-02*s34+(-2.771184e-01)*s35+2.373685e-01*s36+7.903257e-01*s37+(-1.141490e+00)*s38+2.381015e-01*s39 \
v57_part1=2.778344e-01*s0+(-3.971165e-01)*s1+3.807133e-01*s2+(-1.981177e-01)*s3+8.197111e-01*s4+(-3.319385e+00)*s5+(-4.158722e-02)*s6+(-2.311377e-01)*s7+8.000904e-01*s8+2.290295e-01*s9 \
v57_part2=v57_part1+8.035623e-02*s10+(-8.018547e-01)*s11+1.514935e+00*s12+2.179857e+00*s13+(-1.149653e+00)*s14+3.766595e-01*s15+5.658435e-01*s16+(-9.133509e-02)*s17+1.401089e-01*s18+6.195691e-01*s19 \
v57_part3=v57_part2+1.669223e+00*s20+(-2.338831e-01)*s21+3.883561e+00*s22+2.757622e-01*s23+5.494803e-01*s24+4.190236e-01*s25+2.491794e-01*s26+(-2.440610e-01)*s27+2.364212e+00*s28+(-6.040287e-01)*s29 \
v57=v57_part3+(-2.571604e-01)*s30+1.235993e-01*s31+(-8.993621e-03)*s32+7.734806e-01*s33+(-8.139919e-02)*s34+8.848156e-02*s35+(-1.810607e-01)*s36+1.436400e-01*s37+1.338460e+00*s38+7.481560e-01*s39 \
v58_part1=5.466308e-03*s0+4.090481e-01*s1+7.526483e-01*s2+1.361790e+00*s3+2.468565e+00*s4+3.405548e-01*s5+4.737249e-01*s6+1.007580e+00*s7+1.393536e+00*s8+2.204729e+00*s9 \
v58_part2=v58_part1+9.434293e-01*s10+2.505854e-01*s11+3.799061e-01*s12+7.237403e-01*s13+1.070946e+00*s14+8.641002e-02*s15+(-1.783478e-01)*s16+2.897557e-01*s17+6.356692e-01*s18+1.238630e+00*s19 \
v58_part3=v58_part2+5.064847e-02*s20+2.225136e-01*s21+4.269054e-01*s22+9.526173e-01*s23+1.184037e+00*s24+2.828657e-02*s25+1.683015e-02*s26+2.485733e-01*s27+5.724729e-01*s28+6.313456e-01*s29 \
v58=v58_part3+(-2.725464e-02)*s30+2.238020e-02*s31+1.900383e-01*s32+5.114143e-01*s33+8.333475e-01*s34+(-1.205011e-01)*s35+(-5.432333e-03)*s36+6.534819e-01*s37+3.387578e-01*s38+4.749625e-01*s39 \
v59_part1=1.291810e+00*s0+1.468026e+00*s1+1.929125e+00*s2+1.784110e+00*s3+1.378863e+00*s4+1.303695e+00*s5+2.014976e+00*s6+2.158239e+00*s7+2.638515e+00*s8+2.812525e+00*s9 \
v59_part2=v59_part1+4.105893e-01*s10+1.283655e+00*s11+1.583964e+00*s12+1.671273e+00*s13+1.821848e+00*s14+1.378686e+00*s15+2.008905e+00*s16+1.797862e+00*s17+1.916762e+00*s18+1.811136e+00*s19 \
v59_part3=v59_part2+1.548683e+00*s20+1.774686e+00*s21+1.976830e+00*s22+1.906052e+00*s23+2.344607e+00*s24+1.121153e+00*s25+1.327681e+00*s26+1.327761e+00*s27+1.271401e+00*s28+1.626410e+00*s29 \
v59=v59_part3+1.287907e+00*s30+1.458157e+00*s31+1.501798e+00*s32+1.441926e+00*s33+1.452827e+00*s34+1.185586e+00*s35+1.217239e+00*s36+5.986115e-01*s37+1.269995e+00*s38+1.392232e+00*s39 \
v60_part1=(-1.624677e-01)*s0+(-1.283639e+00)*s1+(-2.569414e+00)*s2+(-4.090874e+00)*s3+(-6.408207e+00)*s4+(-6.558081e-01)*s5+(-1.796694e+00)*s6+(-3.095709e+00)*s7+(-4.431586e+00)*s8+(-6.588013e+00)*s9 \
v60_part2=v60_part1+(-1.155855e+00)*s10+(-6.004764e-01)*s11+(-1.320052e+00)*s12+(-2.452141e+00)*s13+(-3.442200e+00)*s14+(-1.947851e-01)*s15+(-2.913486e-01)*s16+(-1.326388e+00)*s17+(-2.288753e+00)*s18+(-3.632658e+00)*s19 \
v60_part3=v60_part2+(-2.740292e-01)*s20+(-9.682317e-01)*s21+(-1.580451e+00)*s22+(-2.908235e+00)*s23+(-3.810372e+00)*s24+(-1.519858e-01)*s25+(-2.689913e-01)*s26+(-9.910579e-01)*s27+(-1.789834e+00)*s28+(-2.315673e+00)*s29 \
v60=v60_part3+(-5.944003e-02)*s30+(-4.128546e-01)*s31+(-9.152224e-01)*s32+(-1.686605e+00)*s33+(-2.515276e+00)*s34+1.007064e-01*s35+(-2.495219e-01)*s36+(-1.245756e+00)*s37+(-1.246574e+00)*s38+(-1.750531e+00)*s39 \
v61_part1=3.289266e+00*s0+5.908383e+00*s1+8.328533e+00*s2+1.108759e+01*s3+1.413024e+01*s4+4.358325e+00*s5+7.247117e+00*s6+9.937006e+00*s7+1.222637e+01*s8+1.503680e+01*s9 \
v61_part2=v61_part1+2.732649e+00*s10+3.296973e+00*s11+4.723459e+00*s12+6.438241e+00*s13+7.674700e+00*s14+2.034420e+00*s15+3.035564e+00*s16+5.050111e+00*s17+6.518400e+00*s18+8.281597e+00*s19 \
v61_part3=v61_part2+2.325130e+00*s20+4.082753e+00*s21+5.402028e+00*s22+7.338135e+00*s23+8.509007e+00*s24+1.312782e+00*s25+1.979532e+00*s26+3.208508e+00*s27+4.354284e+00*s28+4.973693e+00*s29 \
v61=v61_part3+1.262553e+00*s30+2.186819e+00*s31+3.231348e+00*s32+4.395911e+00*s33+5.481209e+00*s34+7.363652e-01*s35+1.499002e+00*s36+2.985099e+00*s37+3.054082e+00*s38+3.706000e+00*s39 \
v62_part1=3.947707e-02*s0+6.180504e-02*s1+1.479596e-01*s2+(-2.403300e-02)*s3+1.372646e-01*s4+1.731285e-02*s5+3.561692e-02*s6+(-1.705558e-02)*s7+(-4.057358e-02)*s8+4.751099e-02*s9 \
v62_part2=v62_part1+(-8.657820e-03)*s10+(-2.610092e-01)*s11+(-2.698220e-02)*s12+(-2.145527e-03)*s13+(-4.144657e-02)*s14+(-1.185311e-02)*s15+1.142014e-02*s16+(-8.530918e-03)*s17+(-2.892106e-02)*s18+(-8.583300e-02)*s19 \
v62_part3=v62_part2+(-1.259953e-01)*s20+(-1.220519e-03)*s21+(-6.373686e-03)*s22+(-1.181440e-01)*s23+(-4.864299e-02)*s24+7.661812e-03*s25+(-1.660024e-01)*s26+(-3.898798e-02)*s27+3.065361e-02*s28+(-4.413958e-03)*s29 \
v62=v62_part3+(-2.673425e-03)*s30+(-2.187110e-02)*s31+(-7.293978e-03)*s32+(-2.829457e-02)*s33+(-3.407695e-02)*s34+(-2.394563e-02)*s35+2.007353e-02*s36+(-7.850802e-02)*s37+(-4.078414e-02)*s38+(-7.386478e-02)*s39 \
v63_part1=1.545629e-01*s0+4.279496e-01*s1+4.199895e-01*s2+8.643244e-01*s3+1.043524e+00*s4+2.058369e-01*s5+4.864650e-01*s6+7.941965e-01*s7+9.824213e-01*s8+1.251093e+00*s9 \
v63_part2=v63_part1+9.366606e-02*s10+6.289369e-01*s11+4.420561e-01*s12+5.581870e-01*s13+6.761541e-01*s14+1.402881e-01*s15+4.349258e-01*s16+4.472482e-01*s17+6.656334e-01*s18+8.294153e-01*s19 \
v63_part3=v63_part2+2.737197e-01*s20+3.329457e-01*s21+5.089071e-01*s22+7.069435e-01*s23+8.708342e-01*s24+9.350704e-02*s25+3.690282e-01*s26+3.741216e-01*s27+4.009285e-01*s28+4.293163e-01*s29 \
v63=v63_part3+1.244929e-01*s30+2.352829e-01*s31+3.142552e-01*s32+4.297726e-01*s33+5.299874e-01*s34+1.776986e-01*s35+1.264682e-01*s36+2.970801e-01*s37+2.992955e-01*s38+3.482016e-01*s39 \
v64_part1=(-4.903551e-02)*s0+(-2.310387e-01)*s1+(-2.634008e-01)*s2+(-4.509479e-01)*s3+(-8.466421e-01)*s4+(-2.009432e-02)*s5+(-1.758375e-01)*s6+(-3.150743e-01)*s7+(-4.163197e-01)*s8+(-8.233162e-01)*s9 \
v64_part2=v64_part1+1.372122e-02*s10+(-1.462329e-01)*s11+(-1.737476e-01)*s12+(-2.936455e-01)*s13+(-3.720635e-01)*s14+(-7.141240e-03)*s15+(-2.280183e-01)*s16+(-1.371983e-01)*s17+(-2.933737e-01)*s18+(-3.757022e-01)*s19 \
v64_part3=v64_part2+2.465782e-02*s20+(-9.768812e-02)*s21+(-2.016591e-01)*s22+(-2.264330e-01)*s23+(-4.777632e-01)*s24+(-3.623790e-02)*s25+(-3.804465e-02)*s26+(-1.400680e-01)*s27+(-2.683350e-01)*s28+(-2.510938e-01)*s29 \
v64=v64_part3+(-4.100844e-02)*s30+(-6.220114e-02)*s31+(-1.053623e-01)*s32+(-1.659872e-01)*s33+(-2.611384e-01)*s34+(-7.679234e-02)*s35+(-5.122114e-02)*s36+(-7.197498e-02)*s37+(-1.166231e-01)*s38+(-1.283553e-01)*s39 \
v65_part1=1.316582e+00*s0+3.484368e+00*s1+(-9.815842e-01)*s2+3.058417e+00*s3+7.528759e-01*s4+2.563651e+00*s5+1.436361e-01*s6+4.898021e-01*s7+3.009233e+00*s8+3.160579e+00*s9 \
v65_part2=v65_part1+5.085796e+00*s10+2.153636e+00*s11+1.969955e+00*s12+2.125197e+00*s13+1.880029e+00*s14+7.691418e+00*s15+(-1.758661e+00)*s16+1.130708e+01*s17+4.433783e+00*s18+2.576521e+00*s19 \
v65_part3=v65_part2+1.250163e+00*s20+2.118737e+00*s21+2.028625e+00*s22+1.704823e+00*s23+3.315672e+00*s24+2.042012e+00*s25+7.324856e+00*s26+5.583292e+00*s27+1.960157e+00*s28+2.411028e+00*s29 \
v65=v65_part3+2.934076e+00*s30+1.064155e+01*s31+8.270713e+00*s32+(-1.458259e+00)*s33+(-6.762757e-02)*s34+3.113785e+02*s35+5.348776e+00*s36+1.833485e+00*s37+2.334399e+00*s38+4.077411e+00*s39 \
v66_part1=(-4.289738e-02)*s0+(-2.109513e+00)*s1+5.101910e+00*s2+(-1.434015e+00)*s3+1.801697e+00*s4+(-1.256399e+00)*s5+2.666072e+00*s6+1.972633e+00*s7+(-7.725057e-01)*s8+(-1.696843e+00)*s9 \
v66_part2=v66_part1+(-2.455811e+00)*s10+4.064038e-01*s11+1.898877e+00*s12+(-8.407561e-01)*s13+1.184708e+00*s14+(-6.065561e+00)*s15+5.523142e+00*s16+(-9.194212e+00)*s17+(-2.890070e+00)*s18+6.540921e-01*s19 \
v66_part3=v66_part2+(-4.741816e-02)*s20+(-9.360971e-01)*s21+7.063076e-02*s22+(-2.370434e-01)*s23+(-1.493388e+00)*s24+(-8.600506e-01)*s25+2.370506e-02*s26+4.172637e+00*s27+3.115467e-01*s28+1.912734e-01*s29 \
v66=v66_part3+(-1.319194e+00)*s30+(-8.477083e+00)*s31+(-6.359440e+00)*s32+5.706788e+00*s33+7.657463e+00*s34+3.832986e+01*s35+(-1.989498e-01)*s36+7.023710e-01*s37+(-3.662704e-01)*s38+(-2.394902e+00)*s39 \
v67_part1=3.361750e+00*s0+1.843082e-01*s1+1.536697e+00*s2+1.543499e-01*s3+7.106436e-02*s4+5.438879e-01*s5+2.367449e-01*s6+3.229445e-01*s7+3.230475e+00*s8+1.722221e-01*s9 \
v67_part2=v67_part1+(-2.263987e+00)*s10+1.368619e+00*s11+2.257998e+00*s12+1.026653e-01*s13+7.239357e-01*s14+(-1.217158e-01)*s15+2.120575e+00*s16+3.320801e+00*s17+1.230208e+01*s18+(-2.323059e+00)*s19 \
v67_part3=v67_part2+1.072234e+00*s20+9.454994e-02*s21+1.495410e+00*s22+6.332429e-01*s23+(-1.630962e-01)*s24+(-3.176298e-01)*s25+1.643221e+00*s26+(-2.303392e+00)*s27+1.353380e+00*s28+6.734013e-01*s29 \
v67=v67_part3+7.780536e+00*s30+8.165687e+00*s31+(-1.486631e+00)*s32+1.738027e+00*s33+(-7.313081e+00)*s34+1.029852e+01*s35+8.558855e-02*s36+(-4.645462e-02)*s37+6.757821e-01*s38+(-7.433271e-01)*s39 \
v68_part1=(-3.390843e+00)*s0+(-3.012505e-01)*s1+(-3.179533e+00)*s2+(-4.338856e-01)*s3+(-4.654568e-01)*s4+(-7.127879e-01)*s5+(-4.764569e-01)*s6+(-5.078466e-01)*s7+(-3.916350e+00)*s8+(-3.049732e-01)*s9 \
v68_part2=v68_part1+1.466196e+00*s10+(-1.953893e+00)*s11+(-3.036446e+00)*s12+(-2.247240e-01)*s13+(-1.481865e+00)*s14+1.558933e-01*s15+(-2.887359e+00)*s16+(-3.157072e+00)*s17+(-1.141409e+01)*s18+1.941970e+00*s19 \
v68_part3=v68_part2+(-9.351071e-01)*s20+(-1.351430e-01)*s21+(-1.701826e+00)*s22+(-9.420156e-01)*s23+5.621395e-02*s24+2.590719e-01*s25+(-3.591114e+00)*s26+4.018379e+00*s27+(-1.827531e+00)*s28+(-1.330316e+00)*s29 \
v68=v68_part3+(-7.549396e+00)*s30+(-7.891485e+00)*s31+1.260084e+00*s32+(-2.952511e+00)*s33+1.133932e+01*s34+(-7.661329e+01)*s35+(-1.077954e-01)*s36+9.516310e-01*s37+(-9.385645e-01)*s38+1.534674e+00*s39 \
v69_part1=1.375845e-01*s0+6.640385e-02*s1+5.904025e-02*s2+6.077242e-02*s3+(-1.878618e-01)*s4+3.038576e-01*s5+7.807836e-02*s6+2.424996e-01*s7+2.970113e+00*s8+3.616598e-01*s9 \
v69_part2=v69_part1+4.118169e-01*s10+(-4.041057e-01)*s11+(-1.202317e-01)*s12+2.939936e-02*s13+(-5.987678e-01)*s14+6.912848e-01*s15+4.285648e-01*s16+(-1.782018e+00)*s17+9.452928e-01*s18+(-6.417999e-01)*s19 \
v69_part3=v69_part2+(-3.298039e-01)*s20+1.573704e-02*s21+2.212177e+00*s22+(-6.144487e-01)*s23+(-9.049719e-01)*s24+1.884366e-02*s25+6.112475e-02*s26+(-7.995814e+01)*s27+1.379365e-01*s28+1.912854e-02*s29 \
v69=v69_part3+8.183853e-01*s30+5.596383e-02*s31+(-1.848602e-01)*s32+5.824322e-01*s33+(-3.184876e-01)*s34+3.002317e+00*s35+1.906873e+00*s36+8.183080e-02*s37+(-1.515955e-01)*s38+6.616467e-01*s39 \
v70_part1=(-2.380820e-01)*s0+(-1.620644e-02)*s1+(-1.816233e+00)*s2+(-1.377831e-01)*s3+6.020508e-01*s4+(-6.682934e-01)*s5+(-2.679615e-01)*s6+4.428028e-02*s7+(-2.423447e+00)*s8+(-3.563158e-01)*s9 \
v70_part2=v70_part1+(-4.340917e-01)*s10+3.134777e-03*s11+2.627534e+00*s12+(-6.936804e-02)*s13+(-1.827699e-01)*s14+(-6.412163e-01)*s15+2.797279e+00*s16+1.738885e+00*s17+(-1.016932e+00)*s18+(-1.076189e-01)*s19 \
v70_part3=v70_part2+2.872282e-01*s20+2.669547e-03*s21+(-8.273352e-01)*s22+5.485237e-01*s23+4.573131e-01*s24+7.506815e-02*s25+3.477015e-01*s26+1.115126e+02*s27+4.241509e-02*s28+(-5.770879e-01)*s29 \
v70=v70_part3+(-8.502780e-01)*s30+1.018888e-01*s31+1.794869e-01*s32+(-4.660409e-01)*s33+2.438496e-01*s34+1.010569e+00*s35+(-1.772272e+00)*s36+1.222636e-01*s37+3.647559e-01*s38+(-6.418638e-02)*s39 \
v71_part1=1.027314e-01*s0+(-4.955818e-02)*s1+8.373562e-01*s2+7.281991e-02*s3+(-1.165543e-01)*s4+4.064956e-01*s5+6.662653e-02*s6+(-3.289745e-01)*s7+(-3.261481e-01)*s8+3.443229e-02*s9 \
v71_part2=v71_part1+(-3.062498e-02)*s10+4.675987e-01*s11+(-3.005786e+00)*s12+1.514605e-02*s13+7.988894e-01*s14+3.630605e-02*s15+(-2.015614e+00)*s16+(-1.093904e-01)*s17+2.807625e-01*s18+6.015999e-01*s19 \
v71_part3=v71_part2+1.652050e-02*s20+(-1.545160e-02)*s21+(-1.801509e+00)*s22+8.605799e-02*s23+1.802738e-01*s24+(-1.079470e-01)*s25+(-4.459280e+00)*s26+7.644849e+00*s27+(-2.437252e-01)*s28+3.838596e-01*s29 \
v71=v71_part3+8.426003e-02*s30+2.268113e-01*s31+(-1.123045e-02)*s32+(-3.600949e-01)*s33+2.269215e-01*s34+3.883610e+00*s35+1.958203e+00*s36+2.767119e-02*s37+(-1.091533e-01)*s38+3.073496e-01*s39 \
v72_part1=3.819474e+00*s0+3.368345e+00*s1+4.055216e+00*s2+3.653153e+00*s3+1.389023e+00*s4+9.221636e-01*s5+2.901952e+00*s6+6.432689e+00*s7+(-5.366353e+02)*s8+(-8.760996e-01)*s9 \
v72_part2=v72_part1+2.413919e+01*s10+1.205379e+00*s11+4.340392e+00*s12+(-1.000000e+04)*s13+4.148076e+00*s14+(-9.472235e+03)*s15+4.191839e-01*s16+1.282769e+00*s17+(-7.245018e-02)*s18+9.511022e+00*s19 \
v72_part3=v72_part2+(-2.300716e-01)*s20+(-2.931740e+02)*s21+2.817511e+00*s22+(-3.108307e+02)*s23+1.141496e+01*s24+(-3.616096e+02)*s25+1.123402e+00*s26+1.245701e+00*s27+6.163831e+00*s28+2.593697e+00*s29 \
v72=v72_part3+(-2.990126e+00)*s30+(-1.220404e+00)*s31+(-1.755242e+00)*s32+5.912019e+00*s33+1.914291e+00*s34+6.080607e-01*s35+4.429289e-01*s36+8.547557e+00*s37+4.125313e+00*s38+1.573269e+00*s39 \
v73_part1=(-3.831872e+00)*s0+(-3.322053e+00)*s1+(-5.330293e+00)*s2+(-3.472253e+00)*s3+(-4.954530e-01)*s4+(-1.333211e+00)*s5+(-2.749177e+00)*s6+(-7.850037e+00)*s7+(-1.965344e+03)*s8+2.799432e+00*s9 \
v73_part2=v73_part1+(-2.467334e+01)*s10+(-1.357460e+00)*s11+(-5.217233e+00)*s12+(-1.000000e+04)*s13+(-2.717617e+00)*s14+(-3.118478e+03)*s15+(-2.841071e-01)*s16+(-1.424282e+00)*s17+2.272923e+00*s18+(-9.586430e+00)*s19 \
v73_part3=v73_part2+6.179806e-01*s20+(-2.384738e+03)*s21+(-1.768821e+00)*s22+(-7.630748e+01)*s23+(-9.425682e+00)*s24+(-5.077409e+03)*s25+(-8.048130e-01)*s26+(-1.265755e+00)*s27+(-5.888730e+00)*s28+(-2.610058e+00)*s29 \
v73=v73_part3+1.466089e+00*s30+1.848810e+00*s31+3.887540e+00*s32+(-5.104327e+00)*s33+(-2.014656e+00)*s34+(-9.139836e-01)*s35+(-4.100425e-01)*s36+(-9.204619e+00)*s37+(-3.527680e+00)*s38+(-1.627603e+00)*s39 \
v74_part1=3.837828e-01*s0+(-2.526156e-01)*s1+(-1.434379e+00)*s2+(-1.964933e+00)*s3+(-4.891406e-01)*s4+3.280894e-01*s5+9.552596e-01*s6+1.619555e-01*s7+(-4.886704e+02)*s8+(-2.753927e+00)*s9 \
v74_part2=v74_part1+6.546350e+00*s10+4.532355e-01*s11+(-8.793854e-01)*s12+(-1.000000e+04)*s13+(-3.275401e+00)*s14+(-1.000000e+04)*s15+4.056843e+00*s16+(-1.351239e+00)*s17+2.759485e-01*s18+(-2.292555e+00)*s19 \
v74_part3=v74_part2+2.378121e+00*s20+(-1.282247e+03)*s21+(-1.902503e+00)*s22+(-2.162511e+03)*s23+6.638551e+00*s24+(-5.084966e+02)*s25+4.577750e-01*s26+2.392132e+00*s27+(-3.558299e+00)*s28+1.543386e+00*s29 \
v74=v74_part3+6.977557e+00*s30+1.017237e+00*s31+1.035571e-02*s32+(-1.554846e+00)*s33+(-1.785269e+00)*s34+1.111987e+00*s35+4.174525e+00*s36+7.425631e+00*s37+(-1.123488e+00)*s38+1.681080e+00*s39 \
v75_part1=6.500863e-02*s0+4.782730e-01*s1+2.798888e+00*s2+2.014019e+00*s3+(-1.712081e-01)*s4+2.462601e-01*s5+(-2.180937e+00)*s6+(-6.898597e-01)*s7+(-1.105368e+03)*s8+3.171014e+00*s9 \
v75_part2=v75_part1+(-6.279275e+00)*s10+1.649132e-01*s11+1.305494e+00*s12+(-1.000000e+04)*s13+2.674274e+00*s14+(-1.000000e+04)*s15+(-3.860914e+00)*s16+1.851690e+00*s17+(-1.730682e+00)*s18+3.535404e+00*s19 \
v75_part3=v75_part2+(-2.107526e+00)*s20+(-2.765179e+03)*s21+1.553677e+00*s22+(-5.669675e+03)*s23+(-2.288218e+01)*s24+(-2.525785e+02)*s25+(-6.171313e-01)*s26+(-3.025025e+00)*s27+4.090121e+00*s28+(-7.088379e-01)*s29 \
v75=v75_part3+(-6.309708e+00)*s30+(-1.183412e+00)*s31+(-5.658299e-01)*s32+1.259035e+00*s33+2.401263e+00*s34+(-9.887176e-01)*s35+(-4.885214e+00)*s36+(-1.008300e+01)*s37+1.811775e+00*s38+(-1.995381e+00)*s39 \
v76_part1=2.074619e-01*s0+(-1.093438e-01)*s1+(-9.356219e-01)*s2+(-6.274821e-01)*s3+1.058291e+00*s4+4.178431e-01*s5+(-2.114919e+00)*s6+(-2.005183e-01)*s7+(-4.940386e+02)*s8+(-5.644545e+00)*s9 \
v76_part2=v76_part1+1.332991e+00*s10+1.966175e+00*s11+1.233758e-01*s12+(-3.079338e+01)*s13+3.806667e-01*s14+(-2.632303e+00)*s15+(-5.109665e+00)*s16+4.228137e-03*s17+(-4.534234e-02)*s18+2.823838e+00*s19 \
v76_part3=v76_part2+1.117594e+00*s20+(-5.467026e+00)*s21+(-1.954554e+00)*s22+(-4.789264e+00)*s23+4.622820e+01*s24+(-5.198172e+00)*s25+(-3.235267e+00)*s26+4.164656e-01*s27+(-1.548629e+00)*s28+(-2.103615e+00)*s29 \
v76=v76_part3+7.255946e-01*s30+(-9.556245e-01)*s31+(-4.833006e-02)*s32+7.569772e-01*s33+6.260902e-02*s34+2.469205e+00*s35+(-9.747805e-02)*s36+(-8.136156e-01)*s37+(-1.172286e+00)*s38+(-2.461694e+00)*s39 \
v77_part1=(-1.412060e-01)*s0+2.180483e-01*s1+2.915113e+00*s2+7.872056e-01*s3+(-1.348672e+00)*s4+(-2.269944e-01)*s5+3.029987e+00*s6+5.080879e-01*s7+(-7.802815e+02)*s8+7.023876e+00*s9 \
v77_part2=v77_part1+(-1.604712e+00)*s10+(-9.923118e-01)*s11+(-2.603814e-01)*s12+(-4.863487e+01)*s13+1.017065e+00*s14+(-1.095553e-01)*s15+7.003454e+00*s16+(-4.243663e-02)*s17+2.496216e-01*s18+(-4.004533e-01)*s19 \
v77_part3=v77_part2+(-7.191388e-01)*s20+(-8.634586e+00)*s21+8.161138e-01*s22+(-1.993271e-01)*s23+(-6.840190e+01)*s24+(-8.209960e+00)*s25+2.440278e+00*s26+(-4.239010e-03)*s27+(-1.283433e+00)*s28+1.977318e+00*s29 \
v77=v77_part3+(-5.421944e-01)*s30+1.193794e+00*s31+5.394432e-02*s32+(-3.879525e-01)*s33+9.921035e-02*s34+(-1.718530e+00)*s35+1.487702e-01*s36+9.859729e-01*s37+(-1.602751e-01)*s38+5.603798e-01*s39 \
v78_part1=4.351232e-02*s0+(-6.691718e-02)*s1+(-1.232667e+00)*s2+(-6.902252e-02)*s3+(-1.110532e-01)*s4+(-2.553710e-01)*s5+(-1.498802e-01)*s6+(-3.052124e-01)*s7+(-2.645097e+02)*s8+1.502842e+00*s9 \
v78_part2=v78_part1+7.178418e-01*s10+(-1.278549e+00)*s11+(-1.108119e-01)*s12+(-1.648687e+01)*s13+(-1.407672e+00)*s14+(-1.058377e+00)*s15+(-2.262191e+00)*s16+1.550857e-02*s17+(-2.234856e-01)*s18+(-2.571256e+00)*s19 \
v78_part3=v78_part2+(-5.546071e-01)*s20+(-2.927062e+00)*s21+1.470418e+00*s22+(-1.925632e+00)*s23+(-5.540492e+00)*s24+(-2.783117e+00)*s25+7.807503e-01*s26+(-3.662297e-01)*s27+3.543389e+00*s28+7.797018e-01*s29 \
v78=v78_part3+(-4.138231e-01)*s30+(-2.245014e-02)*s31+(-3.286271e-02)*s32+(-5.492716e-01)*s33+(-9.047078e-02)*s34+(-1.543094e+00)*s35+(-2.403156e-01)*s36+4.633450e-02*s37+1.611491e+00*s38+1.369932e+00*s39 \
v79_part1=1.290771e+02*s0+1.795073e+02*s1+3.011996e+03*s2+(-7.710897e-01)*s3+3.591663e+03*s4+(-1.363593e+01)*s5+6.217609e+03*s6+3.730200e+03*s7+(-4.455779e+00)*s8+(-3.394274e+02)*s9 \
v79_part2=v79_part1+(-1.892787e+00)*s10+(-1.749622e+00)*s11+(-1.635893e+00)*s12+(-1.652760e+00)*s13+1.000000e+04*s14+(-1.350449e+00)*s15+(-1.439210e+00)*s16+(-1.646274e+01)*s17+1.830527e+03*s18+2.880392e+03*s19 \
v79_part3=v79_part2+1.854849e+03*s20+8.982636e-01*s21+8.887166e+03*s22+1.734327e+00*s23+4.404613e-01*s24+(-1.032412e+00)*s25+(-1.246766e+00)*s26+(-4.515752e-02)*s27+9.910700e+03*s28+1.000000e+04*s29 \
v79=v79_part3+9.446269e-01*s30+(-7.715827e-01)*s31+2.304449e+03*s32+1.899784e+03*s33+4.495367e+01*s34+6.344822e-02*s35+6.597390e-02*s36+7.755734e-01*s37+1.000000e+04*s38+(-1.346827e+00)*s39 \
v80_part1=1.165014e+01*s0+2.256046e+03*s1+1.000000e+04*s2+1.429260e+00*s3+1.000000e+04*s4+1.385305e+01*s5+9.982062e+03*s6+1.000000e+04*s7+5.239786e+00*s8+1.110319e+03*s9 \
v80_part2=v80_part1+4.422244e+00*s10+3.920473e-01*s11+2.311278e+00*s12+2.739216e+00*s13+1.000000e+04*s14+3.519551e+00*s15+4.903155e+00*s16+(-5.746411e+01)*s17+4.638221e+01*s18+6.093578e+03*s19 \
v80_part3=v80_part2+4.514171e+03*s20+(-8.948048e-01)*s21+1.000000e+04*s22+(-3.058988e+00)*s23+(-6.499984e-01)*s24+1.696079e+00*s25+2.386208e+00*s26+2.390281e+00*s27+1.000000e+04*s28+1.000000e+04*s29 \
v80=v80_part3+1.335274e+00*s30+1.330446e+00*s31+1.000000e+04*s32+1.000000e+04*s33+(-7.527646e+01)*s34+1.740118e+00*s35+1.720990e+00*s36+1.533726e+00*s37+1.000000e+04*s38+2.514369e+00*s39 \
v81_part1=1.669387e+01*s0+(-1.004169e+01)*s1+(-6.051786e+03)*s2+(-2.265447e+00)*s3+1.000000e+04*s4+2.169446e+01*s5+7.717242e+03*s6+(-1.000000e+04)*s7+4.056348e+00*s8+(-4.017273e+03)*s9 \
v81_part2=v81_part1+9.190098e-01*s10+(-9.191945e+00)*s11+3.123194e-01*s12+(-1.636457e-02)*s13+9.551411e+03*s14+2.439585e+00*s15+5.445572e+00*s16+3.356893e-01*s17+2.390618e+02*s18+(-3.699246e+03)*s19 \
v81_part3=v81_part2+4.412402e+01*s20+(-2.210423e+00)*s21+(-3.003646e+03)*s22+(-9.223469e+00)*s23+(-1.834196e+00)*s24+(-7.738152e-02)*s25+(-3.320221e-01)*s26+2.569626e+00*s27+9.995795e+03*s28+1.000000e+04*s29 \
v81=v81_part3+(-9.243795e-01)*s30+(-2.566674e-01)*s31+(-1.000000e+04)*s32+1.000000e+04*s33+(-1.110074e+02)*s34+(-1.884373e-01)*s35+9.995813e-01*s36+(-1.539767e+00)*s37+9.860835e+03*s38+3.706146e-02*s39 \
v82_part1=6.741251e+01*s0+2.476165e+03*s1+8.780160e+03*s2+4.752639e+00*s3+1.000000e+04*s4+(-2.194179e+01)*s5+9.999983e+03*s6+1.000000e+04*s7+(-4.696176e+00)*s8+6.364218e+03*s9 \
v82_part2=v82_part1+(-2.394041e+00)*s10+5.874356e-01*s11+(-4.056070e-01)*s12+(-1.858776e-01)*s13+(-9.611394e+03)*s14+(-3.182671e+00)*s15+(-4.507556e+00)*s16+(-5.465796e+00)*s17+6.231672e+01*s18+3.432472e+03*s19 \
v82_part3=v82_part2+4.526581e+02*s20+2.563650e+00*s21+9.999999e+03*s22+1.551104e+01*s23+2.756229e+00*s24+1.768742e-02*s25+1.811418e+00*s26+(-3.930566e+00)*s27+(-2.924206e+03)*s28+1.000000e+04*s29 \
v82=v82_part3+4.256757e-01*s30+7.715632e-01*s31+1.000000e+04*s32+5.750926e+03*s33+1.856735e+02*s34+2.778805e-01*s35+(-1.717493e+00)*s36+(-3.759717e+00)*s37+9.999939e+03*s38+5.222004e-01*s39 \
v83_part1=3.088414e+00*s0+8.063598e+00*s1+(-1.364675e+01)*s2+(-4.267752e-02)*s3+1.000000e+04*s4+(-1.981304e-01)*s5+(-6.643379e+01)*s6+1.004804e+00*s7+(-1.617501e+00)*s8+1.922933e+01*s9 \
v83_part2=v83_part1+4.414185e-01*s10+1.875534e+00*s11+1.182363e+00*s12+(-2.299031e-01)*s13+1.711727e-01*s14+2.173047e-01*s15+1.000000e+04*s16+(-4.883636e+00)*s17+7.893511e+00*s18+2.137488e+01*s19 \
v83_part3=v83_part2+7.335858e-01*s20+(-1.010580e+00)*s21+(-3.575940e+00)*s22+(-1.486332e+00)*s23+(-1.644364e+00)*s24+(-7.531587e-01)*s25+1.358584e+00*s26+2.605586e-01*s27+(-1.139377e+03)*s28+(-1.000000e+04)*s29 \
v83=v83_part3+(-9.024773e-02)*s30+6.186538e-02*s31+(-3.977347e+01)*s32+8.637183e+02*s33+2.097439e+00*s34+1.140497e+00*s35+4.417010e-01*s36+1.000098e+00*s37+6.908075e+01*s38+(-3.955425e-01)*s39 \
v84_part1=1.533150e+00*s0+1.356369e+01*s1+9.628171e+01*s2+3.209217e-01*s3+2.082823e+03*s4+7.377622e-01*s5+2.248623e+00*s6+1.371333e+02*s7+2.005264e+00*s8+3.541983e+02*s9 \
v84_part2=v84_part1+(-3.091705e-01)*s10+(-1.428227e+00)*s11+(-2.110653e+00)*s12+4.096428e-01*s13+2.492149e+00*s14+(-2.383889e-01)*s15+8.833093e+03*s16+(-1.355434e+01)*s17+1.327759e+01*s18+1.009876e+02*s19 \
v84_part3=v84_part2+1.033437e+00*s20+1.390178e+00*s21+(-5.783157e-01)*s22+2.493107e+00*s23+2.153630e+00*s24+1.749769e+00*s25+(-4.494308e+00)*s26+(-1.435802e+00)*s27+8.668143e-01*s28+1.000000e+04*s29 \
v84=v84_part3+(-1.455070e-01)*s30+6.851136e-01*s31+4.127824e+00*s32+1.089502e+03*s33+(-3.327901e+00)*s34+(-1.427243e+00)*s35+(-3.988844e-01)*s36+1.202306e-02*s37+1.516450e+02*s38+7.121517e-01*s39 \
v85_part1=4.624168e+00*s0+2.354789e+01*s1+(-2.111993e+02)*s2+(-3.951949e-02)*s3+1.000000e+04*s4+(-4.291981e-01)*s5+(-1.093289e+01)*s6+(-4.201853e+00)*s7+2.189692e-01*s8+(-1.377924e+02)*s9 \
v85_part2=v85_part1+(-1.631249e-01)*s10+3.066800e+00*s11+2.021714e-01*s12+(-1.055435e-01)*s13+(-1.421159e+03)*s14+(-2.454182e-02)*s15+1.000000e+04*s16+(-1.252986e+01)*s17+2.305120e+01*s18+8.542713e+01*s19 \
v85_part3=v85_part2+2.267789e+00*s20+(-2.028373e-01)*s21+(-1.882712e+01)*s22+(-1.111170e-01)*s23+3.976784e-01*s24+(-4.185223e-01)*s25+(-5.633319e-01)*s26+(-4.508063e-01)*s27+(-3.103110e+02)*s28+(-1.000000e+04)*s29 \
v85=v85_part3+2.535580e-01*s30+1.731585e-02*s31+(-1.161493e+02)*s32+5.270838e+02*s33+(-1.606042e-01)*s34+4.922957e-02*s35+9.576570e-02*s36+2.697447e+00*s37+3.593800e+02*s38+(-3.954128e-01)*s39 \
v86_part1=1.328683e+02*s0+1.782167e+01*s1+2.231572e+01*s2+5.609568e+00*s3+2.094955e+01*s4+2.714712e+01*s5+2.018080e+01*s6+2.345131e+01*s7+9.594713e+02*s8+4.372436e+01*s9 \
v86_part2=v86_part1+2.130103e+01*s10+7.108369e+00*s11+(-2.014487e+03)*s12+(-1.363956e+01)*s13+1.972465e+01*s14+(-8.066381e+00)*s15+9.881604e+01*s16+8.116620e+02*s17+(-5.296472e+00)*s18+7.118168e+01*s19 \
v86_part3=v86_part2+2.356038e+01*s20+1.442513e+02*s21+1.973728e+01*s22+2.339131e+02*s23+(-3.042592e+01)*s24+6.826180e+03*s25+(-2.189850e+00)*s26+4.886996e+03*s27+1.807521e+01*s28+2.123270e+01*s29 \
v86=v86_part3+7.425018e-01*s30+2.112978e+01*s31+3.100856e+01*s32+1.924274e+01*s33+3.364174e+02*s34+1.089873e+00*s35+7.831594e-01*s36+8.205429e+00*s37+1.984752e+01*s38+5.777472e+01*s39 \
v87_part1=(-3.601443e+02)*s0+(-6.770186e+00)*s1+(-1.144005e+01)*s2+(-2.169772e+01)*s3+(-7.008983e+00)*s4+4.048635e+01*s5+(-8.733059e+00)*s6+(-1.043348e+01)*s7+2.779188e+03*s8+1.530103e+00*s9 \
v87_part2=v87_part1+(-1.357553e+01)*s10+6.538689e+00*s11+(-3.996940e+03)*s12+2.642567e+01*s13+(-9.715973e+00)*s14+1.416665e+01*s15+(-1.626028e+01)*s16+1.034837e+03*s17+4.507227e+01*s18+(-5.587090e+01)*s19 \
v87_part3=v87_part2+(-1.248896e+01)*s20+3.344589e+03*s21+(-9.419747e+00)*s22+2.149604e+00*s23+(-2.659556e+01)*s24+1.000000e+04*s25+1.018819e+01*s26+1.000000e+04*s27+(-7.580822e+00)*s28+(-1.098882e+01)*s29 \
v87=v87_part3+1.831289e+00*s30+(-1.310359e+01)*s31+(-1.809332e+01)*s32+(-8.709256e+00)*s33+4.269714e+01*s34+1.844284e+00*s35+5.358174e-01*s36+6.178991e+00*s37+(-9.785915e+00)*s38+(-6.482693e+01)*s39 \
v88_part1=4.004835e+02*s0+2.903998e+00*s1+(-1.931597e+00)*s2+(-2.198239e+01)*s3+4.457873e+00*s4+2.881190e+02*s5+1.868686e+00*s6+(-9.727686e-01)*s7+8.424067e+02*s8+4.987359e+01*s9 \
v88_part2=v88_part1+(-4.262382e+00)*s10+1.798831e+00*s11+(-9.716947e+02)*s12+(-2.992031e+02)*s13+9.722683e-01*s14+3.057520e+00*s15+9.042449e+01*s16+7.583363e+02*s17+1.669834e+02*s18+(-3.951317e+01)*s19 \
v88_part3=v88_part2+(-2.989460e+00)*s20+1.873329e+01*s21+1.225734e+00*s22+(-8.345775e+01)*s23+7.699658e+01*s24+1.000000e+04*s25+8.609468e+00*s26+(-8.166902e+01)*s27+2.593075e+00*s28+(-1.452301e+00)*s29 \
v88=v88_part3+(-4.366223e+00)*s30+1.494135e+01*s31+(-3.355877e+00)*s32+6.441130e-01*s33+2.406165e+01*s34+4.443310e-01*s35+(-7.695680e+00)*s36+4.219634e+01*s37+(-3.193742e-01)*s38+8.916824e-01*s39 \
v89_part1=1.237524e+03*s0+(-2.786975e+00)*s1+1.977930e+00*s2+8.317910e+01*s3+(-6.100939e+00)*s4+1.419904e+00*s5+(-1.793945e+00)*s6+3.498268e-01*s7+2.666466e+01*s8+(-5.821886e+01)*s9 \
v89_part2=v89_part1+2.199838e+00*s10+3.533073e+01*s11+(-7.070613e+03)*s12+3.254989e+02*s13+(-7.352575e-01)*s14+(-4.634805e+00)*s15+1.705112e+01*s16+1.324002e+02*s17+(-1.466340e+02)*s18+4.589006e+01*s19 \
v89_part3=v89_part2+2.220322e+00*s20+9.674669e+00*s21+(-1.084668e+00)*s22+2.202472e+02*s23+6.298775e+01*s24+1.000000e+04*s25+8.460039e-01*s26+8.423216e+03*s27+(-3.084178e+00)*s28+1.320976e+00*s29 \
v89=v89_part3+4.269798e+00*s30+(-2.711440e+01)*s31+3.207496e+00*s32+(-4.633900e-01)*s33+(-1.851914e+02)*s34+(-1.816011e+00)*s35+1.108662e+01*s36+1.754916e+01*s37+2.857072e-01*s38+(-1.627500e+00)*s39 \
v90_part1=(-4.253328e+00)*s0+9.294498e-01*s1+(-8.855454e-01)*s2+(-1.283444e+01)*s3+(-8.834561e+00)*s4+(-2.660341e+00)*s5+2.815697e-01*s6+(-7.289179e-02)*s7+1.714772e+02*s8+(-4.770659e+01)*s9 \
v90_part2=v90_part1+(-1.266196e+01)*s10+(-4.103983e+00)*s11+(-3.408282e+01)*s12+1.372226e+01*s13+(-3.622294e-01)*s14+(-4.270703e-01)*s15+2.870072e+02*s16+1.571645e+01*s17+(-8.283286e+00)*s18+5.573208e+00*s19 \
v90_part3=v90_part2+7.447684e-02*s20+1.274285e+01*s21+1.095397e+00*s22+(-1.845847e+00)*s23+2.948109e+02*s24+1.215241e+01*s25+(-2.512286e+01)*s26+8.063038e+03*s27+4.099165e-01*s28+3.928998e-01*s29 \
v90=v90_part3+2.551535e-01*s30+(-9.453443e-01)*s31+1.774859e+00*s32+5.334721e-01*s33+1.325570e+02*s34+1.295631e+00*s35+(-2.315349e+00)*s36+2.533044e-01*s37+4.478560e-01*s38+2.272494e+00*s39 \
v91_part1=(-5.526050e+00)*s0+(-8.028596e-01)*s1+9.708357e-01*s2+3.681968e+01*s3+6.155016e+00*s4+(-1.896579e+00)*s5+1.782283e-01*s6+(-2.658221e-01)*s7+1.454499e+03*s8+(-5.980926e+00)*s9 \
v91_part2=v91_part1+(-1.727009e+01)*s10+(-5.800822e+00)*s11+(-4.817476e+01)*s12+1.871626e+01*s13+1.245484e-01*s14+1.061541e+00*s15+(-2.722108e+02)*s16+2.221460e+01*s17+(-1.446316e+01)*s18+6.305133e+00*s19 \
v91_part3=v91_part2+(-8.038767e-02)*s20+1.738040e+01*s21+(-5.258511e-01)*s22+(-1.531380e+00)*s23+4.021027e+02*s24+1.657508e+01*s25+8.787486e-01*s26+9.605011e+03*s27+4.527162e-01*s28+(-2.500347e-01)*s29 \
v91=v91_part3+(-1.008554e+00)*s30+(-6.977973e-03)*s31+3.254692e-02*s32+(-2.899965e-01)*s33+(-1.019961e+02)*s34+(-3.849992e+00)*s35+4.035712e+00*s36+5.798431e+00*s37+2.967356e-01*s38+(-4.508800e+00)*s39 \
v92_part1=(-4.345082e+00)*s0+(-2.406067e-01)*s1+(-1.893549e-01)*s2+(-1.581486e+01)*s3+4.445205e+00*s4+(-1.385072e+00)*s5+(-3.326328e-01)*s6+3.698002e-01*s7+1.911250e+03*s8+5.592153e+01*s9 \
v92_part2=v92_part1+(-2.269333e+01)*s10+(-8.172567e-01)*s11+(-6.787167e+00)*s12+(-1.612554e+01)*s13+2.266077e-01*s14+(-2.682703e-01)*s15+(-3.445546e+02)*s16+3.129733e+00*s17+1.647932e+00*s18+(-1.227145e+01)*s19 \
v92_part3=v92_part2+(-4.490960e-01)*s20+2.283830e+01*s21+(-7.517488e-01)*s22+(-3.132778e+00)*s23+5.283733e+02*s24+2.178008e+01*s25+(-2.787625e+01)*s26+2.205207e+03*s27+(-1.058009e+00)*s28+(-3.846779e-01)*s29 \
v92=v92_part3+6.833261e-01*s30+1.472019e+00*s31+(-1.608545e+00)*s32+(-3.189965e-01)*s33+(-6.813498e+01)*s34+1.337804e+00*s35+(-3.745861e-01)*s36+5.316377e+00*s37+(-8.208021e-01)*s38+1.023558e+00*s39 \
v93_part1=2.113813e+00*s0+(-7.228828e+00)*s1+(-2.154843e+00)*s2+(-1.015122e+02)*s3+2.990774e+00*s4+(-1.364544e+03)*s5+(-2.966799e-02)*s6+1.590255e+01*s7+4.296654e+02*s8+1.820049e+01*s9 \
v93_part2=v93_part1+8.588432e+02*s10+2.793232e+03*s11+1.000000e+04*s12+6.044374e+01*s13+(-7.702661e+00)*s14+7.463571e+01*s15+8.165488e-01*s16+(-8.646075e+02)*s17+4.044183e+00*s18+(-1.180958e+03)*s19 \
v93_part3=v93_part2+4.039842e-01*s20+3.407445e+03*s21+7.476983e+00*s22+(-1.598586e+01)*s23+7.056369e+02*s24+1.014116e+02*s25+5.375141e+01*s26+1.841010e+01*s27+(-1.854195e+00)*s28+5.681703e+00*s29 \
v93=v93_part3+(-9.601408e+01)*s30+(-8.967847e+00)*s31+1.809738e+00*s32+6.017558e+00*s33+(-4.400423e+01)*s34+1.892224e+01*s35+1.261599e+02*s36+1.156334e+02*s37+1.955283e+01*s38+1.160262e+01*s39 \
v94_part1=9.247105e+00*s0+2.143458e+01*s1+1.022000e+01*s2+2.072364e+02*s3+7.420853e+00*s4+(-2.090005e+02)*s5+8.439684e+00*s6+(-2.463088e+01)*s7+2.126170e+03*s8+(-6.155200e+00)*s9 \
v94_part2=v94_part1+6.193169e+02*s10+1.285314e+03*s11+1.000000e+04*s12+(-1.922415e+01)*s13+2.558075e+01*s14+1.959642e+01*s15+(-2.842745e+01)*s16+(-7.521577e+02)*s17+2.142142e+01*s18+1.462043e+01*s19 \
v94_part3=v94_part2+1.280735e+00*s20+(-3.406593e+03)*s21+1.644453e+01*s22+2.384405e+01*s23+5.497306e+01*s24+3.166785e+01*s25+1.590347e+01*s26+(-2.778498e+02)*s27+6.516992e+00*s28+(-3.507181e+00)*s29 \
v94=v94_part3+3.330388e+02*s30+8.571073e+01*s31+(-2.093667e+00)*s32+8.093472e+00*s33+7.578976e+01*s34+3.773771e+01*s35+(-3.624243e+01)*s36+1.951428e+01*s37+(-2.321659e+01)*s38+7.076213e+00*s39 \
v95_part1=4.696152e+00*s0+7.713482e+00*s1+(-2.387372e+00)*s2+7.022586e+01*s3+(-7.519945e+00)*s4+(-1.469713e+01)*s5+1.066286e+00*s6+2.646018e+01*s7+9.516905e+00*s8+(-3.681798e+00)*s9 \
v95_part2=v95_part1+5.602469e+02*s10+2.815428e+03*s11+1.000000e+04*s12+4.462352e+01*s13+(-2.088779e+01)*s14+(-6.296253e+01)*s15+2.708180e+01*s16+(-1.616962e+03)*s17+(-2.643201e-01)*s18+2.732746e+01*s19 \
v95_part3=v95_part2+4.722157e+00*s20+4.656203e+01*s21+(-4.731177e+01)*s22+(-1.577100e+00)*s23+3.890964e+02*s24+1.581482e+01*s25+8.199827e+00*s26+1.855639e+01*s27+1.262130e+01*s28+8.422577e+00*s29 \
v95=v95_part3+(-5.660968e+00)*s30+(-4.989153e+01)*s31+3.973619e+00*s32+(-9.351705e+00)*s33+3.371961e+00*s34+(-2.283047e+02)*s35+1.107257e+02*s36+9.440575e+01*s37+(-2.274294e+01)*s38+3.104262e+00*s39 \
v96_part1=2.174716e-01*s0+(-1.129464e+01)*s1+4.852046e+00*s2+(-1.398954e+02)*s3+1.557074e+01*s4+(-1.671173e+00)*s5+(-9.445434e+00)*s6+(-4.416056e+01)*s7+1.882957e+03*s8+3.263351e+00*s9 \
v96_part2=v96_part1+1.006009e+02*s10+7.804990e+03*s11+1.000000e+04*s12+(-7.502659e+01)*s13+2.491155e+01*s14+1.159115e-01*s15+(-7.889476e+01)*s16+6.706821e+03*s17+(-3.666398e-01)*s18+8.193362e+00*s19 \
v96_part3=v96_part2+(-3.624473e+00)*s20+(-4.727707e+01)*s21+4.950461e+01*s22+3.798595e+00*s23+6.426510e+01*s24+2.362945e+01*s25+2.720118e+00*s26+1.079287e+03*s27+(-1.784121e+01)*s28+(-1.030726e+01)*s29 \
v96=v96_part3+(-1.838149e+02)*s30+8.128704e+01*s31+(-4.651375e+00)*s32+(-2.778127e+00)*s33+(-8.026515e+00)*s34+2.578315e+02*s35+(-1.853500e+02)*s36+1.686405e+01*s37+9.553215e+00*s38+(-4.643310e+00)*s39 \
v97_part1=(-3.009808e-02)*s0+(-3.508595e+00)*s1+(-1.592044e+00)*s2+7.337642e+00*s3+(-5.625089e+00)*s4+(-4.924667e+00)*s5+(-6.137859e+00)*s6+9.806171e-01*s7+(-7.981259e+02)*s8+3.126726e+00*s9 \
v97_part2=v97_part1+(-9.098342e+00)*s10+(-2.343668e-01)*s11+8.122518e+00*s12+6.677881e+00*s13+(-4.124781e+00)*s14+(-9.751046e-01)*s15+1.041357e+03*s16+(-3.489953e+00)*s17+6.338091e-02*s18+1.617135e+02*s19 \
v97_part3=v97_part2+(-1.494913e+00)*s20+2.017912e+00*s21+2.878054e+00*s22+(-1.942171e-01)*s23+(-2.174733e+02)*s24+(-9.058896e+00)*s25+4.629482e-01*s26+(-5.992836e+01)*s27+(-7.083426e+00)*s28+(-1.515418e+01)*s29 \
v97=v97_part3+(-6.176003e+00)*s30+(-1.519359e+00)*s31+2.483544e-01*s32+(-2.615228e+01)*s33+2.208870e+00*s34+8.201796e-01*s35+(-2.610281e-01)*s36+3.589555e+00*s37+6.577992e+02*s38+(-9.011280e-01)*s39 \
v98_part1=1.727757e+00*s0+(-5.532197e-01)*s1+4.363214e+00*s2+(-2.661794e+00)*s3+(-8.466968e+00)*s4+(-5.728470e+00)*s5+(-2.428340e+00)*s6+(-4.336375e+00)*s7+(-4.629644e+01)*s8+(-7.875654e+00)*s9 \
v98_part2=v98_part1+(-5.277624e-01)*s10+(-1.504012e+00)*s11+5.212498e+01*s12+1.298021e-01*s13+5.828070e+00*s14+1.381541e+00*s15+(-1.635247e+03)*s16+(-2.239623e+01)*s17+3.605007e-01*s18+9.380428e+00*s19 \
v98_part3=v98_part2+(-5.388674e-01)*s20+(-9.967773e-02)*s21+(-7.290365e-01)*s22+2.175024e+00*s23+(-1.261485e+01)*s24+(-5.254743e-01)*s25+2.752095e-01*s26+(-3.936591e+02)*s27+(-1.025144e+00)*s28+1.942410e+01*s29 \
v98=v98_part3+(-3.582480e-01)*s30+(-5.980305e+00)*s31+(-4.216458e-01)*s32+(-4.528185e+00)*s33+(-3.419167e+00)*s34+5.263374e+00*s35+(-3.239061e+00)*s36+1.885990e+00*s37+(-1.125774e+03)*s38+3.236666e+00*s39 \
v99_part1=(-1.749199e+00)*s0+5.895356e+00*s1+(-6.352747e-01)*s2+(-4.764598e+00)*s3+1.114930e+01*s4+(-3.801632e+00)*s5+9.048240e+00*s6+2.090071e+00*s7+(-1.248247e+03)*s8+1.693564e+00*s9 \
v99_part2=v99_part1+(-1.422956e+01)*s10+5.002090e+00*s11+4.756454e+01*s12+(-1.386261e+01)*s13+(-2.014740e+00)*s14+(-2.971039e+00)*s15+6.018376e+01*s16+(-2.043677e+01)*s17+(-4.375757e-01)*s18+2.529156e+02*s19 \
v99_part3=v99_part2+(-3.617369e+00)*s20+(-2.817308e+00)*s21+(-2.576696e+00)*s22+(-1.214425e+00)*s23+(-3.401223e+02)*s24+(-1.416787e+01)*s25+7.420213e+00*s26+(-4.917622e+02)*s27+1.340900e+01*s28+(-1.797125e+00)*s29 \
v99=v99_part3+9.575007e+00*s30+(-1.599813e+00)*s31+1.097895e-01*s32+3.069975e+01*s33+(-4.122418e-01)*s34+4.802878e+00*s35+(-1.415954e+00)*s36+5.956232e-01*s37+5.652932e+01*s38+(-8.879864e+00)*s39 \
v100_part1=5.723314e+02*s0+3.999553e-01*s1+(-1.004733e+00)*s2+5.386842e+03*s3+2.961758e+00*s4+3.858075e+01*s5+4.606522e-02*s6+(-3.749687e-02)*s7+1.000000e+04*s8+1.000000e+04*s9 \
v100_part2=v100_part1+2.052721e+03*s10+3.785106e+02*s11+2.528963e+01*s12+5.348637e+03*s13+5.888526e-01*s14+2.307170e+03*s15+6.537483e+00*s16+2.905636e+03*s17+2.007941e+03*s18+2.963321e+03*s19 \
v100_part3=v100_part2+4.753288e-01*s20+3.112246e+03*s21+(-1.002505e+00)*s22+1.000000e+04*s23+6.652971e+03*s24+3.799180e+03*s25+1.132558e+02*s26+(-2.734836e+03)*s27+(-3.843224e-01)*s28+(-1.685677e-01)*s29 \
v100=v100_part3+1.000000e+04*s30+(-1.497322e+02)*s31+1.000000e+04*s32+6.744073e-02*s33+1.000000e+04*s34+2.050530e+03*s35+6.207531e+03*s36+1.663393e+02*s37+(-2.430766e-01)*s38+9.997495e+03*s39 \
v101_part1=4.555675e+03*s0+(-1.644425e-02)*s1+2.914907e+00*s2+1.000000e+04*s3+(-4.514375e+00)*s4+2.394155e+01*s5+9.080577e-01*s6+2.145450e+00*s7+1.000000e+04*s8+1.000000e+04*s9 \
v101_part2=v101_part1+6.367310e+02*s10+4.401311e+02*s11+8.510728e+03*s12+1.000000e+04*s13+(-2.505875e-01)*s14+1.000000e+04*s15+2.947115e+02*s16+1.000000e+04*s17+2.036937e+03*s18+1.000000e+04*s19 \
v101_part3=v101_part2+2.259020e+00*s20+1.000000e+04*s21+(-7.384923e-02)*s22+1.000000e+04*s23+1.000000e+04*s24+1.000000e+04*s25+3.791964e+02*s26+1.000000e+04*s27+2.168768e+00*s28+1.989006e+00*s29 \
v101=v101_part3+1.000000e+04*s30+5.181593e+03*s31+1.000000e+04*s32+4.228171e-01*s33+1.000000e+04*s34+1.000000e+04*s35+7.933332e+03*s36+4.291081e+02*s37+2.211064e+00*s38+9.999999e+03*s39 \
v102_part1=5.158002e+02*s0+(-9.763339e-01)*s1+1.339305e+00*s2+1.000000e+04*s3+(-4.958633e+00)*s4+5.163295e+01*s5+(-4.183187e-01)*s6+(-8.016231e-02)*s7+1.000000e+04*s8+1.000000e+04*s9 \
v102_part2=v102_part1+(-1.839686e+03)*s10+3.993589e+01*s11+1.366617e+02*s12+(-1.000000e+04)*s13+2.660131e+00*s14+5.942137e+02*s15+5.359566e+00*s16+(-1.000000e+04)*s17+6.168078e+01*s18+2.243930e+03*s19 \
v102_part3=v102_part2+3.312453e-02*s20+5.403345e+03*s21+2.787332e+00*s22+1.000000e+04*s23+6.328598e+03*s24+1.867082e+03*s25+3.563865e+02*s26+(-4.128378e+02)*s27+(-2.182692e-01)*s28+(-9.767333e-01)*s29 \
v102=v102_part3+2.402373e+03*s30+1.136843e+02*s31+1.000000e+04*s32+3.943096e-01*s33+1.000000e+04*s34+2.826067e+02*s35+4.609523e+03*s36+2.545746e+02*s37+2.243123e-01*s38+9.385669e+03*s39 \
v103_part1=(-2.160172e+02)*s0+2.043115e+00*s1+(-1.839235e+00)*s2+1.000000e+04*s3+8.467598e+00*s4+5.718005e+02*s5+1.902360e+00*s6+(-2.880636e-02)*s7+1.000000e+04*s8+1.000000e+04*s9 \
v103_part2=v103_part1+(-8.805645e+02)*s10+1.210710e+02*s11+3.590007e+02*s12+1.000000e+04*s13+(-3.201847e+00)*s14+1.000000e+04*s15+1.543466e+02*s16+1.000000e+04*s17+4.559841e+02*s18+3.042129e+03*s19 \
v103_part3=v103_part2+(-8.947947e-01)*s20+1.000000e+04*s21+6.261581e-01*s22+1.000000e+04*s23+1.000000e+04*s24+1.000000e+04*s25+5.176516e+02*s26+7.961223e+03*s27+2.972295e-01*s28+1.029212e+00*s29 \
v103=v103_part3+2.954192e+02*s30+4.111721e+02*s31+1.000000e+04*s32+6.916719e-01*s33+1.000000e+04*s34+8.263655e+03*s35+4.515916e+03*s36+2.263817e+03*s37+(-1.541311e-01)*s38+9.999963e+03*s39 \
v104_part1=5.222451e-01*s0+4.627350e-01*s1+2.049348e-01*s2+9.099577e+01*s3+4.868215e-01*s4+1.626382e+00*s5+4.817508e-01*s6+(-1.843526e-01)*s7+9.153705e+01*s8+1.482121e+02*s9 \
v104_part2=v104_part1+9.754021e-01*s10+6.942967e+00*s11+4.833908e+01*s12+5.854771e+00*s13+6.839373e-01*s14+3.854541e+00*s15+1.000000e+04*s16+1.519596e+01*s17+1.148352e+00*s18+3.573614e+01*s19 \
v104_part3=v104_part2+1.043454e+00*s20+1.168822e+00*s21+3.343496e-01*s22+5.605253e+00*s23+2.534816e+01*s24+7.528522e-01*s25+8.638195e+00*s26+1.279685e+03*s27+4.419544e-01*s28+1.368986e+00*s29 \
v104=v104_part3+1.173701e+00*s30+6.034548e+00*s31+5.691989e+00*s32+1.594960e+00*s33+5.831830e+01*s34+9.014415e+00*s35+9.723669e+00*s36+7.169485e+00*s37+2.418766e-01*s38+(-2.240940e+01)*s39 \
v105_part1=4.152453e+00*s0+(-1.881246e-01)*s1+(-4.780999e-01)*s2+5.059217e+01*s3+1.550150e+00*s4+5.709406e+00*s5+9.266245e-01*s6+1.502654e-01*s7+3.116045e+01*s8+5.045339e+01*s9 \
v105_part2=v105_part1+3.320400e-01*s10+3.967623e+00*s11+2.762382e+01*s12+1.993043e+00*s13+(-5.816241e-01)*s14+1.944348e+00*s15+1.000000e+04*s16+1.312083e+01*s17+3.909144e-01*s18+1.216506e+01*s19 \
v105_part3=v105_part2+(-6.963524e-01)*s20+3.978829e-01*s21+(-1.200249e+00)*s22+2.827461e+00*s23+8.628855e+00*s24+3.811966e-01*s25+2.940558e+00*s26+5.873039e+03*s27+1.598749e-01*s28+(-1.566882e+00)*s29 \
v105=v105_part3+3.995436e-01*s30+4.357139e+00*s31+1.937630e+00*s32+7.574261e-01*s33+1.985234e+01*s34+5.151371e+00*s35+5.556681e+00*s36+6.418887e+00*s37+(-3.830866e-02)*s38+(-1.872794e+00)*s39 \
v106_part1=3.696050e+00*s0+(-4.861561e-01)*s1+3.149175e-02*s2+7.573514e+01*s3+(-1.432383e+00)*s4+4.357557e-01*s5+(-1.347096e+00)*s6+8.683939e-02*s7+1.585152e+03*s8+2.566597e+03*s9 \
v106_part2=v106_part1+(-1.322402e+00)*s10+6.038154e+00*s11+3.098151e+01*s12+1.900033e+01*s13+(-1.433852e-01)*s14+7.563721e+00*s15+1.000000e+04*s16+(-1.660745e+01)*s17+1.988607e+01*s18+5.757863e+02*s19 \
v106_part3=v106_part2+(-1.592225e-01)*s20+2.024057e+01*s21+4.347313e-01*s22+1.099912e+01*s23+4.389555e+02*s24+1.303719e+01*s25+1.495881e+02*s26+(-8.740151e+03)*s27+(-9.924086e-01)*s28+(-1.143458e-01)*s29 \
v106=v106_part3+2.032505e+01*s30+7.507540e+00*s31+9.856851e+01*s32+(-2.180764e+00)*s33+1.009901e+03*s34+7.839650e+00*s35+8.456473e+00*s36+6.497111e+00*s37+(-3.065492e-01)*s38+(-1.948899e+01)*s39 \
v107_part1=2.347285e+01*s0+(-5.182752e+01)*s1+(-3.146009e+01)*s2+2.362154e+01*s3+(-5.590172e+02)*s4+1.488404e+01*s5+(-1.776237e+01)*s6+6.080432e+00*s7+2.057716e+01*s8+3.525171e+01*s9 \
v107_part2=v107_part1+5.268471e+00*s10+2.119061e+01*s11+1.903663e+01*s12+2.057606e+01*s13+(-1.097607e+02)*s14+2.011233e+01*s15+2.658078e+01*s16+2.166028e+01*s17+3.744024e+01*s18+2.895994e+01*s19 \
v107_part3=v107_part2+5.253720e+00*s20+2.230458e+01*s21+1.360966e+01*s22+1.109710e+01*s23+2.143538e+01*s24+2.177371e+01*s25+1.884190e+01*s26+2.264758e+01*s27+1.571932e-01*s28+(-3.674295e+01)*s29 \
v107=v107_part3+3.589477e+01*s30+2.068208e+01*s31+7.627039e+01*s32+(-6.013810e+00)*s33+2.246547e+01*s34+1.753658e+01*s35+1.888143e+01*s36+1.727844e+01*s37+(-2.797440e+00)*s38+1.999678e+01*s39 \
v108_part1=(-1.265653e+01)*s0+7.454269e+01*s1+6.589852e+01*s2+(-1.093245e+01)*s3+6.911385e+02*s4+5.153834e+00*s5+2.575838e+01*s6+(-4.910920e+00)*s7+(-8.452606e+00)*s8+(-2.189507e+01)*s9 \
v108_part2=v108_part1+(-2.007508e+01)*s10+(-9.432000e+00)*s11+(-8.193691e+00)*s12+(-1.023937e+01)*s13+1.842584e+02*s14+(-9.080603e+00)*s15+(-1.416517e+01)*s16+(-1.107885e+01)*s17+(-2.028040e+01)*s18+(-1.113155e+00)*s19 \
v108_part3=v108_part2+(-3.414426e+00)*s20+(-1.215090e+01)*s21+1.775962e+03*s22+1.487287e+00*s23+(-1.135372e+01)*s24+(-1.141361e+01)*s25+(-7.264158e+00)*s26+(-1.204278e+01)*s27+3.109961e+00*s28+5.584167e+01*s29 \
v108=v108_part3+(-2.605485e+01)*s30+(-9.992228e+00)*s31+(-2.602919e+01)*s32+7.440240e+00*s33+(-1.059264e+01)*s34+(-6.580966e+00)*s35+(-8.182230e+00)*s36+(-4.501054e+00)*s37+8.134299e+00*s38+(-9.517217e+00)*s39 \
v109_part1=(-2.031827e+00)*s0+3.990376e+01*s1+(-1.629758e+01)*s2+1.171028e-01*s3+1.796436e+02*s4+7.045154e+00*s5+3.422786e-01*s6+(-4.783489e+00)*s7+3.667092e+00*s8+(-7.031915e+00)*s9 \
v109_part2=v109_part1+4.737776e+01*s10+2.618613e+00*s11+1.266447e+00*s12+(-4.214248e-01)*s13+3.189080e+01*s14+1.831494e+00*s15+(-2.019832e+00)*s16+(-4.630152e-01)*s17+(-6.515876e+00)*s18+2.017651e+01*s19 \
v109_part3=v109_part2+(-4.177486e+00)*s20+(-1.706378e+00)*s21+(-4.585162e+02)*s22+1.981129e+01*s23+(-1.028329e+00)*s24+(-8.035906e-01)*s25+3.444239e+00*s26+(-1.910565e+00)*s27+(-7.052982e+00)*s28+2.861522e+01*s29 \
v109=v109_part3+(-1.785815e+01)*s30+1.713328e+00*s31+3.253567e+01*s32+(-7.634006e+00)*s33+1.670023e+00*s34+3.046028e+00*s35+1.748057e+00*s36+7.224569e+00*s37+(-8.797165e+00)*s38+1.607610e+00*s39 \
v110_part1=1.692316e+00*s0+(-3.885249e+01)*s1+1.449933e+01*s2+(-1.172187e-01)*s3+5.662078e+00*s4+(-1.306659e+01)*s5+8.423198e+00*s6+5.560820e+00*s7+(-3.307276e+00)*s8+8.687424e+00*s9 \
v110_part2=v110_part1+(-2.145615e+00)*s10+(-3.811402e+00)*s11+(-1.744402e+00)*s12+6.025182e-01*s13+(-5.299642e+01)*s14+(-2.000008e+00)*s15+4.925910e-01*s16+5.323579e-01*s17+4.297250e+00*s18+(-2.630077e+01)*s19 \
v110_part3=v110_part2+1.276539e+00*s20+2.165063e+00*s21+2.033814e+03*s22+(-1.961571e+01)*s23+1.462602e+00*s24+9.957135e-01*s25+(-4.268518e+00)*s26+1.559711e+00*s27+1.132599e+01*s28+(-3.587676e+01)*s29 \
v110=v110_part3+1.913116e+01*s30+(-1.786937e+00)*s31+(-2.820960e+01)*s32+1.692806e+01*s33+(-1.467828e+00)*s34+(-3.451547e+00)*s35+(-1.936506e+00)*s36+(-8.968481e+00)*s37+1.155840e+01*s38+(-1.796871e+00)*s39 \
v111_part1=2.168058e-01*s0+(-6.136304e+00)*s1+(-1.093398e+00)*s2+8.689456e-01*s3+1.534198e+02*s4+(-1.018973e-01)*s5+(-1.026156e+01)*s6+1.127628e+01*s7+2.241484e+00*s8+7.631703e+00*s9 \
v111_part2=v111_part1+(-1.638476e+00)*s10+(-9.088077e-01)*s11+(-1.857733e-01)*s12+(-1.268942e-01)*s13+3.286343e+01*s14+6.415878e-01*s15+(-2.247884e+00)*s16+(-2.271205e-02)*s17+1.616806e+00*s18+(-8.991499e+00)*s19 \
v111_part3=v111_part2+9.100725e-01*s20+(-1.579438e-01)*s21+1.146059e+01*s22+6.523247e-01*s23+3.071553e-01*s24+(-2.984211e-02)*s25+(-1.535969e+00)*s26+(-1.170591e-01)*s27+(-3.023267e+00)*s28+2.113947e+01*s29 \
v111=v111_part3+(-1.298430e-01)*s30+9.950428e-01*s31+(-2.485376e+01)*s32+3.967500e+00*s33+(-5.601070e-01)*s34+1.711555e-01*s35+1.071062e-01*s36+(-3.499902e+00)*s37+(-2.401932e-01)*s38+(-4.308799e-01)*s39 \
v112_part1=1.717801e-01*s0+3.980462e+00*s1+1.358812e+01*s2+(-1.959772e+00)*s3+(-3.346094e+02)*s4+(-1.785987e+00)*s5+2.399414e+01*s6+6.072109e+00*s7+2.280770e+00*s8+5.308144e-01*s9 \
v112_part2=v112_part1+4.424732e+00*s10+6.117568e-01*s11+(-1.678566e-01)*s12+1.436926e-01*s13+(-5.383922e+01)*s14+(-4.919719e-01)*s15+(-4.915265e-02)*s16+3.570908e-03*s17+2.104479e+00*s18+(-6.545828e+00)*s19 \
v112_part3=v112_part2+(-1.547580e+00)*s20+3.288496e-01*s21+7.006658e+00*s22+(-3.490158e-01)*s23+(-1.712887e-01)*s24+6.901934e-03*s25+(-1.526388e-01)*s26+1.349703e-01*s27+5.640400e+00*s28+(-3.247060e+01)*s29 \
v112=v112_part3+(-1.268794e-01)*s30+(-7.880179e-01)*s31+8.138983e-01*s32+(-5.247642e-02)*s33+1.128745e+00*s34+(-1.307480e+00)*s35+2.872713e-02*s36+2.400176e+00*s37+(-2.796817e+00)*s38+6.867373e-01*s39 \
v113_part1=(-3.702438e-01)*s0+7.145519e+00*s1+(-9.342175e+00)*s2+8.129078e-01*s3+4.163670e+01*s4+1.618543e+00*s5+(-7.528171e+00)*s6+(-2.049379e+01)*s7+(-5.406707e+00)*s8+(-8.626953e+00)*s9 \
v113_part2=v113_part1+(-3.061750e+00)*s10+4.119749e-01*s11+4.172903e-01*s12+1.151865e-01*s13+2.169150e-02*s14+(-2.285272e-01)*s15+5.638796e+00*s16+3.683615e-02*s17+(-2.810701e+00)*s18+1.600418e+01*s19 \
v113_part3=v113_part2+4.943250e-01*s20+(-2.140192e-01)*s21+1.670307e+01*s22+(-2.502574e-01)*s23+(-1.305649e-01)*s24+9.136110e-02*s25+8.864867e-01*s26+(-2.931908e-01)*s27+5.132196e-01*s28+(-2.786810e+00)*s29 \
v113=v113_part3+2.761851e-01*s30+(-2.842565e-01)*s31+2.224841e+01*s32+(-3.974532e+00)*s33+(-5.729840e-02)*s34+8.502848e-01*s35+(-1.076961e-01)*s36+1.381999e+00*s37+2.069256e+00*s38+(-2.387028e-01)*s39 \
v114_part1=4.094564e+00*s0+(-3.230498e+01)*s1+1.950667e+00*s2+2.586086e+01*s3+(-6.929099e+00)*s4+7.486012e+00*s5+3.769873e+01*s6+(-5.967131e+02)*s7+3.409638e+00*s8+(-2.986404e+01)*s9 \
v114_part2=v114_part1+2.070803e+01*s10+4.069459e+00*s11+1.573984e+01*s12+1.828807e+01*s13+(-8.395636e+02)*s14+2.674742e+00*s15+1.612356e+01*s16+8.082806e-01*s17+(-5.790758e-02)*s18+(-1.171468e+01)*s19 \
v114_part3=v114_part2+7.510314e+00*s20+4.963945e+00*s21+8.950103e+01*s22+2.171087e+01*s23+2.664044e+00*s24+1.712663e+01*s25+1.265629e+01*s26+9.784983e+00*s27+(-7.276573e+03)*s28+(-1.056061e+03)*s29 \
v114=v114_part3+3.355920e+00*s30+8.304168e+00*s31+(-8.646032e-01)*s32+(-1.642718e+00)*s33+2.491360e+01*s34+(-3.256434e+00)*s35+(-2.417558e+00)*s36+7.734063e+00*s37+(-9.387985e+02)*s38+1.318666e+01*s39 \
v115_part1=3.909251e+00*s0+4.828689e+01*s1+3.651291e+01*s2+(-2.840138e+01)*s3+2.792610e+01*s4+1.113257e+01*s5+7.212520e+01*s6+1.222753e+02*s7+1.804885e+01*s8+4.969409e+01*s9 \
v115_part2=v115_part1+(-2.148343e+01)*s10+1.606099e+01*s11+6.897092e-01*s12+(-7.899526e+00)*s13+1.151872e+03*s14+(-6.549159e-01)*s15+2.856706e+00*s16+2.007718e+01*s17+(-3.696649e-01)*s18+4.071798e+01*s19 \
v115_part3=v115_part2+1.988605e+02*s20+1.470776e+01*s21+(-8.516225e+01)*s22+(-1.044467e+00)*s23+1.873822e+01*s24+(-6.313725e+00)*s25+(-6.092693e-01)*s26+(-8.472776e+00)*s27+1.000000e+04*s28+1.541907e+03*s29 \
v115=v115_part3+(-9.169180e+00)*s30+5.758872e+00*s31+2.018718e+01*s32+1.600110e+02*s33+(-2.195293e+01)*s34+(-6.735175e-01)*s35+5.729300e+00*s36+7.033868e+00*s37+1.391741e+03*s38+(-3.189479e+00)*s39 \
v116_part1=(-4.724258e+00)*s0+3.242594e+01*s1+1.716420e+01*s2+(-5.132403e+00)*s3+1.005749e+01*s4+(-1.462615e+01)*s5+8.788334e+00*s6+6.531381e+02*s7+(-2.902244e+00)*s8+(-1.518991e-01)*s9 \
v116_part2=v116_part1+(-5.069997e-01)*s10+5.054622e+00*s11+(-2.633190e+00)*s12+(-1.514864e+00)*s13+1.808163e+03*s14+(-8.919244e+00)*s15+(-1.593916e+01)*s16+(-1.580810e-01)*s17+1.998885e+00*s18+9.524622e+00*s19 \
v116_part3=v116_part2+(-4.759111e+01)*s20+1.501225e+00*s21+(-9.351114e+00)*s22+(-5.821341e+00)*s23+(-4.111934e+00)*s24+3.507525e+00*s25+2.741814e+00*s26+(-1.494199e+01)*s27+(-5.547662e+02)*s28+1.375951e-01*s29 \
v116=v116_part3+3.935727e+00*s30+7.489288e+00*s31+(-9.828742e-01)*s32+(-5.139258e+01)*s33+2.798661e+00*s34+1.823627e+01*s35+6.659405e+00*s36+(-1.248755e+00)*s37+(-5.486935e+01)*s38+9.098228e+00*s39 \
v117_part1=(-3.150787e+00)*s0+(-3.756389e+01)*s1+(-3.892140e+01)*s2+6.231190e+00*s3+(-3.059963e+01)*s4+1.812422e+01*s5+(-3.269069e+01)*s6+5.933641e+02*s7+1.576575e+00*s8+7.127423e-01*s9 \
v117_part2=v117_part1+4.703628e+00*s10+(-7.240196e+00)*s11+1.424734e+00*s12+3.396943e+00*s13+(-2.467941e+03)*s14+1.110358e+01*s15+1.539603e+01*s16+1.681691e-01*s17+(-2.315993e+00)*s18+(-1.853085e+01)*s19 \
v117_part3=v117_part2+4.800177e+02*s20+(-3.996042e+00)*s21+4.605006e+00*s22+1.956222e+00*s23+3.525930e+00*s24+(-3.341174e+00)*s25+(-1.469546e+01)*s26+2.163357e+01*s27+7.106057e+02*s28+(-7.096283e+01)*s29 \
v117=v117_part3+(-3.040231e-01)*s30+(-1.255899e+01)*s31+6.701048e-01*s32+(-1.745375e+01)*s33+(-6.231334e+00)*s34+(-2.044484e+01)*s35+(-2.732724e+00)*s36+6.665674e+00*s37+3.773374e+01*s38+(-1.835494e+01)*s39 \
v118_part1=(-4.529562e-02)*s0+5.185609e-01*s1+(-1.132935e+01)*s2+(-2.091323e+00)*s3+3.922648e+01*s4+(-1.887995e+00)*s5+(-1.516344e+00)*s6+(-4.389386e+00)*s7+5.540533e+00*s8+(-5.190676e+00)*s9 \
v118_part2=v118_part1+(-4.756862e+00)*s10+4.505378e+00*s11+(-1.133868e+01)*s12+(-4.947223e-01)*s13+(-6.073029e+01)*s14+(-2.658727e-01)*s15+(-2.550807e+00)*s16+(-1.356081e-01)*s17+3.878693e+00*s18+2.936703e+00*s19 \
v118_part3=v118_part2+1.068053e-02*s20+1.964424e+00*s21+(-6.924201e+00)*s22+(-1.592030e+00)*s23+1.951131e+01*s24+4.251306e+00*s25+2.397670e+01*s26+4.503149e+00*s27+2.092125e+01*s28+(-7.332144e+03)*s29 \
v118=v118_part3+1.514365e+00*s30+(-9.002365e-01)*s31+(-3.037779e-01)*s32+(-2.043227e+02)*s33+(-3.925951e+00)*s34+1.111767e+00*s35+(-2.432771e+00)*s36+(-8.709031e-01)*s37+7.558776e+02*s38+1.918190e+00*s39 \
v119_part1=(-1.259940e+00)*s0+(-3.943032e+00)*s1+(-3.007835e+01)*s2+1.955636e+00*s3+(-7.444825e+00)*s4+2.810395e+00*s5+(-1.900481e+01)*s6+(-1.361869e+01)*s7+(-1.376189e+01)*s8+1.256911e+01*s9 \
v119_part2=v119_part1+3.454638e+00*s10+(-5.112482e+00)*s11+1.878449e+01*s12+1.138114e+00*s13+9.335714e+01*s14+1.953939e+00*s15+(-4.991948e+00)*s16+(-1.683116e-01)*s17+(-8.508420e+00)*s18+(-4.095680e+00)*s19 \
v119_part3=v119_part2+1.903323e-01*s20+(-2.776890e+00)*s21+(-2.739484e-01)*s22+5.606424e-01*s23+(-2.046134e+01)*s24+(-1.798506e+01)*s25+(-5.093991e+00)*s26+6.829088e+00*s27+1.707949e-01*s28+1.000000e+04*s29 \
v119=v119_part3+(-1.730812e+00)*s30+(-5.215048e+00)*s31+2.261134e-01*s32+2.898495e+02*s33+2.799664e+00*s34+(-3.895268e+00)*s35+2.589226e+00*s36+(-8.482262e-01)*s37+(-9.662763e+02)*s38+(-2.405312e+00)*s39 \
v120_part1=1.161481e+00*s0+(-5.513727e-01)*s1+3.756926e+01*s2+(-3.786417e-02)*s3+(-3.397854e+01)*s4+(-7.702601e-01)*s5+(-2.468920e-01)*s6+(-4.669203e+01)*s7+3.888557e+00*s8+(-3.648132e+00)*s9 \
v120_part2=v120_part1+1.419513e+00*s10+(-1.481950e-02)*s11+(-5.205146e-01)*s12+(-2.973959e-01)*s13+(-6.365096e+00)*s14+(-1.561636e+00)*s15+8.494240e+00*s16+3.435901e-01*s17+1.770985e+00*s18+1.523257e-01*s19 \
v120_part3=v120_part2+2.882528e-02*s20+(-4.479067e-01)*s21+9.337445e+00*s22+1.713713e-01*s23+(-7.242642e+00)*s24+8.771832e+00*s25+(-5.997226e+00)*s26+1.550202e+00*s27+(-4.197015e+01)*s28+(-4.900040e+00)*s29 \
v120=v120_part3+(-9.947723e-01)*s30+(-8.385324e-01)*s31+2.422968e-01*s32+(-2.271742e+01)*s33+3.097011e+00*s34+(-2.438060e+00)*s35+(-2.094387e+00)*s36+8.528881e-01*s37+(-6.482423e+01)*s38+1.702224e+00*s39 \
v121_part1=(-3.319978e-01)*s0+6.524191e+03*s1+1.017835e+00*s2+1.000000e+04*s3+4.527101e+01*s4+2.978637e+03*s5+1.671647e+02*s6+1.000000e+04*s7+(-1.584852e+02)*s8+1.672272e+00*s9 \
v121_part2=v121_part1+8.848801e+03*s10+8.918400e+02*s11+(-4.977105e-01)*s12+6.241117e-02*s13+(-2.012392e-01)*s14+1.089952e+00*s15+(-2.230571e+00)*s16+3.679261e-01*s17+1.000000e+04*s18+2.557646e+00*s19 \
v121_part3=v121_part2+(-8.923712e+00)*s20+5.399885e-01*s21+7.428526e-01*s22+1.000000e+04*s23+(-1.569636e-01)*s24+(-1.679454e-02)*s25+5.094918e+03*s26+(-1.437392e-01)*s27+1.138540e+00*s28+(-4.537801e-01)*s29 \
v121=v121_part3+2.276289e-02*s30+(-1.970269e+00)*s31+4.003554e-01*s32+1.919787e-01*s33+1.000000e+04*s34+8.198902e-01*s35+2.663753e-01*s36+3.222403e+03*s37+2.524307e-01*s38+4.326388e-01*s39 \
v122_part1=9.769540e-01*s0+(-1.569096e+03)*s1+(-9.468617e-01)*s2+1.000000e+04*s3+1.000000e+04*s4+2.687837e+03*s5+3.682037e+03*s6+1.000000e+04*s7+2.565277e+02*s8+(-1.989457e+00)*s9 \
v122_part2=v122_part1+1.419454e+03*s10+2.631381e+02*s11+1.285414e+00*s12+6.466684e-01*s13+1.115671e+00*s14+(-5.645505e-01)*s15+3.013696e+00*s16+2.135694e-01*s17+1.000000e+04*s18+(-3.779700e+00)*s19 \
v122_part3=v122_part2+8.455114e+00*s20+(-2.747037e-01)*s21+(-8.038865e-01)*s22+1.000000e+04*s23+1.012701e+00*s24+8.474682e-01*s25+3.393464e+02*s26+2.541287e-01*s27+(-7.618292e-01)*s28+1.302607e+00*s29 \
v122=v122_part3+3.599415e-01*s30+2.107767e+01*s31+1.875240e-01*s32+3.243527e-01*s33+1.000000e+04*s34+9.193714e-02*s35+3.377218e-01*s36+1.216343e+03*s37+5.909239e-01*s38+5.773571e-02*s39 \
v123_part1=4.787907e-01*s0+(-4.370612e+03)*s1+(-1.057913e+00)*s2+1.000000e+04*s3+9.157845e+01*s4+7.898743e+02*s5+(-3.751318e+01)*s6+1.000000e+04*s7+(-1.090952e+03)*s8+2.384048e-01*s9 \
v123_part2=v123_part1+2.570113e+03*s10+1.016679e+03*s11+9.124117e-01*s12+(-2.525891e-01)*s13+2.203177e-01*s14+(-1.266836e+00)*s15+3.534607e+00*s16+2.461178e-02*s17+1.000000e+04*s18+(-1.688469e+00)*s19 \
v123_part3=v123_part2+8.749326e+00*s20+(-9.195027e-01)*s21+1.546434e+00*s22+1.000000e+04*s23+1.676555e+00*s24+(-8.231857e-01)*s25+2.354953e+03*s26+(-1.610714e+00)*s27+(-1.021840e+00)*s28+7.639117e-01*s29 \
v123=v123_part3+(-9.533703e-02)*s30+1.140433e+01*s31+(-1.250612e-01)*s32+7.619700e-02*s33+1.000000e+04*s34+(-7.661935e-01)*s35+(-1.128061e+00)*s36+6.251750e+03*s37+(-8.325481e-02)*s38+(-5.163398e-01)*s39 \
v124_part1=(-3.962306e-01)*s0+9.734321e+03*s1+2.330839e+00*s2+1.000000e+04*s3+1.524536e+03*s4+4.026032e+02*s5+(-3.718210e+03)*s6+1.000000e+04*s7+1.835265e+03*s8+(-2.129381e-01)*s9 \
v124_part2=v124_part1+2.560069e+03*s10+3.893216e+03*s11+(-1.139219e+00)*s12+2.892677e-01*s13+(-3.258393e-01)*s14+1.540348e+00*s15+(-3.682994e+00)*s16+(-8.250128e-02)*s17+1.000000e+04*s18+3.972763e+00*s19 \
v124_part3=v124_part2+(-7.973741e+00)*s20+1.764450e+00*s21+(-2.257374e+00)*s22+1.000000e+04*s23+(-2.463392e+00)*s24+9.633528e-01*s25+2.366058e+03*s26+2.329267e+00*s27+1.387361e+00*s28+(-8.921085e-01)*s29 \
v124=v124_part3+5.224332e-01*s30+1.378833e+01*s31+1.000163e-01*s32+2.056128e-01*s33+1.000000e+04*s34+6.046202e-01*s35+1.301828e+00*s36+7.732604e+03*s37+8.187005e-02*s38+8.046262e-01*s39 \
v125_part1=2.551624e-02*s0+9.835423e-01*s1+(-3.206291e-01)*s2+1.097178e+02*s3+1.000000e+04*s4+1.019484e+00*s5+(-6.101470e+01)*s6+1.140581e+01*s7+1.702036e+01*s8+1.263676e-01*s9 \
v125_part2=v125_part1+1.080867e+00*s10+2.135238e+00*s11+(-2.271440e-01)*s12+6.622286e-02*s13+(-2.432389e-01)*s14+(-1.765551e-01)*s15+8.618607e-02*s16+2.924622e-02*s17+1.104339e+00*s18+(-5.357685e-01)*s19 \
v125_part3=v125_part2+4.127893e-01*s20+(-1.795632e-01)*s21+(-1.733660e-01)*s22+1.233075e+01*s23+(-4.748008e-01)*s24+1.866153e-01*s25+8.307123e+00*s26+5.903098e-01*s27+1.074271e-01*s28+3.865859e-01*s29 \
v125=v125_part3+8.398851e-02*s30+(-5.074127e+00)*s31+1.698072e-02*s32+5.704562e-01*s33+5.608316e+01*s34+(-6.105269e-02)*s35+(-3.089650e-01)*s36+7.056274e+00*s37+(-2.923468e-01)*s38+5.077551e-02*s39 \
v126_part1=(-1.096927e-01)*s0+2.282720e+01*s1+9.014167e-01*s2+4.319971e+01*s3+1.446831e+03*s4+7.145146e+00*s5+(-2.414805e-01)*s6+2.307904e+02*s7+1.590421e+00*s8+(-1.742864e-01)*s9 \
v126_part2=v126_part1+2.187076e+01*s10+5.406319e-01*s11+7.001537e-01*s12+(-1.775488e-01)*s13+3.175718e-01*s14+2.632527e-02*s15+7.468433e-01*s16+9.710039e-03*s17+2.234571e+01*s18+6.182796e-01*s19 \
v126_part3=v126_part2+6.922948e-02*s20+3.578187e-01*s21+4.078948e-01*s22+4.416714e+00*s23+1.672141e-02*s24+4.346122e-01*s25+1.680901e+02*s26+(-4.018187e-01)*s27+(-1.557640e-01)*s28+(-7.423865e-01)*s29 \
v126=v126_part3+2.703589e-02*s30+(-2.398319e+00)*s31+6.703778e-03*s32+1.394801e-03*s33+1.134812e+03*s34+(-9.644650e-02)*s35+3.484057e-01*s36+3.915552e+00*s37+(-2.250282e-01)*s38+(-2.690101e-01)*s39 \
v127_part1=9.347193e-02*s0+5.582221e+00*s1+2.004707e-01*s2+9.989278e+01*s3+7.348973e+02*s4+4.297897e+00*s5+(-5.987974e+01)*s6+6.473516e+01*s7+(-2.707538e+01)*s8+2.425332e-02*s9 \
v127_part2=v127_part1+6.134600e+00*s10+6.293524e+00*s11+(-3.355314e-01)*s12+7.239375e-02*s13+4.737384e-02*s14+1.815216e-01*s15+(-7.397611e-01)*s16+(-5.138468e-02)*s17+6.267819e+00*s18+(-8.859519e-02)*s19 \
v127_part3=v127_part2+(-1.733563e-01)*s20+(-1.230660e-01)*s21+(-1.342670e-01)*s22+1.394730e+00*s23+4.192123e-01*s24+(-6.264907e-01)*s25+4.714814e+01*s26+(-1.026962e-02)*s27+1.966904e-03*s28+2.118274e-01*s29 \
v127=v127_part3+(-1.234007e-01)*s30+(-2.890769e+00)*s31+(-3.609831e-02)*s32+(-6.333970e-01)*s33+3.183072e+02*s34+1.113881e-01*s35+1.001054e-01*s36+4.344169e+00*s37+3.742788e-01*s38+1.772558e-01*s39 \
v128_part1=(-9.230862e+03)*s0+8.028245e+01*s1+1.280079e+01*s2+1.382216e+02*s3+1.134037e+02*s4+7.869177e+01*s5+7.148360e+02*s6+2.093743e+02*s7+2.030100e+02*s8+(-1.000000e+04)*s9 \
v128_part2=v128_part1+4.436226e+01*s10+1.658599e+02*s11+8.667651e+03*s12+(-1.000000e+04)*s13+1.000000e+04*s14+(-2.416969e+03)*s15+(-4.894748e+01)*s16+(-1.000000e+04)*s17+1.526420e+02*s18+4.864997e+03*s19 \
v128_part3=v128_part2+(-1.000000e+04)*s20+1.315405e+01*s21+1.000000e+04*s22+4.312569e+02*s23+1.000000e+04*s24+9.806902e+00*s25+2.372702e+02*s26+(-1.000000e+04)*s27+(-1.000000e+04)*s28+(-1.000000e+04)*s29 \
v128=v128_part3+(-4.439537e+03)*s30+9.067458e+02*s31+(-1.000000e+04)*s32+(-2.277084e+02)*s33+3.434707e+02*s34+(-6.846226e+02)*s35+(-5.318182e+03)*s36+6.196857e+01*s37+1.000000e+04*s38+(-1.936671e+02)*s39 \
v129_part1=(-5.518345e+03)*s0+(-7.868249e+01)*s1+4.424326e+03*s2+(-8.972800e+01)*s3+(-1.101119e+02)*s4+(-7.383305e+01)*s5+(-5.500319e+02)*s6+(-1.403967e+02)*s7+(-9.190512e+01)*s8+(-1.000000e+04)*s9 \
v129_part2=v129_part1+3.641243e+01*s10+(-1.992496e+01)*s11+(-4.250918e+03)*s12+(-1.000000e+04)*s13+1.000000e+04*s14+(-5.294529e+03)*s15+8.159932e+01*s16+(-1.000000e+04)*s17+(-4.782844e+01)*s18+(-6.540717e+03)*s19 \
v129_part3=v129_part2+(-1.000000e+04)*s20+(-2.275820e+01)*s21+9.821774e+03*s22+(-3.360619e+02)*s23+1.000000e+04*s24+(-6.253693e+00)*s25+9.953807e+01*s26+(-1.000000e+04)*s27+(-1.000000e+04)*s28+(-1.000000e+04)*s29 \
v129=v129_part3+(-8.497333e+03)*s30+2.662451e+02*s31+(-1.000000e+04)*s32+(-4.129329e+02)*s33+(-1.934468e+02)*s34+(-1.118525e+02)*s35+(-3.818790e+02)*s36+(-5.218522e+01)*s37+1.000000e+04*s38+(-1.572799e+02)*s39 \
v130_part1=(-9.639926e+03)*s0+2.229529e+03*s1+9.446722e+03*s2+1.762027e+02*s3+9.527935e+01*s4+1.896533e+02*s5+1.202491e+01*s6+3.061622e+01*s7+1.663153e+01*s8+(-1.000000e+04)*s9 \
v130_part2=v130_part1+7.328828e-01*s10+7.054226e+01*s11+8.561038e+03*s12+(-1.000000e+04)*s13+1.000000e+04*s14+(-1.013050e+03)*s15+1.732052e+02*s16+(-1.000000e+04)*s17+3.104717e+01*s18+3.008883e+03*s19 \
v130_part3=v130_part2+(-1.000000e+04)*s20+(-6.153941e+01)*s21+1.000000e+04*s22+(-3.526883e+02)*s23+1.000000e+04*s24+(-1.041564e+01)*s25+5.586182e+01*s26+(-1.000000e+04)*s27+(-1.000000e+04)*s28+(-1.000000e+04)*s29 \
v130=v130_part3+(-3.382131e+03)*s30+7.756744e+01*s31+(-1.000000e+04)*s32+(-9.068572e+01)*s33+1.472407e+01*s34+(-6.392318e+02)*s35+(-1.716146e+03)*s36+1.847432e+02*s37+1.000000e+04*s38+(-7.835170e+02)*s39 \
v131_part1=(-2.014258e+01)*s0+(-1.476825e+03)*s1+9.491187e+03*s2+(-1.164034e+02)*s3+1.074132e+01*s4+(-1.334349e+02)*s5+6.932660e+01*s6+(-5.492423e+00)*s7+(-4.019743e+01)*s8+(-1.000000e+04)*s9 \
v131_part2=v131_part1+(-7.006051e+01)*s10+(-3.118798e+01)*s11+1.054508e+03*s12+(-1.000000e+04)*s13+1.000000e+04*s14+(-1.903995e+03)*s15+(-2.150504e+02)*s16+(-1.000000e+04)*s17+(-1.025120e+01)*s18+(-1.832042e+02)*s19 \
v131_part3=v131_part2+(-1.000000e+04)*s20+1.222989e+02*s21+1.000000e+04*s22+3.366677e+02*s23+1.000000e+04*s24+2.055151e+01*s25+2.829333e+01*s26+(-1.000000e+04)*s27+(-1.000000e+04)*s28+(-1.000000e+04)*s29 \
v131=v131_part3+(-1.000000e+04)*s30+1.934674e+01*s31+(-1.000000e+04)*s32+(-1.667721e+02)*s33+(-3.813893e+00)*s34+(-1.277978e+03)*s35+(-1.723054e+02)*s36+(-1.818776e+01)*s37+1.000000e+04*s38+(-7.793516e+01)*s39 \
v132_part1=(-5.947927e+00)*s0+3.728432e+00*s1+(-5.366344e+01)*s2+(-2.839058e+01)*s3+3.777847e+02*s4+3.562725e+00*s5+(-4.352039e+01)*s6+(-1.025351e+00)*s7+(-1.455230e+02)*s8+(-5.244012e+02)*s9 \
v132_part2=v132_part1+2.757126e+00*s10+2.310641e+00*s11+3.032442e+00*s12+(-2.040660e+01)*s13+4.685624e+02*s14+(-1.548952e-01)*s15+1.619478e+02*s16+(-8.679802e+00)*s17+3.641512e+00*s18+1.212127e+02*s19 \
v132_part3=v132_part2+(-6.632475e+00)*s20+2.584148e-01*s21+1.664339e+01*s22+(-7.612211e-02)*s23+8.593416e+01*s24+2.535404e+00*s25+2.907768e+01*s26+(-2.343646e+02)*s27+(-1.891383e+03)*s28+(-1.000000e+04)*s29 \
v132=v132_part3+(-3.868836e+00)*s30+2.221279e+00*s31+(-2.158726e+01)*s32+(-2.591297e+02)*s33+2.713702e-01*s34+(-2.578826e+00)*s35+(-3.605462e+00)*s36+1.433073e+00*s37+1.000000e+04*s38+(-1.018583e+01)*s39 \
v133_part1=(-2.152334e+00)*s0+1.846904e+00*s1+(-1.553651e+02)*s2+7.382213e+01*s3+(-2.427499e+02)*s4+(-3.110389e-01)*s5+6.008055e+00*s6+1.738113e-01*s7+(-8.202179e+01)*s8+(-2.597657e+02)*s9 \
v133_part2=v133_part1+(-1.673137e+00)*s10+3.986331e+00*s11+5.231586e+00*s12+(-1.010855e+01)*s13+1.279493e+03*s14+(-2.034779e+00)*s15+(-2.348087e+02)*s16+(-1.497444e+01)*s17+(-1.874140e+00)*s18+6.004354e+01*s19 \
v133_part3=v133_part2+(-3.921639e+00)*s20+1.280075e-01*s21+2.279148e+01*s22+(-1.690172e+00)*s23+4.256808e+01*s24+(-1.666878e+00)*s25+1.440383e+01*s26+4.131344e+03*s27+(-9.950065e+02)*s28+(-1.000000e+04)*s29 \
v133=v133_part3+(-1.916455e+00)*s30+3.024364e+00*s31+(-1.069340e+01)*s32+(-1.166553e+03)*s33+(-1.095943e+02)*s34+(-4.449005e+00)*s35+(-6.220163e+00)*s36+2.575914e+00*s37+1.000000e+04*s38+(-1.757264e+01)*s39 \
v134_part1=(-1.074868e+00)*s0+2.372743e+01*s1+(-8.820390e+01)*s2+(-2.898732e+01)*s3+(-2.046280e+02)*s4+3.701024e+00*s5+(-5.047461e+00)*s6+3.286641e+00*s7+2.735928e+02*s8+(-3.337245e+03)*s9 \
v134_part2=v134_part1+(-1.080316e+00)*s10+3.801170e+00*s11+4.988584e+00*s12+(-1.298659e+02)*s13+5.882003e+02*s14+(-5.137280e+00)*s15+7.295109e+01*s16+(-1.427889e+01)*s17+2.317427e+01*s18+7.713872e+02*s19 \
v134_part3=v134_part2+(-8.964467e-01)*s20+(-1.874917e+01)*s21+3.512405e+00*s22+(-2.523465e+00)*s23+5.468777e+02*s24+1.627836e+00*s25+1.850479e+02*s26+3.939447e+03*s27+(-1.957853e+03)*s28+(-1.000000e+04)*s29 \
v134=v134_part3+(-2.462094e+01)*s30+2.067934e+00*s31+(-1.373795e+02)*s32+(-5.588832e+02)*s33+5.418990e+01*s34+(-4.242353e+00)*s35+(-5.931242e+00)*s36+4.252971e+00*s37+2.628648e+03*s38+(-1.675641e+01)*s39 \
v135_part1=5.931738e+02*s0+3.999280e+00*s1+2.281048e+01*s2+(-1.473989e+00)*s3+5.840429e+00*s4+6.170871e+00*s5+2.441832e+00*s6+4.749257e+00*s7+8.990910e+00*s8+5.243659e+03*s9 \
v135_part2=v135_part1+(-2.407368e+00)*s10+(-7.021403e-01)*s11+1.248579e+02*s12+1.000000e+04*s13+9.999960e+03*s14+5.839988e+03*s15+(-5.014846e-01)*s16+1.000000e+04*s17+1.624853e+01*s18+3.358244e+01*s19 \
v135_part3=v135_part2+(-4.891555e+00)*s20+2.082712e+01*s21+9.999968e+03*s22+(-1.076085e+02)*s23+3.006969e+03*s24+(-2.541461e+00)*s25+(-3.094719e-01)*s26+1.000000e+04*s27+1.000000e+04*s28+1.000000e+04*s29 \
v135=v135_part3+1.000000e+04*s30+2.989348e+00*s31+1.000000e+04*s32+1.000000e+04*s33+1.614036e+01*s34+4.084680e+01*s35+1.000000e+04*s36+(-1.543226e+01)*s37+1.026852e+02*s38+6.950728e+02*s39 \
v136_part1=1.012137e+02*s0+2.802330e+00*s1+3.413509e+01*s2+1.123981e+01*s3+(-1.067740e+00)*s4+(-6.276601e+00)*s5+4.262888e+00*s6+2.738479e-01*s7+(-5.289999e+00)*s8+4.903365e+03*s9 \
v136_part2=v136_part1+7.748426e+00*s10+5.965385e+00*s11+(-1.646778e+02)*s12+1.000000e+04*s13+(-9.964455e+03)*s14+1.262712e+03*s15+1.960631e+01*s16+1.000000e+04*s17+1.312094e+01*s18+(-2.891713e+00)*s19 \
v136_part3=v136_part2+2.920043e+02*s20+3.337680e+01*s21+9.999937e+03*s22+3.778520e+02*s23+(-1.786982e+02)*s24+3.215860e+01*s25+3.003721e+00*s26+1.000000e+04*s27+1.000000e+04*s28+1.000000e+04*s29 \
v136=v136_part3+1.000000e+04*s30+3.075960e+00*s31+1.000000e+04*s32+1.000000e+04*s33+(-1.817859e+01)*s34+5.195698e+02*s35+1.000000e+04*s36+2.868239e+01*s37+(-7.521473e+01)*s38+5.725443e+03*s39 \
v137_part1=5.694092e+02*s0+(-1.349346e-01)*s1+(-1.747611e+01)*s2+3.215478e+00*s3+8.472004e-02*s4+1.300204e+01*s5+1.260656e+00*s6+(-1.718976e-01)*s7+3.163446e-02*s8+8.889993e+00*s9 \
v137_part2=v137_part1+5.152416e-01*s10+(-2.469042e+00)*s11+6.739202e+00*s12+2.099262e+02*s13+9.972811e+03*s14+1.000000e+04*s15+4.227898e+00*s16+1.000000e+04*s17+(-9.971993e-03)*s18+5.905332e-01*s19 \
v137_part3=v137_part2+(-1.160914e+02)*s20+6.021324e-02*s21+9.913799e+03*s22+(-3.794966e+02)*s23+2.916123e+00*s24+(-2.700930e-02)*s25+1.522571e-03*s26+1.000000e+04*s27+1.000000e+04*s28+1.000000e+04*s29 \
v137=v137_part3+2.234145e+02*s30+(-2.467866e+00)*s31+4.284561e+02*s32+1.000000e+04*s33+(-6.230760e-01)*s34+2.934289e+00*s35+1.873107e+03*s36+2.088423e+01*s37+9.751023e+01*s38+2.356425e+02*s39 \
v138_part1=6.082877e+02*s0+1.007242e+00*s1+(-2.210794e+01)*s2+(-5.300235e+00)*s3+1.456709e+00*s4+(-1.396815e+01)*s5+(-1.952766e+00)*s6+9.037960e-01*s7+(-4.581078e-01)*s8+1.000000e+04*s9 \
v138_part2=v138_part1+(-1.484435e+00)*s10+3.777135e+00*s11+7.413641e+01*s12+1.000000e+04*s13+(-1.000000e+04)*s14+1.000000e+04*s15+1.967719e+00*s16+1.000000e+04*s17+(-9.953481e+01)*s18+(-2.227931e+01)*s19 \
v138_part3=v138_part2+(-1.739084e+02)*s20+(-3.414199e+01)*s21+9.689278e+03*s22+(-7.529937e+01)*s23+9.994852e+03*s24+(-9.876520e+00)*s25+1.675178e+00*s26+1.000000e+04*s27+1.000000e+04*s28+1.000000e+04*s29 \
v138=v138_part3+1.000000e+04*s30+1.391758e+00*s31+1.000000e+04*s32+3.886143e+03*s33+2.149248e+00*s34+4.273140e+02*s35+1.000000e+04*s36+(-3.081281e+01)*s37+(-1.141392e+02)*s38+8.741229e+03*s39 \
v139_part1=2.133416e+00*s0+(-7.279800e-02)*s1+(-2.355856e+01)*s2+2.924127e-01*s3+(-3.252584e+00)*s4+(-8.018308e-01)*s5+(-7.108273e-01)*s6+4.651475e+00*s7+3.994056e+00*s8+1.459995e+03*s9 \
v139_part2=v139_part1+5.519846e-01*s10+(-6.934843e-02)*s11+5.481274e-02*s12+5.767369e+01*s13+4.623323e+00*s14+7.491030e+00*s15+7.337993e+01*s16+3.768200e-01*s17+9.839856e+00*s18+6.059076e+01*s19 \
v139_part3=v139_part2+4.200686e+00*s20+(-7.621214e-01)*s21+6.315830e+00*s22+(-7.256831e+00)*s23+(-1.476006e+02)*s24+1.479930e+00*s25+(-9.089395e+00)*s26+2.845694e+02*s27+4.051154e+02*s28+1.000000e+04*s29 \
v139=v139_part3+1.156180e+01*s30+8.863643e-01*s31+6.089803e+01*s32+9.562997e+02*s33+1.915427e+00*s34+1.695658e-01*s35+1.829072e-01*s36+1.862480e+00*s37+1.337164e+03*s38+4.636073e-01*s39 \
v140_part1=2.317184e+00*s0+2.749120e+00*s1+(-3.233561e+01)*s2+(-1.118043e+00)*s3+3.908557e+00*s4+8.714461e-01*s5+2.538330e-01*s6+4.835194e-01*s7+(-5.362298e+00)*s8+7.948365e+02*s9 \
v140_part2=v140_part1+3.734415e-01*s10+4.687039e-01*s11+(-1.103748e+00)*s12+3.139815e+01*s13+1.550210e+01*s14+6.862164e-01*s15+6.119513e+00*s16+1.426801e+00*s17+5.356919e+00*s18+(-1.775623e+00)*s19 \
v140_part3=v140_part2+4.518525e+00*s20+(-5.665952e+00)*s21+1.113750e+01*s22+(-6.647627e-01)*s23+(-1.315669e+02)*s24+(-4.950157e+00)*s25+1.504496e+01*s26+1.077501e+03*s27+1.243086e+02*s28+1.000000e+04*s29 \
v140=v140_part3+6.294361e+00*s30+(-1.965424e+00)*s31+3.315351e+01*s32+9.351424e+02*s33+(-5.491652e-02)*s34+3.406929e-01*s35+6.925646e-01*s36+1.228228e-01*s37+(-1.314586e+03)*s38+1.755415e+00*s39 \
v141_part1=5.787165e+00*s0+(-2.517469e+00)*s1+3.937864e+01*s2+4.405893e-01*s3+5.744743e-01*s4+5.669662e-01*s5+6.395506e-01*s6+(-6.154429e+00)*s7+1.027142e+00*s8+2.498264e+03*s9 \
v141_part2=v141_part1+(-6.737074e-01)*s10+(-3.963968e-01)*s11+(-1.808522e+01)*s12+9.868805e+01*s13+(-2.167791e+01)*s14+3.865931e+00*s15+(-9.385158e+01)*s16+2.409544e+01*s17+1.683742e+01*s18+(-5.474401e+01)*s19 \
v141_part3=v141_part2+5.476153e-01*s20+1.194887e+01*s21+(-2.072171e+01)*s22+(-3.745067e+00)*s23+(-2.525660e+02)*s24+9.653483e-01*s25+6.347459e-01*s26+1.000000e+04*s27+5.870657e+02*s28+1.000000e+04*s29 \
v141=v141_part3+1.978391e+01*s30+9.842018e-01*s31+1.042054e+02*s32+4.309339e+02*s33+(-2.537916e+00)*s34+1.084274e+01*s35+1.169585e+01*s36+(-1.381744e+00)*s37+(-1.071133e+01)*s38+2.964498e+01*s39 \
_p0=v0+v1*od_+v2*w_+v3*od_*w_ \
_p1=_p0+v4*(s_-0.7)+v5*(s_-0.7)*od_+v6*(s_-0.7)*w_ \
_p2=0.5*(_p1+sqrt(_p1*_p1+0.001)) \
_p3=1e-15*_p2 \
_p4=v7+v8*od_+v9*w_+v10*od_*w_+v11*od_/w_ \
_p5=_p4+v12*(s_-0.7)+v13*(s_-0.7)*od_+v14*(s_-0.7)*w_ \
_p6=sqsknw_drs_1p6m0t1f*0.5*(_p5+sqrt(_p5*_p5+0.001)) \
_p7=v15+v16*od_+v17*w_+v18*od_*w_ \
_p8=_p7+v19*(s_-0.7)+v20*(s_-0.7)*od_+v21*(s_-0.7)*w_ \
_p9=0.5*(_p8+sqrt(_p8*_p8+0.001)) \
_p10=sqsknw_dls_1p6m0t1f*1e-09*_p9 \
_p11=v22+v23*od_+v24*w_+v25*od_*w_+v26*od_/w_ \
_p12=_p11+v27*(s_-0.7)+v28*(s_-0.7)*od_+v29*(s_-0.7)*w_ \
_p13=sqsknw_drs_1p6m0t1f*0.5*(_p12+sqrt(_p12*_p12+0.001)) \
_p14=v30+v31*od_+v32*w_+v33*od_*w_ \
_p15=_p14+v34*(s_-0.7)+v35*(s_-0.7)*od_+v36*(s_-0.7)*w_ \
_p16=0.5*(_p15+sqrt(_p15*_p15+0.001)) \
_p17=sqsknw_dls_1p6m0t1f*1e-09*_p16 \
_p18=v37+v38*od_+v39*w_+v40*od_*w_ \
_p19=_p18+v41*(s_-0.7)+v42*(s_-0.7)*od_+v43*(s_-0.7)*w_ \
_p20=0.5*(atan(2*_p19)/1.5708+1) \
_p21=v44+v45*od_+v46*w_+v47*od_*w_ \
_p22=_p21+v48*(s_-0.7)+v49*(s_-0.7)*od_+v50*(s_-0.7)*w_ \
_p23=0.5*(_p22+sqrt(_p22*_p22+0.001)) \
_p24=v51+v52*od_+v53*w_+v54*od_*w_ \
_p25=_p24+v55*(s_-0.7)+v56*(s_-0.7)*od_+v57*(s_-0.7)*w_ \
_p26=0.5*(_p25+sqrt(_p25*_p25+0.001)) \
_p27=v58+v59*od_+v60*w_+v61*od_*w_ \
_p28=_p27+v62*(s_-0.7)+v63*(s_-0.7)*od_+v64*(s_-0.7)*w_ \
_p29=0.5*(_p28+sqrt(_p28*_p28+0.001)) \
_p30=v65+v66*od_+v67*w_+v68*od_*w_ \
_p31=_p30+v69*(s_-0.7)+v70*(s_-0.7)*od_+v71*(s_-0.7)*w_ \
_p32=0.5*(_p31+sqrt(_p31*_p31+0.001)) \
_p33=1e-14*_p23 \
_p34=100*_p26 \
_p35=1e-14*_p29 \
_p36=100*_p32 \
_p37=v72+v73*od_+v74*w_+v75*od_*w_ \
_p38=_p37+v76*(s_-0.7)+v77*(s_-0.7)*od_+v78*(s_-0.7)*w_ \
_p39=0.5*(_p38+sqrt(_p38*_p38+0.001)) \
_p40=100*_p39 \
_p41=v79+v80*od_+v81*w_+v82*od_*w_ \
_p42=_p41+v83*(s_-0.7)+v84*(s_-0.7)*od_+v85*(s_-0.7)*w_ \
_p43=0.5*(_p42+sqrt(_p42*_p42+0.001)) \
_p44=v86+v87*od_+v88*w_+v89*od_*w_ \
_p45=_p44+v90*(s_-0.7)+v91*(s_-0.7)*od_+v92*(s_-0.7)*w_ \
_p46=0.5*(_p45+sqrt(_p45*_p45+0.001)) \
_p47=v93+v94*od_+v95*w_+v96*od_*w_ \
_p48=_p47+v97*(s_-0.7)+v98*(s_-0.7)*od_+v99*(s_-0.7)*w_ \
_p49=0.5*(_p48+sqrt(_p48*_p48+0.001)) \
_p50=v100+v101*od_+v102*w_+v103*od_*w_ \
_p51=_p50+v104*(s_-0.7)+v105*(s_-0.7)*od_+v106*(s_-0.7)*w_ \
_p52=0.5*(_p51+sqrt(_p51*_p51+0.001)) \
_p53=v107+v108*od_+v109*w_+v110*od_*w_ \
_p54=_p53+v111*(s_-0.7)+v112*(s_-0.7)*od_+v113*(s_-0.7)*w_ \
_p55=0.5*(_p54+sqrt(_p54*_p54+0.001)) \
_p56=v114+v115*od_+v116*w_+v117*od_*w_ \
_p57=_p56+v118*(s_-0.7)+v119*(s_-0.7)*od_+v120*(s_-0.7)*w_ \
_p58=0.5*(_p57+sqrt(_p57*_p57+0.001)) \
_p59=v121+v122*od_+v123*w_+v124*od_*w_ \
_p60=_p59+v125*(s_-0.7)+v126*(s_-0.7)*od_+v127*(s_-0.7)*w_ \
_p61=0.5*(_p60+sqrt(_p60*_p60+0.001)) \
_p62=v128+v129*od_+v130*w_+v131*od_*w_ \
_p63=_p62+v132*(s_-0.7)+v133*(s_-0.7)*od_+v134*(s_-0.7)*w_ \
_p64=0.5*(_p63+sqrt(_p63*_p63+0.001)) \
_p65=v135+v136*od_+v137*w_+v138*od_*w_ \
_p66=_p65+v139*(s_-0.7)+v140*(s_-0.7)*od_+v141*(s_-0.7)*w_ \
_p67=0.5*(_p66+sqrt(_p66*_p66+0.001)) \
_p68=1e-14*_p43 \
_p69=sqsknw_drs_sub_1p6m0t1f*100*_p46 \
_p70=1e-15*_p49 \
_p71=1e-14*_p52 \
_p72=sqsknw_drs_sub_1p6m0t1f*100*_p55 \
_p73=1e-15*_p58 \
_p74=1e-14*_p61 \
_p75=100*_p64 \
_p76=1e-15*_p67
cs (top bottom) capacitor c=_p3
rs1_1 (top n1_1) resistor r=_p6
ls1_1 (n1_1 bottom) inductor l=_p10
rs1_2 (top n1_2) resistor r=_p13
ls1_2 (n1_2 bottom) inductor l=_p17
k1 mutual_inductor coupling=_p20 ind1=ls1_1 ind2=ls1_2
c_1_wsub (top _n1_1_wsub) capacitor c=_p33
rs_1_wsub (_n1_1_wsub nwell) resistor r=_p34
c_2_wsub (bottom _n1_2_wsub) capacitor c=_p35
rs_2_wsub (_n1_2_wsub nwell) resistor r=_p36
rx_1_2_wsub (_n1_1_wsub _n1_2_wsub) resistor r=_p40
c_1_sub (_n1_1_wsub _n1_1_sub) capacitor c=_p68
rs_1_sub (_n1_1_sub sub) resistor r=_p69
cs_1_sub (_n1_1_sub sub) capacitor c=_p70
c_2_sub (_n1_2_wsub _n1_2_sub) capacitor c=_p71
rs_2_sub (_n1_2_sub sub) resistor r=_p72
cs_2_sub (_n1_2_sub sub) capacitor c=_p73
c_3_sub (nwell _n1_3_sub) capacitor c=_p74
rs_3_sub (_n1_3_sub sub) resistor r=_p75
cs_3_sub (_n1_3_sub sub) capacitor c=_p76
ends lnw_sqsk_rfvil_1p6m0t1f
