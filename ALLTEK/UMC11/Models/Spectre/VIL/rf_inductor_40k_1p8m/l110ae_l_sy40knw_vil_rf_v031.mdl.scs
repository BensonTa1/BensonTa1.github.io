simulator lang=spectre insensitive=yes
// model: lnw_sy40k_rfvil
// planar symmetric rf inductor, n well, 4.0um metal8
// umc 110nm 1p8m1t1u rfcmos process
// date: 2011-05-06
// model coverage: (before shrinkage)
// od: (75 - 299) * 1e-06
// w: (2.23 - 9.7) * 1e-06
// s: (2.23 - 5) * 1e-06
// nt: 2 - 7
// frequency range: 100mhz - 0.8 * resonance (maximum 20.0 ghz)
subckt lnw_sy40k_rfvil (outer inner nwell sub)
parameters od=0.00015 od_=od/0.000299 w=6e-06 w_=w/9.97e-06 w_jump_=max(floor((w_-0.0752257)/0.0902708), 1) s=2.52e-06 s_=s/5e-06 nt=3  \
s0=(nt==2) \
s1=(nt==3) \
s2=(nt==4) \
s3=(nt==5) \
s4=(nt==6) \
s5=(nt==7) \
v0=2.022811e+00*s0+(-3.919974e+00)*s1+(-3.960791e-01)*s2+(-7.428055e+00)*s3+8.873499e-01*s4+(-2.336006e+01)*s5 \
v1=1.256536e+01*s0+4.258724e+01*s1+6.690843e+01*s2+9.693796e+01*s3+1.229823e+02*s4+1.800300e+02*s5 \
v2=(-5.391118e+00)*s0+8.097364e-01*s1+(-1.313704e+01)*s2+4.217792e-01*s3+(-3.959373e+01)*s4+(-6.586300e+00)*s5 \
v3=6.741672e-01*s0+4.245447e+00*s1+2.024404e+01*s2+(-1.524568e+01)*s3+9.598234e+00*s4+(-4.360286e+01)*s5 \
v4=(-4.034052e+00)*s0+(-6.983569e+00)*s1+(-1.123788e+01)*s2+(-3.682701e+01)*s3+(-3.696258e+00)*s4+(-2.374716e+01)*s5 \
v5=(-3.419553e+01)*s0+(-4.953653e+01)*s1+(-8.077699e+01)*s2+(-9.147702e+01)*s3+(-1.507807e+02)*s4+(-1.230528e+02)*s5 \
v6=1.009434e+01*s0+1.441893e+01*s1+3.891479e+01*s2+8.494157e+01*s3+4.347541e+01*s4+4.279321e+01*s5 \
v7=5.537904e-01*s0+5.703863e+01*s1+4.783621e+00*s2+5.319461e+01*s3+1.792466e+02*s4+1.856875e+01*s5 \
v8=(-1.345514e+01)*s0+(-8.357546e+01)*s1+(-4.684990e+00)*s2+4.946494e+01*s3+(-9.139833e+02)*s4+4.318665e+01*s5 \
v9=(-9.757018e-01)*s0+6.751768e+00*s1+1.168527e+00*s2+(-7.020008e+01)*s3+(-2.206386e+02)*s4+6.077937e+00*s5 \
v10=5.778704e+00*s0+9.177835e+01*s1+1.435346e+00*s2+(-1.627332e+01)*s3+1.521897e+03*s4+(-2.205318e+01)*s5 \
v11=9.988279e-01*s0+8.708755e+00*s1+1.164578e+00*s2+(-5.978019e+00)*s3+8.482044e+01*s4+(-3.965266e+00)*s5 \
v12=6.866878e-01*s0+(-2.953908e+01)*s1+(-2.323250e+00)*s2+2.874121e+01*s3+(-2.612988e+02)*s4+(-9.383820e+00)*s5 \
v13=8.474045e+00*s0+1.494190e+01*s1+3.745603e+00*s2+(-2.975425e+01)*s3+1.165395e+02*s4+(-1.118230e+01)*s5 \
v14=(-9.797662e-01)*s0+1.476523e+00*s1+(-5.049622e-01)*s2+4.437604e+00*s3+(-2.003427e+00)*s4+(-7.580527e-01)*s5 \
v15=(-2.724494e+00)*s0+(-4.145682e+02)*s1+(-4.184297e+01)*s2+(-1.764973e+02)*s3+(-1.479066e+02)*s4+(-2.618516e+02)*s5 \
v16=9.625906e+00*s0+1.191820e+03*s1+1.184716e+02*s2+6.162696e+02*s3+8.157384e+01*s4+8.319200e+02*s5 \
v17=(-5.983701e-01)*s0+(-4.006593e-01)*s1+(-4.721878e-01)*s2+1.888956e+00*s3+4.729062e+01*s4+(-1.874219e+00)*s5 \
v18=(-1.195662e-02)*s0+2.691178e+00*s1+(-2.793024e-01)*s2+(-4.310245e-01)*s3+(-2.136272e+01)*s4+(-5.201426e-01)*s5 \
v19=5.815189e-01*s0+3.513013e+00*s1+7.400666e-01*s2+(-1.883511e+00)*s3+(-1.220166e+02)*s4+2.478953e+00*s5 \
v20=1.030867e-02*s0+(-4.874921e-02)*s1+(-2.101961e-01)*s2+(-1.140064e-02)*s3+5.910949e-02*s4+(-4.302283e+00)*s5 \
v21=2.777753e-02*s0+(-3.239461e-01)*s1+2.754067e-01*s2+6.081603e-01*s3+(-5.252998e-02)*s4+3.383930e+00*s5 \
v22=(-2.681880e-01)*s0+2.741590e+00*s1+3.521777e-01*s2+1.485266e-01*s3+(-8.519658e-01)*s4+(-8.472031e-02)*s5 \
v23=1.160618e+00*s0+(-3.330165e+00)*s1+(-1.629663e-01)*s2+(-3.464778e+00)*s3+8.924588e+00*s4+5.678018e+00*s5 \
v24=8.295156e-02*s0+(-3.688389e+00)*s1+1.656138e-01*s2+(-5.312511e+00)*s3+(-2.600981e+00)*s4+3.614552e+01*s5 \
v25=4.200701e-01*s0+2.595428e+00*s1+3.751147e+00*s2+6.881357e+00*s3+3.600849e+00*s4+(-8.991502e-01)*s5 \
v26=(-2.187661e-01)*s0+6.912956e+00*s1+8.463874e-01*s2+1.830975e+01*s3+(-7.006551e+00)*s4+(-8.470497e+01)*s5 \
v27=(-6.168608e-02)*s0+1.225701e+00*s1+(-7.703348e-01)*s2+3.353157e+00*s3+4.471296e+00*s4+(-2.699795e+01)*s5 \
v28=(-4.321404e-01)*s0+6.703491e-01*s1+(-1.926942e+00)*s2+(-1.201703e+01)*s3+(-6.784260e+00)*s4+5.466984e+01*s5 \
v29=(-2.653219e-02)*s0+(-2.702711e+00)*s1+7.297254e-01*s2+(-1.202424e+01)*s3+(-1.241067e+01)*s4+6.606942e+01*s5 \
v30=2.626167e-01*s0+(-1.448626e+00)*s1+(-3.103437e-01)*s2+7.171518e+00*s3+3.228557e+01*s4+(-4.357580e+01)*s5 \
v31=(-2.678977e-02)*s0+(-1.208883e-01)*s1+(-4.059616e-01)*s2+(-4.409369e-01)*s3+(-5.841916e-01)*s4+(-1.647817e+00)*s5 \
v32=(-1.033550e-01)*s0+7.253808e-02*s1+(-4.524167e-01)*s2+(-1.127832e+00)*s3+(-2.002057e+00)*s4+(-1.353848e+00)*s5 \
v33=3.303031e-02*s0+2.394903e-02*s1+3.008802e-01*s2+5.749736e-01*s3+5.416920e-01*s4+1.155173e+00*s5 \
v34=1.015124e+02*s0+9.514446e+00*s1+(-1.224702e+02)*s2+1.591519e+02*s3+5.768433e+01*s4+2.990201e+02*s5 \
v35=2.931980e+01*s0+(-1.252690e+01)*s1+(-5.920637e+03)*s2+(-9.518436e+01)*s3+1.070331e+02*s4+(-9.769317e+02)*s5 \
v36=(-2.074033e+02)*s0+(-1.637159e+01)*s1+2.267716e+03*s2+(-3.482772e+02)*s3+(-5.834792e+01)*s4+(-4.024402e+02)*s5 \
v37=(-4.209747e+00)*s0+7.387060e+00*s1+1.292834e+03*s2+1.223303e+02*s3+(-4.369251e+01)*s4+6.164570e+02*s5 \
v38=(-3.335805e+00)*s0+(-4.452679e-02)*s1+4.604319e+03*s2+6.438632e+00*s3+(-1.277659e+01)*s4+4.059367e+02*s5 \
v39=1.324477e+02*s0+8.006851e+00*s1+(-1.246982e+03)*s2+2.122115e+02*s3+1.974970e+01*s4+3.466402e+02*s5 \
v40=(-1.672179e+01)*s0+8.429509e+00*s1+1.265001e+03*s2+2.766055e+01*s3+(-4.803579e+01)*s4+1.846525e+02*s5 \
v41=2.855608e+00*s0+(-6.674205e-01)*s1+(-2.306172e+02)*s2+(-2.040746e+00)*s3+5.420207e+00*s4+(-1.894387e+01)*s5 \
v42=(-1.256872e+02)*s0+(-1.211669e+01)*s1+(-5.852660e+02)*s2+(-1.881790e+02)*s3+(-3.225316e+02)*s4+(-3.996292e+02)*s5 \
v43=9.967654e+01*s0+2.381593e+01*s1+3.045055e+02*s2+1.349922e+02*s3+1.023845e+03*s4+2.556126e+02*s5 \
v44=1.598136e+00*s0+(-2.525876e-01)*s1+1.528785e-01*s2+2.751267e-01*s3+(-5.775318e-01)*s4+7.250030e+01*s5 \
v45=9.234844e-01*s0+4.073180e-02*s1+(-5.080574e+01)*s2+(-4.951143e+00)*s3+(-8.449701e-02)*s4+(-7.729480e+01)*s5 \
v46=(-1.742118e+00)*s0+4.710098e-02*s1+1.619214e+02*s2+1.932775e+00*s3+4.727666e-01*s4+(-5.988910e+01)*s5 \
v47=2.757899e-02*s0+6.169379e-02*s1+2.236964e-01*s2+5.138878e-01*s3+(-5.304327e-02)*s4+5.732536e-01*s5 \
v48=(-1.352378e-01)*s0+9.505473e-02*s1+1.732870e-01*s2+1.430891e-01*s3+4.636083e+00*s4+2.631122e+00*s5 \
v49=5.594134e-01*s0+(-1.638948e+00)*s1+(-4.548975e+00)*s2+(-4.897946e+00)*s3+(-2.974110e+01)*s4+(-3.944821e+01)*s5 \
v50=3.414631e+00*s0+6.557558e+00*s1+1.309576e+01*s2+1.264480e+01*s3+3.427061e+01*s4+5.556133e+01*s5 \
v51=(-1.999385e+00)*s0+1.589604e+00*s1+6.243349e+00*s2+(-6.206243e+00)*s3+5.684093e+01*s4+1.248839e+02*s5 \
v52=7.598863e-01*s0+2.402707e-01*s1+(-1.155301e+01)*s2+6.476773e+00*s3+(-3.710396e+00)*s4+(-2.759138e+01)*s5 \
v53=(-3.964103e+00)*s0+(-5.622979e+00)*s1+(-1.446108e+01)*s2+2.778288e+01*s3+(-8.639092e+01)*s4+(-2.186047e+02)*s5 \
v54=1.552052e+00*s0+(-1.256191e+00)*s1+1.107497e+01*s2+1.302550e+01*s3+(-3.800477e+01)*s4+(-1.255286e+02)*s5 \
v55=3.128530e-01*s0+3.213236e+00*s1+6.049887e+01*s2+(-3.962431e+01)*s3+4.151899e+01*s4+2.014976e+02*s5 \
v56=2.750193e+00*s0+2.972353e+00*s1+(-7.553690e+01)*s2+(-5.236763e+01)*s3+6.627609e+01*s4+2.226206e+02*s5 \
v57=(-2.450082e-01)*s0+(-2.541327e+00)*s1+7.984402e+01*s2+5.661967e+01*s3+(-3.662919e+01)*s4+(-1.661527e+02)*s5 \
v58=(-1.001099e-01)*s0+(-1.850408e-01)*s1+(-5.984239e-01)*s2+(-4.360460e-01)*s3+(-9.175627e-01)*s4+7.612026e-01*s5 \
v59=(-2.536169e-01)*s0+(-6.862282e-01)*s1+(-8.605914e-01)*s2+(-2.498456e+00)*s3+(-3.562677e+00)*s4+(-4.544954e+00)*s5 \
v60=1.727421e-01*s0+2.263426e-01*s1+1.202916e+00*s2+3.637784e-01*s3+1.388270e+00*s4+(-6.679679e+00)*s5 \
v61=(-7.127974e-02)*s0+(-4.300885e-01)*s1+(-4.586578e-01)*s2+(-7.161574e-01)*s3+(-4.287800e-01)*s4+(-7.794556e-01)*s5 \
v62=4.554177e-02*s0+1.382337e-03*s1+2.895721e-01*s2+9.062263e-01*s3+(-2.042568e-01)*s4+4.015904e-01*s5 \
v63=3.155237e-01*s0+2.904710e+00*s1+2.488409e+00*s2+5.350698e-01*s3+1.236232e+00*s4+1.227789e+01*s5 \
v64=(-1.060758e+00)*s0+(-9.823140e-01)*s1+(-8.962022e+00)*s2+(-8.705729e+00)*s3+5.734955e-01*s4+(-3.228850e+01)*s5 \
v65=6.680963e-01*s0+(-3.327130e+00)*s1+(-5.504997e+00)*s2+6.729075e-01*s3+6.895151e+00*s4+(-4.162100e+01)*s5 \
v66=5.734364e-01*s0+(-4.763319e-01)*s1+5.159570e+00*s2+5.847595e+00*s3+(-3.733474e-01)*s4+1.881487e+01*s5 \
v67=1.672873e+00*s0+(-1.459985e+00)*s1+2.647257e+01*s2+1.591350e+01*s3+(-1.518745e+01)*s4+1.092369e+02*s5 \
v68=(-8.106568e-01)*s0+1.806684e+00*s1+2.713333e+00*s2+8.680044e-01*s3+(-1.005836e+01)*s4+3.268392e+01*s5 \
v69=(-1.080767e+00)*s0+2.295318e+00*s1+(-1.789110e+01)*s2+(-1.218118e+01)*s3+7.383895e+00*s4+(-6.526623e+01)*s5 \
v70=(-4.940083e-01)*s0+9.092799e-01*s1+(-1.913949e+01)*s2+(-1.063187e+01)*s3+1.904827e+01*s4+(-8.380616e+01)*s5 \
v71=4.320287e-01*s0+(-1.278528e+00)*s1+1.191907e+01*s2+7.618117e+00*s3+(-9.746212e+00)*s4+4.982334e+01*s5 \
v72=1.407409e-02*s0+(-1.886416e-01)*s1+(-2.355471e-01)*s2+(-1.743713e-01)*s3+(-2.816399e-01)*s4+(-1.353823e+00)*s5 \
v73=3.372546e-02*s0+9.065877e-02*s1+2.768465e-01*s2+4.475965e-02*s3+1.927680e-01*s4+4.914875e-01*s5 \
v74=(-6.327020e-02)*s0+2.448892e-02*s1+(-3.944397e-01)*s2+1.072740e-01*s3+7.762718e-02*s4+9.394133e-01*s5 \
v75=(-4.423296e-01)*s0+2.251186e-01*s1+(-6.663039e-01)*s2+(-9.878340e-01)*s3+(-5.615902e-01)*s4+(-1.757353e+00)*s5 \
v76=3.713018e+00*s0+2.687380e+00*s1+8.107698e+00*s2+3.420771e+00*s3+5.921461e+00*s4+7.889854e-01*s5 \
v77=8.808828e-01*s0+(-2.254737e-01)*s1+(-9.523060e-01)*s2+3.361810e+00*s3+4.213617e-01*s4+1.017035e+01*s5 \
v78=1.168316e-02*s0+1.555955e+00*s1+(-4.054729e+00)*s2+1.580093e+00*s3+(-6.237219e-01)*s4+2.510610e+00*s5 \
v79=1.553957e+00*s0+7.358034e-01*s1+3.359508e+00*s2+9.778407e+00*s3+8.742803e+00*s4+1.575874e+01*s5 \
v80=(-2.411859e-01)*s0+(-3.798346e-02)*s1+(-1.200328e+00)*s2+(-7.697581e+00)*s3+(-3.558109e+00)*s4+(-1.604715e+01)*s5 \
v81=3.660608e-01*s0+3.325796e-01*s1+4.919417e-01*s2+4.115191e+00*s3+(-1.775714e+00)*s4+4.406574e+00*s5 \
v82=4.062596e-02*s0+2.917322e-01*s1+(-9.132402e-01)*s2+(-8.627248e-01)*s3+2.784900e+00*s4+(-1.431333e+00)*s5 \
v83=(-6.591342e-01)*s0+(-8.836117e-01)*s1+(-1.605447e+00)*s2+(-1.096402e+01)*s3+(-5.536343e-01)*s4+(-1.178915e+01)*s5 \
v84=1.110503e+00*s0+8.864518e-01*s1+1.086049e+00*s2+3.286452e+00*s3+1.244682e+00*s4+1.906544e+00*s5 \
v85=6.483390e-01*s0+(-1.642805e-01)*s1+1.734069e+00*s2+(-4.716199e+00)*s3+8.527936e-01*s4+(-2.764020e+00)*s5 \
v86=(-3.454260e-01)*s0+(-3.556805e-01)*s1+(-1.560204e+00)*s2+5.359271e-01*s3+1.548963e-01*s4+2.337729e+00*s5 \
v87=(-6.655850e-01)*s0+5.780893e-01*s1+(-1.832978e+00)*s2+2.731452e+00*s3+(-7.447624e-01)*s4+2.428015e+00*s5 \
v88=9.329502e-03*s0+(-7.535338e-01)*s1+1.932047e+00*s2+(-5.110063e-01)*s3+4.900133e-02*s4+(-2.766789e+00)*s5 \
v89=2.425131e-01*s0+3.287973e-01*s1+(-2.503858e-01)*s2+1.787733e-01*s3+3.880467e-02*s4+2.883960e-01*s5 \
v90=(-8.708577e-02)*s0+(-9.420361e-04)*s1+(-1.692324e-01)*s2+(-6.060310e-01)*s3+8.342693e-01*s4+2.393701e-01*s5 \
v91=(-1.704219e-01)*s0+(-2.919066e-01)*s1+2.599282e-01*s2+8.051342e-01*s3+(-4.945675e-01)*s4+(-3.465131e-01)*s5 \
v92=1.979044e-01*s0+8.289872e-02*s1+9.520882e-03*s2+(-1.189639e-01)*s3+(-3.571009e-01)*s4+3.103971e-01*s5 \
v93=1.547364e+00*s0+(-1.043561e+00)*s1+7.466270e-01*s2+1.172717e+00*s3+2.749109e-01*s4+2.328482e+00*s5 \
v94=(-3.225048e+00)*s0+3.564555e+00*s1+(-6.353179e+00)*s2+3.053293e+00*s3+(-8.174928e-02)*s4+7.508991e+00*s5 \
v95=(-2.344158e+00)*s0+9.279611e-01*s1+1.643396e+00*s2+(-6.506958e+00)*s3+(-2.964243e+00)*s4+(-1.844634e+01)*s5 \
v96=2.711393e+00*s0+(-3.526401e+00)*s1+7.425972e+00*s2+(-3.679077e+00)*s3+2.534145e-01*s4+(-3.152706e+00)*s5 \
v97=3.370825e+00*s0+9.080420e+00*s1+6.535624e+00*s2+(-1.651375e-01)*s3+5.153128e+00*s4+(-6.056877e+00)*s5 \
v98=1.931218e-01*s0+(-1.970729e+00)*s1+(-1.131263e-01)*s2+9.539608e+00*s3+1.706332e+00*s4+2.180381e+01*s5 \
v99=(-5.989887e-01)*s0+(-6.419027e-01)*s1+(-1.249032e+00)*s2+(-8.727850e+00)*s3+2.169673e+00*s4+(-8.957117e+00)*s5 \
v100=1.579436e+00*s0+3.005281e+00*s1+5.415487e+00*s2+9.176847e+00*s3+2.238169e+00*s4+1.022967e+01*s5 \
v101=6.849914e-01*s0+(-1.333696e-01)*s1+7.313550e-01*s2+1.533786e+01*s3+(-2.967312e+00)*s4+1.579975e+01*s5 \
v102=1.000000e+04*s0+1.000000e+04*s1+2.770313e+02*s2+(-3.135144e+00)*s3+(-3.249684e+00)*s4+(-5.130528e+00)*s5 \
v103=1.000000e+04*s0+1.000000e+04*s1+(-6.733004e+02)*s2+1.220066e+01*s3+(-4.773398e+00)*s4+3.448727e+01*s5 \
v104=1.000000e+04*s0+1.000000e+04*s1+(-3.292604e+01)*s2+1.408321e+00*s3+9.420415e+00*s4+(-1.112837e+01)*s5 \
v105=1.000000e+04*s0+1.000000e+04*s1+4.378140e+02*s2+(-6.583558e+00)*s3+9.547415e+00*s4+(-2.690957e+01)*s5 \
v106=1.000000e+04*s0+(-1.000000e+04)*s1+(-3.204861e+01)*s2+2.427376e-01*s3+(-1.237739e+01)*s4+1.391999e+01*s5 \
v107=1.000000e+04*s0+1.000000e+04*s1+1.345699e+02*s2+(-1.617933e+00)*s3+1.459720e+00*s4+(-2.460318e+00)*s5 \
v108=(-1.000000e+04)*s0+2.633465e+01*s1+(-4.655664e+01)*s2+3.454763e+00*s3+2.539029e+00*s4+(-3.734882e+00)*s5 \
v109=(-1.000000e+04)*s0+(-8.204365e+01)*s1+3.864693e+01*s2+(-1.551975e+00)*s3+(-2.363966e+00)*s4+1.422209e+00*s5 \
v110=(-1.000000e+04)*s0+(-1.071129e+01)*s1+(-9.525781e+00)*s2+(-2.528203e+00)*s3+3.943982e-01*s4+6.475154e-01*s5 \
v111=1.312568e+00*s0+(-2.228819e+01)*s1+6.492706e+02*s2+(-3.514484e+01)*s3+1.000000e+04*s4+1.000000e+04*s5 \
v112=(-2.346281e+00)*s0+2.251465e-01*s1+8.914350e+01*s2+(-7.432629e+00)*s3+(-1.763390e+03)*s4+1.000000e+04*s5 \
v113=(-2.478071e-01)*s0+6.795423e+01*s1+(-1.491391e+03)*s2+1.625318e+02*s3+(-8.388432e+03)*s4+1.000000e+04*s5 \
v114=2.072253e+00*s0+1.923315e+00*s1+6.746233e+03*s2+1.500990e+02*s3+(-1.000000e+04)*s4+1.000000e+04*s5 \
v115=(-1.443221e+00)*s0+(-5.801772e+00)*s1+(-1.000000e+04)*s2+(-3.527483e+02)*s3+(-1.000000e+04)*s4+1.000000e+04*s5 \
v116=9.725232e-01*s0+(-4.132752e+01)*s1+4.252311e+03*s2+3.796780e+01*s3+(-3.840727e+02)*s4+1.000000e+04*s5 \
v117=5.101587e-02*s0+(-9.763444e-02)*s1+1.094198e+01*s2+3.322268e+01*s3+(-1.214271e+03)*s4+(-1.000000e+04)*s5 \
v118=(-3.029318e-01)*s0+3.826348e-02*s1+(-1.215688e+03)*s2+(-5.336377e+01)*s3+(-2.645121e+03)*s4+(-1.000000e+04)*s5 \
v119=1.723252e-01*s0+9.308381e-01*s1+8.443077e+02*s2+9.396770e-01*s3+(-2.659105e+03)*s4+(-1.000000e+04)*s5 \
v120=1.023177e+01*s0+1.474896e+01*s1+5.645271e+00*s2+1.869025e+01*s3+5.989756e+02*s4+5.529935e+02*s5 \
v121=(-2.872215e+01)*s0+(-6.632381e+00)*s1+(-1.457397e+01)*s2+9.802185e+01*s3+(-4.585610e+02)*s4+9.578535e+00*s5 \
v122=(-7.340390e-01)*s0+(-1.658380e+01)*s1+3.173153e+00*s2+6.308823e+00*s3+4.392389e+01*s4+(-1.161972e+03)*s5 \
v123=2.765341e+01*s0+2.446900e+00*s1+8.779781e+00*s2+(-9.693377e+00)*s3+(-1.297716e+02)*s4+(-6.800136e+02)*s5 \
v124=(-7.320121e+00)*s0+4.113400e+00*s1+(-2.534869e+00)*s2+(-2.002158e+02)*s3+(-2.307239e+01)*s4+1.311764e+03*s5 \
v125=2.724788e+00*s0+5.862271e+00*s1+(-4.082437e-01)*s2+3.111979e+01*s3+2.741249e+00*s4+(-3.218933e+01)*s5 \
v126=8.569912e+00*s0+(-4.134636e+00)*s1+(-3.775409e+00)*s2+(-9.791738e+01)*s3+(-3.803560e+02)*s4+2.005446e+01*s5 \
v127=(-5.903356e+00)*s0+2.538524e+00*s1+3.474129e-01*s2+2.739868e+01*s3+3.850881e+02*s4+(-3.197560e+01)*s5 \
v128=(-4.270424e+00)*s0+1.581477e+00*s1+3.305152e+00*s2+7.975484e+01*s3+(-2.617661e+01)*s4+1.218982e+01*s5 \
v129=3.655788e+00*s0+(-1.057114e+01)*s1+(-5.791132e-01)*s2+(-5.719140e+00)*s3+(-6.022556e+00)*s4+(-1.697951e+00)*s5 \
v130=(-4.016488e+00)*s0+3.659556e+01*s1+1.147862e+00*s2+4.431023e+01*s3+4.266948e+01*s4+3.045189e+01*s5 \
v131=(-8.422468e+00)*s0+1.486558e+01*s1+(-1.011973e+00)*s2+(-4.657978e+00)*s3+4.050489e+00*s4+(-4.241486e+00)*s5 \
v132=1.305275e+02*s0+6.121514e+01*s1+1.375468e+00*s2+7.716338e+01*s3+8.400389e+01*s4+9.722046e+01*s5 \
v133=2.694153e+00*s0+(-4.848776e+01)*s1+7.308185e+00*s2+4.551525e+00*s3+(-1.093120e+01)*s4+(-1.192574e+01)*s5 \
v134=2.562900e+00*s0+(-3.742606e+00)*s1+5.706384e-02*s2+(-3.666424e+00)*s3+(-2.645611e-01)*s4+4.991627e+00*s5 \
v135=(-1.718071e+00)*s0+1.264183e+00*s1+1.254241e-01*s2+(-1.234704e+00)*s3+4.539589e+00*s4+4.422888e+00*s5 \
v136=2.034524e+01*s0+(-5.818633e+00)*s1+(-2.751165e+00)*s2+1.032600e+01*s3+(-2.900053e+00)*s4+(-9.242998e+00)*s5 \
v137=5.917448e+00*s0+(-1.033711e+00)*s1+9.443524e-01*s2+(-1.872797e+01)*s3+(-1.153292e+01)*s4+(-2.787718e+00)*s5 \
v138=1.419245e+01*s0+2.069647e+01*s1+1.625885e+01*s2+1.313975e+01*s3+1.557557e+01*s4+1.523082e+01*s5 \
v139=(-1.896792e+01)*s0+(-3.078045e+01)*s1+3.132359e+01*s2+(-1.590854e+01)*s3+(-2.298834e+01)*s4+(-2.202531e+01)*s5 \
v140=1.572645e-01*s0+3.611871e+00*s1+(-3.522815e+01)*s2+(-1.285980e+00)*s3+(-7.965681e-01)*s4+(-4.533571e-01)*s5 \
v141=8.141741e+00*s0+1.356497e+01*s1+(-2.499484e+01)*s2+5.906639e+00*s3+1.084798e+01*s4+1.027375e+01*s5 \
v142=2.439013e-01*s0+(-1.521044e+00)*s1+8.586432e+00*s2+1.794930e+00*s3+3.325150e-01*s4+2.981243e-01*s5 \
v143=(-2.050820e-01)*s0+1.503088e-01*s1+1.385947e+01*s2+(-3.707834e-01)*s3+6.822114e-02*s4+2.393456e-01*s5 \
v144=1.464159e+00*s0+7.060899e-01*s1+2.891630e+00*s2+1.117560e+00*s3+(-2.330091e+00)*s4+(-1.264800e+00)*s5 \
v145=(-1.262143e+00)*s0+(-2.390854e-01)*s1+2.810811e+00*s2+(-1.075780e+00)*s3+1.724634e+00*s4+1.605457e+00*s5 \
v146=(-1.241152e-01)*s0+4.213720e-01*s1+(-9.326200e+00)*s2+(-4.800745e-01)*s3+7.878660e-01*s4+(-9.265226e-01)*s5 \
v147=1.283953e+01*s0+2.119310e+00*s1+(-1.089768e+01)*s2+1.274096e+01*s3+6.624977e+00*s4+2.355970e+01*s5 \
v148=(-4.027190e+01)*s0+4.248109e+01*s1+2.888117e+01*s2+(-3.238322e+01)*s3+2.071466e+01*s4+(-2.029372e+01)*s5 \
v149=1.041377e+01*s0+(-1.497114e+00)*s1+2.589230e+01*s2+4.632011e+00*s3+(-2.603055e+01)*s4+(-5.717759e+01)*s5 \
v150=2.662795e+01*s0+(-3.878936e+01)*s1+(-2.102369e+01)*s2+3.471833e+01*s3+(-3.731731e+01)*s4+(-6.276244e+00)*s5 \
v151=(-4.057747e+00)*s0+(-1.046839e+00)*s1+(-1.848925e+01)*s2+(-5.081667e+01)*s3+4.909674e+01*s4+3.816856e+01*s5 \
v152=(-5.791477e+00)*s0+1.274224e+00*s1+1.008978e+01*s2+3.809422e+01*s3+1.133760e+01*s4+2.659222e+01*s5 \
v153=(-8.049391e+00)*s0+(-3.877484e+00)*s1+(-2.878027e+00)*s2+(-1.699682e+01)*s3+2.121104e+01*s4+1.190693e+01*s5 \
v154=7.372491e+00*s0+9.194778e+00*s1+(-3.333964e+00)*s2+1.772282e+01*s3+2.962315e+01*s4+(-2.404123e+01)*s5 \
v155=1.587547e+00*s0+(-2.661265e+00)*s1+(-3.862388e+00)*s2+1.296181e+01*s3+(-3.769792e+01)*s4+2.549886e+01*s5 \
v156=(-3.134578e+00)*s0+8.218980e+01*s1+(-4.678456e+00)*s2+(-2.143796e+00)*s3+(-1.179734e+00)*s4+(-1.979285e+00)*s5 \
v157=1.440699e+01*s0+(-2.810025e+02)*s1+7.221803e+01*s2+1.287191e+01*s3+5.135733e+00*s4+3.155515e+00*s5 \
v158=(-4.177037e-01)*s0+(-7.869225e+01)*s1+(-2.227696e+01)*s2+1.756677e+00*s3+2.821348e+00*s4+9.486291e+00*s5 \
v159=(-7.606404e+00)*s0+3.342034e+02*s1+1.624769e+02*s2+(-5.072986e+00)*s3+4.595284e+00*s4+(-6.824143e+00)*s5 \
v160=6.919976e-01*s0+2.146663e+02*s1+7.843733e+01*s2+1.317653e+00*s3+(-5.861063e+00)*s4+1.620338e+01*s5 \
v161=8.916236e-02*s0+2.669670e+01*s1+(-3.168524e+01)*s2+(-6.398027e+00)*s3+(-6.604489e-01)*s4+(-1.612626e+01)*s5 \
v162=1.955852e-01*s0+8.285168e-01*s1+(-2.113867e+00)*s2+1.713865e+00*s3+(-1.821679e+00)*s4+4.087800e+00*s5 \
v163=(-2.199197e-01)*s0+1.647854e-01*s1+(-1.230408e+01)*s2+(-4.882418e+00)*s3+(-4.213335e+00)*s4+(-4.377664e+00)*s5 \
v164=3.775029e-01*s0+(-7.560201e+00)*s1+9.700029e+00*s2+(-6.859986e-01)*s3+3.930908e+00*s4+(-7.221813e+00)*s5 \
v165=(-6.748715e-01)*s0+1.306759e+01*s1+5.265881e+00*s2+(-5.933818e+02)*s3+1.528039e+01*s4+(-2.922637e+01)*s5 \
v166=3.739212e+00*s0+(-1.270153e+01)*s1+(-5.680809e+00)*s2+(-5.505007e+01)*s3+(-2.213020e+01)*s4+6.018808e+01*s5 \
v167=2.053230e-01*s0+(-3.040249e+00)*s1+4.902860e-01*s2+(-2.393593e+03)*s3+(-9.574195e+00)*s4+3.368548e+01*s5 \
v168=(-4.912724e+00)*s0+5.992960e+00*s1+2.163738e+00*s2+(-3.601088e+00)*s3+8.755922e+00*s4+(-2.526676e-01)*s5 \
v169=4.753480e+00*s0+1.447500e-01*s1+(-2.265521e-01)*s2+9.046596e+00*s3+9.135678e+00*s4+(-9.080057e+01)*s5 \
v170=(-1.976079e+00)*s0+1.922320e-02*s1+(-3.175643e-02)*s2+(-1.196584e+00)*s3+4.678829e+00*s4+1.970966e+01*s5 \
v171=(-2.141476e+00)*s0+(-8.968827e-01)*s1+8.818314e-01*s2+4.842298e+02*s3+4.927921e+00*s4+(-1.364638e+01)*s5 \
v172=1.420005e+00*s0+(-2.441264e-01)*s1+(-1.176357e+00)*s2+1.372464e+02*s3+(-2.099259e+00)*s4+3.336469e+00*s5 \
v173=8.389759e-01*s0+7.884987e-01*s1+3.268704e-01*s2+5.618986e+02*s3+(-1.235961e+00)*s4+2.268038e+01*s5 \
v174=(-2.295318e+03)*s0+1.081388e+01*s1+1.925018e+01*s2+5.323690e+03*s3+1.127737e+02*s4+1.788288e+03*s5 \
v175=5.500828e+03*s0+3.509757e+01*s1+1.841676e+01*s2+7.261737e+03*s3+(-1.308829e+02)*s4+(-2.786761e+03)*s5 \
v176=(-1.857595e+02)*s0+(-3.628207e+01)*s1+(-9.798378e-01)*s2+3.382739e+03*s3+(-1.651298e+02)*s4+(-1.783453e+03)*s5 \
v177=(-3.162341e+03)*s0+3.093105e+00*s1+(-2.574477e+01)*s2+2.597552e+03*s3+(-1.397243e+02)*s4+8.335387e+02*s5 \
v178=(-2.813915e+01)*s0+3.406555e+01*s1+(-1.355666e+01)*s2+1.714764e+03*s3+3.673151e+02*s4+1.648375e+03*s5 \
v179=1.205141e+02*s0+1.300210e+01*s1+1.060143e+00*s2+1.000000e+04*s3+(-8.848191e+00)*s4+7.522005e+02*s5 \
v180=(-1.000000e+04)*s0+(-4.079227e+00)*s1+(-1.540071e+00)*s2+8.041840e+02*s3+(-6.324848e+01)*s4+5.692855e+03*s5 \
v181=(-1.000000e+04)*s0+7.984972e+00*s1+3.122627e+01*s2+2.761520e+02*s3+1.100295e+02*s4+(-4.146950e+03)*s5 \
v182=(-1.000000e+04)*s0+(-2.152717e+00)*s1+(-3.118458e+01)*s2+3.367346e+03*s3+(-1.422944e+01)*s4+(-3.898146e+03)*s5 \
v183=3.753681e-01*s0+8.059397e-02*s1+1.733057e+00*s2+9.035250e-01*s3+(-1.549104e-01)*s4+(-1.170926e+00)*s5 \
v184=1.866044e+00*s0+(-2.883963e+00)*s1+(-6.136537e+00)*s2+(-5.284993e+00)*s3+1.342364e+00*s4+6.086357e+00*s5 \
v185=(-1.528885e+00)*s0+1.536844e+00*s1+1.326739e+00*s2+(-3.396419e-01)*s3+7.522132e-01*s4+(-2.059721e+00)*s5 \
v186=1.966043e+00*s0+7.314148e+00*s1+1.260098e+01*s2+3.213945e+00*s3+(-1.133875e+00)*s4+5.952260e+00*s5 \
v187=1.798448e-01*s0+(-3.208351e+00)*s1+(-4.212195e+00)*s2+7.314762e+00*s3+(-9.206255e-01)*s4+(-1.487552e+01)*s5 \
v188=8.647780e-01*s0+(-4.327171e-01)*s1+(-9.691450e-01)*s2+(-1.704511e+00)*s3+(-5.978162e-01)*s4+1.008469e+01*s5 \
v189=1.173957e+00*s0+4.546090e-01*s1+(-1.642029e-01)*s2+1.664421e+00*s3+(-2.106146e+00)*s4+(-3.280144e+00)*s5 \
v190=(-1.172532e+00)*s0+(-1.879873e+00)*s1+(-2.299650e+00)*s2+1.978600e+00*s3+1.864868e+00*s4+3.028391e+00*s5 \
v191=(-2.162563e-01)*s0+6.160306e-01*s1+2.484018e+00*s2+(-3.023271e+00)*s3+1.825344e+00*s4+1.342416e+00*s5 \
v192=(-1.000000e+04)*s0+4.642240e+01*s1+6.503456e+03*s2+(-2.258969e+03)*s3+(-9.618748e+03)*s4+(-1.688835e+01)*s5 \
v193=(-1.000000e+04)*s0+(-1.016610e+02)*s1+9.188524e+03*s2+(-2.769970e+03)*s3+2.892295e+03*s4+1.653562e+01*s5 \
v194=(-1.000000e+04)*s0+1.198035e+00*s1+(-9.506050e+03)*s2+5.265859e+03*s3+1.420603e+03*s4+8.690487e+01*s5 \
v195=(-1.000000e+04)*s0+5.647952e+01*s1+1.000000e+04*s2+9.972520e+02*s3+4.721831e+03*s4+1.222689e+01*s5 \
v196=(-1.000000e+04)*s0+(-1.011244e+00)*s1+(-1.000000e+04)*s2+8.181943e+02*s3+2.832163e+03*s4+(-1.180924e+02)*s5 \
v197=(-1.000000e+04)*s0+(-1.518580e-01)*s1+(-6.180109e+03)*s2+4.572356e+03*s3+3.734439e+03*s4+(-5.638598e+00)*s5 \
v198=(-1.000000e+04)*s0+7.118537e+00*s1+3.200976e+03*s2+9.428227e+00*s3+(-4.271220e+02)*s4+(-2.092344e+01)*s5 \
v199=(-1.000000e+04)*s0+(-7.809821e+00)*s1+(-7.837176e+02)*s2+(-4.599118e+01)*s3+(-1.459942e+02)*s4+2.831658e+01*s5 \
v200=(-1.000000e+04)*s0+3.469714e+00*s1+(-2.354262e+03)*s2+1.342965e+01*s3+2.621485e+01*s4+(-8.156933e+00)*s5 \
v201=(-1.000000e+04)*s0+1.269452e+02*s1+1.565263e+02*s2+6.862748e+02*s3+(-8.748766e+03)*s4+(-2.480370e+02)*s5 \
v202=(-1.000000e+04)*s0+(-1.062105e+02)*s1+(-1.889993e+02)*s2+(-2.811917e+03)*s3+(-5.558084e+03)*s4+1.539833e+03*s5 \
v203=(-1.000000e+04)*s0+(-1.990422e-01)*s1+3.450733e+02*s2+3.578227e+02*s3+(-9.220742e+03)*s4+6.657639e+01*s5 \
v204=(-1.000000e+04)*s0+(-2.332487e+02)*s1+1.162415e+02*s2+(-4.614140e+03)*s3+(-9.057678e+03)*s4+(-3.304186e+02)*s5 \
v205=(-1.000000e+04)*s0+(-3.757303e+02)*s1+(-4.020759e+02)*s2+6.558320e+03*s3+(-9.171305e+03)*s4+(-3.349539e+03)*s5 \
v206=(-1.000000e+04)*s0+6.617503e+01*s1+1.757582e+02*s2+9.092516e+03*s3+(-9.720043e+03)*s4+1.221007e+03*s5 \
v207=(-1.000000e+04)*s0+(-2.363527e+01)*s1+5.467176e+01*s2+1.102980e+02*s3+2.667247e+03*s4+2.657283e+03*s5 \
v208=(-1.000000e+04)*s0+(-3.549975e+01)*s1+(-1.209318e+02)*s2+1.058451e+02*s3+1.081015e+03*s4+(-2.142580e+03)*s5 \
v209=(-1.000000e+04)*s0+1.542496e+01*s1+2.851853e+02*s2+7.882083e+01*s3+2.430497e+03*s4+(-2.781039e+03)*s5 \
_p0=v0+v1*od_+v2*w_+v3*od_*w_ \
_p1=_p0+v4*(s_-0.446)+v5*(s_-0.446)*od_+v6*(s_-0.446)*w_ \
_p2=0.5*(_p1+sqrt(_p1*_p1+0.001)) \
_p3=1e-15*_p2 \
_p4=v7+v8*od_+v9*w_+v10*od_*w_+v11*od_*od_+v12*w_*w_+v13*od_/w_+v14*od_*od_/w_/w_+v15/w_jump_+v16/(w_jump_*w_jump_) \
_p5=_p4+v17*(s_-0.446)+v18*(s_-0.446)*od_+v19*(s_-0.446)*w_ \
_p6=synw_drs*0.5*(_p5+sqrt(_p5*_p5+0.001)) \
_p7=v20/od_+v21/w_+v22+v23*od_+v24*w_+v25*od_*od_+v26*od_*w_+v27*w_*w_+v28*od_*od_*w_+v29*od_*w_*w_+v30*od_*od_*w_*w_ \
_p8=_p7+v31*(s_-0.446)+v32*(s_-0.446)*od_+v33*(s_-0.446)*w_ \
_p9=0.5*(_p8+sqrt(_p8*_p8+0.001)) \
_p10=synw_dls*1e-09*_p9 \
_p11=synw_dls*1e-09*_p9 \
_p12=v34+v35*od_+v36*w_+v37*od_*w_+v38*od_*od_+v39*w_*w_+v40*od_/w_+v41*od_*od_/w_/w_+v42/w_jump_+v43/(w_jump_*w_jump_) \
_p13=_p12+v44*(s_-0.446)+v45*(s_-0.446)*od_+v46*(s_-0.446)*w_ \
_p14=synw_drs*0.5*(_p13+sqrt(_p13*_p13+0.001)) \
_p15=v47/od_+v48/w_+v49+v50*od_+v51*w_+v52*od_*od_+v53*od_*w_+v54*w_*w_+v55*od_*od_*w_+v56*od_*w_*w_+v57*od_*od_*w_*w_ \
_p16=_p15+v58*(s_-0.446)+v59*(s_-0.446)*od_+v60*(s_-0.446)*w_ \
_p17=0.5*(_p16+sqrt(_p16*_p16+0.001)) \
_p18=synw_dls*1e-09*_p17 \
_p19=v61/od_+v62/w_+v63+v64*od_+v65*w_+v66*od_*od_+v67*od_*w_+v68*w_*w_+v69*od_*od_*w_+v70*od_*w_*w_+v71*od_*od_*w_*w_ \
_p20=_p19+v72*(s_-0.446)+v73*(s_-0.446)*od_+v74*(s_-0.446)*w_ \
_p21=0.5*(atan(2*_p20)/1.5708+1) \
_p22=v75+v76*od_+v77*w_+v78*od_*od_+v79*od_*w_+v80*w_*w_ \
_p23=_p22+v81*(s_-0.446)+v82*(s_-0.446)*od_+v83*(s_-0.446)*w_ \
_p24=0.5*(_p23+sqrt(_p23*_p23+0.001)) \
_p25=v84+v85*od_+v86*w_+v87*od_*od_+v88*od_*w_+v89*w_*w_ \
_p26=_p25+v90*(s_-0.446)+v91*(s_-0.446)*od_+v92*(s_-0.446)*w_ \
_p27=0.5*(_p26+sqrt(_p26*_p26+0.001)) \
_p28=v93+v94*od_+v95*w_+v96*od_*od_+v97*od_*w_+v98*w_*w_ \
_p29=_p28+v99*(s_-0.446)+v100*(s_-0.446)*od_+v101*(s_-0.446)*w_ \
_p30=0.5*(_p29+sqrt(_p29*_p29+0.001)) \
_p31=v102+v103*od_+v104*w_+v105*od_*od_+v106*od_*w_+v107*w_*w_ \
_p32=_p31+v108*(s_-0.446)+v109*(s_-0.446)*od_+v110*(s_-0.446)*w_ \
_p33=0.5*(_p32+sqrt(_p32*_p32+0.001)) \
_p34=1e-14*_p24 \
_p35=100*_p27 \
_p36=1e-14*_p24 \
_p37=100*_p27 \
_p38=1e-14*_p30 \
_p39=100*_p33 \
_p40=v111+v112*od_+v113*w_+v114*od_*od_+v115*od_*w_+v116*w_*w_ \
_p41=_p40+v117*(s_-0.446)+v118*(s_-0.446)*od_+v119*(s_-0.446)*w_ \
_p42=0.5*(_p41+sqrt(_p41*_p41+0.001)) \
_p43=100*_p42 \
_p44=v120+v121*od_+v122*w_+v123*od_*od_+v124*od_*w_+v125*w_*w_ \
_p45=_p44+v126*(s_-0.446)+v127*(s_-0.446)*od_+v128*(s_-0.446)*w_ \
_p46=0.5*(_p45+sqrt(_p45*_p45+0.001)) \
_p47=100*_p46 \
_p48=100*_p46 \
_p49=v129+v130*od_+v131*w_+v132*od_*od_+v133*od_*w_+v134*w_*w_ \
_p50=_p49+v135*(s_-0.446)+v136*(s_-0.446)*od_+v137*(s_-0.446)*w_ \
_p51=0.5*(_p50+sqrt(_p50*_p50+0.001)) \
_p52=v138+v139*od_+v140*w_+v141*od_*od_+v142*od_*w_+v143*w_*w_ \
_p53=_p52+v144*(s_-0.446)+v145*(s_-0.446)*od_+v146*(s_-0.446)*w_ \
_p54=0.5*(_p53+sqrt(_p53*_p53+0.001)) \
_p55=v147+v148*od_+v149*w_+v150*od_*od_+v151*od_*w_+v152*w_*w_ \
_p56=_p55+v153*(s_-0.446)+v154*(s_-0.446)*od_+v155*(s_-0.446)*w_ \
_p57=0.5*(_p56+sqrt(_p56*_p56+0.001)) \
_p58=v156+v157*od_+v158*w_+v159*od_*od_+v160*od_*w_+v161*w_*w_ \
_p59=_p58+v162*(s_-0.446)+v163*(s_-0.446)*od_+v164*(s_-0.446)*w_ \
_p60=0.5*(_p59+sqrt(_p59*_p59+0.001)) \
_p61=v165+v166*od_+v167*w_+v168*od_*od_+v169*od_*w_+v170*w_*w_ \
_p62=_p61+v171*(s_-0.446)+v172*(s_-0.446)*od_+v173*(s_-0.446)*w_ \
_p63=0.5*(_p62+sqrt(_p62*_p62+0.001)) \
_p64=v174+v175*od_+v176*w_+v177*od_*od_+v178*od_*w_+v179*w_*w_ \
_p65=_p64+v180*(s_-0.446)+v181*(s_-0.446)*od_+v182*(s_-0.446)*w_ \
_p66=0.5*(_p65+sqrt(_p65*_p65+0.001)) \
_p67=v183+v184*od_+v185*w_+v186*od_*od_+v187*od_*w_+v188*w_*w_ \
_p68=_p67+v189*(s_-0.446)+v190*(s_-0.446)*od_+v191*(s_-0.446)*w_ \
_p69=0.5*(_p68+sqrt(_p68*_p68+0.001)) \
_p70=v192+v193*od_+v194*w_+v195*od_*od_+v196*od_*w_+v197*w_*w_ \
_p71=_p70+v198*(s_-0.446)+v199*(s_-0.446)*od_+v200*(s_-0.446)*w_ \
_p72=0.5*(_p71+sqrt(_p71*_p71+0.001)) \
_p73=v201+v202*od_+v203*w_+v204*od_*od_+v205*od_*w_+v206*w_*w_ \
_p74=_p73+v207*(s_-0.446)+v208*(s_-0.446)*od_+v209*(s_-0.446)*w_ \
_p75=0.5*(_p74+sqrt(_p74*_p74+0.001)) \
_p76=1e-14*_p51 \
_p77=synw_drs_sub*100*_p54 \
_p78=1e-15*_p57 \
_p79=1e-14*_p51 \
_p80=synw_drs_sub*100*_p54 \
_p81=1e-15*_p57 \
_p82=1e-14*_p60 \
_p83=synw_drs_sub*100*_p63 \
_p84=1e-15*_p66 \
_p85=1e-14*_p69 \
_p86=100*_p72 \
_p87=1e-15*_p75
cs (outer inner) capacitor c=_p3
rs1_1 (outer n1_1) resistor r=_p6
ls1_1 (n1_1 ni_1) inductor l=_p10
rs2_1 (ni_1 n2_1) resistor r=_p6
ls2_1 (n2_1 inner) inductor l=_p11
rs1_2 (outer n1_2) resistor r=_p14
ls1_2 (n1_2 inner) inductor l=_p18
k1 mutual_inductor coupling=_p21 ind1=ls1_1 ind2=ls1_2
k2 mutual_inductor coupling=_p21 ind1=ls2_1 ind2=ls1_2
c_1_wsub (outer _n1_1_wsub) capacitor c=_p34
rs_1_wsub (_n1_1_wsub nwell) resistor r=_p35
c_2_wsub (inner _n1_2_wsub) capacitor c=_p36
rs_2_wsub (_n1_2_wsub nwell) resistor r=_p37
c_3_wsub (ni_1 _n1_3_wsub) capacitor c=_p38
rs_3_wsub (_n1_3_wsub nwell) resistor r=_p39
rx_1_2_wsub (_n1_1_wsub _n1_2_wsub) resistor r=_p43
rx_1_3_wsub (_n1_1_wsub _n1_3_wsub) resistor r=_p47
rx_2_3_wsub (_n1_2_wsub _n1_3_wsub) resistor r=_p48
c_1_sub (_n1_1_wsub _n1_1_sub) capacitor c=_p76
rs_1_sub (_n1_1_sub sub) resistor r=_p77
cs_1_sub (_n1_1_sub sub) capacitor c=_p78
c_2_sub (_n1_2_wsub _n1_2_sub) capacitor c=_p79
rs_2_sub (_n1_2_sub sub) resistor r=_p80
cs_2_sub (_n1_2_sub sub) capacitor c=_p81
c_3_sub (_n1_3_wsub _n1_3_sub) capacitor c=_p82
rs_3_sub (_n1_3_sub sub) resistor r=_p83
cs_3_sub (_n1_3_sub sub) capacitor c=_p84
c_4_sub (nwell _n1_4_sub) capacitor c=_p85
rs_4_sub (_n1_4_sub sub) resistor r=_p86
cs_4_sub (_n1_4_sub sub) capacitor c=_p87
ends lnw_sy40k_rfvil
