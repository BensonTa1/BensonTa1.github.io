simulator lang=spectre insensitive=yes
// model: lnw_sy40kct_rfvil
// planar symmetric center-tapped rf inductor, n well, 4.0um metal8
// umc 110nm 1p8m1t1u rfcmos process
// date: 2011-05-05
// model coverage:(before shrinkage)
// od: (75 - 299) * 1e-06
// w: (2.23 - 9.7) * 1e-06
// s: (2.23 - 5) * 1e-06
// nt: 2 - 7
// frequency range: 100mhz - 0.8 * resonance (maximum 20.0 ghz)
subckt lnw_sy40kct_rfvil (p1 p2 ct nwell sub)
parameters od=0.00015 od_=od/0.000299 w=6e-06 w_=w/9.99e-06 w_jump_=max(floor((w_-0.04004)/0.0700701), 1) s=2.52e-06 s_=s/5e-06 nt=3  \
s0=(nt==1) \
s1=(nt==2) \
s2=(nt==3) \
s3=(nt==4) \
s4=(nt==5) \
s5=(nt==6) \
s6=(nt==7) \
v0=(-7.411562e-03)*s0+(-2.242751e-02)*s1+(-4.340648e-03)*s2+7.901743e-01*s3+1.533431e-01*s4+(-1.661338e-01)*s5+1.398267e-01*s6 \
v1=(-1.238658e-02)*s0+1.063351e-01*s1+1.932456e-01*s2+5.121026e-01*s3+2.057963e-01*s4+1.559930e+00*s5+(-7.219896e-01)*s6 \
v2=7.156954e-02*s0+(-4.488049e-01)*s1+(-3.636612e-01)*s2+(-8.264758e+00)*s3+(-1.532271e+00)*s4+(-8.951461e+00)*s5+(-4.075411e+00)*s6 \
v3=2.143197e-01*s0+8.520173e-01*s1+(-1.037015e+00)*s2+6.448605e+00*s3+(-9.510120e-01)*s4+5.597718e+00*s5+2.014593e+01*s6 \
v4=1.448107e-01*s0+7.502430e-01*s1+(-3.431304e-01)*s2+4.249232e+00*s3+(-5.555233e-03)*s4+1.584897e+01*s5+2.251007e+01*s6 \
v5=4.029924e-01*s0+(-1.236392e-01)*s1+1.525517e+00*s2+2.445715e+00*s3+6.012863e+00*s4+4.111582e+00*s5+3.103145e+00*s6 \
v6=(-9.821661e-01)*s0+(-7.416873e-01)*s1+5.796831e+00*s2+1.267867e+00*s3+6.385960e+00*s4+(-7.195518e+00)*s5+(-4.959995e+01)*s6 \
v7=(-1.694568e-01)*s0+(-5.856900e-01)*s1+(-1.856051e-01)*s2+1.524193e+00*s3+(-7.773142e+00)*s4+(-9.740841e+00)*s5+(-7.918595e+00)*s6 \
v8=3.725097e-02*s0+1.426556e+00*s1+(-1.452032e-01)*s2+(-9.543100e+00)*s3+(-1.176095e+01)*s4+(-8.522658e+00)*s5+1.323807e+01*s6 \
v9=8.254885e-01*s0+1.105348e+00*s1+(-2.210349e+00)*s2+5.918855e+00*s3+4.088411e+01*s4+4.975090e+00*s5+(-5.393040e+00)*s6 \
v10=(-6.199582e-02)*s0+(-1.503834e+00)*s1+(-1.435531e+00)*s2+1.112503e+02*s3+(-1.161191e+01)*s4+4.810683e+00*s5+1.566286e+01*s6 \
v11=1.920713e-02*s0+5.025051e-03*s1+(-1.681737e-01)*s2+(-9.916882e-01)*s3+5.099163e-01*s4+(-1.113798e+00)*s5+(-8.115750e-01)*s6 \
v12=(-8.381197e-02)*s0+(-7.565522e-02)*s1+(-1.736471e-01)*s2+7.096635e-01*s3+(-1.268747e+00)*s4+(-6.019688e-01)*s5+(-7.356961e+00)*s6 \
v13=(-3.477628e-02)*s0+(-4.617025e-02)*s1+1.696324e-01*s2+2.616334e+00*s3+(-1.752230e+00)*s4+9.469442e-01*s5+5.175390e+00*s6 \
v14=1.790377e-01*s0+1.216354e+00*s1+6.352039e-01*s2+8.806678e+00*s3+6.142891e+01*s4+6.699419e+01*s5+1.353381e+02*s6 \
v15=1.844307e+00*s0+3.808230e+01*s1+3.286578e+00*s2+(-1.070747e+02)*s3+(-8.573398e+01)*s4+3.993171e-01*s5+(-2.684348e+01)*s6 \
v16=5.993239e-01*s0+(-8.456168e+00)*s1+(-1.977606e+00)*s2+(-7.728645e+00)*s3+(-6.879437e+01)*s4+(-8.723336e+01)*s5+(-2.044203e+02)*s6 \
v17=(-8.697726e-03)*s0+(-2.062396e+01)*s1+(-4.321264e+00)*s2+6.054924e+01*s3+3.457865e+01*s4+(-1.969414e+01)*s5+3.664980e+01*s6 \
v18=(-3.474402e-01)*s0+(-5.519908e+00)*s1+1.101718e+00*s2+2.631893e+00*s3+1.724319e+01*s4+2.042448e+01*s5+1.785526e+00*s6 \
v19=(-5.254958e-01)*s0+5.871899e+00*s1+2.362902e+00*s2+1.476431e+00*s3+3.049016e+01*s4+4.448891e+01*s5+9.472121e+01*s6 \
v20=3.335025e-01*s0+(-7.939658e+00)*s1+9.839529e-01*s2+5.467054e+01*s3+3.476553e+01*s4+3.355292e+00*s5+1.037607e+01*s6 \
v21=2.128967e-01*s0+1.906611e-01*s1+(-2.958535e-01)*s2+(-4.416350e+00)*s3+(-2.870350e+00)*s4+(-2.182949e+00)*s5+(-1.156532e+00)*s6 \
v22=4.285740e+00*s0+(-4.243726e+00)*s1+(-1.040888e+01)*s2+(-5.915924e+01)*s3+(-2.221245e+02)*s4+(-2.674271e+02)*s5+(-4.136483e+02)*s6 \
v23=(-1.609636e+00)*s0+8.978079e+01*s1+1.055228e+02*s2+5.194410e+01*s3+2.775583e+02*s4+5.766524e+02*s5+5.830572e+02*s6 \
v24=(-9.643896e-01)*s0+(-1.847546e-01)*s1+(-3.400827e-01)*s2+(-1.397363e-01)*s3+(-2.782287e+00)*s4+(-3.814936e+00)*s5+4.549707e+00*s6 \
v25=8.304340e-01*s0+1.265451e-03*s1+2.506255e-01*s2+(-1.185640e+00)*s3+1.835316e+00*s4+1.376296e+00*s5+(-1.295815e+00)*s6 \
v26=2.757222e-01*s0+4.834021e-01*s1+1.466433e-02*s2+8.506354e-01*s3+9.137440e-01*s4+6.375511e+00*s5+(-8.778135e+00)*s6 \
v27=4.170054e-02*s0+2.509412e-01*s1+6.807404e-01*s2+(-2.022250e+00)*s3+(-1.852121e-01)*s4+(-6.506100e-01)*s5+5.716258e+00*s6 \
v28=2.447716e-01*s0+(-1.290691e-01)*s1+(-1.425207e-01)*s2+4.340453e+00*s3+5.601267e-01*s4+3.625548e+00*s5+2.519799e+01*s6 \
v29=(-6.990975e-01)*s0+3.089786e-01*s1+(-1.818949e+00)*s2+(-1.251904e+01)*s3+(-4.057390e+00)*s4+(-9.105792e+00)*s5+(-1.366592e+02)*s6 \
v30=(-1.850948e+00)*s0+3.408436e+00*s1+4.244309e+00*s2+(-4.845816e+00)*s3+(-1.410849e+00)*s4+(-2.277877e+00)*s5+3.340970e+01*s6 \
v31=2.561758e-01*s0+(-3.541566e+00)*s1+(-3.514337e+00)*s2+6.315143e+00*s3+8.714673e+00*s4+7.113840e+00*s5+1.467394e+02*s6 \
v32=1.732335e+00*s0+(-1.015029e+00)*s1+(-1.825053e+00)*s2+(-1.374566e-01)*s3+5.863208e+00*s4+1.063263e+01*s5+3.592554e+01*s6 \
v33=3.650293e+00*s0+2.635239e+00*s1+2.885809e+00*s2+3.467201e+00*s3+(-5.119051e+00)*s4+(-2.671763e+00)*s5+3.847565e+01*s6 \
v34=1.126253e+00*s0+5.904390e-01*s1+1.014137e+00*s2+3.210084e-01*s3+8.457474e+00*s4+4.998788e+00*s5+(-8.261388e+01)*s6 \
v35=(-2.666138e+00)*s0+(-6.133350e+00)*s1+(-2.181227e+00)*s2+1.901253e+01*s3+(-2.614391e+00)*s4+(-1.173376e+01)*s5+(-1.342873e+02)*s6 \
v36=(-3.309269e+00)*s0+(-5.079666e-01)*s1+1.899716e+00*s2+1.339442e+01*s3+(-4.474780e+00)*s4+(-7.431027e+00)*s5+1.977872e+01*s6 \
v37=(-9.215711e-01)*s0+4.972127e+00*s1+1.289350e+00*s2+(-2.186679e+01)*s3+9.070135e-01*s4+8.736202e+00*s5+4.824672e+01*s6 \
v38=(-1.046977e+00)*s0+3.336921e-01*s1+4.169906e+00*s2+1.066596e+01*s3+1.994427e-01*s4+2.026268e+00*s5+(-1.461379e+00)*s6 \
v39=8.860980e-01*s0+(-1.728230e-01)*s1+(-5.301446e+00)*s2+(-1.713986e+01)*s3+(-3.088935e+00)*s4+(-1.631906e-01)*s5+4.358207e+00*s6 \
v40=1.352275e+00*s0+(-6.813292e-02)*s1+3.786544e+00*s2+(-3.019848e+01)*s3+2.425682e+00*s4+(-1.754884e+00)*s5+(-3.530561e+00)*s6 \
v41=(-2.119859e-01)*s0+(-9.699828e-02)*s1+1.326567e-01*s2+(-1.205784e+00)*s3+(-9.738449e+00)*s4+(-7.480738e+03)*s5+(-4.160198e-01)*s6 \
v42=3.196894e-01*s0+1.016530e-01*s1+(-4.223938e-01)*s2+6.183591e+00*s3+(-9.737498e+02)*s4+(-1.000000e+04)*s5+3.393364e-01*s6 \
v43=8.328262e-02*s0+(-7.725104e-02)*s1+4.376951e-02*s2+(-2.792772e-01)*s3+(-9.736587e+03)*s4+(-8.152842e+03)*s5+2.084897e+00*s6 \
v44=(-3.822796e-01)*s0+8.089017e-02*s1+(-3.234515e-01)*s2+(-3.087582e+00)*s3+(-7.899315e+01)*s4+(-1.000000e+04)*s5+(-3.084560e+00)*s6 \
v45=(-1.075063e-01)*s0+1.979689e-01*s1+(-4.100268e-01)*s2+3.878416e-02*s3+3.718248e+03*s4+1.000000e+04*s5+(-2.172914e-02)*s6 \
v46=6.780243e-02*s0+(-1.127016e-01)*s1+(-2.314442e-01)*s2+(-1.895460e+00)*s3+1.789321e+03*s4+1.000000e+04*s5+7.069272e-01*s6 \
v47=2.753547e-01*s0+(-7.280299e-03)*s1+2.236661e+00*s2+1.742233e+00*s3+9.974492e+02*s4+1.000000e+04*s5+1.072297e-01*s6 \
v48=(-5.034688e-02)*s0+(-6.521420e+02)*s1+(-4.241832e-01)*s2+(-1.898749e+00)*s3+(-1.416451e+00)*s4+(-7.827327e+02)*s5+(-1.799345e+03)*s6 \
v49=1.132858e-01*s0+(-8.820044e+02)*s1+1.190038e+00*s2+(-4.813856e-01)*s3+(-1.564240e+03)*s4+(-1.000000e+04)*s5+(-5.150623e+03)*s6 \
v50=6.822503e-02*s0+(-3.397628e+03)*s1+(-1.002975e+00)*s2+4.248359e+00*s3+2.844964e+03*s4+(-4.993010e+03)*s5+(-1.000000e+04)*s6 \
v51=(-7.812690e-02)*s0+(-8.205033e+02)*s1+4.133245e+00*s2+(-4.671479e+00)*s3+(-8.134672e+03)*s4+(-1.000000e+04)*s5+(-5.234705e+03)*s6 \
v52=(-2.106905e-02)*s0+(-3.169888e+03)*s1+(-2.632573e+00)*s2+1.825040e+00*s3+(-3.178187e+01)*s4+(-5.107321e+03)*s5+(-7.212311e+02)*s6 \
v53=(-6.082575e-02)*s0+2.548419e+02*s1+9.122363e+00*s2+(-9.327256e-01)*s3+1.148926e+03*s4+1.000000e+04*s5+2.670661e+03*s6 \
v54=4.844525e-02*s0+1.282396e+03*s1+3.320202e+00*s2+(-4.395856e+00)*s3+(-1.495408e+02)*s4+1.000000e+04*s5+7.028775e+03*s6 \
v55=2.020029e-02*s0+5.852270e+02*s1+(-1.414300e+01)*s2+4.002773e+00*s3+(-5.253225e+02)*s4+1.000000e+04*s5+7.101884e+03*s6 \
v56=(-3.144169e-03)*s0+(-1.160405e-01)*s1+1.363041e-01*s2+(-9.422928e-02)*s3+(-2.439720e-01)*s4+3.328468e-01*s5+1.722375e+00*s6 \
v57=3.641480e-02*s0+(-3.321495e-02)*s1+1.354755e-01*s2+2.706780e-01*s3+2.645300e+00*s4+2.552587e-01*s5+(-4.180100e-01)*s6 \
v58=(-1.139173e-01)*s0+7.681959e-01*s1+(-2.268481e+00)*s2+(-5.290807e-01)*s3+(-1.336101e+01)*s4+(-4.191754e+00)*s5+(-7.403762e+00)*s6 \
v59=(-3.710870e-02)*s0+(-8.316183e-01)*s1+4.045747e+00*s2+1.667315e+00*s3+3.981800e+00*s4+9.473477e+00*s5+1.631169e+01*s6 \
v60=1.544475e-01*s0+(-1.422472e-01)*s1+2.345326e+00*s2+2.301272e-01*s3+2.939578e+01*s4+(-2.687662e+00)*s5+(-4.331966e+00)*s6 \
v61=4.904781e-01*s0+3.853572e+00*s1+1.935733e+00*s2+8.351848e-01*s3+9.374796e+00*s4+9.869566e+00*s5+1.472219e+00*s6 \
v62=3.302915e-01*s0+4.365094e-01*s1+(-2.740901e+00)*s2+(-8.242647e-01)*s3+(-2.844840e+01)*s4+(-1.567268e+01)*s5+5.136681e-01*s6 \
v63=(-1.008915e-01)*s0+2.760630e-01*s1+(-1.375760e+00)*s2+9.229077e-02*s3+(-1.895909e+01)*s4+2.001954e+01*s5+2.946485e+00*s6 \
v64=(-6.643931e-01)*s0+(-4.716779e+00)*s1+(-5.029359e+00)*s2+6.170813e-02*s3+(-3.066715e+00)*s4+(-5.605241e+01)*s5+(-1.129881e+01)*s6 \
v65=(-8.259634e-02)*s0+(-9.376080e-01)*s1+1.120768e+00*s2+(-3.298848e-01)*s3+2.610107e+01*s4+(-2.177419e+01)*s5+(-7.171457e-01)*s6 \
v66=2.804909e-01*s0+2.681323e+00*s1+3.285870e+00*s2+3.725643e-02*s3+(-5.502136e+00)*s4+2.048871e+02*s5+6.143855e+00*s6 \
v67=2.342437e-02*s0+(-3.805331e-02)*s1+1.735757e-01*s2+(-3.382323e-01)*s3+(-5.075873e-01)*s4+6.514559e-01*s5+1.949813e-01*s6 \
v68=(-5.397557e-02)*s0+(-3.152768e-01)*s1+(-7.505976e-01)*s2+(-3.711035e-02)*s3+(-7.973001e-01)*s4+(-6.054017e+00)*s5+(-9.660448e-01)*s6 \
v69=(-1.844390e-02)*s0+1.352292e-01*s1+2.220840e-01*s2+1.746262e-01*s3+6.121683e-01*s4+2.675269e+00*s5+(-9.119232e-01)*s6 \
v70=(-2.502364e-01)*s0+2.706598e+00*s1+4.073827e+01*s2+1.132679e+00*s3+1.467509e+01*s4+2.391243e+00*s5+(-1.198459e+01)*s6 \
v71=(-2.630315e-01)*s0+(-9.095588e+00)*s1+(-5.009183e+01)*s2+1.163234e+01*s3+8.599694e+01*s4+(-6.680063e+01)*s5+2.698665e+00*s6 \
v72=3.621982e-01*s0+(-1.252870e+00)*s1+(-3.992984e+01)*s2+3.732012e-02*s3+(-5.379406e+01)*s4+(-1.444097e+01)*s5+5.780990e+01*s6 \
v73=1.217187e-01*s0+5.843684e+00*s1+2.341723e+01*s2+(-1.390451e+01)*s3+(-5.948097e+01)*s4+5.263301e+01*s5+5.652200e+01*s6 \
v74=2.133143e-02*s0+(-1.121446e-03)*s1+8.719650e-01*s2+3.799532e+00*s3+(-3.433616e-01)*s4+5.363391e-02*s5+(-2.694666e+01)*s6 \
v75=(-1.777136e-01)*s0+(-4.156968e-01)*s1+1.355386e+01*s2+2.563399e+00*s3+4.212510e+01*s4+2.302291e+00*s5+(-5.901549e+01)*s6 \
v76=5.269987e-01*s0+4.151313e+00*s1+2.959121e+01*s2+(-2.007700e+00)*s3+(-2.971289e+01)*s4+1.385192e+01*s5+(-3.669447e+01)*s6 \
v77=(-1.538930e-02)*s0+7.671630e-02*s1+(-1.798953e+00)*s2+(-2.427075e-01)*s3+1.619240e+00*s4+2.536601e+00*s5+1.708783e+01*s6 \
v78=5.860168e-01*s0+(-1.515798e+01)*s1+(-1.717595e+02)*s2+(-1.401177e+01)*s3+(-6.631440e-01)*s4+1.705269e+02*s5+(-2.449540e+01)*s6 \
v79=(-7.723639e-01)*s0+4.129332e+01*s1+1.986170e+02*s2+1.705857e+02*s3+4.325750e+02*s4+(-1.711843e+02)*s5+9.994563e+02*s6 \
v80=(-3.340404e-03)*s0+4.377551e-01*s1+5.045837e+00*s2+(-2.821188e+00)*s3+5.356698e+00*s4+(-4.554768e+00)*s5+3.249182e+00*s6 \
v81=1.595435e-02*s0+(-1.563699e-01)*s1+1.017700e+00*s2+1.568867e+00*s3+(-3.697531e+00)*s4+2.402092e+00*s5+(-1.347645e+00)*s6 \
v82=(-1.806551e-03)*s0+(-4.630178e-01)*s1+(-6.288871e+00)*s2+1.977435e+00*s3+(-1.851849e+00)*s4+1.419309e+00*s5+(-1.982327e+00)*s6 \
v83=4.264279e-02*s0+(-7.072195e-01)*s1+(-7.894693e+00)*s2+(-1.359430e-01)*s3+(-6.581101e+00)*s4+1.000000e+04*s5+5.265414e+02*s6 \
v84=(-2.030688e-01)*s0+(-4.087286e-01)*s1+(-9.783396e+00)*s2+3.223973e-01*s3+(-2.122660e+00)*s4+1.000000e+04*s5+2.903654e+03*s6 \
v85=4.402140e+00*s0+4.178844e+00*s1+7.640653e+01*s2+(-7.401159e-01)*s3+3.597762e+01*s4+8.463304e+03*s5+2.060108e+03*s6 \
v86=(-6.352067e+00)*s0+1.525730e+02*s1+(-3.920295e+00)*s2+6.850455e-01*s3+(-4.053326e+01)*s4+1.000000e+04*s5+9.059900e+03*s6 \
v87=(-5.431020e+00)*s0+1.617950e-01*s1+(-1.199314e-01)*s2+2.649933e+00*s3+(-3.595304e+00)*s4+1.000000e+04*s5+2.368133e+03*s6 \
v88=2.540233e+00*s0+1.431643e+01*s1+1.073161e+01*s2+8.857366e-01*s3+3.347822e+01*s4+1.185366e+03*s5+9.694990e+03*s6 \
v89=5.965171e+00*s0+(-1.188412e+03)*s1+(-1.957878e+02)*s2+4.336441e-01*s3+(-5.482903e+00)*s4+1.000000e+04*s5+3.694697e+03*s6 \
v90=1.914637e+00*s0+3.817543e+01*s1+4.094926e+01*s2+(-2.787461e+00)*s3+(-1.490137e+01)*s4+1.000000e+04*s5+4.417753e+03*s6 \
v91=(-2.085588e+00)*s0+(-9.180099e+01)*s1+4.613431e+01*s2+(-4.131139e+00)*s3+(-4.222105e+01)*s4+1.000000e+04*s5+1.000000e+04*s6 \
v92=(-9.409887e-01)*s0+2.113134e+03*s1+(-1.198813e+02)*s2+2.740720e+00*s3+4.224563e+01*s4+1.000000e+04*s5+3.311867e+03*s6 \
v93=1.537416e-01*s0+2.076646e+02*s1+2.408440e+02*s2+9.147771e-01*s3+8.388293e+00*s4+1.000000e+04*s5+1.151619e+03*s6 \
v94=1.663457e+00*s0+2.010437e+00*s1+3.636216e+00*s2+(-3.337256e-01)*s3+1.412062e+00*s4+(-1.000000e+04)*s5+(-7.462467e+03)*s6 \
v95=(-1.053485e+00)*s0+(-8.187829e-01)*s1+2.382899e+01*s2+2.236318e-01*s3+7.096980e-01*s4+(-1.000000e+04)*s5+(-4.662785e+02)*s6 \
v96=(-5.155349e-01)*s0+(-7.354512e+00)*s1+(-2.609260e+01)*s2+(-4.281037e-01)*s3+(-3.165614e+00)*s4+(-1.000000e+04)*s5+(-2.520131e+03)*s6 \
v97=6.574746e-01*s0+8.319866e-02*s1+(-4.764946e-01)*s2+(-9.033702e+03)*s3+(-6.978979e-01)*s4+(-6.260708e-01)*s5+1.154230e+00*s6 \
v98=(-1.115155e+00)*s0+6.487841e-02*s1+9.999928e-01*s2+(-1.000000e+04)*s3+(-1.265150e+00)*s4+1.254668e-01*s5+(-2.762638e+00)*s6 \
v99=(-6.361620e-01)*s0+2.084763e-01*s1+4.734664e-01*s2+(-1.000000e+04)*s3+(-2.363114e-01)*s4+2.764720e+00*s5+(-2.461115e+00)*s6 \
v100=6.248392e-01*s0+1.627081e-01*s1+(-7.638481e-01)*s2+(-2.020245e+03)*s3+4.685719e+00*s4+(-7.400485e-01)*s5+4.824782e+00*s6 \
v101=(-3.078460e-01)*s0+1.949223e-01*s1+5.813035e-01*s2+(-1.000000e+04)*s3+9.341316e+00*s4+8.188773e-01*s5+1.375785e+01*s6 \
v102=8.760126e-01*s0+4.599562e-01*s1+(-2.922218e-01)*s2+(-1.000000e+04)*s3+(-2.209562e+00)*s4+2.044708e+00*s5+(-7.108542e+00)*s6 \
v103=5.544192e-01*s0+(-4.631420e-01)*s1+(-5.264022e-01)*s2+(-1.000000e+04)*s3+(-1.211252e+01)*s4+(-4.493404e+00)*s5+(-6.887770e+00)*s6 \
v104=(-2.607690e-01)*s0+(-8.139879e-01)*s1+(-1.931271e+00)*s2+(-3.189707e-01)*s3+3.805777e+00*s4+(-1.000000e+04)*s5+1.702797e+01*s6 \
v105=1.327148e+00*s0+4.607455e+00*s1+7.260871e+00*s2+(-6.441010e+00)*s3+1.037724e+01*s4+(-1.000000e+04)*s5+2.465682e+01*s6 \
v106=3.897112e-01*s0+1.748471e+00*s1+2.891354e+00*s2+(-6.475441e-01)*s3+(-5.156678e+00)*s4+(-1.215882e+03)*s5+(-1.498648e+01)*s6 \
v107=(-1.033678e+00)*s0+(-8.163555e+00)*s1+(-9.432642e+00)*s2+(-1.359408e+01)*s3+(-7.736159e+00)*s4+(-2.401680e+03)*s5+(-1.219192e+01)*s6 \
v108=(-5.540391e-02)*s0+(-1.362447e-01)*s1+4.155358e-01*s2+(-7.862352e-01)*s3+(-2.964827e+00)*s4+(-4.826292e+03)*s5+(-1.584408e+01)*s6 \
v109=(-7.874019e-01)*s0+(-5.593263e-01)*s1+1.204685e+00*s2+(-7.931440e+03)*s3+(-3.221338e+00)*s4+1.000000e+04*s5+(-9.515360e+00)*s6 \
v110=7.835862e-01*s0+1.970647e-01*s1+(-1.401692e+01)*s2+1.000000e+04*s3+8.741145e-01*s4+1.000000e+04*s5+1.068337e+01*s6 \
v111=2.326294e-01*s0+6.403507e-01*s1+1.719213e+00*s2+(-1.000000e+04)*s3+5.827404e+00*s4+1.000000e+04*s5+1.345141e-01*s6 \
v112=(-5.840795e-01)*s0+2.749728e+01*s1+1.721270e-01*s2+1.370858e-01*s3+1.190103e-01*s4+(-2.297121e+00)*s5+(-1.758447e+00)*s6 \
v113=(-1.698951e-01)*s0+2.822039e+00*s1+3.583772e-02*s2+(-4.025649e+00)*s3+9.442274e-01*s4+(-2.823063e+00)*s5+(-3.906362e+00)*s6 \
v114=2.410983e+00*s0+2.616870e+02*s1+1.800406e-01*s2+2.105019e+01*s3+(-2.156966e+00)*s4+2.307015e+01*s5+2.033097e+01*s6 \
v115=(-2.566581e+00)*s0+1.420316e+01*s1+(-5.936112e-01)*s2+4.152956e+01*s3+1.736225e+00*s4+(-2.177396e+01)*s5+(-1.386167e+01)*s6 \
v116=2.058581e+00*s0+2.067992e+01*s1+2.894905e-01*s2+(-1.847323e+01)*s3+(-1.107796e+01)*s4+(-2.066478e+00)*s5+(-9.774772e+00)*s6 \
v117=3.405649e-01*s0+(-6.222129e+03)*s1+3.898231e-01*s2+(-9.006277e+01)*s3+(-1.131582e+01)*s4+(-8.408426e+00)*s5+4.972718e+00*s6 \
v118=4.235362e-01*s0+3.315794e+01*s1+(-1.255812e+00)*s2+(-2.668637e+01)*s3+2.213461e+01*s4+(-5.953476e+00)*s5+8.346544e+01*s6 \
v119=(-3.201445e+00)*s0+1.912757e+00*s1+(-7.796351e-02)*s2+(-9.039152e+01)*s3+1.252020e+01*s4+(-9.509635e+00)*s5+(-8.915440e+00)*s6 \
v120=4.579474e-01*s0+(-4.100541e-01)*s1+(-1.182539e+00)*s2+1.462389e+02*s3+1.034215e+01*s4+2.285205e+01*s5+(-7.245178e+01)*s6 \
v121=1.795600e+00*s0+(-5.090689e+01)*s1+(-1.030174e+00)*s2+(-4.008346e+00)*s3+(-2.800407e+01)*s4+7.893027e+00*s5+(-1.515524e+02)*s6 \
v122=(-1.260992e+00)*s0+(-8.379126e+01)*s1+1.999995e+00*s2+1.198170e+01*s3+2.574805e+00*s4+(-5.575289e+00)*s5+1.463945e+02*s6 \
v123=8.103810e-01*s0+(-3.058349e+00)*s1+(-3.182973e+00)*s2+7.997081e+00*s3+(-8.053028e-01)*s4+7.681863e+00*s5+(-2.209381e+01)*s6 \
v124=(-1.177026e+00)*s0+1.408844e+01*s1+3.598742e+00*s2+(-4.194378e+00)*s3+9.812239e-01*s4+1.863404e+01*s5+1.601463e+01*s6 \
v125=7.321219e-01*s0+(-3.420746e-01)*s1+(-2.243031e+00)*s2+(-3.015827e+01)*s3+1.739118e-01*s4+(-3.743454e+01)*s5+6.650230e+00*s6 \
v126=(-1.284945e-02)*s0+(-1.788299e-02)*s1+1.636173e-02*s2+(-1.584638e-01)*s3+(-1.168693e+00)*s4+2.587245e+00*s5+(-7.170075e+00)*s6 \
v127=(-3.891624e-02)*s0+8.230455e-01*s1+8.108044e-01*s2+1.852684e+00*s3+1.856309e+00*s4+5.545553e-01*s5+5.668533e+00*s6 \
v128=1.989005e-01*s0+(-2.630201e+00)*s1+(-5.851644e-01)*s2+(-2.448519e+00)*s3+1.840533e+00*s4+(-9.718353e+00)*s5+1.434158e+01*s6 \
v129=(-4.799887e-02)*s0+(-1.616699e+00)*s1+(-2.086842e-01)*s2+(-6.227481e+00)*s3+(-1.176030e+01)*s4+5.517770e+00*s5+(-5.921367e+01)*s6 \
v130=5.196809e-02*s0+2.970763e+00*s1+(-1.621158e+00)*s2+(-2.630042e-01)*s3+(-1.001059e+00)*s4+6.497828e-01*s5+(-8.280187e+00)*s6 \
v131=1.779718e-01*s0+1.302872e+00*s1+(-1.003635e+00)*s2+(-1.129044e+00)*s3+(-4.285888e+00)*s4+(-2.478389e+00)*s5+1.548587e+01*s6 \
v132=(-7.547865e-01)*s0+4.610794e+00*s1+1.734134e+00*s2+1.462761e+01*s3+2.026992e+01*s4+8.111498e+00*s5+9.752439e+01*s6 \
v133=(-1.163924e-01)*s0+(-1.147161e+00)*s1+1.568624e+00*s2+1.191764e+00*s3+1.938707e+00*s4+(-3.443762e+00)*s5+1.517407e+01*s6 \
v134=5.158690e-01*s0+(-3.830045e+00)*s1+3.038242e-01*s2+2.428122e+00*s3+1.050517e+01*s4+5.996848e-01*s5+(-1.186381e+01)*s6 \
v135=6.943627e-01*s0+(-2.803188e+00)*s1+(-1.930800e+00)*s2+(-7.898282e+00)*s3+(-1.460699e+01)*s4+4.520827e+00*s5+(-6.863067e+01)*s6 \
v136=(-5.530505e-01)*s0+2.637521e+00*s1+2.028364e+00*s2+(-1.525205e+00)*s3+(-2.711657e+00)*s4+(-6.505282e+00)*s5+8.133935e+00*s6 \
v137=(-1.151302e-02)*s0+(-1.963917e-01)*s1+(-1.126894e+00)*s2+4.458714e-01*s3+(-7.386119e-01)*s4+7.657865e-01*s5+(-7.045819e-01)*s6 \
v138=(-7.237774e-03)*s0+8.685234e-02*s1+2.323363e-01*s2+(-1.593327e-01)*s3+(-7.216279e-02)*s4+(-2.328055e-01)*s5+(-2.731442e+00)*s6 \
v139=(-1.613829e-02)*s0+1.353611e-01*s1+1.110673e+00*s2+(-5.827978e-01)*s3+4.489435e-01*s4+(-7.122565e-01)*s5+2.420168e+00*s6 \
v140=6.268027e+00*s0+(-2.221774e+00)*s1+9.058923e+00*s2+5.243645e+00*s3+7.925596e+00*s4+1.129936e+01*s5+(-2.538274e+01)*s6 \
v141=(-9.722166e+00)*s0+1.422127e+01*s1+1.729919e+01*s2+7.641002e+00*s3+(-8.952774e+00)*s4+6.395670e+01*s5+8.669726e+01*s6 \
v142=(-1.544532e+01)*s0+(-1.673578e+00)*s1+(-2.011330e+01)*s2+(-1.764511e+01)*s3+(-4.479240e+01)*s4+(-3.992667e+01)*s5+(-1.250383e+01)*s6 \
v143=1.157573e+01*s0+(-4.198767e+00)*s1+(-1.631377e+00)*s2+4.722572e+01*s3+1.041371e+02*s4+4.482279e+01*s5+(-5.158667e+01)*s6 \
v144=6.131765e+01*s0+(-3.456709e-01)*s1+(-2.993259e+01)*s2+1.450691e+01*s3+3.297417e+01*s4+(-4.695494e+01)*s5+(-4.775365e+01)*s6 \
v145=(-5.912619e+01)*s0+(-2.218507e+01)*s1+(-2.682647e+01)*s2+(-7.078485e+01)*s3+(-2.029428e+01)*s4+(-4.713979e+01)*s5+(-6.568494e+01)*s6 \
v146=(-7.288634e+01)*s0+5.100406e-01*s1+2.463596e+01*s2+(-1.884685e+01)*s3+(-3.858990e+01)*s4+(-8.648148e+00)*s5+(-4.449615e+01)*s6 \
v147=4.850277e+00*s0+9.683436e-01*s1+(-2.373926e+00)*s2+1.911772e-01*s3+7.777526e-01*s4+(-3.321710e+00)*s5+8.797530e-01*s6 \
v148=(-2.203714e+00)*s0+2.589556e+00*s1+7.372385e+00*s2+1.611763e+01*s3+2.289325e+01*s4+2.596779e+01*s5+2.341820e+01*s6 \
v149=1.740994e+01*s0+(-2.937662e-01)*s1+2.459937e+00*s2+(-2.124105e+00)*s3+(-1.588134e+00)*s4+7.681158e-01*s5+(-2.153458e+00)*s6 \
v150=(-1.435419e+01)*s0+4.212883e+00*s1+1.318370e+01*s2+(-1.036519e+00)*s3+(-6.917130e+00)*s4+(-9.725029e+00)*s5+1.817011e+01*s6 \
v151=(-5.210730e+00)*s0+1.958867e+00*s1+1.164645e+01*s2+(-5.912878e+00)*s3+(-9.565626e+00)*s4+6.194569e+00*s5+(-1.239058e+01)*s6 \
v152=3.489641e+00*s0+(-6.134577e-01)*s1+(-8.277578e+00)*s2+(-4.538292e+00)*s3+(-1.475643e+01)*s4+(-1.785928e+01)*s5+1.239841e+00*s6 \
v153=1.950016e+00*s0+(-3.562570e+00)*s1+(-2.040330e+01)*s2+1.162483e+01*s3+1.398038e+01*s4+2.392431e+00*s5+(-1.318922e+01)*s6 \
v154=1.354876e+01*s0+1.955279e+00*s1+9.197387e+00*s2+1.138666e+01*s3+1.822918e+01*s4+7.791784e+00*s5+(-1.897249e+01)*s6 \
v155=(-4.593604e+00)*s0+(-1.317191e+00)*s1+(-1.553354e+00)*s2+4.375981e+00*s3+4.673108e+00*s4+7.258032e+00*s5+(-5.259912e+00)*s6 \
v156=1.790770e+01*s0+(-6.449499e-01)*s1+(-5.228372e+00)*s2+(-1.060773e+01)*s3+(-1.926884e+01)*s4+(-2.985492e+00)*s5+9.590926e+01*s6 \
v157=(-2.182504e+01)*s0+8.409460e-01*s1+3.048223e+00*s2+(-3.518878e+00)*s3+(-7.082579e-01)*s4+(-1.124590e+01)*s5+3.070082e+00*s6 \
v158=2.659215e+01*s0+4.070622e-01*s1+(-1.036101e+01)*s2+(-2.037653e+01)*s3+(-3.238942e+01)*s4+(-1.701373e+01)*s5+3.107528e+01*s6 \
v159=(-3.683812e+01)*s0+3.240256e-01*s1+(-1.462635e+00)*s2+(-2.614647e+00)*s3+(-7.279034e+00)*s4+6.304414e-01*s5+2.007772e+01*s6 \
v160=1.110027e+01*s0+(-1.526154e+00)*s1+3.387741e+00*s2+2.245557e+01*s3+3.573037e+01*s4+9.150692e+00*s5+(-1.671849e+02)*s6 \
v161=(-4.267253e+00)*s0+5.661992e+01*s1+(-1.068888e+01)*s2+(-5.257893e+00)*s3+(-1.689808e+01)*s4+(-5.370567e+01)*s5+(-6.435386e+01)*s6 \
v162=3.613584e+00*s0+(-6.374084e+00)*s1+1.075271e+02*s2+3.003014e+01*s3+6.306617e+01*s4+4.967168e+02*s5+1.803481e+02*s6 \
v163=(-5.145629e+00)*s0+1.628951e+01*s1+(-2.833561e+01)*s2+1.880340e+01*s3+(-7.952994e+00)*s4+(-1.872704e+02)*s5+7.312497e+01*s6 \
v164=3.900829e+01*s0+1.651833e+01*s1+5.374343e+01*s2+1.807451e+02*s3+2.095269e+02*s4+1.281840e+02*s5+(-3.574890e+00)*s6 \
v165=(-5.436795e+01)*s0+2.280718e+02*s1+1.636150e+02*s2+9.766093e+01*s3+1.693035e+02*s4+(-2.459799e+02)*s5+(-2.872743e+01)*s6 \
v166=9.553371e+01*s0+(-3.196331e+02)*s1+(-8.325202e+02)*s2+2.706086e+02*s3+5.218304e+02*s4+(-3.685866e+02)*s5+(-5.037108e+01)*s6 \
v167=(-3.403536e+01)*s0+(-8.714171e+01)*s1+2.221977e+02*s2+(-5.174563e+02)*s3+(-1.223631e+03)*s4+1.136944e+03*s5+3.065781e+02*s6 \
v168=1.605817e+01*s0+1.697073e+00*s1+(-3.816740e+00)*s2+6.024622e-01*s3+(-1.874300e-01)*s4+(-7.928656e+00)*s5+1.481324e+01*s6 \
v169=(-1.090958e+02)*s0+5.205109e-01*s1+(-3.877874e+00)*s2+(-1.931874e+00)*s3+(-1.264068e+00)*s4+4.896938e-01*s5+(-1.150058e+01)*s6 \
v170=5.190598e+02*s0+(-1.457758e+01)*s1+3.445180e+01*s2+(-7.629451e-01)*s3+6.063327e+00*s4+2.832049e+01*s5+(-1.905737e+01)*s6 \
v171=3.115570e+02*s0+2.444135e+01*s1+1.414602e+01*s2+4.674535e+00*s3+8.735354e-01*s4+(-3.043165e+01)*s5+4.426261e+01*s6 \
v172=(-6.536317e+02)*s0+9.461641e+00*s1+(-1.314943e+01)*s2+1.351094e+01*s3+(-5.177011e+00)*s4+1.520242e+01*s5+(-7.122046e+00)*s6 \
v173=8.628217e+01*s0+(-1.402420e+01)*s1+(-1.230964e+01)*s2+(-2.799199e+00)*s3+8.687454e-01*s4+7.585082e+00*s5+1.726300e+01*s6 \
v174=(-7.102082e+02)*s0+(-4.836382e+01)*s1+(-1.653951e+02)*s2+2.198344e+00*s3+(-7.866109e+00)*s4+9.680122e+00*s5+(-2.876011e+01)*s6 \
v175=1.268910e+02*s0+6.746793e+01*s1+3.351075e+01*s2+(-4.567035e+00)*s3+(-2.003619e-01)*s4+3.128120e+01*s5+(-6.360502e+00)*s6 \
v176=4.885737e+02*s0+3.433620e+01*s1+7.765363e+00*s2+3.877803e+00*s3+2.550832e-01*s4+1.679759e+01*s5+(-5.580456e+01)*s6 \
v177=6.791582e+02*s0+(-9.025246e+01)*s1+4.953562e+01*s2+(-2.031116e+01)*s3+1.142507e+01*s4+(-5.706873e+01)*s5+4.267002e+01*s6 \
v178=(-6.648632e+02)*s0+5.076625e+01*s1+2.171026e+02*s2+5.806365e+00*s3+(-4.418814e+00)*s4+(-3.503434e+01)*s5+1.312566e+01*s6 \
v179=3.868543e+01*s0+6.791064e+01*s1+1.197380e+02*s2+8.019411e-01*s3+3.305783e+01*s4+(-4.206179e+01)*s5+9.450087e+00*s6 \
v180=(-1.142308e+02)*s0+5.398662e+01*s1+(-8.021864e+01)*s2+(-1.311221e+00)*s3+4.491488e+01*s4+4.594590e+01*s5+(-1.519102e+01)*s6 \
v181=(-1.477631e+00)*s0+(-1.331361e+02)*s1+(-1.469369e+02)*s2+2.488449e+00*s3+(-1.036124e+02)*s4+8.482665e+01*s5+1.575546e+01*s6 \
v182=(-1.533618e-02)*s0+1.379747e-01*s1+6.860893e-02*s2+(-1.390600e+00)*s3+1.676838e+01*s4+(-8.381805e-02)*s5+(-2.402111e+00)*s6 \
v183=(-1.166509e-01)*s0+1.520276e-02*s1+(-1.294670e-01)*s2+(-2.219714e-01)*s3+1.724447e+01*s4+(-2.568809e+01)*s5+1.791479e+00*s6 \
v184=3.980409e-01*s0+(-2.467420e+00)*s1+(-3.243285e+00)*s2+8.731575e+00*s3+(-7.165515e+01)*s4+4.007702e+01*s5+(-7.355542e-01)*s6 \
v185=(-9.100031e-02)*s0+7.661891e+00*s1+1.368233e+01*s2+(-4.340694e+00)*s3+(-1.083695e+02)*s4+2.679707e+00*s5+(-1.318689e+00)*s6 \
v186=2.299546e-01*s0+2.651454e+00*s1+3.451464e+00*s2+(-2.159302e+00)*s3+2.524748e+01*s4+(-1.873133e+01)*s5+1.361909e+01*s6 \
v187=(-2.537625e-02)*s0+(-4.261614e+00)*s1+(-7.674212e+00)*s2+(-2.315746e+00)*s3+7.708926e+01*s4+2.807584e+00*s5+7.509090e+01*s6 \
v188=3.297255e+00*s0+(-1.090635e+01)*s1+(-1.440759e+01)*s2+(-1.542394e+01)*s3+2.536796e+02*s4+5.983139e+00*s5+(-8.206585e+01)*s6 \
v189=(-4.466877e+00)*s0+(-1.523373e+00)*s1+5.668396e-01*s2+2.149372e+00*s3+(-9.671883e+01)*s4+(-1.188922e+02)*s5+5.734888e+00*s6 \
v190=7.265700e-02*s0+1.124071e+01*s1+6.600564e+00*s2+1.872678e+01*s3+(-1.348366e+02)*s4+6.022237e+01*s5+(-6.048515e+01)*s6 \
v191=3.308344e+00*s0+6.027608e+00*s1+(-4.119941e-01)*s2+(-1.585282e+00)*s3+1.016952e+02*s4+5.603322e+01*s5+3.866825e+01*s6 \
v192=(-8.616692e+00)*s0+(-7.185478e+00)*s1+2.550296e+00*s2+6.264591e+00*s3+(-7.510869e+01)*s4+3.468105e+01*s5+1.941350e+01*s6 \
v193=(-4.666792e-01)*s0+(-2.035177e+00)*s1+1.749445e-01*s2+(-3.449601e+00)*s3+(-8.760856e+00)*s4+5.001349e+01*s5+(-2.769765e+00)*s6 \
v194=2.643236e-01*s0+1.216343e+00*s1+8.719567e+00*s2+5.914044e-01*s3+(-3.583939e+00)*s4+(-1.015817e+02)*s5+(-2.694363e+01)*s6 \
v195=6.703166e-01*s0+1.877486e+00*s1+(-4.859887e+00)*s2+6.941404e+00*s3+2.033520e+01*s4+8.199674e+01*s5+2.008553e+01*s6 \
v196=8.713419e-01*s0+7.861865e-01*s1+5.537073e-02*s2+8.626892e-01*s3+5.209421e-01*s4+3.591027e-01*s5+3.591027e-01*s6 \
v197=1.478695e-01*s0+3.708875e-02*s1+2.146842e-01*s2+4.959473e-01*s3+5.854516e-01*s4+7.526603e-01*s5+7.526603e-01*s6 \
v198=8.119254e-01*s0+7.504707e-01*s1+2.494583e-01*s2+8.948838e-01*s3+9.242734e-01*s4+9.070844e-03*s5+9.070844e-03*s6 \
v199=4.355271e-01*s0+2.105020e-01*s1+3.901640e-01*s2+5.723879e-01*s3+6.062309e-01*s4+1.757877e-02*s5+1.757877e-02*s6 \
v200=2.241579e-01*s0+3.211299e-01*s1+8.164868e-01*s2+5.033170e-01*s3+7.102515e-01*s4+3.211299e-01*s5+8.087995e-01*s6 \
v201=2.677541e-01*s0+8.762742e-01*s1+5.245133e-01*s2+7.268264e-01*s3+9.580171e-01*s4+8.762742e-01*s5+7.080809e-01*s6 \
v202=7.474153e-01*s0+5.284132e-01*s1+1.641664e-01*s2+8.894833e-01*s3+3.722681e-02*s4+5.284132e-01*s5+6.807312e-01*s6 \
v203=9.158665e-01*s0+1.405968e-01*s1+5.613342e-02*s2+9.704113e-01*s3+5.312237e-01*s4+2.103089e-01*s5+2.103089e-01*s6 \
v204=2.031002e-01*s0+6.964558e-02*s1+5.130380e-01*s2+2.941160e-01*s3+7.138633e-01*s4+8.089641e-01*s5+8.089641e-01*s6 \
v205=2.626569e-01*s0+8.947460e-01*s1+2.573457e-01*s2+4.759104e-01*s3+7.501376e-01*s4+1.561761e-01*s5+1.561761e-01*s6 \
v206=8.513492e-01*s0+3.799115e-01*s1+7.669067e-01*s2+3.644574e-01*s3+6.754842e-01*s4+9.544638e-01*s5+9.544638e-01*s6 \
v207=6.969656e-01*s0+3.861172e-01*s1+9.684084e-02*s2+9.202239e-01*s3+7.090458e-01*s4+3.861172e-01*s5+1.526273e-01*s6 \
v208=3.240447e-01*s0+5.852677e-01*s1+9.973826e-01*s2+1.391783e-01*s3+2.383397e-01*s4+5.852677e-01*s5+8.966791e-01*s6 \
v209=9.649081e-01*s0+4.641587e-01*s1+2.182508e-01*s2+9.353835e-01*s3+3.471699e-01*s4+4.641587e-01*s5+2.793930e-01*s6 \
v210=8.442424e-01*s0+2.068277e-01*s1+9.016621e-01*s2+6.232261e-01*s3+9.191630e-01*s4+4.075356e-01*s5+4.075356e-01*s6 \
v211=1.360721e-01*s0+6.500837e-01*s1+3.569379e-01*s2+4.008950e-01*s3+3.119080e-01*s4+4.233364e-01*s5+4.233364e-01*s6 \
v212=8.668935e-01*s0+1.892827e-01*s1+1.876864e-01*s2+7.814401e-01*s3+6.183559e-01*s4+3.415365e-01*s5+3.415365e-01*s6 \
v213=8.986067e-01*s0+7.855776e-01*s1+2.872571e-01*s2+7.527316e-01*s3+3.129049e-01*s4+5.647979e-01*s5+5.647979e-01*s6 \
v214=3.430217e-01*s0+3.239710e-01*s1+1.338608e-01*s2+1.340700e-01*s3+7.958431e-01*s4+3.239710e-01*s5+4.826558e-02*s6 \
v215=4.035434e-01*s0+8.129968e-01*s1+1.971231e-01*s2+8.851672e-01*s3+8.477928e-01*s4+8.129968e-01*s5+3.913446e-01*s6 \
v216=8.476345e-01*s0+5.806134e-01*s1+3.123160e-01*s2+9.167224e-01*s3+6.926570e-01*s4+5.806134e-01*s5+9.829944e-01*s6 \
_p0=v0/od_+v1/w_+v2+v3*od_+v4*w_+v5*od_*od_+v6*od_*w_+v7*w_*w_+v8*od_*od_*w_+v9*od_*w_*w_+v10*od_*od_*w_*w_ \
_p1=_p0+v11*(s_-0.446)+v12*(s_-0.446)*od_+v13*(s_-0.446)*w_ \
_p2=0.5*(_p1+sqrt(_p1*_p1+0.001)) \
_p3=syctnw_dls*1e-09*_p2 \
_p4=syctnw_dls*1e-09*_p2 \
_p5=v14+v15*od_+v16*w_+v17*od_*w_+v18*od_*od_+v19*w_*w_+v20*od_/w_+v21*od_*od_/w_/w_+v22/w_jump_+v23/(w_jump_*w_jump_) \
_p6=_p5+v24*(s_-0.446)+v25*(s_-0.446)*od_+v26*(s_-0.446)*w_ \
_p7=syctnw_drs*syctnw_drs*0.5*(_p6+sqrt(_p6*_p6+0.001)) \
_p8=v27/od_+v28/w_+v29+v30*od_+v31*w_+v32*od_*od_+v33*od_*w_+v34*w_*w_+v35*od_*od_*w_+v36*od_*w_*w_+v37*od_*od_*w_*w_ \
_p9=_p8+v38*(s_-0.446)+v39*(s_-0.446)*od_+v40*(s_-0.446)*w_ \
_p10=0.5*(atan(2*_p9)/1.5708+1) \
_p11=v41+v42*od_+v43*w_+v44*od_*w_ \
_p12=_p11+v45*(s_-0.446)+v46*(s_-0.446)*od_+v47*(s_-0.446)*w_ \
_p13=0.5*(_p12+sqrt(_p12*_p12+0.001)) \
_p14=syctnw_dls*1e-09*_p13 \
_p15=v48+v49*od_+v50*w_+v51*od_*w_+v52*od_/w_ \
_p16=_p15+v53*(s_-0.446)+v54*(s_-0.446)*od_+v55*(s_-0.446)*w_ \
_p17=0.5*(_p16+sqrt(_p16*_p16+0.001)) \
_p18=syctnw_drs*1e-09*_p17 \
_p19=v56/od_+v57/w_+v58+v59*od_+v60*w_+v61*od_*od_+v62*od_*w_+v63*w_*w_+v64*od_*od_*w_+v65*od_*w_*w_+v66*od_*od_*w_*w_ \
_p20=_p19+v67*(s_-0.446)+v68*(s_-0.446)*od_+v69*(s_-0.446)*w_ \
_p21=0.5*(_p20+sqrt(_p20*_p20+0.001)) \
_p22=syctnw_dls*1e-09*_p21 \
_p23=syctnw_dls*1e-09*_p21 \
_p24=v70+v71*od_+v72*w_+v73*od_*w_+v74*od_*od_+v75*w_*w_+v76*od_/w_+v77*od_*od_/w_/w_+v78/w_jump_+v79/(w_jump_*w_jump_) \
_p25=_p24+v80*(s_-0.446)+v81*(s_-0.446)*od_+v82*(s_-0.446)*w_ \
_p26=syctnw_drs*syctnw_drs*0.5*(_p25+sqrt(_p25*_p25+0.001)) \
_p27=v83/od_+v84/w_+v85+v86*od_+v87*w_+v88*od_*od_+v89*od_*w_+v90*w_*w_+v91*od_*od_*w_+v92*od_*w_*w_+v93*od_*od_*w_*w_ \
_p28=_p27+v94*(s_-0.446)+v95*(s_-0.446)*od_+v96*(s_-0.446)*w_ \
_p29=0.5*(atan(2*_p28)/1.5708+1) \
_p30=v97+v98*od_+v99*w_+v100*od_*w_ \
_p31=_p30+v101*(s_-0.446)+v102*(s_-0.446)*od_+v103*(s_-0.446)*w_ \
_p32=0.5*(_p31+sqrt(_p31*_p31+0.001)) \
_p33=syctnw_dls*1e-09*_p32 \
_p34=v104+v105*od_+v106*w_+v107*od_*w_+v108*od_/w_ \
_p35=_p34+v109*(s_-0.446)+v110*(s_-0.446)*od_+v111*(s_-0.446)*w_ \
_p36=0.5*(_p35+sqrt(_p35*_p35+0.001)) \
_p37=syctnw_drs*1e-09*_p36 \
_p38=v112/od_+v113/w_+v114+v115*od_+v116*w_+v117*od_*od_+v118*od_*w_+v119*w_*w_+v120*od_*od_*w_+v121*od_*w_*w_+v122*od_*od_*w_*w_ \
_p39=_p38+v123*(s_-0.446)+v124*(s_-0.446)*od_+v125*(s_-0.446)*w_ \
_p40=0.5*(atan(2*_p39)/1.5708+1) \
_p41=v126/od_+v127/w_+v128+v129*od_+v130*w_+v131*od_*od_+v132*od_*w_+v133*w_*w_+v134*od_*od_*w_+v135*od_*w_*w_+v136*od_*od_*w_*w_ \
_p42=_p41+v137*(s_-0.446)+v138*(s_-0.446)*od_+v139*(s_-0.446)*w_ \
_p43=0.5*(_p42+sqrt(_p42*_p42+0.001)) \
_p44=syctnw_dls*1e-09*_p43 \
_p45=syctnw_dls*1e-09*_p43 \
_p46=syctnw_drs*syctnw_drs*1e-06 \
_p47=v140+v141*od_+v142*w_+v143*od_*w_ \
_p48=_p47+v144*(s_-0.446)+v145*(s_-0.446)*od_+v146*(s_-0.446)*w_ \
_p49=0.5*(_p48+sqrt(_p48*_p48+0.001)) \
_p50=1e-15*_p49 \
_p51=v147+v148*od_+v149*w_+v150*od_*w_ \
_p52=_p51+v151*(s_-0.446)+v152*(s_-0.446)*od_+v153*(s_-0.446)*w_ \
_p53=0.5*(_p52+sqrt(_p52*_p52+0.001)) \
_p54=v154+v155*od_+v156*w_+v157*od_*w_ \
_p55=_p54+v158*(s_-0.446)+v159*(s_-0.446)*od_+v160*(s_-0.446)*w_ \
_p56=0.5*(_p55+sqrt(_p55*_p55+0.001)) \
_p57=v161+v162*od_+v163*w_+v164*od_*w_ \
_p58=_p57+v165*(s_-0.446)+v166*(s_-0.446)*od_+v167*(s_-0.446)*w_ \
_p59=0.5*(_p58+sqrt(_p58*_p58+0.001)) \
_p60=1e-14*_p53 \
_p61=syctnw_drs_sub*100*_p56 \
_p62=1e-15*_p59 \
_p63=1e-14*_p53 \
_p64=syctnw_drs_sub*100*_p56 \
_p65=1e-15*_p59 \
_p66=v168/od_+v169/w_+v170+v171*od_+v172*w_+v173*od_*od_+v174*od_*w_+v175*w_*w_+v176*od_*od_*w_+v177*od_*w_*w_+v178*od_*od_*w_*w_ \
_p67=_p66+v179*(s_-0.446)+v180*(s_-0.446)*od_+v181*(s_-0.446)*w_ \
_p68=0.5*(_p67+sqrt(_p67*_p67+0.001)) \
_p69=v182/od_+v183/w_+v184+v185*od_+v186*w_+v187*od_*od_+v188*od_*w_+v189*w_*w_+v190*od_*od_*w_+v191*od_*w_*w_+v192*od_*od_*w_*w_ \
_p70=_p69+v193*(s_-0.446)+v194*(s_-0.446)*od_+v195*(s_-0.446)*w_ \
_p71=0.5*(_p70+sqrt(_p70*_p70+0.001)) \
_p72=syctnw_drs_sub*100*_p68 \
_p73=1e-13*_p71 \
_p74=v196+v197*od_+v198*w_+v199*od_*w_ \
_p75=_p74+v200*(s_-0.446)+v201*(s_-0.446)*od_+v202*(s_-0.446)*w_ \
_p76=0.5*(_p75+sqrt(_p75*_p75+0.001)) \
_p77=1e-15*_p76 \
_p78=v203+v204*od_+v205*w_+v206*od_*w_ \
_p79=_p78+v207*(s_-0.446)+v208*(s_-0.446)*od_+v209*(s_-0.446)*w_ \
_p80=0.5*(_p79+sqrt(_p79*_p79+0.001)) \
_p81=v210+v211*od_+v212*w_+v213*od_*w_ \
_p82=_p81+v214*(s_-0.446)+v215*(s_-0.446)*od_+v216*(s_-0.446)*w_ \
_p83=0.5*(_p82+sqrt(_p82*_p82+0.001)) \
_p84=1e-15*_p83
l1_sect1 (p1 _n1i_sect1) inductor l=_p3
l2_sect1 (_n2i_sect1 p2) inductor l=_p4
r1_sect1 (_n1i_sect1 _n_sect1) resistor r=_p7
r2_sect1 (_n_sect1 _n2i_sect1) resistor r=_p7
k12_sect1 mutual_inductor coupling=_p10 ind1=l1_sect1 ind2=l2_sect1
lc_sect1 (_nc_sect1 ct) inductor l=_p14
rc_sect1 (_n_sect1 _nc_sect1) resistor r=_p18
l1_sect2 (p1 _n1i_sect2) inductor l=_p22
l2_sect2 (_n2i_sect2 p2) inductor l=_p23
r1_sect2 (_n1i_sect2 _n_sect2) resistor r=_p26
r2_sect2 (_n_sect2 _n2i_sect2) resistor r=_p26
k12_sect2 mutual_inductor coupling=_p29 ind1=l1_sect2 ind2=l2_sect2
lc_sect2 (_nc_sect2 ct) inductor l=_p33
rc_sect2 (_n_sect2 _nc_sect2) resistor r=_p37
ks1s2_1 mutual_inductor coupling=_p40 ind1=l1_sect1 ind2=l1_sect2
ks1s2_2 mutual_inductor coupling=_p40 ind1=l2_sect1 ind2=l2_sect2
lx1 (_n1i_sect1 _nx1) inductor l=_p44
lx2 (_n2i_sect1 _nx2) inductor l=_p45
rx1 (_nx1 _n1i_sect2) resistor r=_p46
rx2 (_nx2 _n2i_sect2) resistor r=_p46
c12 (p1 p2) capacitor c=_p50
c_1_sub (p1 _n1_1_sub) capacitor c=_p60
rs_1_sub (_n1_1_sub nwell) resistor r=_p61
cs_1_sub (_n1_1_sub nwell) capacitor c=_p62
c_2_sub (p2 _n1_2_sub) capacitor c=_p63
rs_2_sub (_n1_2_sub nwell) resistor r=_p64
cs_2_sub (_n1_2_sub nwell) capacitor c=_p65
rx_1_2_sub (_n1_1_sub _n1_2_sub) resistor r=_p72
cx_1_2_sub (_n1_1_sub _n1_2_sub) capacitor c=_p73
csw (nwell nsw) capacitor c=_p77
rsw (nsw sub) resistor r=_p80
csw1 (nsw sub) capacitor c=_p84
ends lnw_sy40kct_rfvil
