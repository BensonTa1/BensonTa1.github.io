simulator lang=spectre insensitive=yes
library l110ae_l_sqsknw_vil_rf_v021_lib
//
section tt
parameters sqsknw_drs=1
parameters sqsknw_drs_sub=1
parameters sqsknw_dls=1
include "l110ae_l_sqsknw_vil_rf_v021.mdl.scs"
endsection tt
//
section ff
parameters sqsknw_drs=1.15
parameters sqsknw_drs_sub=0.85
parameters sqsknw_dls=1.05
include "l110ae_l_sqsknw_vil_rf_v021.mdl.scs"
endsection ff
//
section ss
parameters sqsknw_drs=0.85
parameters sqsknw_drs_sub=1.15
parameters sqsknw_dls=0.95
include "l110ae_l_sqsknw_vil_rf_v021.mdl.scs"
endsection ss
//
endlibrary l110ae_l_sqsknw_vil_rf_v021_lib
