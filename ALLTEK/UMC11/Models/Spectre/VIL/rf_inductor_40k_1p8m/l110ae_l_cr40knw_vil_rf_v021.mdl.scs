simulator lang=spectre insensitive=yes
// Model: lnw_cr40k_rfvil
// Planar circular RF inductor, N well, 4.0um metal8
// UMC 110nm 1P8M1T1F RFCMOS process
// Date: 2010
// Model coverage:(before shrinkage)
// od: (75 - 299) * 1e-06
// w: (2.23 - 9.7) * 1e-06
// s: (2.23 - 5) * 1e-06
// nt: 1.5 - 7.5
// Frequency range: 100MH - 0.8 * resonance (maximum 20.0 GHz)
subckt lnw_cr40k_rfvil (outer inner nwell sub)
parameters od=0.00015 od_=od/0.000299 w=6e-06 w_=w/9.97e-06 w_jump_=max(floor((w_-0.0401204)/0.0702106), 1) s=2.52e-06 s_=s/5e-06 nt=3.5  \
s0=(nt==1.5) \
s1=(nt==2.5) \
s2=(nt==3.5) \
s3=(nt==4.5) \
s4=(nt==5.5) \
s5=(nt==6.5) \
s6=(nt==7.5) \
v0=(-1.361226e+00)*s0+(-1.061287e+00)*s1+8.929476e-01*s2+3.848607e+00*s3+2.374234e+00*s4+(-2.531497e+00)*s5+2.742564e+00*s6 \
v1=5.609027e+00*s0+9.016736e+00*s1+6.828215e+00*s2+5.676091e+00*s3+6.551626e-01*s4+1.981196e+01*s5+(-2.592655e-04)*s6 \
v2=4.327321e-01*s0+3.209027e+00*s1+(-4.737386e+00)*s2+(-8.394889e+00)*s3+(-3.085778e+00)*s4+4.033801e+00*s5+(-9.160132e+00)*s6 \
v3=2.014773e+00*s0+(-1.114055e+01)*s1+(-2.554646e-01)*s2+8.983485e+00*s3+(-1.805588e+00)*s4+1.007896e+01*s5+(-4.621558e+00)*s6 \
v4=5.694712e+00*s0+(-7.607860e-01)*s1+(-1.766968e+00)*s2+(-2.581414e+00)*s3+5.578763e+00*s4+1.249547e+00*s5+(-7.069670e+03)*s6 \
v5=(-2.157349e+01)*s0+(-2.114835e+01)*s1+(-2.075121e+01)*s2+(-2.529389e+01)*s3+(-8.482370e+00)*s4+(-9.014318e+00)*s5+(-1.000000e+04)*s6 \
v6=(-4.455424e+00)*s0+5.891900e+00*s1+5.738261e+00*s2+2.264572e+00*s3+(-2.575167e+01)*s4+8.691256e-01*s5+(-1.000000e+04)*s6 \
v7=6.264981e+00*s0+6.071035e+00*s1+4.618539e+00*s2+(-3.639204e+00)*s3+4.088073e+00*s4+1.641020e+01*s5+2.342167e-01*s6 \
v8=(-3.152507e+00)*s0+1.964618e+02*s1+(-6.477425e+01)*s2+1.333327e+00*s3+(-2.259865e+01)*s4+(-3.383957e+01)*s5+(-9.129898e+01)*s6 \
v9=(-1.261326e+00)*s0+(-1.229931e+02)*s1+8.461014e+00*s2+(-6.707890e+00)*s3+(-9.917168e-02)*s4+(-1.690553e+01)*s5+(-2.537231e+01)*s6 \
v10=3.453770e+00*s0+(-1.135307e+02)*s1+3.342589e+01*s2+2.653882e+00*s3+1.011924e+01*s4+1.980931e+01*s5+6.979642e+01*s6 \
v11=(-5.044060e-01)*s0+(-3.322507e+01)*s1+1.325587e-01*s2+8.149903e-01*s3+5.516131e+00*s4+9.903742e+00*s5+(-1.251677e+01)*s6 \
v12=(-1.206321e-01)*s0+1.022519e+02*s1+(-8.043783e+00)*s2+8.942573e+00*s3+(-4.946673e-01)*s4+5.155984e+00*s5+1.722779e-01*s6 \
v13=1.582707e+00*s0+(-4.540161e+01)*s1+3.529540e+01*s2+1.065843e+00*s3+8.151055e+00*s4+9.138920e+00*s5+6.141354e+01*s6 \
v14=1.795013e-01*s0+5.236256e+00*s1+(-1.660972e+00)*s2+(-3.116230e-02)*s3+(-5.890524e-01)*s4+(-3.238066e-01)*s5+(-5.972095e+00)*s6 \
v15=(-7.390886e+01)*s0+2.450697e+02*s1+(-8.897468e+01)*s2+4.301493e+01*s3+(-5.223072e+00)*s4+(-3.721696e+01)*s5+1.557776e+02*s6 \
v16=2.954411e+02*s0+(-2.016780e+02)*s1+2.493073e+02*s2+(-5.056485e+01)*s3+1.690280e+00*s4+3.870712e+01*s5+(-3.491017e+02)*s6 \
v17=4.617333e-01*s0+8.472214e+00*s1+5.213057e-02*s2+(-1.028722e-01)*s3+1.335344e+00*s4+3.419649e-01*s5+(-1.438491e+01)*s6 \
v18=(-4.366047e-01)*s0+(-5.848405e+00)*s1+(-2.003636e-01)*s2+8.036877e-01*s3+(-4.113308e-01)*s4+(-1.940687e-01)*s5+2.391922e+01*s6 \
v19=(-2.001509e-01)*s0+1.591367e+00*s1+8.154960e-02*s2+(-1.018223e+00)*s3+(-1.060547e+00)*s4+(-2.395224e-01)*s5+(-8.877720e+00)*s6 \
v20=7.592748e-03*s0+1.675250e-01*s1+2.385999e-02*s2+7.023332e-02*s3+(-6.457936e-02)*s4+1.551304e+00*s5+(-5.818116e-01)*s6 \
v21=1.069814e-01*s0+1.232209e+00*s1+6.057047e-01*s2+2.523984e-02*s3+2.857118e-02*s4+3.505755e-01*s5+9.778278e-01*s6 \
v22=(-5.512746e-01)*s0+(-6.651691e+00)*s1+(-3.016315e+00)*s2+(-1.177462e+00)*s3+(-6.179157e-01)*s4+(-1.537327e+01)*s5+(-5.953549e-02)*s6 \
v23=1.107204e+00*s0+4.575635e+00*s1+4.375995e+00*s2+6.111792e+00*s3+6.451854e+00*s4+3.431240e+01*s5+5.051381e-01*s6 \
v24=5.309969e-01*s0+7.446982e+00*s1+2.899820e+00*s2+(-1.583282e-02)*s3+(-8.775063e-01)*s4+1.503622e+01*s5+(-1.497717e+00)*s6 \
v25=2.044637e-01*s0+(-3.311568e-01)*s1+1.625871e+00*s2+1.410634e+00*s3+3.057907e+00*s4+(-1.055106e+01)*s5+8.651493e+00*s6 \
v26=(-5.906558e-01)*s0+8.627252e-01*s1+(-1.762717e+00)*s2+(-4.957025e+00)*s3+(-5.619580e+00)*s4+(-4.603439e+01)*s5+(-1.072752e-01)*s6 \
v27=(-1.868892e-01)*s0+(-3.211609e+00)*s1+(-9.863939e-01)*s2+(-8.172103e-02)*s3+5.855190e-01*s4+(-1.048109e+01)*s5+(-6.030420e-01)*s6 \
v28=(-2.871697e-01)*s0+3.864907e-02*s1+(-2.093273e+00)*s2+(-3.501426e-01)*s3+(-5.597196e-01)*s4+2.403618e+01*s5+(-2.338608e+00)*s6 \
v29=1.433078e-01*s0+(-1.673757e+00)*s1+(-9.924746e-01)*s2+1.567641e+00*s3+1.097782e+00*s4+2.850762e+01*s5+2.110117e+00*s6 \
v30=2.670420e-01*s0+(-3.263595e-01)*s1+1.699657e+00*s2+5.214702e-01*s3+4.167002e-01*s4+(-1.555033e+01)*s5+(-1.879199e+00)*s6 \
v31=8.299081e-04*s0+(-2.667227e-01)*s1+(-3.715944e-01)*s2+(-3.187236e-01)*s3+(-7.355286e-01)*s4+(-7.752131e-01)*s5+(-1.249415e+00)*s6 \
v32=(-7.191321e-02)*s0+(-3.101391e-01)*s1+(-6.082072e-01)*s2+(-1.009677e+00)*s3+(-1.589341e+00)*s4+(-2.826276e+00)*s5+(-3.264956e+00)*s6 \
v33=2.510679e-03*s0+3.701879e-01*s1+4.805362e-01*s2+5.774292e-01*s3+1.158046e+00*s4+1.764229e+00*s5+2.470661e+00*s6 \
v34=6.520020e+00*s0+2.013003e+00*s1+2.687972e+01*s2+5.555316e+01*s3+(-2.841343e+00)*s4+1.130466e+02*s5+2.708012e+00*s6 \
v35=2.118775e+00*s0+(-6.454820e+00)*s1+(-2.035265e+01)*s2+(-2.207749e+00)*s3+(-6.942271e+00)*s4+(-2.992569e+02)*s5+(-6.507013e+00)*s6 \
v36=(-8.097941e+00)*s0+(-4.501204e+00)*s1+(-6.058826e+01)*s2+(-3.074175e+01)*s3+(-2.019394e+01)*s4+(-7.012712e+01)*s5+(-4.437556e+00)*s6 \
v37=(-2.438834e+00)*s0+3.526262e+00*s1+1.836221e+01*s2+(-4.885779e-01)*s3+1.473730e+01*s4+1.382220e+02*s5+3.683779e+00*s6 \
v38=4.025228e-01*s0+7.349186e-01*s1+3.758380e+00*s2+(-9.049312e-01)*s3+(-2.126461e+01)*s4+6.012737e+01*s5+3.766605e+00*s6 \
v39=1.857572e+00*s0+2.799273e+00*s1+4.182268e+01*s2+2.883968e+00*s3+8.250856e+00*s4+(-4.934802e+00)*s5+3.340584e+00*s6 \
v40=1.798724e+00*s0+4.400854e+00*s1+5.356017e+00*s2+8.474127e+00*s3+9.190901e+00*s4+6.387991e+01*s5+4.262695e+00*s6 \
v41=(-2.401780e-01)*s0+(-3.253395e-01)*s1+(-5.705708e-02)*s2+(-8.193399e-01)*s3+1.651922e+01*s4+(-3.333815e+00)*s5+4.675524e-01*s6 \
v42=1.118141e+01*s0+8.281364e+00*s1+(-1.265200e+01)*s2+(-4.866548e+02)*s3+1.796405e+02*s4+1.619122e+02*s5+1.461505e+01*s6 \
v43=(-1.009578e+01)*s0+9.139381e+00*s1+1.942292e+00*s2+1.766050e+03*s3+1.081499e+02*s4+(-4.300516e+02)*s5+1.095917e+01*s6 \
v44=3.725828e-01*s0+1.024891e+00*s1+8.626998e-01*s2+6.348324e+00*s3+(-1.518153e+01)*s4+(-1.353305e+00)*s5+3.177528e+00*s6 \
v45=6.428541e-01*s0+(-4.472095e-01)*s1+1.491671e-01*s2+(-3.670057e+00)*s3+(-1.791711e+01)*s4+(-6.052878e-01)*s5+(-4.811283e+00)*s6 \
v46=(-5.785767e-01)*s0+(-7.762119e-01)*s1+(-9.799550e-01)*s2+(-3.296150e+00)*s3+3.272886e+01*s4+2.431465e+00*s5+1.666577e+00*s6 \
v47=2.043284e-02*s0+7.306925e-02*s1+5.391832e-02*s2+(-6.220568e-01)*s3+(-9.454690e-01)*s4+3.135216e+01*s5+1.174146e+00*s6 \
v48=4.909583e-03*s0+5.999355e-02*s1+1.133890e-01*s2+9.797341e-01*s3+3.034853e+00*s4+2.980274e+00*s5+(-3.141716e-02)*s6 \
v49=(-2.986841e-01)*s0+(-1.198716e+00)*s1+(-1.541641e+00)*s2+1.991310e+00*s3+(-7.238807e+00)*s4+(-1.313965e+02)*s5+(-8.222376e+00)*s6 \
v50=1.959671e+00*s0+4.936075e+00*s1+7.454004e+00*s2+(-4.277151e-01)*s3+1.471358e+01*s4+1.681520e+02*s5+3.145368e+01*s6 \
v51=8.249724e-02*s0+4.421250e-01*s1+1.899476e-01*s2+(-6.093360e+00)*s3+4.268260e+00*s4+5.606156e-01*s5+(-4.472985e+00)*s6 \
v52=2.827437e-01*s0+5.290036e-01*s1+1.777380e+00*s2+9.866419e+00*s3+3.867500e+00*s4+(-5.462849e+01)*s5+6.357397e+00*s6 \
v53=(-1.015406e+00)*s0+(-2.515584e+00)*s1+(-4.824113e+00)*s2+1.186787e+01*s3+(-8.880074e+00)*s4+(-2.043598e+00)*s5+(-2.727738e+01)*s6 \
v54=(-6.344182e-02)*s0+(-1.722486e-01)*s1+1.046131e-01*s2+3.916973e+00*s3+(-9.018480e-02)*s4+7.709764e+00*s5+4.348413e+00*s6 \
v55=(-2.250929e-01)*s0+(-2.476738e-01)*s1+(-3.771740e-01)*s2+(-1.254520e+01)*s3+2.009275e+00*s4+(-7.042184e+00)*s5+1.745867e+00*s6 \
v56=2.746680e-01*s0+3.593200e-01*s1+5.995072e-01*s2+(-9.748120e+00)*s3+1.826009e-01*s4+(-1.834706e+01)*s5+7.620169e+00*s6 \
v57=2.390962e-01*s0+4.993451e-01*s1+9.155994e-01*s2+7.633677e+00*s3+(-1.672769e+00)*s4+1.194481e+01*s5+(-5.360793e-01)*s6 \
v58=(-2.627412e-02)*s0+(-1.176927e-01)*s1+(-3.651856e-01)*s2+(-9.095948e-01)*s3+(-3.086936e+00)*s4+(-1.503124e+00)*s5+(-2.711882e+00)*s6 \
v59=(-1.059717e-01)*s0+(-5.405991e-01)*s1+(-1.078719e+00)*s2+(-2.144174e+00)*s3+(-3.806587e+00)*s4+(-5.340741e+00)*s5+(-7.709167e+00)*s6 \
v60=3.747472e-02*s0+2.160217e-01*s1+5.784680e-01*s2+1.354834e+00*s3+4.145137e+00*s4+3.606076e+00*s5+5.779653e+00*s6 \
v61=3.318311e-02*s0+(-1.722119e-01)*s1+(-5.373282e-03)*s2+8.181441e-01*s3+3.217923e-01*s4+(-2.208579e+00)*s5+2.723790e+00*s6 \
v62=(-2.556542e-01)*s0+(-6.211172e-01)*s1+5.678119e-02*s2+9.011512e-01*s3+5.346628e-01*s4+(-1.074353e-01)*s5+5.132549e-01*s6 \
v63=1.698395e+00*s0+3.453727e+00*s1+(-3.331918e+00)*s2+(-1.478573e+01)*s3+(-6.143635e+00)*s4+5.625166e+00*s5+(-1.861326e+01)*s6 \
v64=1.176968e+00*s0+4.632615e-01*s1+2.076675e+00*s2+1.564687e+01*s3+9.589868e-01*s4+(-3.228982e+00)*s5+4.691127e+00*s6 \
v65=(-4.291463e+00)*s0+(-2.234387e+00)*s1+1.095192e+01*s2+2.400178e+01*s3+1.156792e+01*s4+2.336567e+01*s5+2.289689e+01*s6 \
v66=(-1.358188e+00)*s0+2.018030e-01*s1+(-8.163739e-01)*s2+(-1.092382e+01)*s3+(-1.234662e+00)*s4+(-5.601179e-01)*s5+3.129830e+01*s6 \
v67=4.707082e+00*s0+(-3.585331e+00)*s1+5.607819e+00*s2+(-9.995965e+00)*s3+2.728717e+00*s4+(-5.718515e+01)*s5+(-1.331104e+01)*s6 \
v68=2.054842e+00*s0+3.770428e-01*s1+(-1.049780e+01)*s2+(-1.323157e+01)*s3+(-3.528055e+00)*s4+(-2.346419e+01)*s5+(-1.049329e+01)*s6 \
v69=1.308281e+00*s0+4.111387e-01*s1+(-3.762537e+00)*s2+1.894393e+01*s3+1.002894e+01*s4+4.170600e+01*s5+(-3.721742e+01)*s6 \
v70=1.442360e-01*s0+3.235345e+00*s1+2.991639e+00*s2+1.272311e+00*s3+(-8.997227e+00)*s4+6.093157e+01*s5+1.480967e+01*s6 \
v71=(-2.547927e+00)*s0+(-3.955103e-01)*s1+(-1.705032e+00)*s2+(-1.131366e+01)*s3+(-3.462871e+00)*s4+(-4.293707e+01)*s5+4.736529e+00*s6 \
v72=(-3.331925e-01)*s0+(-1.356989e-01)*s1+(-3.911087e-01)*s2+(-2.658570e-01)*s3+(-3.832701e-01)*s4+(-3.459139e-01)*s5+2.709414e+00*s6 \
v73=8.931096e-03*s0+5.172228e-02*s1+3.331453e-02*s2+(-6.171611e-01)*s3+6.132916e-01*s4+1.218109e-01*s5+(-8.580987e+00)*s6 \
v74=4.394705e-01*s0+(-7.482362e-02)*s1+1.528248e-01*s2+5.018450e-01*s3+(-7.203520e-01)*s4+(-7.795648e-01)*s5+4.563119e+00*s6 \
v75=(-1.842732e-01)*s0+2.336296e-01*s1+4.630955e-01*s2+(-4.258110e-01)*s3+1.433295e-01*s4+2.422959e-01*s5+2.231514e-01*s6 \
v76=2.954276e+00*s0+3.086152e+00*s1+3.711358e+00*s2+3.991703e+00*s3+4.175882e+00*s4+1.680595e+00*s5+4.965233e+00*s6 \
v77=8.029277e-01*s0+(-5.650773e-01)*s1+(-1.388051e+00)*s2+4.078211e-01*s3+(-6.014625e-01)*s4+4.217776e-01*s5+(-9.726174e-01)*s6 \
v78=7.285420e-01*s0+6.223236e-01*s1+9.176077e-02*s2+3.062546e-01*s3+6.114171e-01*s4+(-2.068605e-01)*s5+2.784589e-01*s6 \
v79=1.750820e-01*s0+4.688931e+00*s1+4.364649e+00*s2+2.224145e+00*s3+5.888591e+00*s4+3.024144e+00*s5+5.739247e+00*s6 \
v80=(-2.166668e-01)*s0+(-4.258337e-01)*s1+6.389176e-01*s2+3.777411e-02*s3+(-1.016029e+00)*s4+(-1.699213e+00)*s5+(-7.989006e-01)*s6 \
v81=(-2.986087e-01)*s0+1.172486e+00*s1+5.782360e-01*s2+(-1.257814e-02)*s3+1.237899e+00*s4+(-5.551908e-01)*s5+(-3.789352e-01)*s6 \
v82=(-8.703218e-01)*s0+(-2.160017e+00)*s1+(-9.907765e-01)*s2+6.110100e-01*s3+(-2.911725e+00)*s4+1.007733e+00*s5+(-1.689321e+00)*s6 \
v83=6.399214e-01*s0+(-1.368546e+00)*s1+(-1.373346e+00)*s2+1.468320e-01*s3+(-8.815385e-01)*s4+(-9.721297e-01)*s5+7.411436e-01*s6 \
v84=2.059255e+01*s0+2.105631e+01*s1+1.477491e+01*s2+3.130231e+00*s3+4.660437e+00*s4+(-1.348962e+01)*s5+9.009432e+01*s6 \
v85=6.268261e+00*s0+1.178624e+00*s1+(-2.991819e+00)*s2+2.809096e+00*s3+(-5.229246e+00)*s4+5.597295e+01*s5+1.198540e+01*s6 \
v86=(-3.710190e+01)*s0+(-4.467459e+01)*s1+(-2.159634e+01)*s2+(-4.380171e+00)*s3+(-1.874278e+00)*s4+2.195678e+01*s5+(-1.975100e+02)*s6 \
v87=3.058004e+00*s0+9.955777e-01*s1+(-6.450720e-01)*s2+(-1.526814e-01)*s3+2.433611e+00*s4+(-4.168520e+00)*s5+3.374308e-01*s6 \
v88=(-8.904027e+00)*s0+(-3.255079e+00)*s1+3.112719e+00*s2+(-3.461010e+00)*s3+8.080109e-01*s4+(-4.824446e+01)*s5+(-1.901275e+01)*s6 \
v89=2.037614e+01*s0+2.683380e+01*s1+8.790429e+00*s2+2.964944e+00*s3+7.825763e-01*s4+(-5.916050e+00)*s5+1.205249e+02*s6 \
v90=3.322880e+00*s0+1.397113e+00*s1+1.127259e+00*s2+1.736886e+00*s3+5.676579e-01*s4+(-9.598211e+00)*s5+4.690190e+01*s6 \
v91=6.216360e+00*s0+2.411165e-01*s1+6.023759e-01*s2+2.092394e+00*s3+(-1.319794e+00)*s4+5.847240e+00*s5+1.005890e+01*s6 \
v92=(-6.718988e+00)*s0+(-1.471420e+00)*s1+(-1.571648e+00)*s2+(-2.844194e+00)*s3+1.046427e+00*s4+6.332309e+00*s5+(-5.843107e+01)*s6 \
v93=(-9.115889e-01)*s0+(-4.466542e-01)*s1+(-1.560718e-01)*s2+(-9.847460e-01)*s3+(-2.051087e-01)*s4+8.514449e-02*s5+1.117856e-01*s6 \
v94=3.325381e+00*s0+3.460404e+00*s1+3.528582e+00*s2+4.005950e+00*s3+3.305958e+00*s4+8.954591e-01*s5+2.914418e+00*s6 \
v95=2.154648e+00*s0+7.418108e-01*s1+1.924508e-01*s2+1.451528e+00*s3+1.628525e-01*s4+(-1.192448e-01)*s5+(-2.445871e-01)*s6 \
v96=4.262937e-01*s0+1.582336e-01*s1+(-6.398692e-02)*s2+(-1.773621e-01)*s3+5.853874e-01*s4+(-7.090304e-01)*s5+1.247560e+00*s6 \
v97=3.834852e-01*s0+5.004086e+00*s1+4.698733e+00*s2+2.689720e+00*s3+6.533270e+00*s4+4.148219e+00*s5+5.213060e+00*s6 \
v98=(-1.143204e+00)*s0+(-1.407546e+00)*s1+(-7.138551e-01)*s2+(-1.016302e+00)*s3+(-1.958136e+00)*s4+(-1.765999e+00)*s5+(-8.108657e-01)*s6 \
v99=(-4.499903e-01)*s0+1.068782e+00*s1+4.612288e-01*s2+(-1.263118e-01)*s3+9.597009e-01*s4+(-1.096435e+00)*s5+(-3.967966e-01)*s6 \
v100=(-7.663661e-01)*s0+(-2.085720e+00)*s1+(-1.128739e+00)*s2+5.336250e-01*s3+(-3.137266e+00)*s4+5.223559e-01*s5+(-2.258725e+00)*s6 \
v101=6.048138e-01*s0+(-1.255313e+00)*s1+(-1.189100e+00)*s2+1.928658e-01*s3+(-3.974330e-01)*s4+1.109854e-01*s5+1.319288e+00*s6 \
v102=2.261292e+00*s0+7.246853e-01*s1+2.673111e+00*s2+1.052440e-01*s3+1.256562e+00*s4+(-2.602264e+03)*s5+2.093527e+00*s6 \
v103=(-2.191824e+00)*s0+2.799902e-03*s1+(-2.431690e+00)*s2+2.011851e+00*s3+1.225079e+00*s4+7.754590e+03*s5+5.363444e-01*s6 \
v104=(-1.467374e+00)*s0+(-3.047200e-01)*s1+(-1.532407e+00)*s2+1.127611e+00*s3+9.097695e+00*s4+4.250763e+03*s5+(-2.335690e+00)*s6 \
v105=1.128234e+00*s0+(-5.749458e-02)*s1+8.460065e-01*s2+(-1.279335e+00)*s3+(-8.267786e-01)*s4+2.406841e+03*s5+(-6.741651e-01)*s6 \
v106=9.630442e-01*s0+(-1.878164e-01)*s1+7.129779e-01*s2+(-1.426473e+00)*s3+(-2.021703e+00)*s4+1.876009e+03*s5+(-1.143364e-01)*s6 \
v107=1.190470e+00*s0+8.669823e-01*s1+1.046514e+00*s2+1.105150e-01*s3+(-6.510924e+00)*s4+4.620895e+03*s5+2.548104e+00*s6 \
v108=1.829601e-01*s0+3.736896e-02*s1+(-5.143831e-02)*s2+(-7.135820e-01)*s3+(-2.534489e+00)*s4+3.224818e+02*s5+2.659744e-01*s6 \
v109=1.978050e-01*s0+3.921212e-02*s1+(-6.843061e-02)*s2+4.232735e-01*s3+1.864781e+00*s4+1.104704e+02*s5+(-4.189158e-01)*s6 \
v110=(-2.649300e-01)*s0+(-1.966684e-01)*s1+(-3.794476e-02)*s2+1.114721e+00*s3+1.182718e+00*s4+9.422239e+00*s5+3.602188e-01*s6 \
v111=9.375833e-01*s0+(-1.102574e-01)*s1+(-7.475405e-01)*s2+1.134246e+00*s3+(-1.203674e-01)*s4+(-2.017937e+00)*s5+(-8.831128e-01)*s6 \
v112=(-3.374611e-01)*s0+1.799295e+00*s1+1.125213e+00*s2+8.015852e-01*s3+1.831499e+00*s4+9.347759e+00*s5+3.381385e+00*s6 \
v113=(-1.715325e+00)*s0+(-3.369711e-01)*s1+5.595763e-01*s2+(-3.396838e+00)*s3+(-1.919016e+00)*s4+1.566314e+00*s5+(-2.490267e+00)*s6 \
v114=(-5.488666e-01)*s0+(-1.777143e+00)*s1+7.544727e-02*s2+(-1.816489e-01)*s3+(-7.357603e-01)*s4+(-5.891157e-01)*s5+(-1.339768e+00)*s6 \
v115=4.893367e+00*s0+(-1.690549e+00)*s1+4.199082e+00*s2+1.241984e+01*s3+8.437878e+00*s4+1.468317e+01*s5+1.635430e+01*s6 \
v116=(-1.433537e-01)*s0+9.642771e-01*s1+(-2.132409e+00)*s2+(-2.044737e+00)*s3+(-1.436177e+00)*s4+(-6.663368e+00)*s5+(-5.779260e+00)*s6 \
v117=6.224263e-01*s0+(-4.060117e+00)*s1+(-1.221699e+00)*s2+(-1.913981e-01)*s3+(-2.784300e+00)*s4+(-1.088330e+00)*s5+(-1.976580e+00)*s6 \
v118=2.015546e+00*s0+8.931872e+00*s1+5.102770e+00*s2+3.798007e+00*s3+1.138707e+01*s4+6.147978e+00*s5+1.260191e+01*s6 \
v119=(-1.242963e+00)*s0+2.508393e+00*s1+1.389669e+00*s2+(-3.346853e+00)*s3+(-1.719925e+00)*s4+(-2.719170e+00)*s5+(-6.334809e+00)*s6 \
v120=(-9.612191e-01)*s0+1.000000e+04*s1+1.640660e+00*s2+1.546316e+01*s3+(-1.862179e-01)*s4+6.424085e-01*s5+1.172543e+00*s6 \
v121=1.297558e+00*s0+8.862723e+01*s1+(-8.017752e-01)*s2+(-2.744315e+01)*s3+2.996410e+00*s4+(-7.030293e-01)*s5+(-9.508093e-01)*s6 \
v122=3.077749e+00*s0+(-1.000000e+04)*s1+(-2.341410e+00)*s2+(-4.591355e+00)*s3+6.759677e-01*s4+4.949568e-01*s5+1.244264e+00*s6 \
v123=(-7.245364e-01)*s0+(-3.749801e+00)*s1+6.289275e-01*s2+1.881919e+01*s3+(-1.529399e+00)*s4+4.612855e-01*s5+4.746586e-01*s6 \
v124=(-1.450477e+00)*s0+(-8.202488e+01)*s1+3.427586e+00*s2+(-1.297387e+00)*s3+(-5.110186e-01)*s4+(-2.728155e-01)*s5+2.656118e-01*s6 \
v125=(-6.198255e-01)*s0+1.369167e+00*s1+2.307649e+00*s2+5.454408e+00*s3+2.033257e-01*s4+9.124015e-02*s5+(-1.114204e+00)*s6 \
v126=1.907506e+00*s0+(-9.032579e+02)*s1+(-3.542965e-01)*s2+(-9.871861e-01)*s3+8.725289e-01*s4+5.811762e-01*s5+(-2.587550e-01)*s6 \
v127=(-1.315059e-01)*s0+4.690279e+00*s1+7.546481e-01*s2+(-3.367764e+00)*s3+1.057370e-01*s4+(-3.290317e-01)*s5+(-1.762009e-01)*s6 \
v128=(-1.585883e+00)*s0+9.007044e+02*s1+2.568234e-01*s2+2.083895e+00*s3+(-1.390777e+00)*s4+(-2.488882e-01)*s5+3.948300e-01*s6 \
v129=1.109700e+00*s0+2.657187e-01*s1+2.984711e+00*s2+3.771338e+00*s3+(-1.702531e+00)*s4+(-1.299004e+03)*s5+1.210818e+00*s6 \
v130=(-2.366724e+00)*s0+(-9.444098e-01)*s1+(-1.456709e+01)*s2+3.377417e-01*s3+(-7.212444e-01)*s4+(-3.239677e+03)*s5+(-2.375652e+00)*s6 \
v131=4.754490e-01*s0+6.331354e-01*s1+1.705330e+00*s2+(-9.912514e+00)*s3+5.647096e+00*s4+1.604153e+03*s5+(-1.810654e+00)*s6 \
v132=1.312705e+00*s0+5.986112e-01*s1+1.527006e+01*s2+(-1.409517e+00)*s3+1.632064e+00*s4+(-7.962874e+02)*s5+1.661904e+00*s6 \
v133=(-2.083708e-01)*s0+(-7.471947e-03)*s1+9.538356e-01*s2+2.163745e+00*s3+(-2.341385e+00)*s4+1.000000e+04*s5+(-3.819784e-01)*s6 \
v134=(-1.097808e-01)*s0+(-3.983201e-01)*s1+2.616172e+00*s2+5.834113e+00*s3+2.570500e+00*s4+1.000000e+04*s5+2.477008e+00*s6 \
v135=4.131268e-01*s0+1.958762e-01*s1+1.953635e+00*s2+5.090787e-01*s3+(-1.127591e+01)*s4+6.136698e+02*s5+1.372075e+00*s6 \
v136=(-3.050695e-01)*s0+(-1.226487e-01)*s1+(-6.681205e+00)*s2+(-4.862209e-02)*s3+1.090079e+01*s4+(-7.851132e+02)*s5+1.886154e-01*s6 \
v137=(-1.512070e-01)*s0+(-1.092963e-01)*s1+4.887780e+00*s2+(-8.951506e-01)*s3+2.417220e+01*s4+4.697907e+02*s5+(-2.038603e+00)*s6 \
v138=1.281534e+02*s0+(-2.464754e+01)*s1+4.558594e-01*s2+(-1.693251e+00)*s3+5.969132e+01*s4+1.000000e+04*s5+4.434918e-02*s6 \
v139=(-6.194498e+01)*s0+3.415774e+02*s1+(-1.750960e+00)*s2+(-1.274249e+00)*s3+(-7.992255e-01)*s4+1.000000e+04*s5+2.815764e-02*s6 \
v140=(-1.127239e+01)*s0+(-6.677926e+01)*s1+1.139548e+00*s2+1.020571e-01*s3+(-4.177306e+01)*s4+1.000000e+04*s5+1.034758e+00*s6 \
v141=4.315985e+02*s0+(-5.648515e+02)*s1+8.996390e-01*s2+3.510803e-02*s3+(-2.062895e+01)*s4+1.000000e+04*s5+4.418602e-02*s6 \
v142=(-2.471315e+00)*s0+1.240112e+02*s1+9.058024e-01*s2+3.134326e+00*s3+(-8.754286e+01)*s4+1.000000e+04*s5+6.593519e-02*s6 \
v143=(-1.842410e+02)*s0+(-1.945883e+00)*s1+(-1.606870e+00)*s2+1.544293e+01*s3+(-3.524735e+01)*s4+1.000000e+04*s5+(-1.153778e+00)*s6 \
v144=(-2.464356e+01)*s0+(-4.276946e+01)*s1+5.050820e-01*s2+1.690146e+01*s3+1.133534e+02*s4+(-1.402642e+02)*s5+(-8.642456e-01)*s6 \
v145=(-7.172150e+01)*s0+6.600069e+01*s1+(-3.249878e-01)*s2+(-2.233279e+01)*s3+(-2.332501e+02)*s4+(-8.301726e+02)*s5+5.382218e+00*s6 \
v146=5.662320e+01*s0+1.277481e+01*s1+(-4.177394e-01)*s2+(-2.073639e+01)*s3+(-4.763007e+01)*s4+(-1.030243e+03)*s5+(-7.582957e+00)*s6 \
v147=(-9.978421e-01)*s0+7.074278e+03*s1+(-6.048973e-01)*s2+3.054101e+00*s3+2.416677e+00*s4+1.342042e+01*s5+(-7.725338e+00)*s6 \
v148=2.453215e+00*s0+7.459809e+02*s1+5.894640e-01*s2+(-1.247055e+01)*s3+1.489959e-01*s4+(-7.050794e+00)*s5+(-2.767490e+00)*s6 \
v149=2.865251e+01*s0+1.000000e+04*s1+9.280446e-01*s2+5.185426e+00*s3+(-6.411141e+00)*s4+4.090279e+01*s5+1.194661e+01*s6 \
v150=(-2.381673e-01)*s0+1.000000e+04*s1+(-3.315192e-01)*s2+3.169358e+00*s3+(-1.984974e+00)*s4+(-1.107212e+00)*s5+(-9.473188e-01)*s6 \
v151=(-2.401920e+01)*s0+4.154775e+03*s1+(-4.052194e-01)*s2+1.787220e+01*s3+1.848813e+00*s4+(-1.562905e+00)*s5+(-4.512038e+00)*s6 \
v152=(-4.187513e-01)*s0+1.000000e+04*s1+(-4.037864e-02)*s2+(-8.900477e+00)*s3+4.192509e+00*s4+(-4.616912e+01)*s5+7.423388e+00*s6 \
v153=1.944679e+00*s0+(-1.202693e+03)*s1+(-3.743739e-02)*s2+1.740699e+00*s3+2.291637e-01*s4+(-3.279062e+01)*s5+(-1.884470e+01)*s6 \
v154=(-3.115962e+00)*s0+(-4.204269e+02)*s1+1.246577e-01*s2+5.212684e+00*s3+(-9.637053e-02)*s4+2.702693e+01*s5+5.021246e+01*s6 \
v155=1.683545e+00*s0+(-6.236971e+02)*s1+3.974934e-02*s2+(-1.651315e+01)*s3+(-1.737309e-01)*s4+7.317814e+00*s5+(-2.831691e+01)*s6 \
v156=(-2.536217e+00)*s0+(-4.186628e-01)*s1+(-9.551555e+00)*s2+(-1.521027e+01)*s3+(-1.556831e+01)*s4+(-5.243098e+01)*s5+(-1.353294e+01)*s6 \
v157=1.025691e+01*s0+8.970017e+00*s1+3.175357e+01*s2+9.077284e+01*s3+6.099687e+01*s4+(-1.573397e+03)*s5+1.683163e+02*s6 \
v158=3.269206e+00*s0+1.205992e+00*s1+(-5.649635e+00)*s2+(-1.812030e+01)*s3+(-7.344401e+00)*s4+1.341257e+03*s5+3.307504e+00*s6 \
v159=(-1.569564e+00)*s0+(-2.508775e+00)*s1+7.366744e+01*s2+(-4.004353e+01)*s3+5.623380e+01*s4+7.952237e+03*s5+4.436813e+01*s6 \
v160=(-2.276030e+00)*s0+(-3.827795e+00)*s1+3.879022e+01*s2+1.825183e+02*s3+2.026349e+01*s4+(-1.000000e+04)*s5+(-5.789046e+00)*s6 \
v161=(-1.244889e+00)*s0+(-1.281071e-01)*s1+5.464527e+00*s2+(-5.690787e+01)*s3+3.256194e+00*s4+2.915240e+03*s5+(-1.118094e+01)*s6 \
v162=1.241722e+00*s0+(-1.025603e+00)*s1+1.057655e+01*s2+(-1.502101e+01)*s3+1.253912e+01*s4+8.138040e+02*s5+1.683248e+01*s6 \
v163=(-1.712900e+00)*s0+2.398315e-01*s1+(-6.117031e+01)*s2+5.644027e+01*s3+(-2.095182e+01)*s4+8.437753e+01*s5+(-2.160567e+02)*s6 \
v164=(-1.993215e-01)*s0+1.120407e+00*s1+8.687539e+00*s2+(-7.073513e+01)*s3+1.950516e+01*s4+2.976440e+02*s5+9.457887e+01*s6 \
v165=(-4.637429e-01)*s0+1.518376e+00*s1+1.380632e+01*s2+1.110722e+01*s3+8.740752e+00*s4+2.451422e+02*s5+7.312512e+00*s6 \
v166=9.078532e-02*s0+(-1.753912e+00)*s1+(-1.831541e+01)*s2+(-3.579627e+00)*s3+(-4.112390e+00)*s4+(-3.226188e+02)*s5+(-7.267419e+00)*s6 \
v167=1.359376e+00*s0+(-1.336837e+00)*s1+(-6.113683e+00)*s2+(-5.765297e+00)*s3+(-1.482513e+00)*s4+(-9.248823e+01)*s5+(-5.488463e-01)*s6 \
v168=4.857075e-01*s0+6.132033e-01*s1+1.184150e+01*s2+(-7.912165e-01)*s3+1.330178e+00*s4+9.138344e+01*s5+2.921254e+00*s6 \
v169=(-1.242970e+00)*s0+2.900485e+00*s1+(-6.155613e-01)*s2+2.073844e+00*s3+(-1.585156e+00)*s4+1.507629e+02*s5+6.864994e-01*s6 \
v170=(-2.120919e-01)*s0+(-4.729617e-01)*s1+3.352394e+00*s2+8.986779e-01*s3+4.108536e-01*s4+(-6.165916e+01)*s5+(-2.592101e-01)*s6 \
v171=(-3.997231e-02)*s0+(-2.132786e+00)*s1+5.056500e-01*s2+1.033288e+00*s3+2.711950e+00*s4+5.028704e+01*s5+3.845636e+00*s6 \
v172=(-7.685446e-02)*s0+1.971995e+00*s1+3.236164e-01*s2+2.058501e+00*s3+(-2.111380e+00)*s4+(-5.106099e+01)*s5+(-4.507392e-01)*s6 \
v173=(-1.899706e-01)*s0+1.040972e+00*s1+(-5.958325e-01)*s2+(-3.459417e+00)*s3+(-3.720314e-01)*s4+1.230337e+00*s5+(-1.906385e+00)*s6 \
v174=1.329452e+01*s0+9.668387e+01*s1+1.368377e+01*s2+3.775548e+01*s3+1.464635e+01*s4+(-1.939003e+01)*s5+8.356469e+00*s6 \
v175=4.476503e+02*s0+3.165741e+02*s1+5.112482e+01*s2+(-9.699668e+01)*s3+2.847852e+00*s4+(-1.207617e+01)*s5+(-2.230535e+01)*s6 \
v176=(-7.159263e+01)*s0+(-2.991907e+02)*s1+(-1.893871e+01)*s2+(-3.888128e+01)*s3+(-9.554730e+00)*s4+1.075588e+02*s5+1.233566e+01*s6 \
v177=3.038319e+02*s0+(-2.150291e+02)*s1+(-4.707710e+01)*s2+7.648639e+01*s3+(-9.638117e-01)*s4+7.719673e+01*s5+5.029898e+00*s6 \
v178=(-8.280291e+02)*s0+(-5.892011e+01)*s1+3.428239e+01*s2+3.340955e+00*s3+1.211216e+01*s4+(-7.459278e+01)*s5+5.535082e+00*s6 \
v179=(-8.297897e+01)*s0+1.017050e+02*s1+(-2.329667e-01)*s2+4.760085e+01*s3+9.116240e+00*s4+(-4.803058e+01)*s5+3.645328e+00*s6 \
v180=1.767819e+01*s0+(-1.089139e+02)*s1+(-1.156074e+01)*s2+(-1.080467e+01)*s3+5.837847e+01*s4+1.567940e+01*s5+3.080955e+01*s6 \
v181=(-6.114384e+02)*s0+(-5.987697e+01)*s1+3.000832e+01*s2+(-1.025716e+00)*s3+(-7.345338e+01)*s4+(-9.795256e-01)*s5+4.987780e+01*s6 \
v182=(-7.420931e+02)*s0+1.029566e+02*s1+(-7.214154e-01)*s2+2.033678e+01*s3+(-2.928222e+00)*s4+(-3.567217e+01)*s5+(-2.460929e+01)*s6 \
v183=(-6.443957e+00)*s0+5.616238e+00*s1+8.960000e-01*s2+5.180836e+00*s3+2.392419e+01*s4+8.235013e+01*s5+(-5.213805e+00)*s6 \
v184=8.093320e+01*s0+5.502344e+01*s1+(-3.709456e+00)*s2+(-3.941386e+01)*s3+4.833379e+01*s4+(-1.348853e+02)*s5+1.088450e+01*s6 \
v185=1.016152e+01*s0+1.063586e+01*s1+(-7.167380e-01)*s2+(-2.707675e-01)*s3+(-3.660941e+01)*s4+(-2.670990e+01)*s5+(-1.923117e+01)*s6 \
v186=1.695595e+02*s0+2.094828e+02*s1+1.111820e+01*s2+9.651744e+01*s3+1.025381e+02*s4+5.293093e+01*s5+7.886264e+01*s6 \
v187=8.686355e+01*s0+(-3.997899e+01)*s1+(-3.147312e+00)*s2+(-2.492144e+01)*s3+(-2.428677e+01)*s4+4.378615e+01*s5+1.297369e+01*s6 \
v188=(-3.183630e+01)*s0+2.119532e+00*s1+1.936297e+00*s2+7.790969e+00*s3+4.096710e+01*s4+(-1.435047e+01)*s5+1.051988e+01*s6 \
v189=(-3.377017e+00)*s0+1.647198e+00*s1+1.069016e+00*s2+7.539633e+00*s3+(-1.855226e+01)*s4+1.182202e+01*s5+(-5.642875e+01)*s6 \
v190=6.667967e+00*s0+6.996725e-01*s1+(-3.488799e+00)*s2+(-3.055354e+01)*s3+1.090263e+01*s4+(-1.592859e+01)*s5+2.226602e+02*s6 \
v191=1.880524e+00*s0+(-1.104411e+01)*s1+5.359309e-01*s2+2.665000e+00*s3+(-2.075137e+01)*s4+3.571443e+00*s5+(-5.716873e+01)*s6 \
v192=4.962947e+00*s0+6.341716e+00*s1+8.372777e+00*s2+2.067318e+01*s3+9.858357e+00*s4+(-2.735923e+02)*s5+1.019415e+01*s6 \
v193=(-6.427399e+00)*s0+(-7.379179e+00)*s1+(-6.947672e+00)*s2+(-3.307866e+01)*s3+(-1.234423e+01)*s4+1.143225e+03*s5+(-9.416562e+00)*s6 \
v194=1.483004e+00*s0+1.993549e+00*s1+(-1.102871e+00)*s2+1.312732e+01*s3+1.106933e+00*s4+1.209838e+01*s5+1.677373e+00*s6 \
v195=2.865406e+00*s0+2.811555e+00*s1+2.138918e+00*s2+1.542154e+01*s3+4.858845e+00*s4+(-8.662627e+02)*s5+2.426784e+00*s6 \
v196=(-1.141412e+00)*s0+(-1.300463e+00)*s1+2.831585e+00*s2+(-9.314389e+00)*s3+(-1.394691e+00)*s4+(-9.703554e+00)*s5+(-1.073768e+00)*s6 \
v197=5.388521e-01*s0+2.933136e-01*s1+4.960082e-01*s2+1.193936e+00*s3+1.354683e+00*s4+(-2.341615e+00)*s5+6.329150e-01*s6 \
v198=(-2.695516e-01)*s0+(-3.869136e-01)*s1+4.993267e+00*s2+6.929484e+00*s3+(-1.744338e+00)*s4+4.403443e+01*s5+(-2.393846e+00)*s6 \
v199=1.015190e-01*s0+1.822639e-01*s1+(-2.796025e+00)*s2+(-7.035404e+00)*s3+1.492296e+00*s4+(-5.121480e+01)*s5+1.845418e-01*s6 \
v200=9.533420e-01*s0+(-4.827739e-01)*s1+(-3.983415e-01)*s2+(-1.529154e+00)*s3+1.001328e-02*s4+(-8.734267e+00)*s5+6.654259e-01*s6 \
v201=2.551564e+01*s0+1.073020e+01*s1+(-2.594658e+01)*s2+(-8.821844e+00)*s3+1.453436e+01*s4+4.188232e+01*s5+2.478890e+01*s6 \
v202=(-5.029065e+00)*s0+(-2.011501e+01)*s1+9.097773e+01*s2+6.306541e+01*s3+5.560089e+00*s4+(-1.644430e+02)*s5+2.067158e+01*s6 \
v203=(-1.608622e+01)*s0+(-2.577110e+01)*s1+(-1.835806e+01)*s2+(-1.189688e+01)*s3+(-6.679999e+00)*s4+1.067563e+01*s5+(-1.049902e+01)*s6 \
v204=(-2.045615e+01)*s0+(-5.911602e-01)*s1+(-6.802330e+00)*s2+(-5.530213e+01)*s3+(-4.692563e+00)*s4+2.224223e+02*s5+(-3.586312e-01)*s6 \
v205=(-1.821246e+01)*s0+5.562950e+01*s1+(-5.016423e+01)*s2+2.165618e+01*s3+(-2.204226e+01)*s4+(-6.468007e+01)*s5+(-2.057225e-01)*s6 \
v206=(-3.837573e+00)*s0+3.505717e+00*s1+3.070361e+01*s2+(-6.808082e+00)*s3+1.065077e+01*s4+2.086228e+01*s5+(-8.703462e+00)*s6 \
v207=(-1.984029e+01)*s0+4.618447e+00*s1+(-9.517548e+00)*s2+(-1.035828e+01)*s3+(-2.543859e+01)*s4+(-3.943583e+01)*s5+(-6.614265e+01)*s6 \
v208=1.448140e+01*s0+(-1.121330e+01)*s1+(-2.937049e+01)*s2+1.028682e+01*s3+1.249810e+00*s4+5.681175e+01*s5+(-1.564960e+00)*s6 \
v209=1.847370e+01*s0+7.921869e-02*s1+2.185011e+01*s2+(-4.049265e+00)*s3+1.320001e+01*s4+2.962787e+01*s5+2.103429e+01*s6 \
v210=8.733706e+00*s0+(-1.231942e+01)*s1+1.241629e+01*s2+7.000032e+00*s3+(-4.731296e+00)*s4+(-1.406235e+02)*s5+1.244805e+01*s6 \
v211=(-1.755658e+01)*s0+3.670583e+01*s1+1.803653e+01*s2+6.444746e+01*s3+1.827895e+01*s4+4.081360e+02*s5+(-4.594637e+01)*s6 \
v212=(-4.603542e+01)*s0+(-1.405699e+01)*s1+3.691013e+01*s2+2.505666e+00*s3+(-9.458289e+00)*s4+2.121856e+02*s5+(-2.375797e+00)*s6 \
v213=6.887747e+00*s0+(-1.170497e+01)*s1+1.536535e+02*s2+1.378403e+02*s3+(-5.125254e+00)*s4+(-9.569287e+01)*s5+4.340609e+01*s6 \
v214=7.033102e+01*s0+6.742889e+01*s1+(-8.659596e+01)*s2+(-1.867356e+02)*s3+6.298349e+00*s4+(-1.296423e+01)*s5+1.006908e+01*s6 \
v215=2.451313e+01*s0+(-3.890801e+00)*s1+(-2.308655e-01)*s2+8.256114e+01*s3+5.140500e+00*s4+(-2.120228e+02)*s5+(-4.597613e+00)*s6 \
v216=(-9.402139e+00)*s0+1.145398e+01*s1+1.565963e+01*s2+2.624938e+00*s3+2.274512e+00*s4+(-1.944710e+01)*s5+(-3.751310e+00)*s6 \
v217=1.789706e+01*s0+(-2.915276e+01)*s1+2.189841e+01*s2+5.987641e+00*s3+(-5.924752e+00)*s4+1.654866e+01*s5+7.277154e+00*s6 \
v218=4.842996e+00*s0+(-7.673399e+00)*s1+(-1.824019e+01)*s2+3.935735e+01*s3+1.492753e+00*s4+(-2.669345e+01)*s5+(-2.141758e-01)*s6 \
v219=5.985472e+01*s0+2.409537e+01*s1+8.650830e+00*s2+1.108157e+01*s3+1.498764e+01*s4+7.371926e+00*s5+4.895115e+01*s6 \
v220=(-6.670710e+01)*s0+(-2.801526e+01)*s1+(-1.121184e+01)*s2+(-1.368692e+01)*s3+(-9.007576e+00)*s4+(-8.782602e+00)*s5+(-2.853521e+01)*s6 \
v221=(-3.789297e+01)*s0+(-1.107600e+01)*s1+6.015572e+00*s2+7.186817e-01*s3+(-6.736944e+00)*s4+1.325380e+00*s5+1.612993e+00*s6 \
v222=2.647942e+01*s0+1.143980e+01*s1+4.519431e+00*s2+7.122379e+00*s3+2.715411e+00*s4+3.684024e+00*s5+(-2.215917e+00)*s6 \
v223=1.051112e+01*s0+3.664325e+00*s1+(-5.015643e+00)*s2+(-3.995433e+00)*s3+(-2.027196e+00)*s4+(-1.465659e-01)*s5+(-7.770377e+00)*s6 \
v224=1.199915e+01*s0+2.947229e+00*s1+(-3.753633e-01)*s2+2.728454e+00*s3+6.133799e+00*s4+(-1.365753e+00)*s5+(-1.223660e+00)*s6 \
v225=(-1.446930e+01)*s0+4.316823e+00*s1+(-1.411745e+00)*s2+(-3.672431e+00)*s3+(-4.672200e+00)*s4+(-3.388460e-01)*s5+(-5.588745e+01)*s6 \
v226=3.449388e+00*s0+4.524183e-01*s1+1.311322e+00*s2+2.681840e+00*s3+(-2.317332e+00)*s4+3.412667e-01*s5+4.705930e+01*s6 \
v227=9.317945e+00*s0+(-3.214143e+00)*s1+(-1.722726e-01)*s2+1.143479e+00*s3+4.188576e+00*s4+(-2.208772e-01)*s5+5.828403e+00*s6 \
v228=(-8.222776e+00)*s0+9.415471e+00*s1+(-9.812721e+03)*s2+(-1.815002e+01)*s3+1.087176e+01*s4+3.815320e+01*s5+2.401154e+00*s6 \
v229=2.334072e+01*s0+(-1.222237e+01)*s1+(-5.177241e+03)*s2+7.583145e+01*s3+2.225390e+00*s4+(-9.297694e+01)*s5+5.712279e+00*s6 \
v230=7.177280e+00*s0+(-5.648174e+00)*s1+(-4.185421e+03)*s2+4.835263e+01*s3+(-1.204423e+01)*s4+6.222513e+01*s5+6.441655e-01*s6 \
v231=(-1.533459e+00)*s0+1.562866e+01*s1+(-6.440121e+01)*s2+(-2.423601e+01)*s3+(-6.692447e-01)*s4+7.982670e+01*s5+(-9.966035e+00)*s6 \
v232=(-2.819627e+01)*s0+(-1.942534e+00)*s1+(-1.657251e+01)*s2+3.237149e+00*s3+2.262904e+01*s4+(-1.646991e+02)*s5+(-1.591275e-01)*s6 \
v233=5.884072e+00*s0+(-5.781786e+00)*s1+(-3.676835e+03)*s2+(-4.559125e+01)*s3+(-4.262776e+00)*s4+1.961865e+01*s5+3.693136e+00*s6 \
v234=2.634424e+00*s0+(-8.923659e+00)*s1+7.398201e+02*s2+3.527735e+01*s3+(-3.707824e+01)*s4+(-1.562697e+01)*s5+(-5.807073e-01)*s6 \
v235=(-6.413791e+00)*s0+(-2.774481e+00)*s1+(-2.705707e+02)*s2+(-2.539300e+01)*s3+9.146633e+01*s4+1.021764e+01*s5+(-1.247166e+01)*s6 \
v236=2.514666e-01*s0+1.401795e+01*s1+(-9.256428e+02)*s2+(-3.845272e+01)*s3+(-2.947403e+01)*s4+1.892519e+01*s5+3.390681e+00*s6 \
v237=5.078817e-01*s0+3.030499e-01*s1+4.642379e-01*s2+9.705099e-01*s3+3.433927e+00*s4+(-7.643403e-01)*s5+1.297069e+00*s6 \
v238=4.922449e-01*s0+7.126389e-01*s1+2.764111e-01*s2+(-2.409255e+00)*s3+(-1.491865e+01)*s4+(-9.164125e+00)*s5+(-1.884792e+00)*s6 \
v239=7.622453e-01*s0+9.083840e-01*s1+6.880594e-01*s2+(-5.374313e-01)*s3+(-2.044881e+00)*s4+4.412457e-01*s5+(-3.947196e+00)*s6 \
v240=2.419920e-01*s0+1.166620e+00*s1+1.697889e+00*s2+3.408469e+00*s3+2.235324e+01*s4+5.146928e+01*s5+4.967121e+00*s6 \
v241=2.161722e+00*s0+8.926493e-01*s1+7.543125e-01*s2+9.268476e+00*s3+6.545454e+00*s4+(-1.716158e+01)*s5+6.361333e+00*s6 \
v242=(-1.241688e+00)*s0+(-1.000066e+00)*s1+(-8.106152e-01)*s2+(-3.014167e+00)*s3+(-5.108967e-01)*s4+5.767952e+00*s5+1.206496e+00*s6 \
v243=7.722792e-02*s0+6.176285e-02*s1+4.673876e-01*s2+5.556051e-01*s3+1.890674e+00*s4+(-4.476495e-01)*s5+(-1.685039e-01)*s6 \
v244=1.200855e+00*s0+9.727223e-01*s1+(-1.844043e-01)*s2+(-1.258834e+00)*s3+(-5.519987e+00)*s4+6.065962e+00*s5+3.839037e-01*s6 \
v245=(-9.093242e-01)*s0+(-6.893818e-01)*s1+(-3.638536e-01)*s2+(-8.978310e-01)*s3+(-8.786293e-01)*s4+(-8.650279e-01)*s5+1.281199e+00*s6 \
v246=(-4.168295e+02)*s0+(-1.000000e+04)*s1+(-1.000000e+04)*s2+(-6.398433e+00)*s3+(-3.835003e+01)*s4+8.425346e+00*s5+(-4.324472e+00)*s6 \
v247=(-8.120464e+02)*s0+(-1.000000e+04)*s1+(-1.000000e+04)*s2+4.721168e+00*s3+1.233823e+02*s4+2.778916e+01*s5+1.329325e+01*s6 \
v248=(-9.995314e+03)*s0+(-1.000000e+04)*s1+(-1.000000e+04)*s2+2.639057e+01*s3+(-1.834057e+01)*s4+(-4.040356e+01)*s5+4.316062e+00*s6 \
v249=1.094845e+02*s0+(-1.000000e+04)*s1+(-1.000000e+04)*s2+2.396681e+00*s3+(-1.113784e+01)*s4+(-2.376193e+01)*s5+(-5.992391e+00)*s6 \
v250=(-1.890914e+03)*s0+(-1.000000e+04)*s1+(-1.000000e+04)*s2+(-1.226947e+01)*s3+3.008360e+01*s4+1.719759e+01*s5+(-4.796224e+00)*s6 \
v251=(-9.922318e+03)*s0+(-1.000000e+04)*s1+(-1.000000e+04)*s2+(-4.885990e+00)*s3+1.208556e+01*s4+2.390528e+01*s5+5.134174e+00*s6 \
v252=4.944467e+03*s0+(-1.086651e+03)*s1+(-1.162416e+03)*s2+(-2.343895e+00)*s3+1.684642e-01*s4+6.942749e+00*s5+1.340342e+01*s6 \
v253=1.035657e+03*s0+(-8.385958e+02)*s1+(-4.419740e+02)*s2+(-2.913092e+00)*s3+(-6.924601e+01)*s4+(-8.937513e+00)*s5+(-1.085742e+01)*s6 \
v254=1.309033e+03*s0+(-3.549444e+02)*s1+(-2.565511e+02)*s2+5.185463e+00*s3+(-1.227700e+01)*s4+3.418813e+00*s5+3.046177e+00*s6 \
v255=4.401308e+03*s0+(-1.000000e+04)*s1+(-9.233842e+03)*s2+1.367619e+02*s3+1.773427e+01*s4+(-2.464358e+01)*s5+1.392891e+02*s6 \
v256=(-2.754040e+03)*s0+(-1.000000e+04)*s1+(-1.000000e+04)*s2+(-1.647728e+02)*s3+1.703311e+01*s4+1.135337e+02*s5+(-1.155622e+02)*s6 \
v257=1.475861e+02*s0+(-1.000000e+04)*s1+(-9.626654e+03)*s2+(-5.741802e+00)*s3+1.061495e+01*s4+4.217009e+01*s5+(-1.579976e+02)*s6 \
v258=(-1.000000e+04)*s0+(-1.000000e+04)*s1+(-1.000000e+04)*s2+1.245067e+02*s3+9.304254e+00*s4+(-4.882442e+01)*s5+4.237254e+01*s6 \
v259=(-1.380797e+03)*s0+(-1.000000e+04)*s1+(-9.629763e+03)*s2+(-6.210572e+01)*s3+1.065306e+00*s4+(-9.889458e+00)*s5+1.442763e+02*s6 \
v260=(-2.148999e+03)*s0+(-1.000000e+04)*s1+(-9.980261e+03)*s2+(-9.824321e+00)*s3+(-1.382329e+01)*s4+(-3.138154e+01)*s5+1.667880e+01*s6 \
v261=9.785970e+02*s0+(-3.101802e+02)*s1+(-2.587082e+02)*s2+(-1.927065e+00)*s3+8.863318e+01*s4+(-3.080831e+00)*s5+(-3.588831e+01)*s6 \
v262=1.000000e+04*s0+(-1.029258e+03)*s1+(-7.870817e+01)*s2+2.198979e+01*s3+(-7.307464e+01)*s4+(-1.672419e+00)*s5+1.493710e+02*s6 \
v263=1.000000e+04*s0+(-1.391163e+03)*s1+8.910104e+02*s2+2.754600e+01*s3+(-1.686657e+01)*s4+1.005061e+01*s5+(-1.106405e+02)*s6 \
_p0=v0+v1*od_+v2*w_+v3*od_*w_ \
_p1=_p0+v4*(s_-0.446)+v5*(s_-0.446)*od_+v6*(s_-0.446)*w_ \
_p2=0.5*(_p1+sqrt(_p1*_p1+0.001)) \
_p3=1e-15*_p2 \
_p4=v7+v8*od_+v9*w_+v10*od_*w_+v11*od_*od_+v12*w_*w_+v13*od_/w_+v14*od_*od_/w_/w_+v15/w_jump_+v16/(w_jump_*w_jump_) \
_p5=_p4+v17*(s_-0.446)+v18*(s_-0.446)*od_+v19*(s_-0.446)*w_ \
_p6=slcrnw_drs*0.5*(_p5+sqrt(_p5*_p5+0.001)) \
_p7=v20/od_+v21/w_+v22+v23*od_+v24*w_+v25*od_*od_+v26*od_*w_+v27*w_*w_+v28*od_*od_*w_+v29*od_*w_*w_+v30*od_*od_*w_*w_ \
_p8=_p7+v31*(s_-0.446)+v32*(s_-0.446)*od_+v33*(s_-0.446)*w_ \
_p9=0.5*(_p8+sqrt(_p8*_p8+0.001)) \
_p10=slcrnw_dls*1e-09*_p9 \
_p11=slcrnw_dls*1e-09*_p9 \
_p12=v34+v35*od_+v36*w_+v37*od_*w_+v38*od_*od_+v39*w_*w_+v40*od_/w_+v41*od_*od_/w_/w_+v42/w_jump_+v43/(w_jump_*w_jump_) \
_p13=_p12+v44*(s_-0.446)+v45*(s_-0.446)*od_+v46*(s_-0.446)*w_ \
_p14=slcrnw_drs*0.5*(_p13+sqrt(_p13*_p13+0.001)) \
_p15=v47/od_+v48/w_+v49+v50*od_+v51*w_+v52*od_*od_+v53*od_*w_+v54*w_*w_+v55*od_*od_*w_+v56*od_*w_*w_+v57*od_*od_*w_*w_ \
_p16=_p15+v58*(s_-0.446)+v59*(s_-0.446)*od_+v60*(s_-0.446)*w_ \
_p17=0.5*(_p16+sqrt(_p16*_p16+0.001)) \
_p18=slcrnw_dls*1e-09*_p17 \
_p19=v61/od_+v62/w_+v63+v64*od_+v65*w_+v66*od_*od_+v67*od_*w_+v68*w_*w_+v69*od_*od_*w_+v70*od_*w_*w_+v71*od_*od_*w_*w_ \
_p20=_p19+v72*(s_-0.446)+v73*(s_-0.446)*od_+v74*(s_-0.446)*w_ \
_p21=0.5*(atan(2*_p20)/1.5708+1) \
_p22=0.7064*_p21 \
_p23=0.7064*_p21 \
_p24=v75+v76*od_+v77*w_+v78*od_*od_+v79*od_*w_+v80*w_*w_ \
_p25=_p24+v81*(s_-0.446)+v82*(s_-0.446)*od_+v83*(s_-0.446)*w_ \
_p26=0.5*(_p25+sqrt(_p25*_p25+0.001)) \
_p27=v84+v85*od_+v86*w_+v87*od_*od_+v88*od_*w_+v89*w_*w_ \
_p28=_p27+v90*(s_-0.446)+v91*(s_-0.446)*od_+v92*(s_-0.446)*w_ \
_p29=0.5*(_p28+sqrt(_p28*_p28+0.001)) \
_p30=v93+v94*od_+v95*w_+v96*od_*od_+v97*od_*w_+v98*w_*w_ \
_p31=_p30+v99*(s_-0.446)+v100*(s_-0.446)*od_+v101*(s_-0.446)*w_ \
_p32=0.5*(_p31+sqrt(_p31*_p31+0.001)) \
_p33=v102+v103*od_+v104*w_+v105*od_*od_+v106*od_*w_+v107*w_*w_ \
_p34=_p33+v108*(s_-0.446)+v109*(s_-0.446)*od_+v110*(s_-0.446)*w_ \
_p35=0.5*(_p34+sqrt(_p34*_p34+0.001)) \
_p36=v111+v112*od_+v113*w_+v114*od_*od_+v115*od_*w_+v116*w_*w_ \
_p37=_p36+v117*(s_-0.446)+v118*(s_-0.446)*od_+v119*(s_-0.446)*w_ \
_p38=0.5*(_p37+sqrt(_p37*_p37+0.001)) \
_p39=v120+v121*od_+v122*w_+v123*od_*od_+v124*od_*w_+v125*w_*w_ \
_p40=_p39+v126*(s_-0.446)+v127*(s_-0.446)*od_+v128*(s_-0.446)*w_ \
_p41=0.5*(_p40+sqrt(_p40*_p40+0.001)) \
_p42=1e-14*_p26 \
_p43=100*_p29 \
_p44=1e-14*_p32 \
_p45=100*_p35 \
_p46=1e-14*_p38 \
_p47=100*_p41 \
_p48=v129+v130*od_+v131*w_+v132*od_*od_+v133*od_*w_+v134*w_*w_ \
_p49=_p48+v135*(s_-0.446)+v136*(s_-0.446)*od_+v137*(s_-0.446)*w_ \
_p50=0.5*(_p49+sqrt(_p49*_p49+0.001)) \
_p51=100*_p50 \
_p52=v138+v139*od_+v140*w_+v141*od_*od_+v142*od_*w_+v143*w_*w_ \
_p53=_p52+v144*(s_-0.446)+v145*(s_-0.446)*od_+v146*(s_-0.446)*w_ \
_p54=0.5*(_p53+sqrt(_p53*_p53+0.001)) \
_p55=100*_p54 \
_p56=v147+v148*od_+v149*w_+v150*od_*od_+v151*od_*w_+v152*w_*w_ \
_p57=_p56+v153*(s_-0.446)+v154*(s_-0.446)*od_+v155*(s_-0.446)*w_ \
_p58=0.5*(_p57+sqrt(_p57*_p57+0.001)) \
_p59=100*_p58 \
_p60=v156+v157*od_+v158*w_+v159*od_*od_+v160*od_*w_+v161*w_*w_ \
_p61=_p60+v162*(s_-0.446)+v163*(s_-0.446)*od_+v164*(s_-0.446)*w_ \
_p62=0.5*(_p61+sqrt(_p61*_p61+0.001)) \
_p63=v165+v166*od_+v167*w_+v168*od_*od_+v169*od_*w_+v170*w_*w_ \
_p64=_p63+v171*(s_-0.446)+v172*(s_-0.446)*od_+v173*(s_-0.446)*w_ \
_p65=0.5*(_p64+sqrt(_p64*_p64+0.001)) \
_p66=v174+v175*od_+v176*w_+v177*od_*od_+v178*od_*w_+v179*w_*w_ \
_p67=_p66+v180*(s_-0.446)+v181*(s_-0.446)*od_+v182*(s_-0.446)*w_ \
_p68=0.5*(_p67+sqrt(_p67*_p67+0.001)) \
_p69=v183+v184*od_+v185*w_+v186*od_*od_+v187*od_*w_+v188*w_*w_ \
_p70=_p69+v189*(s_-0.446)+v190*(s_-0.446)*od_+v191*(s_-0.446)*w_ \
_p71=0.5*(_p70+sqrt(_p70*_p70+0.001)) \
_p72=v192+v193*od_+v194*w_+v195*od_*od_+v196*od_*w_+v197*w_*w_ \
_p73=_p72+v198*(s_-0.446)+v199*(s_-0.446)*od_+v200*(s_-0.446)*w_ \
_p74=0.5*(_p73+sqrt(_p73*_p73+0.001)) \
_p75=v201+v202*od_+v203*w_+v204*od_*od_+v205*od_*w_+v206*w_*w_ \
_p76=_p75+v207*(s_-0.446)+v208*(s_-0.446)*od_+v209*(s_-0.446)*w_ \
_p77=0.5*(_p76+sqrt(_p76*_p76+0.001)) \
_p78=v210+v211*od_+v212*w_+v213*od_*od_+v214*od_*w_+v215*w_*w_ \
_p79=_p78+v216*(s_-0.446)+v217*(s_-0.446)*od_+v218*(s_-0.446)*w_ \
_p80=0.5*(_p79+sqrt(_p79*_p79+0.001)) \
_p81=v219+v220*od_+v221*w_+v222*od_*od_+v223*od_*w_+v224*w_*w_ \
_p82=_p81+v225*(s_-0.446)+v226*(s_-0.446)*od_+v227*(s_-0.446)*w_ \
_p83=0.5*(_p82+sqrt(_p82*_p82+0.001)) \
_p84=v228+v229*od_+v230*w_+v231*od_*od_+v232*od_*w_+v233*w_*w_ \
_p85=_p84+v234*(s_-0.446)+v235*(s_-0.446)*od_+v236*(s_-0.446)*w_ \
_p86=0.5*(_p85+sqrt(_p85*_p85+0.001)) \
_p87=v237+v238*od_+v239*w_+v240*od_*od_+v241*od_*w_+v242*w_*w_ \
_p88=_p87+v243*(s_-0.446)+v244*(s_-0.446)*od_+v245*(s_-0.446)*w_ \
_p89=0.5*(_p88+sqrt(_p88*_p88+0.001)) \
_p90=v246+v247*od_+v248*w_+v249*od_*od_+v250*od_*w_+v251*w_*w_ \
_p91=_p90+v252*(s_-0.446)+v253*(s_-0.446)*od_+v254*(s_-0.446)*w_ \
_p92=0.5*(_p91+sqrt(_p91*_p91+0.001)) \
_p93=v255+v256*od_+v257*w_+v258*od_*od_+v259*od_*w_+v260*w_*w_ \
_p94=_p93+v261*(s_-0.446)+v262*(s_-0.446)*od_+v263*(s_-0.446)*w_ \
_p95=0.5*(_p94+sqrt(_p94*_p94+0.001)) \
_p96=1e-14*_p62 \
_p97=slcrnw_drs_sub*100*_p65 \
_p98=1e-15*_p68 \
_p99=1e-14*_p71 \
_p100=slcrnw_drs_sub*100*_p74 \
_p101=1e-15*_p77 \
_p102=1e-14*_p80 \
_p103=slcrnw_drs_sub*100*_p83 \
_p104=1e-15*_p86 \
_p105=1e-14*_p89 \
_p106=100*_p92 \
_p107=1e-15*_p95
cs (outer inner) capacitor c=_p3
rs1_1 (outer n1_1) resistor r=_p6
ls1_1 (n1_1 ni_1) inductor l=_p10
rs2_1 (ni_1 n2_1) resistor r=_p6
ls2_1 (n2_1 inner) inductor l=_p11
rs1_2 (outer n1_2) resistor r=_p14
ls1_2 (n1_2 inner) inductor l=_p18
k1 mutual_inductor coupling=_p22 ind1=ls1_1 ind2=ls1_2
k2 mutual_inductor coupling=_p23 ind1=ls2_1 ind2=ls1_2
c_1_wsub (outer _n1_1_wsub) capacitor c=_p42
rs_1_wsub (_n1_1_wsub nwell) resistor r=_p43
c_2_wsub (inner _n1_2_wsub) capacitor c=_p44
rs_2_wsub (_n1_2_wsub nwell) resistor r=_p45
c_3_wsub (ni_1 _n1_3_wsub) capacitor c=_p46
rs_3_wsub (_n1_3_wsub nwell) resistor r=_p47
rx_1_2_wsub (_n1_1_wsub _n1_2_wsub) resistor r=_p51
rx_1_3_wsub (_n1_1_wsub _n1_3_wsub) resistor r=_p55
rx_2_3_wsub (_n1_2_wsub _n1_3_wsub) resistor r=_p59
c_1_sub (_n1_1_wsub _n1_1_sub) capacitor c=_p96
rs_1_sub (_n1_1_sub sub) resistor r=_p97
cs_1_sub (_n1_1_sub sub) capacitor c=_p98
c_2_sub (_n1_2_wsub _n1_2_sub) capacitor c=_p99
rs_2_sub (_n1_2_sub sub) resistor r=_p100
cs_2_sub (_n1_2_sub sub) capacitor c=_p101
c_3_sub (_n1_3_wsub _n1_3_sub) capacitor c=_p102
rs_3_sub (_n1_3_sub sub) resistor r=_p103
cs_3_sub (_n1_3_sub sub) capacitor c=_p104
c_4_sub (nwell _n1_4_sub) capacitor c=_p105
rs_4_sub (_n1_4_sub sub) resistor r=_p106
cs_4_sub (_n1_4_sub sub) capacitor c=_p107
ends lnw_cr40k_rfvil
