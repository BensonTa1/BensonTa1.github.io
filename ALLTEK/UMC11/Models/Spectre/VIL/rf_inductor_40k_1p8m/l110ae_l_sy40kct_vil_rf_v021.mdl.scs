simulator lang=spectre insensitive=yes
// Model: l_sy40kct_rfvil
// Planar symmetric center-tapped RF inductor, P sub, 4.0um metal8
// UMC 110nm 1P8M1T1F RFCMOS process
// Date: 2009-12-28
// Model coverage:(before shrinkage)
// od: (75 - 299) * 1e-06
// w: (2.23 - 9.7) * 1e-06
// s: (2.23 - 5) * 1e-06
// nt: 2 - 7
// Frequency range: 100MHz - 0.8 * resonance (maximum 20.0 GHz)
subckt l_sy40kct_rfvil (p1 p2 ct sub)
parameters od=0.00015 od_=od/0.0003 w=6e-06 w_=w/9.97e-06 w_jump_=max(floor((w_-0.0401204)/0.0702106), 1) s=2.52e-06 s_=s/5e-06 nt=3  \
s0=(nt==1) \
s1=(nt==2) \
s2=(nt==3) \
s3=(nt==4) \
s4=(nt==5) \
s5=(nt==6) \
s6=(nt==7) \
v0=(-3.811642e-03)*s0+(-4.996264e-03)*s1+3.209289e-01*s2+6.462304e-02*s3+4.607933e-01*s4+9.994520e-02*s5+1.089071e-01*s6 \
v1=3.653405e-04*s0+(-1.454360e-01)*s1+1.378457e-02*s2+2.335852e-01*s3+(-1.868098e-01)*s4+2.784801e-01*s5+9.888923e-03*s6 \
v2=(-1.927388e-02)*s0+1.491587e+00*s1+(-2.839048e-01)*s2+(-6.940912e-01)*s3+(-4.400697e-01)*s4+(-3.182109e+00)*s5+(-1.117937e+00)*s6 \
v3=3.913204e-01*s0+3.446337e-01*s1+(-2.318417e+00)*s2+(-1.007483e+01)*s3+(-4.628653e-01)*s4+7.180605e+00*s5+3.195906e+00*s6 \
v4=4.492233e-02*s0+(-3.333995e+00)*s1+(-3.637962e+00)*s2+(-1.200310e+00)*s3+(-7.996126e+00)*s4+3.105255e+00*s5+(-3.245464e-01)*s6 \
v5=4.824447e-02*s0+8.717225e-01*s1+9.314168e+00*s2+1.157321e+01*s3+5.405169e+00*s4+2.856823e+00*s5+5.338408e+00*s6 \
v6=(-4.292777e-01)*s0+6.988559e-01*s1+9.452358e+00*s2+3.702834e+01*s3+2.085437e+01*s4+(-7.006246e+00)*s5+1.675739e+00*s6 \
v7=(-4.176209e-02)*s0+2.248388e+00*s1+(-1.971027e+00)*s2+(-4.797428e+00)*s3+1.876877e+00*s4+(-1.543173e+00)*s5+(-2.189477e+00)*s6 \
v8=2.950604e-01*s0+(-1.866824e-01)*s1+(-1.213942e-01)*s2+1.829451e-01*s3+1.503739e+01*s4+(-4.825877e+00)*s5+(-7.987461e+00)*s6 \
v9=2.565997e-01*s0+(-2.839341e-01)*s1+1.200462e+01*s2+(-9.423687e+00)*s3+2.505104e+00*s4+1.656484e+00*s5+1.862098e+00*s6 \
v10=(-2.728103e-01)*s0+6.461977e-02*s1+(-1.595174e+01)*s2+(-1.168995e+00)*s3+(-2.423962e+01)*s4+4.709561e+00*s5+4.273871e+00*s6 \
v11=4.570841e-03*s0+(-2.112005e-01)*s1+(-1.670478e-01)*s2+8.089111e-01*s3+(-1.238394e+00)*s4+(-9.973188e-01)*s5+(-5.937192e-01)*s6 \
v12=(-2.277769e-02)*s0+(-9.453158e-02)*s1+4.292486e-01*s2+(-3.155652e+00)*s3+2.017171e+00*s4+(-1.040901e+00)*s5+(-1.604819e+00)*s6 \
v13=(-9.486457e-03)*s0+2.642442e-01*s1+(-2.884848e-01)*s2+(-8.430122e-01)*s3+4.361933e-01*s4+1.705137e+00*s5+1.174353e+00*s6 \
v14=(-1.591507e-02)*s0+2.190325e+00*s1+6.559686e+00*s2+7.744172e+01*s3+4.665066e+01*s4+5.107520e+00*s5+2.210109e+02*s6 \
v15=(-4.942668e-02)*s0+2.519994e+00*s1+6.184101e-01*s2+(-1.475344e+02)*s3+(-3.663921e+02)*s4+(-6.464058e+01)*s5+7.486173e-01*s6 \
v16=3.950811e-03*s0+(-4.120189e+00)*s1+(-8.840855e+00)*s2+(-4.840607e+01)*s3+2.384809e+02*s4+(-3.359426e+01)*s5+(-2.992064e+02)*s6 \
v17=3.164763e-02*s0+(-1.127266e+00)*s1+(-1.292480e+00)*s2+8.526153e+01*s3+4.519540e+00*s4+3.239669e+01*s5+2.044158e+01*s6 \
v18=(-1.010103e-02)*s0+(-1.069570e-01)*s1+1.471641e-01*s2+2.063530e+01*s3+8.259384e+01*s4+1.432728e+01*s5+(-1.030053e+01)*s6 \
v19=(-7.444357e-03)*s0+2.252354e+00*s1+4.555613e+00*s2+(-2.807048e+00)*s3+(-3.740493e+01)*s4+1.938606e+01*s5+1.197506e+02*s6 \
v20=4.104558e-01*s0+(-5.586638e-01)*s1+1.863589e+00*s2+5.421399e+01*s3+5.971604e+01*s4+1.312299e+01*s5+3.159291e+00*s6 \
v21=(-2.711517e-03)*s0+1.355811e-01*s1+(-8.863527e-02)*s2+(-4.495905e+00)*s3+1.021671e+02*s4+(-1.896365e+00)*s5+7.913111e-02*s6 \
v22=(-5.844781e-02)*s0+(-6.570774e+00)*s1+(-3.494366e+01)*s2+(-3.203387e+02)*s3+(-6.436936e+02)*s4+2.602819e+02*s5+(-6.954860e+02)*s6 \
v23=1.472081e-01*s0+5.534778e+01*s1+1.573837e+02*s2+3.706884e+02*s3+7.555683e+02*s4+(-1.547346e+02)*s5+9.048415e+02*s6 \
v24=(-1.776515e-02)*s0+(-2.654892e-01)*s1+6.173209e-01*s2+1.252788e+00*s3+(-8.925700e+01)*s4+(-2.423180e+00)*s5+9.918394e+00*s6 \
v25=8.311772e-05*s0+7.552982e-02*s1+(-4.736636e-01)*s2+1.148510e+01*s3+(-3.465599e+02)*s4+(-1.970356e+00)*s5+(-8.793401e+00)*s6 \
v26=8.148783e-03*s0+2.529591e-01*s1+(-4.459755e-01)*s2+(-5.659036e+00)*s3+4.839561e+02*s4+4.005681e+00*s5+8.236172e-01*s6 \
v27=4.122634e-02*s0+4.257541e-01*s1+(-5.130172e-01)*s2+(-8.931532e-02)*s3+(-6.722251e-02)*s4+(-1.000000e+04)*s5+(-8.776671e+00)*s6 \
v28=3.712749e-01*s0+9.607386e-01*s1+1.149137e+00*s2+(-2.245314e-02)*s3+(-3.554898e-01)*s4+(-1.000000e+04)*s5+(-3.020305e+02)*s6 \
v29=(-1.221188e-02)*s0+(-2.443682e-02)*s1+1.244881e+00*s2+3.695340e-01*s3+5.697429e-01*s4+(-1.000000e+04)*s5+(-1.341462e+00)*s6 \
v30=5.085669e-02*s0+(-3.939602e+00)*s1+(-3.169925e+00)*s2+(-5.602761e-01)*s3+3.686999e-01*s4+(-1.000000e+04)*s5+(-1.218643e+00)*s6 \
v31=1.905548e-01*s0+(-2.760546e-01)*s1+(-1.778667e+00)*s2+8.564995e-01*s3+2.324471e+00*s4+(-1.000000e+04)*s5+(-1.000000e+04)*s6 \
v32=(-8.771551e-01)*s0+4.491518e-01*s1+3.052037e+00*s2+(-2.134921e-01)*s3+5.458542e+00*s4+9.882429e+03*s5+(-1.000000e+04)*s6 \
v33=(-5.917958e-02)*s0+9.761805e-02*s1+3.645173e-01*s2+(-2.572010e+00)*s3+(-1.425600e+01)*s4+(-1.000000e+04)*s5+(-1.000000e+04)*s6 \
v34=4.711994e-02*s0+6.117063e-02*s1+(-3.315888e-01)*s2+5.598756e-02*s3+(-5.505042e-02)*s4+2.057237e-01*s5+1.257591e-02*s6 \
v35=3.785915e-01*s0+(-9.948491e-01)*s1+9.364067e-01*s2+4.628170e-01*s3+3.242145e+00*s4+1.287097e+00*s5+1.179956e+00*s6 \
v36=(-1.885491e-02)*s0+1.096315e-01*s1+5.365233e-01*s2+(-1.511591e-01)*s3+2.920497e-01*s4+(-2.919986e-01)*s5+3.913111e-02*s6 \
v37=(-4.060263e-01)*s0+9.903725e-01*s1+(-1.304646e+00)*s2+(-3.783460e-02)*s3+(-1.789552e+00)*s4+(-5.606323e-01)*s5+(-8.574467e-01)*s6 \
v38=(-1.855389e-02)*s0+3.432427e-01*s1+7.725292e-01*s2+(-1.732543e-01)*s3+(-1.417347e+00)*s4+(-5.001013e-01)*s5+(-2.503326e-01)*s6 \
v39=(-2.642216e-01)*s0+(-4.097695e-03)*s1+1.363881e+00*s2+7.800306e-02*s3+2.450283e+00*s4+3.746810e-01*s5+(-4.602841e-02)*s6 \
v40=9.955363e-01*s0+1.576391e-01*s1+(-1.171140e+00)*s2+1.418180e-01*s3+(-2.266097e+00)*s4+4.102649e-02*s5+1.700956e-01*s6 \
v41=1.052306e-01*s0+1.065225e-01*s1+(-2.612315e-01)*s2+(-7.315027e-02)*s3+2.088417e-01*s4+(-4.744898e-01)*s5+3.620095e-02*s6 \
v42=9.314566e-03*s0+5.170305e-02*s1+(-3.409438e-02)*s2+4.178003e-01*s3+1.030933e-01*s4+(-5.731748e-02)*s5+(-3.944247e+00)*s6 \
v43=8.356864e-04*s0+1.724558e-02*s1+2.425799e-02*s2+2.677864e+00*s3+(-1.401563e-03)*s4+2.419570e-01*s5+6.752679e+00*s6 \
v44=(-8.076585e-02)*s0+(-6.853094e-01)*s1+(-4.225717e-01)*s2+(-1.370854e+01)*s3+(-4.955553e-01)*s4+(-2.860135e+00)*s5+(-2.422539e+00)*s6 \
v45=4.542812e-01*s0+2.146732e+00*s1+2.649322e+00*s2+(-4.745040e+00)*s3+6.755969e+00*s4+(-1.315876e+00)*s5+9.590942e+00*s6 \
v46=(-1.557414e-02)*s0+2.711125e-01*s1+1.288986e+00*s2+1.143018e+01*s3+(-3.306208e+00)*s4+7.440008e+00*s5+2.764934e-01*s6 \
v47=2.412385e-02*s0+(-1.186172e-01)*s1+(-4.348043e-02)*s2+2.142520e+00*s3+(-1.009389e+00)*s4+6.558526e+00*s5+1.084540e+01*s6 \
v48=(-5.405650e-02)*s0+(-7.638720e-01)*s1+(-5.026768e+00)*s2+6.755465e+00*s3+9.121254e-01*s4+2.369661e+01*s5+(-6.153164e+00)*s6 \
v49=(-4.700211e-03)*s0+1.362994e-01*s1+(-7.109531e-01)*s2+(-4.436959e+00)*s3+1.415197e+00*s4+(-7.899860e+00)*s5+1.626973e+00*s6 \
v50=(-1.911527e-01)*s0+(-7.166798e-01)*s1+1.728608e+00*s2+3.916614e+00*s3+8.512438e-01*s4+1.526473e+01*s5+(-8.178722e+00)*s6 \
v51=(-2.273497e-02)*s0+(-3.829199e-01)*s1+1.637836e+00*s2+7.256158e+01*s3+(-1.498623e+00)*s4+(-1.175197e+01)*s5+(-1.800078e+00)*s6 \
v52=2.016621e-01*s0+1.152735e+00*s1+6.826571e-01*s2+(-1.819033e+00)*s3+(-1.210149e+00)*s4+(-2.250455e+01)*s5+(-1.212435e-01)*s6 \
v53=(-1.041393e-02)*s0+1.671950e-02*s1+(-1.153139e-01)*s2+(-1.684478e+00)*s3+(-2.195131e-01)*s4+(-2.165053e-01)*s5+(-1.256013e+01)*s6 \
v54=1.943970e-02*s0+(-1.082931e-01)*s1+(-3.013615e-01)*s2+4.239889e-02*s3+(-1.236054e+00)*s4+(-3.755881e+00)*s5+(-7.767275e+00)*s6 \
v55=1.892930e-02*s0+(-1.316246e-02)*s1+2.119570e-01*s2+3.668207e+00*s3+2.124669e-01*s4+(-1.417196e+00)*s5+1.561956e+01*s6 \
v56=6.548397e-01*s0+2.684466e+01*s1+1.058743e+01*s2+2.983417e+00*s3+5.140361e+00*s4+9.425892e+01*s5+2.211748e+01*s6 \
v57=6.137647e-01*s0+(-2.375521e+00)*s1+(-1.590119e+01)*s2+(-3.768748e-01)*s3+(-3.477351e+00)*s4+(-1.683459e+02)*s5+9.469620e+00*s6 \
v58=(-1.106005e+00)*s0+(-2.963449e+01)*s1+(-9.637157e+00)*s2+(-2.522616e+00)*s3+(-7.106492e+00)*s4+(-8.254049e+01)*s5+1.133581e+01*s6 \
v59=1.245644e+00*s0+1.583439e+00*s1+1.128480e+01*s2+9.112040e-01*s3+(-8.503625e-01)*s4+1.298876e+02*s5+1.519661e+01*s6 \
v60=(-3.797484e-01)*s0+(-3.479254e+00)*s1+3.964511e-01*s2+(-1.101159e+00)*s3+2.371548e+00*s4+2.839821e+01*s5+(-6.327766e+00)*s6 \
v61=2.928670e-01*s0+1.026026e+01*s1+2.006271e+00*s2+8.702618e-01*s3+4.226615e+00*s4+6.622257e+00*s5+(-2.468410e+01)*s6 \
v62=1.726823e+00*s0+1.013197e+01*s1+9.225150e+00*s2+2.709688e+00*s3+2.970170e+00*s4+3.872968e+01*s5+(-1.987064e+01)*s6 \
v63=1.116192e-01*s0+(-1.046634e+00)*s1+(-7.050763e-01)*s2+7.217482e-03*s3+(-4.086541e-01)*s4+(-1.237776e+00)*s5+7.092996e+00*s6 \
v64=3.250288e+00*s0+(-1.216635e+02)*s1+(-4.524342e+01)*s2+(-3.290355e+01)*s3+(-1.916242e+01)*s4+(-3.279304e+02)*s5+(-1.976842e+02)*s6 \
v65=(-6.191701e+00)*s0+1.684773e+02*s1+1.144681e+02*s2+1.863334e+02*s3+1.271353e+02*s4+4.645345e+02*s5+9.000572e+02*s6 \
v66=(-9.813380e-02)*s0+5.681362e-01*s1+(-3.591712e+00)*s2+(-5.752721e-01)*s3+(-7.507650e-02)*s4+2.479460e+00*s5+5.896408e+00*s6 \
v67=4.617350e-02*s0+2.383437e-01*s1+2.445139e+00*s2+(-1.230401e+00)*s3+(-3.079169e-01)*s4+1.646869e+00*s5+(-3.367159e+00)*s6 \
v68=5.943799e-01*s0+(-1.059759e+00)*s1+2.794855e+00*s2+1.303198e+00*s3+1.443912e-01*s4+(-3.213319e+00)*s5+(-5.156989e+00)*s6 \
v69=(-1.075146e-01)*s0+(-1.000000e+04)*s1+(-1.269580e+00)*s2+(-7.954662e-02)*s3+(-1.096017e-01)*s4+(-1.000000e+04)*s5+5.102827e-02*s6 \
v70=1.842262e-01*s0+(-1.000000e+04)*s1+1.415342e+00*s2+7.706710e-01*s3+1.408082e-01*s4+(-1.000000e+04)*s5+(-4.610541e-01)*s6 \
v71=1.309485e-01*s0+(-1.000000e+04)*s1+1.776181e+00*s2+3.318991e-01*s3+2.596054e+00*s4+(-1.000000e+04)*s5+5.039118e-02*s6 \
v72=(-2.294684e-01)*s0+(-1.000000e+04)*s1+(-2.432715e+00)*s2+(-6.211409e-01)*s3+(-7.392962e+00)*s4+(-1.000000e+04)*s5+2.860737e+00*s6 \
v73=(-5.486748e-02)*s0+(-1.000000e+04)*s1+7.847788e-01*s2+2.183239e-01*s3+(-1.922415e+00)*s4+(-9.999605e+03)*s5+1.961001e+00*s6 \
v74=1.000584e-01*s0+(-1.000000e+04)*s1+(-5.729384e-01)*s2+(-3.055290e-01)*s3+3.741109e+00*s4+(-1.000000e+04)*s5+2.329447e+00*s6 \
v75=6.031923e-03*s0+(-1.000000e+04)*s1+(-5.009762e-01)*s2+8.240268e-03*s3+1.753400e+00*s4+(-1.000000e+04)*s5+(-5.963308e+00)*s6 \
v76=(-8.771277e-02)*s0+(-4.550703e-02)*s1+8.707230e-02*s2+1.779591e+00*s3+2.325626e-01*s4+6.410112e-01*s5+(-1.678003e+01)*s6 \
v77=4.121142e-01*s0+2.176551e-01*s1+3.837871e-01*s2+7.938187e+00*s3+1.336360e-01*s4+1.101442e+00*s5+(-1.271669e+02)*s6 \
v78=(-2.376566e-02)*s0+2.570655e-02*s1+(-5.310323e-01)*s2+(-3.453922e+00)*s3+(-2.838567e-01)*s4+(-2.261364e+00)*s5+8.418574e+00*s6 \
v79=(-6.227167e-02)*s0+(-1.217802e-01)*s1+9.000460e-02*s2+(-1.267709e+01)*s3+1.731542e-01*s4+3.636994e+00*s5+(-8.449757e+00)*s6 \
v80=(-6.093553e-02)*s0+(-2.083866e-02)*s1+(-5.337676e-02)*s2+(-1.375904e+00)*s3+(-9.535084e-02)*s4+(-5.635082e-01)*s5+(-1.863849e+01)*s6 \
v81=5.515136e-02*s0+1.152158e-02*s1+6.094782e-02*s2+6.280944e-01*s3+2.166273e-02*s4+3.331066e-01*s5+(-1.000000e+04)*s6 \
v82=(-1.095763e-01)*s0+6.545048e-02*s1+(-1.430114e-02)*s2+1.821303e+00*s3+3.378654e-01*s4+1.604255e+00*s5+(-1.000000e+04)*s6 \
v83=(-9.532162e-04)*s0+(-2.365205e-02)*s1+(-1.418580e-02)*s2+(-5.085829e+00)*s3+(-2.570684e-01)*s4+(-2.212672e+00)*s5+(-1.000000e+04)*s6 \
v84=(-8.036350e-01)*s0+(-4.389166e-01)*s1+7.951747e+00*s2+1.358813e-01*s3+(-3.268364e-01)*s4+4.261221e+01*s5+(-9.944969e-01)*s6 \
v85=2.010967e+00*s0+9.659894e-01*s1+(-4.413473e-01)*s2+5.427853e-01*s3+5.106547e-01*s4+2.023329e+01*s5+9.320658e+00*s6 \
v86=1.032620e+00*s0+1.125316e+00*s1+(-8.718470e+00)*s2+1.984897e+00*s3+1.067703e+00*s4+(-2.011425e+02)*s5+(-3.726871e+00)*s6 \
v87=(-6.038419e-01)*s0+4.179918e+00*s1+2.941458e+00*s2+(-3.893912e+00)*s3+(-2.837957e-01)*s4+(-9.292144e+02)*s5+3.677893e+00*s6 \
v88=4.674963e+00*s0+(-3.223354e-01)*s1+(-1.310644e+01)*s2+(-7.975293e+00)*s3+1.402703e+00*s4+2.798546e+01*s5+(-3.563330e+00)*s6 \
v89=3.300406e+01*s0+1.630153e+00*s1+3.898722e+00*s2+9.972115e-01*s3+9.577439e-01*s4+2.436042e+03*s5+(-1.217497e+00)*s6 \
v90=2.085463e+00*s0+(-4.275503e+00)*s1+2.720237e+01*s2+1.101449e+01*s3+(-6.280292e+00)*s4+(-1.268791e+02)*s5+(-1.331112e+01)*s6 \
v91=(-2.035426e+01)*s0+(-8.129828e-01)*s1+(-2.238416e+00)*s2+(-1.764006e+00)*s3+(-1.494075e+00)*s4+2.896495e+02*s5+3.141144e+00*s6 \
v92=(-1.935735e+00)*s0+(-6.158529e+00)*s1+(-2.146889e+01)*s2+(-3.257238e+00)*s3+1.285496e+00*s4+(-1.879002e+01)*s5+9.823113e-01*s6 \
v93=7.582915e+01*s0+1.823319e+00*s1+(-2.122641e+00)*s2+(-8.030323e-01)*s3+5.467788e+00*s4+9.672809e+02*s5+(-1.147558e+00)*s6 \
v94=3.788240e+01*s0+3.433517e+00*s1+6.940148e+00*s2+(-9.515309e-01)*s3+(-5.579704e-01)*s4+(-1.175117e+01)*s5+1.361130e+01*s6 \
v95=1.197141e+01*s0+(-4.128526e-01)*s1+(-1.584714e+00)*s2+3.969292e-02*s3+(-1.089433e+00)*s4+5.230795e+02*s5+(-8.515334e+00)*s6 \
v96=(-3.204107e+01)*s0+4.259768e-01*s1+1.322368e+00*s2+2.967590e-01*s3+(-2.060290e-01)*s4+(-1.523746e+03)*s5+4.755348e+01*s6 \
v97=(-8.682882e+00)*s0+3.001083e-02*s1+1.238571e-01*s2+(-1.458187e+00)*s3+1.570269e+00*s4+1.790612e+01*s5+(-3.191230e+01)*s6 \
v98=9.731482e-01*s0+1.010696e-01*s1+1.065078e-01*s2+2.715325e+02*s3+8.808431e+01*s4+1.000000e+04*s5+1.721967e+01*s6 \
v99=8.835862e-01*s0+8.723778e+02*s1+6.076144e-01*s2+1.280369e+03*s3+4.399096e+02*s4+1.000000e+04*s5+1.182006e+02*s6 \
v100=(-4.239747e+00)*s0+8.080029e+02*s1+(-6.178006e+00)*s2+6.931911e+00*s3+8.075206e+02*s4+1.000000e+04*s5+2.612263e+01*s6 \
v101=3.583940e-01*s0+(-1.000000e+04)*s1+1.819979e+01*s2+1.922695e+02*s3+4.038602e+02*s4+1.000000e+04*s5+2.511714e+02*s6 \
v102=(-5.480573e+00)*s0+(-2.570441e+03)*s1+1.064304e+01*s2+2.616275e+01*s3+7.352484e+02*s4+1.000000e+04*s5+(-6.721076e+00)*s6 \
v103=(-9.448675e+00)*s0+4.592180e+03*s1+3.642395e+00*s2+2.460752e+02*s3+7.272842e+03*s4+1.000000e+04*s5+2.353414e+01*s6 \
v104=(-7.385890e-01)*s0+(-1.478824e+02)*s1+(-5.212952e+01)*s2+2.254607e+01*s3+2.409356e+01*s4+1.000000e+04*s5+(-3.207729e+01)*s6 \
v105=5.344899e+00*s0+1.115568e+02*s1+(-6.175144e+00)*s2+3.183199e+00*s3+4.311527e+02*s4+1.000000e+04*s5+(-3.266804e+01)*s6 \
v106=6.789242e+01*s0+1.000000e+04*s1+1.528298e+01*s2+6.790037e+02*s3+9.254006e+03*s4+1.000000e+04*s5+(-1.525791e+02)*s6 \
v107=7.036025e+00*s0+1.000000e+04*s1+4.067298e+01*s2+1.746463e+01*s3+4.336141e+02*s4+(-1.000000e+04)*s5+(-1.944257e+01)*s6 \
v108=(-5.900742e+01)*s0+1.000000e+04*s1+(-2.141688e+01)*s2+3.724384e+00*s3+4.650201e+03*s4+(-1.000000e+04)*s5+(-1.810997e+02)*s6 \
v109=(-7.842649e-02)*s0+3.131034e+03*s1+1.351466e+00*s2+1.000000e+04*s3+8.111938e+03*s4+1.000000e+04*s5+9.035006e+03*s6 \
v110=4.503088e-01*s0+(-4.764488e+03)*s1+(-3.604146e-01)*s2+1.000000e+04*s3+6.289782e+03*s4+9.998270e+03*s5+9.720375e+02*s6 \
v111=7.335433e-01*s0+(-2.949104e+03)*s1+(-2.092654e+00)*s2+1.000000e+04*s3+6.136571e+03*s4+9.998765e+03*s5+(-1.000000e+04)*s6 \
v112=3.121447e-03*s0+2.148007e-02*s1+2.299195e-02*s2+(-4.763585e-01)*s3+6.530246e-01*s4+(-2.677923e+00)*s5+(-1.266744e+00)*s6 \
v113=(-1.662738e-03)*s0+5.126919e-01*s1+2.231259e-01*s2+1.163865e+00*s3+1.138797e+00*s4+8.857556e+00*s5+2.660791e+00*s6 \
v114=(-3.514149e-02)*s0+(-1.627459e+00)*s1+(-6.310485e-01)*s2+(-1.169387e+00)*s3+(-5.716420e+00)*s4+(-4.310082e+00)*s5+(-2.006859e+00)*s6 \
v115=1.329048e-01*s0+(-2.613065e+00)*s1+2.635829e-01*s2+(-3.482841e+00)*s3+(-2.148801e+00)*s4+2.471518e+00*s5+(-1.144920e+01)*s6 \
v116=7.017246e-02*s0+9.383548e-01*s1+4.092456e-01*s2+2.600115e+00*s3+(-2.698689e+00)*s4+(-1.408961e+01)*s5+3.859063e+00*s6 \
v117=(-1.943848e-03)*s0+2.402640e+00*s1+(-1.759651e-01)*s2+(-1.103002e-01)*s3+9.496350e+00*s4+5.939099e-01*s5+5.122189e+00*s6 \
v118=5.820338e-03*s0+9.253318e+00*s1+3.299206e-01*s2+3.252638e+00*s3+6.841890e+00*s4+(-1.702416e+00)*s5+2.765273e+00*s6 \
v119=(-7.481094e-02)*s0+1.230364e-01*s1+(-5.564547e-02)*s2+1.945567e-01*s3+1.037496e+01*s4+(-1.646946e+02)*s5+2.607841e+00*s6 \
v120=(-9.571678e-02)*s0+(-7.392462e+00)*s1+7.386396e-01*s2+3.956981e+00*s3+(-3.834712e+00)*s4+2.764289e+00*s5+4.953033e-01*s6 \
v121=3.341913e-02*s0+(-6.525690e+00)*s1+(-4.606539e-01)*s2+(-3.882887e+00)*s3+(-3.652287e-01)*s4+1.154460e+00*s5+7.105513e-01*s6 \
v122=7.893949e-02*s0+5.142593e+00*s1+(-3.584527e-01)*s2+(-1.633042e+00)*s3+(-7.733798e+00)*s4+2.539385e+00*s5+1.295828e-02*s6 \
v123=(-9.551876e-03)*s0+(-3.394228e-02)*s1+(-1.323441e-02)*s2+(-4.882333e-01)*s3+(-1.828507e+00)*s4+(-4.643775e+01)*s5+9.477008e-01*s6 \
v124=6.247183e-03*s0+(-1.504484e-02)*s1+(-2.405865e-01)*s2+3.161224e-01*s3+(-1.194522e+00)*s4+(-9.019226e+01)*s5+2.634672e-01*s6 \
v125=2.468928e-02*s0+1.067831e-02*s1+7.242794e-02*s2+3.580623e-02*s3+6.397910e+00*s4+2.472454e+02*s5+(-2.632782e+00)*s6 \
v126=(-1.000000e+04)*s0+7.851573e+00*s1+8.529105e+00*s2+9.892492e+00*s3+1.197082e+00*s4+(-6.639884e-01)*s5+9.464900e+00*s6 \
v127=(-1.000000e+04)*s0+3.954474e+00*s1+3.258897e+01*s2+5.487293e+01*s3+8.521367e+01*s4+9.178116e+01*s5+1.041853e+02*s6 \
v128=(-1.000000e+04)*s0+(-2.251914e+01)*s1+(-2.224861e+01)*s2+(-2.761605e+01)*s3+(-1.102967e+01)*s4+(-3.634277e+01)*s5+(-3.067474e+01)*s6 \
v129=(-1.000000e+04)*s0+2.249679e+01*s1+1.154438e+01*s2+2.784605e+01*s3+7.878539e+00*s4+1.735244e+01*s5+(-1.053706e+00)*s6 \
v130=(-1.000000e+04)*s0+(-1.059444e-01)*s1+(-1.315574e+01)*s2+1.256337e+01*s3+(-3.628647e+01)*s4+1.286790e+02*s5+(-9.055247e+00)*s6 \
v131=(-1.000000e+04)*s0+(-2.666913e+01)*s1+(-7.968575e+01)*s2+(-6.271233e+01)*s3+(-6.474146e+01)*s4+(-6.429585e+01)*s5+(-1.639199e+02)*s6 \
v132=(-1.000000e+04)*s0+(-6.526305e-01)*s1+3.128301e+01*s2+1.779717e+01*s3+(-2.381462e+01)*s4+(-3.412423e+02)*s5+9.877767e+01*s6 \
v133=2.688638e-02*s0+(-9.013247e-01)*s1+(-1.447722e+00)*s2+(-4.243818e-02)*s3+2.182896e+00*s4+(-2.417964e-01)*s5+(-2.930551e+00)*s6 \
v134=1.496638e+00*s0+4.551727e+00*s1+5.206167e+00*s2+5.080424e+00*s3+2.593436e+00*s4+1.060727e+01*s5+2.218216e+01*s6 \
v135=1.759167e+00*s0+2.520571e+00*s1+3.017583e+00*s2+(-8.923180e-01)*s3+(-8.289604e+00)*s4+1.447734e+00*s5+(-1.327541e+01)*s6 \
v136=(-5.914563e-01)*s0+(-6.171908e-01)*s1+7.718436e-01*s2+4.041948e+00*s3+1.409762e+01*s4+1.449889e+01*s5+2.768444e+01*s6 \
v137=2.655068e-02*s0+(-7.252583e-01)*s1+(-6.055266e-01)*s2+(-6.121309e+00)*s3+1.158397e+00*s4+(-3.902606e+01)*s5+(-9.205029e+00)*s6 \
v138=1.238362e-02*s0+9.354732e-01*s1+7.150745e+00*s2+3.327999e+00*s3+(-2.141611e+00)*s4+(-1.661702e+01)*s5+(-9.528326e+00)*s6 \
v139=(-1.384671e-01)*s0+(-8.018977e-01)*s1+(-3.463977e+00)*s2+(-3.236383e+00)*s3+8.616960e+00*s4+1.111368e+02*s5+2.963826e+01*s6 \
v140=4.689365e+00*s0+2.773002e+00*s1+3.026984e+00*s2+8.675506e+00*s3+1.303391e+00*s4+1.568375e+01*s5+4.097545e+00*s6 \
v141=(-2.992900e+00)*s0+(-1.284024e+00)*s1+(-1.552983e+00)*s2+(-7.223386e+00)*s3+1.094224e+00*s4+(-1.580550e+01)*s5+(-5.712674e+00)*s6 \
v142=(-3.976162e-01)*s0+3.090763e-01*s1+4.547866e+00*s2+(-7.644242e+00)*s3+1.040287e+00*s4+1.965715e-02*s5+(-1.617250e+00)*s6 \
v143=1.954497e+00*s0+(-3.504354e-01)*s1+(-3.926817e+00)*s2+9.168297e+00*s3+1.059442e-01*s4+1.009749e+01*s5+1.985161e+01*s6 \
v144=2.373936e+00*s0+(-1.126570e+00)*s1+(-1.959161e+00)*s2+1.256818e+01*s3+7.667008e+00*s4+(-3.635727e+01)*s5+(-1.064223e+02)*s6 \
v145=(-1.862090e+00)*s0+(-8.098667e-02)*s1+8.435947e+00*s2+2.503232e+01*s3+(-1.876057e+01)*s4+5.891935e+01*s5+6.647581e+01*s6 \
v146=(-2.165582e-01)*s0+2.960177e-01*s1+(-4.885605e+00)*s2+(-2.171262e+01)*s3+8.415401e+00*s4+4.451995e+00*s5+2.928202e+02*s6 \
v147=4.050397e+01*s0+2.574051e+01*s1+1.332581e+01*s2+1.448584e+01*s3+5.417789e+00*s4+1.472418e+01*s5+2.016377e+01*s6 \
v148=(-4.258088e+01)*s0+4.258610e+01*s1+3.969495e+01*s2+4.286050e+01*s3+2.952503e+01*s4+1.823637e+02*s5+2.181431e+01*s6 \
v149=2.490726e+00*s0+6.726747e+01*s1+2.261078e+01*s2+(-7.099389e+00)*s3+(-5.908881e+00)*s4+(-2.035572e+02)*s5+(-2.146471e+00)*s6 \
v150=1.204406e+01*s0+(-7.872445e+01)*s1+(-2.290498e+01)*s2+5.546833e-01*s3+1.358874e+01*s4+1.989596e+02*s5+3.846078e+01*s6 \
v151=(-1.645821e+01)*s0+(-9.658407e+01)*s1+2.367278e+01*s2+(-1.139739e+02)*s3+2.680137e+02*s4+1.206169e+02*s5+(-2.680067e+02)*s6 \
v152=1.955914e+01*s0+6.261707e+01*s1+(-2.998573e+01)*s2+(-3.068097e+01)*s3+2.943378e+02*s4+5.559969e+01*s5+9.658718e+02*s6 \
v153=(-3.202032e+00)*s0+4.601347e+01*s1+(-1.022795e+01)*s2+2.029246e+00*s3+(-6.099764e+02)*s4+(-2.483907e+02)*s5+(-5.811781e+02)*s6 \
v154=(-2.585620e+01)*s0+(-1.169292e+00)*s1+4.176779e-01*s2+7.274263e-01*s3+(-1.265015e+00)*s4+3.907692e+00*s5+5.863945e+00*s6 \
v155=7.409324e+01*s0+(-6.578791e-01)*s1+8.040939e-01*s2+5.694637e+01*s3+2.928686e+00*s4+(-1.625761e+01)*s5+(-4.000457e+00)*s6 \
v156=(-5.286010e+01)*s0+9.471500e+00*s1+(-2.467644e+00)*s2+(-9.270834e+01)*s3+8.756663e+00*s4+3.449610e+01*s5+1.775731e+01*s6 \
v157=1.192950e+02*s0+(-4.479832e+00)*s1+(-6.952000e-01)*s2+(-5.894975e+00)*s3+(-4.188482e+00)*s4+(-3.486080e-01)*s5+(-2.035170e-01)*s6 \
v158=(-2.202908e-01)*s0+(-5.971181e+00)*s1+2.780109e-02*s2+2.991744e+01*s3+(-6.627433e+00)*s4+1.262596e+01*s5+1.397090e+01*s6 \
v159=1.414699e+02*s0+1.792670e+00*s1+(-8.948096e-01)*s2+(-1.354382e+01)*s3+(-5.219417e+00)*s4+1.247166e+01*s5+7.727795e+01*s6 \
v160=(-5.149464e+01)*s0+(-1.691781e+01)*s1+2.841495e+00*s2+1.103816e+02*s3+3.291849e+00*s4+(-1.568159e+00)*s5+(-1.737109e+01)*s6 \
v161=(-1.038649e+00)*s0+7.445135e+00*s1+(-5.698653e-01)*s2+(-2.282899e+01)*s3+(-1.173195e+00)*s4+(-3.758610e+01)*s5+(-2.535765e+01)*s6 \
v162=9.580066e+01*s0+1.042473e+01*s1+4.239274e+00*s2+(-4.581377e+01)*s3+(-9.794403e-03)*s4+3.717686e-02*s5+4.741518e+01*s6 \
v163=5.994588e-01*s0+3.584366e+00*s1+2.452085e+00*s2+3.224792e+00*s3+1.263348e+00*s4+1.998634e+01*s5+1.525448e+01*s6 \
v164=(-1.570842e+02)*s0+(-9.184903e-01)*s1+(-5.751719e+00)*s2+(-8.496617e+00)*s3+6.881312e-01*s4+1.298521e+01*s5+(-9.362718e+01)*s6 \
v165=(-8.214370e+01)*s0+2.964258e+00*s1+(-2.808821e-01)*s2+7.642610e+03*s3+(-6.040090e+01)*s4+2.934913e+02*s5+2.353627e+01*s6 \
v166=(-3.117464e+02)*s0+(-3.319866e+00)*s1+(-3.457032e-01)*s2+4.698159e+03*s3+4.801413e+01*s4+(-1.014055e+02)*s5+(-2.176761e+02)*s6 \
v167=2.565178e+02*s0+(-3.582598e-01)*s1+(-1.690492e-02)*s2+1.649474e+03*s3+2.305187e+01*s4+(-1.681809e+02)*s5+1.838747e+02*s6 \
v168=2.948978e-01*s0+(-5.880467e-01)*s1+2.604230e-01*s2+1.036651e-01*s3+3.189733e+00*s4+4.598792e-01*s5+(-2.619256e+00)*s6 \
v169=8.230938e-02*s0+(-2.296553e+00)*s1+(-7.562829e-01)*s2+(-2.208416e+00)*s3+4.193111e-01*s4+(-9.459718e-01)*s5+1.248799e+00*s6 \
v170=(-1.973942e+00)*s0+5.877534e+00*s1+2.435863e+00*s2+3.434559e+00*s3+(-4.782571e+00)*s4+9.160466e-01*s5+2.682907e+00*s6 \
v171=2.282694e+00*s0+8.316783e+00*s1+(-3.208155e-01)*s2+1.588063e+01*s3+8.214055e-01*s4+5.408838e+00*s5+(-4.357400e-01)*s6 \
v172=1.390039e+00*s0+(-2.195069e+00)*s1+(-2.380299e-01)*s2+4.539169e+00*s3+(-1.061348e+01)*s4+(-5.921235e-01)*s5+5.795314e+00*s6 \
v173=(-7.997328e-01)*s0+(-8.127253e-01)*s1+(-1.187692e+00)*s2+(-5.713698e+00)*s3+(-3.450505e+00)*s4+2.268786e+00*s5+(-1.666551e+00)*s6 \
v174=(-1.437652e+00)*s0+(-7.433429e+00)*s1+2.705617e-02*s2+(-4.192423e+01)*s3+1.541331e+01*s4+(-1.400425e+01)*s5+(-1.413584e+01)*s6 \
v175=(-7.844509e-01)*s0+1.312196e-01*s1+(-3.714898e-01)*s2+(-4.762964e+00)*s3+(-4.606066e+00)*s4+(-5.063896e-01)*s5+(-2.453001e-01)*s6 \
v176=5.772652e-01*s0+(-5.495720e+00)*s1+(-1.695544e+00)*s2+1.157390e+01*s3+(-1.206700e+00)*s4+5.695057e-01*s5+1.280622e+01*s6 \
v177=8.376759e-01*s0+(-2.013255e-01)*s1+2.342739e+00*s2+2.001056e+01*s3+2.383421e+00*s4+6.149206e+00*s5+(-1.468218e-01)*s6 \
v178=(-4.054080e-01)*s0+5.785755e+00*s1+2.459339e+00*s2+2.620322e+00*s3+2.253302e+01*s4+1.024315e+00*s5+(-2.120469e+00)*s6 \
v179=1.114546e-02*s0+7.269557e-02*s1+(-1.107275e+01)*s2+5.724848e+00*s3+(-5.164078e+01)*s4+(-2.018410e+00)*s5+(-1.318340e+01)*s6 \
v180=(-6.154709e-02)*s0+(-8.714413e-02)*s1+2.657729e+01*s2+(-5.410184e+00)*s3+1.076966e+02*s4+(-5.866812e+00)*s5+(-2.592177e-01)*s6 \
v181=3.986727e-02*s0+(-9.556713e-02)*s1+(-1.823349e+00)*s2+(-2.550878e+00)*s3+6.345935e+01*s4+7.475533e+00*s5+9.645520e+00*s6 \
_p0=v0/od_+v1/w_+v2+v3*od_+v4*w_+v5*od_*od_+v6*od_*w_+v7*w_*w_+v8*od_*od_*w_+v9*od_*w_*w_+v10*od_*od_*w_*w_ \
_p1=_p0+v11*(s_-0.446)+v12*(s_-0.446)*od_+v13*(s_-0.446)*w_ \
_p2=0.5*(_p1+sqrt(_p1*_p1+0.001)) \
_p3=syct_dls*1e-09*_p2 \
_p4=syct_dls*1e-09*_p2 \
_p5=v14+v15*od_+v16*w_+v17*od_*w_+v18*od_*od_+v19*w_*w_+v20*od_/w_+v21*od_*od_/w_/w_+v22/w_jump_+v23/(w_jump_*w_jump_) \
_p6=_p5+v24*(s_-0.446)+v25*(s_-0.446)*od_+v26*(s_-0.446)*w_ \
_p7=syct_drs*syct_drs*0.5*(_p6+sqrt(_p6*_p6+0.001)) \
_p8=v27+v28*od_+v29*w_+v30*od_*w_ \
_p9=_p8+v31*(s_-0.446)+v32*(s_-0.446)*od_+v33*(s_-0.446)*w_ \
_p10=0.5*(_p9+sqrt(_p9*_p9+0.001)) \
_p11=syct_dls*1e-09*_p10 \
_p12=v34+v35*od_+v36*w_+v37*od_*w_+v38*od_/w_ \
_p13=_p12+v39*(s_-0.446)+v40*(s_-0.446)*od_+v41*(s_-0.446)*w_ \
_p14=0.5*(_p13+sqrt(_p13*_p13+0.001)) \
_p15=syct_drs*1e-09*_p14 \
_p16=v42/od_+v43/w_+v44+v45*od_+v46*w_+v47*od_*od_+v48*od_*w_+v49*w_*w_+v50*od_*od_*w_+v51*od_*w_*w_+v52*od_*od_*w_*w_ \
_p17=_p16+v53*(s_-0.446)+v54*(s_-0.446)*od_+v55*(s_-0.446)*w_ \
_p18=0.5*(_p17+sqrt(_p17*_p17+0.001)) \
_p19=syct_dls*1e-09*_p18 \
_p20=syct_dls*1e-09*_p18 \
_p21=v56+v57*od_+v58*w_+v59*od_*w_+v60*od_*od_+v61*w_*w_+v62*od_/w_+v63*od_*od_/w_/w_+v64/w_jump_+v65/(w_jump_*w_jump_) \
_p22=_p21+v66*(s_-0.446)+v67*(s_-0.446)*od_+v68*(s_-0.446)*w_ \
_p23=syct_drs*syct_drs*0.5*(_p22+sqrt(_p22*_p22+0.001)) \
_p24=v69+v70*od_+v71*w_+v72*od_*w_ \
_p25=_p24+v73*(s_-0.446)+v74*(s_-0.446)*od_+v75*(s_-0.446)*w_ \
_p26=0.5*(_p25+sqrt(_p25*_p25+0.001)) \
_p27=syct_dls*1e-09*_p26 \
_p28=v76+v77*od_+v78*w_+v79*od_*w_+v80*od_/w_ \
_p29=_p28+v81*(s_-0.446)+v82*(s_-0.446)*od_+v83*(s_-0.446)*w_ \
_p30=0.5*(_p29+sqrt(_p29*_p29+0.001)) \
_p31=syct_drs*1e-09*_p30 \
_p32=v84/od_+v85/w_+v86+v87*od_+v88*w_+v89*od_*od_+v90*od_*w_+v91*w_*w_+v92*od_*od_*w_+v93*od_*w_*w_+v94*od_*od_*w_*w_ \
_p33=_p32+v95*(s_-0.446)+v96*(s_-0.446)*od_+v97*(s_-0.446)*w_ \
_p34=atan(_p33-0.5)/1.5708 \
_p35=v98/od_+v99/w_+v100+v101*od_+v102*w_+v103*od_*od_+v104*od_*w_+v105*w_*w_+v106*od_*od_*w_+v107*od_*w_*w_+v108*od_*od_*w_*w_ \
_p36=_p35+v109*(s_-0.446)+v110*(s_-0.446)*od_+v111*(s_-0.446)*w_ \
_p37=atan(_p36-0.5)/1.5708 \
_p38=0.5*_p34+0.5*_p37 \
_p39=0.5*_p34-0.5*_p37 \
_p40=v112/od_+v113/w_+v114+v115*od_+v116*w_+v117*od_*od_+v118*od_*w_+v119*w_*w_+v120*od_*od_*w_+v121*od_*w_*w_+v122*od_*od_*w_*w_ \
_p41=_p40+v123*(s_-0.446)+v124*(s_-0.446)*od_+v125*(s_-0.446)*w_ \
_p42=0.5*(_p41+sqrt(_p41*_p41+0.001)) \
_p43=syct_dls*1e-09*_p42 \
_p44=syct_dls*1e-09*_p42 \
_p45=syct_drs*syct_drs*1e-06 \
_p46=v126+v127*od_+v128*w_+v129*od_*w_ \
_p47=_p46+v130*(s_-0.446)+v131*(s_-0.446)*od_+v132*(s_-0.446)*w_ \
_p48=0.5*(_p47+sqrt(_p47*_p47+0.001)) \
_p49=1e-15*_p48 \
_p50=v133+v134*od_+v135*w_+v136*od_*w_ \
_p51=_p50+v137*(s_-0.446)+v138*(s_-0.446)*od_+v139*(s_-0.446)*w_ \
_p52=0.5*(_p51+sqrt(_p51*_p51+0.001)) \
_p53=v140+v141*od_+v142*w_+v143*od_*w_ \
_p54=_p53+v144*(s_-0.446)+v145*(s_-0.446)*od_+v146*(s_-0.446)*w_ \
_p55=0.5*(_p54+sqrt(_p54*_p54+0.001)) \
_p56=v147+v148*od_+v149*w_+v150*od_*w_ \
_p57=_p56+v151*(s_-0.446)+v152*(s_-0.446)*od_+v153*(s_-0.446)*w_ \
_p58=0.5*(_p57+sqrt(_p57*_p57+0.001)) \
_p59=1e-14*_p52 \
_p60=syct_drs_sub*100*_p55 \
_p61=1e-15*_p58 \
_p62=1e-14*_p52 \
_p63=syct_drs_sub*100*_p55 \
_p64=1e-15*_p58 \
_p65=v154/od_+v155/w_+v156+v157*od_+v158*w_+v159*od_*od_+v160*od_*w_+v161*w_*w_+v162*od_*od_*w_+v163*od_*w_*w_+v164*od_*od_*w_*w_ \
_p66=_p65+v165*(s_-0.446)+v166*(s_-0.446)*od_+v167*(s_-0.446)*w_ \
_p67=0.5*(_p66+sqrt(_p66*_p66+0.001)) \
_p68=v168/od_+v169/w_+v170+v171*od_+v172*w_+v173*od_*od_+v174*od_*w_+v175*w_*w_+v176*od_*od_*w_+v177*od_*w_*w_+v178*od_*od_*w_*w_ \
_p69=_p68+v179*(s_-0.446)+v180*(s_-0.446)*od_+v181*(s_-0.446)*w_ \
_p70=0.5*(_p69+sqrt(_p69*_p69+0.001)) \
_p71=syct_drs_sub*100*_p67 \
_p72=1e-13*_p70
l1_sect1 (p1 _n1i_sect1) inductor l=_p3
l2_sect1 (_n2i_sect1 p2) inductor l=_p4
r1_sect1 (_n1i_sect1 _n_sect1) resistor r=_p7
r2_sect1 (_n_sect1 _n2i_sect1) resistor r=_p7
lc_sect1 (_nc_sect1 ct) inductor l=_p11
rc_sect1 (_n_sect1 _nc_sect1) resistor r=_p15
l1_sect2 (p1 _n1i_sect2) inductor l=_p19
l2_sect2 (_n2i_sect2 p2) inductor l=_p20
r1_sect2 (_n1i_sect2 _n_sect2) resistor r=_p23
r2_sect2 (_n_sect2 _n2i_sect2) resistor r=_p23
lc_sect2 (_nc_sect2 ct) inductor l=_p27
rc_sect2 (_n_sect2 _nc_sect2) resistor r=_p31
k12_sect1 mutual_inductor coupling=_p38 ind1=l1_sect1 ind2=l2_sect1
k12_sect2 mutual_inductor coupling=_p38 ind1=l1_sect2 ind2=l2_sect2
ks1s2_1 mutual_inductor coupling=_p39 ind1=l1_sect1 ind2=l1_sect2
ks1s2_2 mutual_inductor coupling=_p39 ind1=l2_sect1 ind2=l2_sect2
lx1 (_n1i_sect1 _nx1) inductor l=_p43
lx2 (_n2i_sect1 _nx2) inductor l=_p44
rx1 (_nx1 _n1i_sect2) resistor r=_p45
rx2 (_nx2 _n2i_sect2) resistor r=_p45
c12 (p1 p2) capacitor c=_p49
c_1_sub (p1 _n1_1_sub) capacitor c=_p59
rs_1_sub (_n1_1_sub sub) resistor r=_p60
cs_1_sub (_n1_1_sub sub) capacitor c=_p61
c_2_sub (p2 _n1_2_sub) capacitor c=_p62
rs_2_sub (_n1_2_sub sub) resistor r=_p63
cs_2_sub (_n1_2_sub sub) capacitor c=_p64
rx_1_2_sub (_n1_1_sub _n1_2_sub) resistor r=_p71
cx_1_2_sub (_n1_1_sub _n1_2_sub) capacitor c=_p72
ends l_sy40kct_rfvil
