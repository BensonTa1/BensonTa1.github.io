simulator lang=spectre insensitive=yes
library l110ae_l_cr40knw_vil_rf_v021_lib
//
section tt
parameters slcrnw_drs=1
parameters slcrnw_drs_sub=1
parameters slcrnw_dls=1
include "l110ae_l_cr40knw_vil_rf_v021.mdl.scs"
endsection tt
//
section ff
parameters slcrnw_drs=1.15
parameters slcrnw_drs_sub=0.85
parameters slcrnw_dls=1.05
include "l110ae_l_cr40knw_vil_rf_v021.mdl.scs"
endsection ff
//
section ss
parameters slcrnw_drs=0.85
parameters slcrnw_drs_sub=1.15
parameters slcrnw_dls=0.95
include "l110ae_l_cr40knw_vil_rf_v021.mdl.scs"
endsection ss
//
endlibrary l110ae_l_cr40knw_vil_rf_v021_lib
