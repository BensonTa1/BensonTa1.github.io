simulator lang=spectre insensitive=yes
library l110ae_l_sy40kct_vil_rf_v021_lib
//
section tt
parameters syct_drs=1
parameters syct_drs_sub=1
parameters syct_dls=1
include "l110ae_l_sy40kct_vil_rf_v021.mdl.scs"
endsection tt
//
section ff
parameters syct_drs=1.15
parameters syct_drs_sub=0.85
parameters syct_dls=1.05
include "l110ae_l_sy40kct_vil_rf_v021.mdl.scs"
endsection ff
//
section ss
parameters syct_drs=0.85
parameters syct_drs_sub=1.15
parameters syct_dls=0.95
include "l110ae_l_sy40kct_vil_rf_v021.mdl.scs"
endsection ss
//
endlibrary l110ae_l_sy40kct_vil_rf_v021_lib
