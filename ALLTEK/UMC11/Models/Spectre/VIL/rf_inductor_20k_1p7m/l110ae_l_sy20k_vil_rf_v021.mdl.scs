simulator lang=spectre insensitive=yes
// model: l_sy20k_rfvil_1p7m0t1f1u
// planar symmetric rf inductor, p sub, 2.0um metal7
// umc 110nm 1p7m0t1f1u rfcmos process
// date: 2011-04-12
// model coverage:(before shrinkage)
// od: (75 - 299) * 1e-06
// w: (2.23 - 9.7) * 1e-06
// s: (2.23 - 5) * 1e-06
// nt: 2 - 7
// frequency range: 100mhz - 0.8 * resonance (maximum 20.0 ghz)
subckt l_sy20k_rfvil_1p7m0t1f1u (outer inner sub)
parameters od=0.00015 od_=od/0.000299 w=6e-06 w_=w/1e-05 w_jump_=max(floor((w_-0.075)/0.09), 1) s=2.52e-06 s_=s/5e-06 nt=3  \
s0=(nt==2) \
s1=(nt==3) \
s2=(nt==4) \
s3=(nt==5) \
s4=(nt==6) \
s5=(nt==7) \
v0=3.238269e+00*s0+1.640221e-01*s1+6.590515e+00*s2+(-6.612620e+00)*s3+1.725661e-01*s4+(-1.402568e+01)*s5 \
v1=3.166540e+00*s0+2.067918e+01*s1+3.514190e+01*s2+5.529547e+01*s3+7.376245e+01*s4+9.674401e+01*s5 \
v2=(-6.477760e+00)*s0+(-1.360673e+01)*s1+(-6.066652e+00)*s2+3.673670e+01*s3+(-1.825610e+01)*s4+(-3.222941e+00)*s5 \
v3=(-3.310406e+00)*s0+1.367237e+01*s1+(-2.554062e+01)*s2+(-4.944720e+01)*s3+(-2.644592e+01)*s4+(-2.077887e+01)*s5 \
v4=(-3.367730e+00)*s0+7.899166e+00*s1+(-2.304268e+01)*s2+2.399866e+01*s3+(-1.243983e+01)*s4+(-1.464084e+01)*s5 \
v5=(-9.336543e+00)*s0+(-5.800107e+01)*s1+(-4.562179e+01)*s2+(-9.926780e+01)*s3+(-1.301110e+02)*s4+(-1.142387e+02)*s5 \
v6=8.116120e+00*s0+9.646175e+00*s1+2.918014e+01*s2+(-1.608665e+01)*s3+5.877155e+01*s4+2.689372e+01*s5 \
v7=7.640182e+01*s0+1.282847e+01*s1+6.518333e+00*s2+1.975706e+02*s3+4.412479e+01*s4+(-2.802059e+02)*s5 \
v8=8.366057e+00*s0+(-8.681343e+00)*s1+(-6.419945e+00)*s2+(-1.352753e+02)*s3+5.135123e+01*s4+9.090839e+01*s5 \
v9=(-1.787484e+02)*s0+(-1.904040e+01)*s1+(-1.106775e+00)*s2+(-3.905892e+02)*s3+(-3.801154e+01)*s4+5.757952e+02*s5 \
v10=1.141074e+01*s0+4.705894e+00*s1+2.171194e+00*s2+2.848501e+02*s3+(-1.923646e+01)*s4+(-2.396485e+02)*s5 \
v11=(-5.867624e+00)*s0+1.833314e+00*s1+1.153198e+00*s2+2.431856e+01*s3+(-5.197741e+00)*s4+3.974073e+02*s5 \
v12=1.496907e+02*s0+8.706758e+00*s1+(-1.352715e+00)*s2+1.898902e+02*s3+9.348792e+00*s4+(-7.444768e+01)*s5 \
v13=(-5.770192e-01)*s0+4.228388e+00*s1+6.094983e+00*s2+1.731613e+01*s3+(-2.469254e+01)*s4+(-1.670242e+02)*s5 \
v14=2.757281e-01*s0+(-1.901644e-01)*s1+(-6.298266e-01)*s2+(-8.075342e-01)*s3+3.192716e+00*s4+2.502001e+00*s5 \
v15=(-9.870042e+01)*s0+(-1.801247e+01)*s1+(-4.847050e+01)*s2+(-2.519489e+02)*s3+(-2.430409e+02)*s4+(-8.261085e+02)*s5 \
v16=6.103929e+01*s0+2.008068e+01*s1+1.238736e+02*s2+1.615433e+02*s3+7.441486e+02*s4+5.581465e+03*s5 \
v17=(-3.039136e+00)*s0+(-2.359576e-01)*s1+(-6.491182e-01)*s2+(-2.692277e+00)*s3+1.726399e+00*s4+1.020079e+02*s5 \
v18=5.448299e+00*s0+6.688496e-02*s1+(-1.530185e-01)*s2+2.850913e-01*s3+(-1.134628e+00)*s4+(-3.878399e+02)*s5 \
v19=(-2.521464e+00)*s0+1.669044e-01*s1+6.946312e-01*s2+3.759230e+00*s3+(-1.185292e+00)*s4+3.388571e+02*s5 \
v20=1.079175e-04*s0+(-1.963616e-02)*s1+(-1.060954e-01)*s2+1.853944e-01*s3+3.223468e-01*s4+(-1.607257e+01)*s5 \
v21=(-5.446921e-02)*s0+(-2.466956e-02)*s1+2.708815e-01*s2+(-3.701346e-02)*s3+1.172583e+00*s4+1.553454e+01*s5 \
v22=6.723117e-01*s0+5.044789e-02*s1+(-6.104855e-01)*s2+(-1.748104e+00)*s3+(-8.496402e+00)*s4+2.934353e+00*s5 \
v23=5.311862e-01*s0+2.756313e+00*s1+2.125973e+00*s2+7.955691e+00*s3+8.995370e+00*s4+(-1.445258e+02)*s5 \
v24=(-3.122306e+00)*s0+(-3.318273e-01)*s1+7.853135e-01*s2+5.052258e-01*s3+8.813356e+00*s4+1.704918e+02*s5 \
v25=7.579252e-01*s0+6.399139e-01*s1+2.515857e+00*s2+2.445900e+00*s3+5.459259e+00*s4+4.511934e+01*s5 \
v26=3.204517e+00*s0+(-3.341890e+00)*s1+(-1.278044e+00)*s2+(-5.151116e+00)*s3+(-4.101351e+00)*s4+2.477285e+01*s5 \
v27=3.340297e+00*s0+(-7.786040e-02)*s1+(-8.171129e-01)*s2+(-2.493694e+00)*s3+(-5.044294e+00)*s4+(-1.614815e+02)*s5 \
v28=(-2.373492e+00)*s0+1.337352e+00*s1+(-6.872566e-01)*s2+(-8.386844e+00)*s3+(-8.406295e+00)*s4+6.720139e+01*s5 \
v29=(-1.738406e+00)*s0+2.140978e+00*s1+1.007656e+00*s2+6.605347e+00*s3+1.392982e+00*s4+5.761627e+01*s5 \
v30=1.899089e+00*s0+(-1.357893e+00)*s1+(-3.779017e-01)*s2+6.314659e+00*s3+4.493065e+00*s4+(-4.424321e+00)*s5 \
v31=5.628070e-03*s0+(-1.210627e-01)*s1+(-3.405272e-01)*s2+(-4.114987e-01)*s3+(-7.237533e-01)*s4+(-1.341290e+01)*s5 \
v32=(-1.506847e-01)*s0+(-3.482560e-01)*s1+(-6.131932e-01)*s2+(-1.486602e+00)*s3+(-2.035650e+00)*s4+2.127533e+01*s5 \
v33=(-4.982611e-02)*s0+1.684150e-01*s1+3.446192e-01*s2+8.005175e-01*s3+1.220101e+00*s4+(-4.596748e+00)*s5 \
v34=2.674664e+00*s0+(-3.127790e+01)*s1+1.446583e+02*s2+2.110083e+01*s3+3.954596e+02*s4+6.824881e+01*s5 \
v35=(-4.379249e+00)*s0+3.478061e+01*s1+(-4.177301e+03)*s2+(-2.028432e+01)*s3+(-4.962752e+02)*s4+(-1.350897e+02)*s5 \
v36=3.108777e+00*s0+8.038948e+01*s1+1.287260e+03*s2+1.167937e+01*s3+(-8.876496e+02)*s4+(-6.051275e+01)*s5 \
v37=3.635636e+00*s0+6.914668e+01*s1+4.349703e+02*s2+1.070897e+01*s3+8.999839e+02*s4+6.296455e+01*s5 \
v38=(-1.048844e+00)*s0+(-1.065548e+02)*s1+3.532847e+03*s2+1.853079e+00*s3+7.683244e+01*s4+2.428235e+01*s5 \
v39=(-3.343697e+00)*s0+(-6.553713e+01)*s1+(-4.261745e+02)*s2+(-1.638972e+01)*s3+4.081625e+02*s4+1.344060e+01*s5 \
v40=4.116346e+00*s0+2.144931e+00*s1+9.129701e+02*s2+1.436880e+01*s3+5.124707e+01*s4+5.447994e+01*s5 \
v41=6.215017e-01*s0+4.903977e+01*s1+(-1.745408e+02)*s2+(-7.356033e-01)*s3+7.514188e-02*s4+(-4.586678e+00)*s5 \
v42=(-3.739276e+01)*s0+(-1.791468e+02)*s1+(-8.778035e+02)*s2+(-2.157117e+02)*s3+(-3.334618e+02)*s4+(-1.468334e+02)*s5 \
v43=1.204462e+02*s0+6.888238e+02*s1+5.138883e+02*s2+6.114251e+02*s3+2.047511e+02*s4+1.366651e+02*s5 \
v44=5.306384e-03*s0+(-8.415701e+00)*s1+(-1.106419e+01)*s2+(-2.422849e+00)*s3+2.675550e+01*s4+(-7.365351e-02)*s5 \
v45=(-1.540708e-01)*s0+(-1.758231e+01)*s1+(-3.716639e+01)*s2+1.058915e+00*s3+(-1.559890e+01)*s4+2.654424e-01*s5 \
v46=(-1.804836e-02)*s0+1.767994e+01*s1+1.669056e+02*s2+1.144160e+00*s3+(-7.618586e+01)*s4+(-1.326974e+00)*s5 \
v47=1.775154e-02*s0+(-1.579540e-01)*s1+4.937067e-02*s2+(-3.874263e-01)*s3+3.013561e-04*s4+3.986047e-01*s5 \
v48=3.276122e-02*s0+2.659591e-01*s1+4.117326e-01*s2+1.108598e+00*s3+1.920286e-01*s4+2.945662e-01*s5 \
v49=(-4.923773e-01)*s0+(-1.277314e+00)*s1+(-5.817407e+00)*s2+(-3.314902e+00)*s3+(-2.658229e+00)*s4+(-7.421076e+00)*s5 \
v50=2.760159e+00*s0+7.484735e+00*s1+8.180214e+00*s2+5.329756e+00*s3+1.357770e+01*s4+2.223589e+01*s5 \
v51=2.664977e-01*s0+4.275946e+00*s1+1.726833e+01*s2+5.794696e+00*s3+(-3.797632e-01)*s4+4.713447e+00*s5 \
v52=6.218073e-01*s0+(-4.662755e+00)*s1+6.387897e+00*s2+9.237564e+00*s3+9.519044e+00*s4+9.325560e+00*s5 \
v53=(-1.455515e+00)*s0+(-1.662765e+01)*s1+(-1.126023e+01)*s2+(-5.632629e+00)*s3+(-1.350890e+01)*s4+(-1.171446e+01)*s5 \
v54=(-2.378156e-01)*s0+(-3.372243e+00)*s1+(-1.851468e+01)*s2+(-4.728475e+00)*s3+1.348346e+00*s4+(-9.179459e+00)*s5 \
v55=(-7.826540e-02)*s0+1.513027e+01*s1+(-1.338086e+01)*s2+(-4.149079e+00)*s3+(-5.058008e+00)*s4+(-1.081436e+01)*s5 \
v56=6.112580e-01*s0+1.197555e+01*s1+2.038231e+01*s2+4.964558e+00*s3+7.298444e+00*s4+1.302616e+01*s5 \
v57=(-6.507201e-02)*s0+(-1.015900e+01)*s1+2.389147e+01*s2+(-6.414974e-01)*s3+1.169071e+01*s4+1.143906e-01*s5 \
v58=(-6.009897e-02)*s0+(-3.881987e-01)*s1+(-2.939747e-01)*s2+(-1.220975e+00)*s3+(-1.158146e+00)*s4+(-2.058820e+00)*s5 \
v59=(-2.304009e-01)*s0+(-2.804632e-02)*s1+(-1.702906e+00)*s2+(-2.497220e+00)*s3+(-4.298105e+00)*s4+(-5.916622e+00)*s5 \
v60=6.569547e-02*s0+8.802329e-02*s1+7.802084e-02*s2+1.618906e+00*s3+1.394889e+00*s4+3.389297e+00*s5 \
v61=(-3.035653e-02)*s0+5.239001e-01*s1+(-1.360475e-01)*s2+(-2.513634e-01)*s3+(-2.607332e-01)*s4+2.197768e-01*s5 \
v62=2.065274e-01*s0+1.202467e+00*s1+1.240365e-02*s2+4.963259e-02*s3+(-3.538430e-02)*s4+2.046827e+00*s5 \
v63=1.658227e-01*s0+(-3.816551e+00)*s1+7.522557e-01*s2+5.736975e-01*s3+1.541037e+00*s4+(-1.050887e+01)*s5 \
v64=(-1.654761e+00)*s0+(-2.375754e+01)*s1+(-1.094168e+00)*s2+(-1.796561e-01)*s3+(-1.517224e+00)*s4+(-1.114226e+01)*s5 \
v65=(-8.194555e-01)*s0+(-1.049864e+00)*s1+(-1.751650e+00)*s2+1.947350e+00*s3+(-2.262136e-01)*s4+5.819602e+00*s5 \
v66=9.739067e-01*s0+1.523280e+01*s1+6.713400e-01*s2+9.239656e-02*s3+3.488891e-01*s4+1.151466e+01*s5 \
v67=4.291579e+00*s0+6.463131e+01*s1+5.541482e+00*s2+(-3.286779e+00)*s3+1.169348e+00*s4+7.417889e+01*s5 \
v68=2.383952e-01*s0+1.559925e+00*s1+(-5.563057e-01)*s2+(-2.398353e+00)*s3+(-8.381375e-01)*s4+(-5.111969e-01)*s5 \
v69=(-2.513384e+00)*s0+(-9.567853e+00)*s1+(-4.433822e+00)*s2+1.577734e+00*s3+(-3.140026e-01)*s4+(-6.410509e+01)*s5 \
v70=(-2.401458e+00)*s0+(-3.686114e+01)*s1+(-2.147463e+00)*s2+3.423951e+00*s3+5.579099e-01*s4+(-7.604609e+01)*s5 \
v71=1.501843e+00*s0+(-6.242614e+00)*s1+2.155062e+00*s2+(-1.708837e+00)*s3+(-3.359693e-01)*s4+6.685092e+01*s5 \
v72=(-5.542582e-02)*s0+5.075734e-01*s1+(-5.232565e-02)*s2+(-9.011868e-02)*s3+(-8.967608e-02)*s4+(-3.018411e-01)*s5 \
v73=4.590696e-02*s0+(-9.366771e-01)*s1+7.701951e-02*s2+2.313391e-01*s3+8.986279e-02*s4+(-3.686019e-01)*s5 \
v74=2.562955e-03*s0+(-1.791242e-01)*s1+(-9.391719e-02)*s2+(-1.570249e-01)*s3+(-8.512448e-02)*s4+4.647092e-01*s5 \
v75=(-2.182682e+00)*s0+(-2.105071e+00)*s1+(-2.644138e+00)*s2+6.213111e-01*s3+(-4.154940e-01)*s4+(-2.685834e+00)*s5 \
v76=6.174300e+00*s0+1.012400e+01*s1+9.267286e+00*s2+5.907351e+00*s3+3.856581e+00*s4+(-1.626696e+00)*s5 \
v77=4.450114e+00*s0+6.386993e-01*s1+(-2.649551e-01)*s2+(-9.811262e+00)*s3+(-6.150542e-01)*s4+2.053160e+01*s5 \
v78=(-1.317039e+00)*s0+(-5.112058e+00)*s1+(-4.273980e+00)*s2+(-1.696533e+00)*s3+1.886923e+00*s4+8.394336e+00*s5 \
v79=1.622699e+00*s0+4.145628e+00*s1+1.026742e+01*s2+1.697949e+01*s3+1.140577e+01*s4+3.006763e+00*s5 \
v80=(-3.177178e+00)*s0+5.189177e-01*s1+(-1.161466e+00)*s2+(-2.109160e+00)*s3+(-1.691014e+00)*s4+(-1.524453e+01)*s5 \
v81=1.223729e+00*s0+(-2.493187e+00)*s1+3.478216e+00*s2+(-5.099073e+00)*s3+2.730050e+00*s4+(-1.334511e+00)*s5 \
v82=(-2.801324e+00)*s0+4.718985e+00*s1+(-1.366360e+00)*s2+6.252299e+00*s3+7.153761e+00*s4+1.405327e+00*s5 \
v83=(-9.864948e-01)*s0+6.041361e-01*s1+(-4.482691e+00)*s2+4.782610e+00*s3+(-1.045221e+01)*s4+1.260982e+01*s5 \
v84=1.408220e+01*s0+3.619139e+01*s1+8.349184e+00*s2+2.032501e+01*s3+1.149505e+02*s4+1.386317e+01*s5 \
v85=(-8.482687e+00)*s0+(-5.820340e+01)*s1+(-6.298880e+01)*s2+(-3.026147e+01)*s3+(-2.516262e+02)*s4+7.219800e+00*s5 \
v86=(-8.039004e+00)*s0+1.374281e+00*s1+(-1.948818e+01)*s2+4.978074e+00*s3+3.175440e+01*s4+(-3.109773e+01)*s5 \
v87=4.073414e+00*s0+2.538218e+01*s1+8.228494e+01*s2+1.374582e+01*s3+1.553279e+02*s4+2.617969e+01*s5 \
v88=(-5.279772e+00)*s0+7.551538e+00*s1+1.176712e+02*s2+(-5.563668e-01)*s3+5.153576e+00*s4+(-3.869581e+02)*s5 \
v89=8.999194e+00*s0+(-3.703724e+00)*s1+1.711278e+01*s2+(-2.571120e+00)*s3+(-3.148272e+01)*s4+1.118555e+03*s5 \
v90=(-4.073481e+00)*s0+5.481543e+00*s1+(-8.729941e+01)*s2+(-6.900803e+00)*s3+(-4.573761e+00)*s4+5.478032e+02*s5 \
v91=3.199685e+00*s0+(-5.253289e+00)*s1+2.623942e+02*s2+6.244572e+00*s3+2.082312e+01*s4+(-4.221200e+02)*s5 \
v92=(-1.515040e+00)*s0+(-3.840688e+00)*s1+3.336839e+01*s2+(-8.124551e-02)*s3+(-2.752730e+01)*s4+(-5.180547e+02)*s5 \
v93=1.839899e+01*s0+(-1.489224e+01)*s1+2.245184e+01*s2+1.974412e+01*s3+1.189662e+01*s4+(-3.429052e+01)*s5 \
v94=(-6.512929e+00)*s0+1.511738e+02*s1+6.178204e+00*s2+1.575068e+01*s3+3.508456e+01*s4+8.135403e+01*s5 \
v95=1.903394e+01*s0+(-1.074204e+01)*s1+5.835024e+00*s2+(-1.172133e+01)*s3+(-4.398092e+00)*s4+2.035833e+01*s5 \
v96=1.336651e+01*s0+(-8.779609e+01)*s1+2.143967e+01*s2+7.484362e+00*s3+(-5.894025e+00)*s4+(-6.318073e+01)*s5 \
v97=5.802024e+00*s0+(-2.652911e+01)*s1+1.054637e+01*s2+3.925791e+01*s3+3.267888e+01*s4+(-2.398022e+01)*s5 \
v98=(-1.872431e+01)*s0+1.063787e+01*s1+(-1.278753e+01)*s2+(-1.060035e+01)*s3+(-1.447971e+01)*s4+2.457960e+01*s5 \
v99=(-2.272042e+01)*s0+(-3.570365e+01)*s1+(-6.265157e+00)*s2+3.116600e+01*s3+(-1.571028e+01)*s4+(-2.471853e+01)*s5 \
v100=3.585935e+00*s0+3.996798e+01*s1+1.050895e+01*s2+(-4.135079e+01)*s3+2.041686e+01*s4+1.895883e+02*s5 \
v101=2.658502e+01*s0+1.304894e+01*s1+(-3.056588e+00)*s2+(-3.145259e+00)*s3+(-5.764245e+01)*s4+(-8.377598e+01)*s5 \
v102=3.601695e+00*s0+3.238779e+00*s1+3.578332e+00*s2+(-9.736219e-01)*s3+(-1.061558e+00)*s4+3.246007e-01*s5 \
v103=(-3.346508e+00)*s0+(-9.777392e+00)*s1+(-1.052151e+01)*s2+(-2.331885e+00)*s3+2.838018e+00*s4+8.068255e+00*s5 \
v104=(-9.216424e+00)*s0+(-2.800835e+00)*s1+4.485465e-01*s2+1.127043e+01*s3+6.735012e+00*s4+(-1.111703e+01)*s5 \
v105=2.176892e+00*s0+6.873635e+00*s1+1.025255e+01*s2+(-3.815750e-01)*s3+(-1.447537e+00)*s4+(-7.131238e+00)*s5 \
v106=3.576266e+00*s0+6.083103e+00*s1+(-5.088965e+00)*s2+1.357767e+00*s3+(-8.779305e+00)*s4+2.883125e+00*s5 \
v107=6.154917e+00*s0+(-3.978814e-01)*s1+1.193435e+00*s2+(-2.689588e+00)*s3+(-7.897403e+00)*s4+8.468037e+00*s5 \
v108=(-5.358434e-01)*s0+4.822508e+00*s1+(-7.201307e+00)*s2+5.949205e+00*s3+(-6.804499e+00)*s4+(-1.654843e+00)*s5 \
v109=4.090905e+00*s0+(-4.934504e+00)*s1+1.148952e+01*s2+(-4.973297e+00)*s3+5.169024e+00*s4+5.042730e+00*s5 \
v110=(-7.030522e-01)*s0+(-1.442142e+00)*s1+5.391914e+00*s2+(-1.197039e+01)*s3+1.537136e+01*s4+(-5.153188e+00)*s5 \
v111=8.276636e+02*s0+6.920208e+00*s1+9.497015e+00*s2+2.920653e+00*s3+4.470003e+00*s4+7.694448e+00*s5 \
v112=(-9.550210e+02)*s0+(-1.183134e+00)*s1+(-1.450719e+01)*s2+4.216181e+01*s3+(-3.739724e+00)*s4+(-1.461138e+01)*s5 \
v113=(-4.827617e+02)*s0+1.574250e+01*s1+2.567937e+00*s2+(-1.422476e+01)*s3+8.512747e+00*s4+(-1.869611e+00)*s5 \
v114=1.139378e+02*s0+(-2.264833e+00)*s1+7.630728e+00*s2+1.075333e+01*s3+2.197707e+00*s4+1.144221e+01*s5 \
v115=7.222357e+02*s0+(-2.323971e+01)*s1+(-3.016544e+00)*s2+(-8.403747e+01)*s3+(-8.973916e+00)*s4+(-1.322343e+01)*s5 \
v116=(-2.000357e+02)*s0+(-3.514382e+00)*s1+4.178685e-01*s2+6.527987e+01*s3+6.941677e-01*s4+6.135597e+00*s5 \
v117=(-8.010805e+01)*s0+6.395757e+00*s1+(-3.547762e-01)*s2+(-4.803547e+01)*s3+1.022914e+01*s4+(-2.420056e+01)*s5 \
v118=3.808133e+01*s0+(-1.336387e+01)*s1+1.750821e+00*s2+6.726902e+01*s3+(-8.143877e+00)*s4+1.218824e+01*s5 \
v119=2.895913e+01*s0+1.401361e+01*s1+(-1.483777e+00)*s2+(-3.167500e+00)*s3+(-2.965268e+00)*s4+3.901127e+01*s5 \
v120=(-3.449340e+01)*s0+9.927519e+01*s1+9.733167e+01*s2+2.447695e+01*s3+9.563505e+00*s4+5.707132e+01*s5 \
v121=1.277444e+02*s0+(-2.450511e+02)*s1+(-9.597371e+01)*s2+(-2.357138e+01)*s3+(-3.852296e+01)*s4+(-1.334809e+01)*s5 \
v122=1.124806e+00*s0+(-1.045252e+02)*s1+(-2.160091e+02)*s2+(-3.685761e+01)*s3+5.914815e-01*s4+(-5.264001e+01)*s5 \
v123=(-4.385648e+01)*s0+8.318833e+01*s1+(-1.552640e+02)*s2+(-2.732477e+00)*s3+6.757625e+00*s4+7.108650e+02*s5 \
v124=(-1.418248e+01)*s0+1.648930e+02*s1+3.374780e+02*s2+(-5.900573e+00)*s3+(-1.499600e+01)*s4+7.670503e+02*s5 \
v125=7.101683e+00*s0+3.103593e+01*s1+3.020980e+01*s2+3.733318e+01*s3+2.476885e+01*s4+(-4.107493e+01)*s5 \
v126=6.226707e+01*s0+4.251768e+01*s1+(-2.522771e+01)*s2+6.122261e+01*s3+(-1.409687e+01)*s4+(-2.355189e+02)*s5 \
v127=(-1.740384e+01)*s0+(-3.397713e+01)*s1+(-2.060428e+01)*s2+(-1.674322e+02)*s3+1.018629e+02*s4+2.978707e+02*s5 \
v128=(-6.258427e+01)*s0+(-1.421087e+01)*s1+4.366274e+01*s2+4.097818e+01*s3+5.752630e+01*s4+(-8.834439e+02)*s5 \
v129=3.134307e+01*s0+2.400363e+01*s1+1.091254e+00*s2+1.021554e+02*s3+8.570556e+01*s4+4.204183e+01*s5 \
v130=(-1.871067e+01)*s0+3.937206e+01*s1+2.802884e+00*s2+9.689953e+01*s3+1.868238e+01*s4+(-1.553783e+01)*s5 \
v131=(-4.162133e+01)*s0+(-2.381705e+02)*s1+3.529663e-01*s2+(-6.794915e+00)*s3+1.347343e+02*s4+(-2.437803e+01)*s5 \
v132=3.837101e+00*s0+1.281412e+01*s1+(-1.118608e+01)*s2+9.135141e+01*s3+(-7.735243e+00)*s4+3.988352e+01*s5 \
v133=1.061624e+01*s0+(-1.974384e+02)*s1+(-4.494744e+00)*s2+(-3.607305e+02)*s3+2.582844e+01*s4+(-6.779234e+01)*s5 \
v134=1.511384e+01*s0+6.678051e+02*s1+5.335625e+00*s2+(-7.793928e+00)*s3+1.331542e+02*s4+2.666114e+01*s5 \
v135=1.199930e+01*s0+(-3.566677e+01)*s1+(-8.104895e+01)*s2+1.000000e+04*s3+3.332720e+03*s4+5.202486e+02*s5 \
v136=(-3.506714e+00)*s0+5.562591e+01*s1+5.517816e+01*s2+1.000000e+04*s3+7.523107e+03*s4+1.273329e+02*s5 \
v137=(-8.463466e+00)*s0+(-1.630808e+01)*s1+4.482364e+01*s2+8.908439e+02*s3+1.111007e+03*s4+(-5.644335e+02)*s5 \
v138=2.242042e+00*s0+4.609519e-01*s1+(-5.103775e+01)*s2+(-1.380007e+02)*s3+(-2.992686e+01)*s4+1.970599e+00*s5 \
v139=(-2.027146e+00)*s0+1.485061e+00*s1+(-1.253184e+02)*s2+(-3.200941e+01)*s3+(-1.512657e+02)*s4+(-5.439900e-01)*s5 \
v140=(-3.717678e+00)*s0+(-2.126699e+00)*s1+(-9.112537e+00)*s2+(-5.482610e+00)*s3+8.844457e+01*s4+(-6.345240e+00)*s5 \
v141=3.455463e-01*s0+(-6.163767e-01)*s1+(-1.649357e+02)*s2+(-4.040966e+02)*s3+(-1.650691e+02)*s4+3.166486e+00*s5 \
v142=5.235721e+00*s0+(-1.056691e-01)*s1+(-3.405642e+02)*s2+(-7.808191e+00)*s3+4.052868e+01*s4+(-5.600353e-01)*s5 \
v143=5.503947e-01*s0+1.273261e+00*s1+(-1.125171e+01)*s2+(-2.952899e+01)*s3+2.355655e+02*s4+4.426305e+00*s5 \
v144=1.777825e+00*s0+(-1.501979e-01)*s1+(-5.978443e+01)*s2+(-1.030085e+02)*s3+1.675871e+02*s4+7.086482e-01*s5 \
v145=(-2.389861e+00)*s0+6.624210e-01*s1+1.000000e+04*s2+6.813051e+02*s3+(-8.384888e+01)*s4+1.475088e+00*s5 \
v146=(-1.415914e+00)*s0+(-3.054496e-01)*s1+1.156647e+03*s2+1.639750e+03*s3+(-1.251500e+02)*s4+(-2.885693e+00)*s5 \
v147=1.668854e+00*s0+1.492137e+01*s1+(-1.425655e+00)*s2+(-1.454778e+00)*s3+2.445510e+00*s4+2.837128e+01*s5 \
v148=1.223078e+01*s0+(-1.377669e+02)*s1+(-6.596059e+00)*s2+(-4.770064e+00)*s3+(-6.558784e-01)*s4+(-4.318467e+01)*s5 \
v149=(-1.742072e+01)*s0+6.219277e+01*s1+3.752428e+00*s2+1.661976e+01*s3+(-5.825156e+00)*s4+5.028149e-01*s5 \
v150=(-3.753019e+00)*s0+1.389374e+02*s1+2.108093e+00*s2+4.123578e+00*s3+1.877299e+00*s4+2.374313e+01*s5 \
v151=(-1.020216e+01)*s0+(-5.053164e+00)*s1+(-1.222825e+00)*s2+(-1.802127e+00)*s3+(-2.048477e+00)*s4+(-9.942681e+00)*s5 \
v152=2.136133e+01*s0+(-4.023429e+00)*s1+3.452668e+00*s2+(-1.604695e+01)*s3+4.309145e+00*s4+5.791598e+00*s5 \
v153=(-8.377281e+00)*s0+(-8.290784e+01)*s1+5.273471e+00*s2+1.262552e+01*s3+(-3.017950e-01)*s4+6.067093e+00*s5 \
v154=8.235472e+00*s0+9.184281e+01*s1+7.319374e+00*s2+5.680502e+01*s3+(-3.457559e-01)*s4+(-5.194283e+00)*s5 \
v155=7.527455e+00*s0+1.273719e+02*s1+(-1.205709e+01)*s2+(-6.781217e+01)*s3+6.415200e-01*s4+(-9.307516e-01)*s5 \
v156=(-1.000000e+04)*s0+(-1.869746e-01)*s1+(-3.259923e+01)*s2+(-4.027307e+01)*s3+(-4.443599e+00)*s4+(-2.324497e-03)*s5 \
v157=(-1.000000e+04)*s0+2.111891e+00*s1+(-4.269235e+01)*s2+8.808279e+01*s3+(-3.584391e+00)*s4+1.568452e-01*s5 \
v158=(-1.000000e+04)*s0+(-7.846229e-01)*s1+(-3.067016e+02)*s2+(-1.586843e+00)*s3+(-5.311224e+00)*s4+7.742228e-01*s5 \
v159=(-1.000000e+04)*s0+(-1.900363e+00)*s1+1.004394e+01*s2+(-7.522719e+01)*s3+7.448596e+00*s4+3.025955e-01*s5 \
v160=(-1.000000e+04)*s0+(-4.457844e-02)*s1+5.918054e+01*s2+1.371870e+02*s3+3.333852e+01*s4+2.432882e-01*s5 \
v161=(-1.000000e+04)*s0+4.686443e-01*s1+5.569210e+02*s2+(-8.536841e+00)*s3+(-2.471684e+01)*s4+(-1.225277e+00)*s5 \
v162=(-1.000000e+04)*s0+(-4.026781e-01)*s1+1.381644e+02*s2+1.399750e+01*s3+1.984940e+01*s4+4.628544e-01*s5 \
v163=(-1.000000e+04)*s0+(-7.402182e-01)*s1+5.935855e+01*s2+1.561454e+01*s3+(-3.442289e+01)*s4+(-2.248396e+00)*s5 \
v164=(-1.000000e+04)*s0+9.551461e-01*s1+(-1.062253e+02)*s2+(-1.148383e+02)*s3+5.219316e+01*s4+6.255894e-01*s5 \
_p0=v0+v1*od_+v2*w_+v3*od_*w_ \
_p1=_p0+v4*(s_-0.446)+v5*(s_-0.446)*od_+v6*(s_-0.446)*w_ \
_p2=0.5*(_p1+sqrt(_p1*_p1+0.001)) \
_p3=1e-15*_p2 \
_p4=v7+v8*od_+v9*w_+v10*od_*w_+v11*od_*od_+v12*w_*w_+v13*od_/w_+v14*od_*od_/w_/w_+v15/w_jump_+v16/(w_jump_*w_jump_) \
_p5=_p4+v17*(s_-0.446)+v18*(s_-0.446)*od_+v19*(s_-0.446)*w_ \
_p6=sy_drs_1p7m0t1f1u*0.5*(_p5+sqrt(_p5*_p5+0.001)) \
_p7=v20/od_+v21/w_+v22+v23*od_+v24*w_+v25*od_*od_+v26*od_*w_+v27*w_*w_+v28*od_*od_*w_+v29*od_*w_*w_+v30*od_*od_*w_*w_ \
_p8=_p7+v31*(s_-0.446)+v32*(s_-0.446)*od_+v33*(s_-0.446)*w_ \
_p9=0.5*(_p8+sqrt(_p8*_p8+0.001)) \
_p10=sy_dls_1p7m0t1f1u*1e-09*_p9 \
_p11=sy_dls_1p7m0t1f1u*1e-09*_p9 \
_p12=v34+v35*od_+v36*w_+v37*od_*w_+v38*od_*od_+v39*w_*w_+v40*od_/w_+v41*od_*od_/w_/w_+v42/w_jump_+v43/(w_jump_*w_jump_) \
_p13=_p12+v44*(s_-0.446)+v45*(s_-0.446)*od_+v46*(s_-0.446)*w_ \
_p14=sy_drs_1p7m0t1f1u*0.5*(_p13+sqrt(_p13*_p13+0.001)) \
_p15=v47/od_+v48/w_+v49+v50*od_+v51*w_+v52*od_*od_+v53*od_*w_+v54*w_*w_+v55*od_*od_*w_+v56*od_*w_*w_+v57*od_*od_*w_*w_ \
_p16=_p15+v58*(s_-0.446)+v59*(s_-0.446)*od_+v60*(s_-0.446)*w_ \
_p17=0.5*(_p16+sqrt(_p16*_p16+0.001)) \
_p18=sy_dls_1p7m0t1f1u*1e-09*_p17 \
_p19=v61/od_+v62/w_+v63+v64*od_+v65*w_+v66*od_*od_+v67*od_*w_+v68*w_*w_+v69*od_*od_*w_+v70*od_*w_*w_+v71*od_*od_*w_*w_ \
_p20=_p19+v72*(s_-0.446)+v73*(s_-0.446)*od_+v74*(s_-0.446)*w_ \
_p21=0.5*(atan(2*_p20)/1.5708+1) \
_p22=v75+v76*od_+v77*w_+v78*od_*od_+v79*od_*w_+v80*w_*w_ \
_p23=_p22+v81*(s_-0.446)+v82*(s_-0.446)*od_+v83*(s_-0.446)*w_ \
_p24=0.5*(_p23+sqrt(_p23*_p23+0.001)) \
_p25=v84+v85*od_+v86*w_+v87*od_*od_+v88*od_*w_+v89*w_*w_ \
_p26=_p25+v90*(s_-0.446)+v91*(s_-0.446)*od_+v92*(s_-0.446)*w_ \
_p27=0.5*(_p26+sqrt(_p26*_p26+0.001)) \
_p28=v93+v94*od_+v95*w_+v96*od_*od_+v97*od_*w_+v98*w_*w_ \
_p29=_p28+v99*(s_-0.446)+v100*(s_-0.446)*od_+v101*(s_-0.446)*w_ \
_p30=0.5*(_p29+sqrt(_p29*_p29+0.001)) \
_p31=v102+v103*od_+v104*w_+v105*od_*od_+v106*od_*w_+v107*w_*w_ \
_p32=_p31+v108*(s_-0.446)+v109*(s_-0.446)*od_+v110*(s_-0.446)*w_ \
_p33=0.5*(_p32+sqrt(_p32*_p32+0.001)) \
_p34=v111+v112*od_+v113*w_+v114*od_*od_+v115*od_*w_+v116*w_*w_ \
_p35=_p34+v117*(s_-0.446)+v118*(s_-0.446)*od_+v119*(s_-0.446)*w_ \
_p36=0.5*(_p35+sqrt(_p35*_p35+0.001)) \
_p37=v120+v121*od_+v122*w_+v123*od_*od_+v124*od_*w_+v125*w_*w_ \
_p38=_p37+v126*(s_-0.446)+v127*(s_-0.446)*od_+v128*(s_-0.446)*w_ \
_p39=0.5*(_p38+sqrt(_p38*_p38+0.001)) \
_p40=1e-14*_p24 \
_p41=sy_drs_sub_1p7m0t1f1u*100*_p27 \
_p42=1e-15*_p30 \
_p43=1e-14*_p24 \
_p44=sy_drs_sub_1p7m0t1f1u*100*_p27 \
_p45=1e-15*_p30 \
_p46=1e-14*_p33 \
_p47=sy_drs_sub_1p7m0t1f1u*100*_p36 \
_p48=1e-15*_p39 \
_p49=v129+v130*od_+v131*w_+v132*od_*od_+v133*od_*w_+v134*w_*w_ \
_p50=_p49+v135*(s_-0.446)+v136*(s_-0.446)*od_+v137*(s_-0.446)*w_ \
_p51=0.5*(_p50+sqrt(_p50*_p50+0.001)) \
_p52=v138+v139*od_+v140*w_+v141*od_*od_+v142*od_*w_+v143*w_*w_ \
_p53=_p52+v144*(s_-0.446)+v145*(s_-0.446)*od_+v146*(s_-0.446)*w_ \
_p54=0.5*(_p53+sqrt(_p53*_p53+0.001)) \
_p55=sy_drs_sub_1p7m0t1f1u*100*_p51 \
_p56=1e-13*_p54 \
_p57=v147+v148*od_+v149*w_+v150*od_*od_+v151*od_*w_+v152*w_*w_ \
_p58=_p57+v153*(s_-0.446)+v154*(s_-0.446)*od_+v155*(s_-0.446)*w_ \
_p59=0.5*(_p58+sqrt(_p58*_p58+0.001)) \
_p60=v156+v157*od_+v158*w_+v159*od_*od_+v160*od_*w_+v161*w_*w_ \
_p61=_p60+v162*(s_-0.446)+v163*(s_-0.446)*od_+v164*(s_-0.446)*w_ \
_p62=0.5*(_p61+sqrt(_p61*_p61+0.001)) \
_p63=sy_drs_sub_1p7m0t1f1u*100*_p59 \
_p64=1e-13*_p62 \
_p65=sy_drs_sub_1p7m0t1f1u*100*_p59 \
_p66=1e-13*_p62
cs (outer inner) capacitor c=_p3
rs1_1 (outer n1_1) resistor r=_p6
ls1_1 (n1_1 ni_1) inductor l=_p10
rs2_1 (ni_1 n2_1) resistor r=_p6
ls2_1 (n2_1 inner) inductor l=_p11
rs1_2 (outer n1_2) resistor r=_p14
ls1_2 (n1_2 inner) inductor l=_p18
k1 mutual_inductor coupling=_p21 ind1=ls1_1 ind2=ls1_2
k2 mutual_inductor coupling=_p21 ind1=ls2_1 ind2=ls1_2
c_1_sub (outer _n1_1_sub) capacitor c=_p40
rs_1_sub (_n1_1_sub sub) resistor r=_p41
cs_1_sub (_n1_1_sub sub) capacitor c=_p42
c_2_sub (inner _n1_2_sub) capacitor c=_p43
rs_2_sub (_n1_2_sub sub) resistor r=_p44
cs_2_sub (_n1_2_sub sub) capacitor c=_p45
c_3_sub (ni_1 _n1_3_sub) capacitor c=_p46
rs_3_sub (_n1_3_sub sub) resistor r=_p47
cs_3_sub (_n1_3_sub sub) capacitor c=_p48
rx_1_2_sub (_n1_1_sub _n1_2_sub) resistor r=_p55
cx_1_2_sub (_n1_1_sub _n1_2_sub) capacitor c=_p56
rx_1_3_sub (_n1_1_sub _n1_3_sub) resistor r=_p63
cx_1_3_sub (_n1_1_sub _n1_3_sub) capacitor c=_p64
rx_2_3_sub (_n1_2_sub _n1_3_sub) resistor r=_p65
cx_2_3_sub (_n1_2_sub _n1_3_sub) capacitor c=_p66
ends l_sy20k_rfvil_1p7m0t1f1u
