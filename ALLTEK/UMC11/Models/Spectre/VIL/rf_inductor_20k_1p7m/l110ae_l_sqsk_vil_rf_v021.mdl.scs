simulator lang=spectre insensitive=yes
// model: l_sqsk_rfvil_1p7m0t1f1u
// stacked inductor, p sub
// umc 110nm 1p7m rfcmos process
// date: 2011-04-12
// model coverage:(before shrinkage)
// od: (45 - 75) * 1e-06
// w: (2 - 3) * 1e-06
// s: (0.28 - 0.4) * 1e-06
// bm: 1 - 4
// ns: 2 - 4
// nt: 1.5 - 5.5
// frequency range: 100mhz - 0.8 * resonance (maximum 10.0 ghz)
subckt l_sqsk_rfvil_1p7m0t1f1u (top bottom sub)
parameters od=5e-05 od_=od/7.5e-05 w=2e-06 w_=w/3e-06 s=2.8e-07 s_=s/4e-07 bm=1 ns=4 nt=3.5  \
s0=(bm==1)*(ns==2)*(nt==1.5) \
s1=(bm==1)*(ns==2)*(nt==2.5) \
s2=(bm==1)*(ns==2)*(nt==3.5) \
s3=(bm==1)*(ns==2)*(nt==4.5) \
s4=(bm==1)*(ns==2)*(nt==5.5) \
s5=(bm==1)*(ns==4)*(nt==1.5) \
s6=(bm==1)*(ns==4)*(nt==2.5) \
s7=(bm==1)*(ns==4)*(nt==3.5) \
s8=(bm==1)*(ns==4)*(nt==4.5) \
s9=(bm==1)*(ns==4)*(nt==5.5) \
s10=(bm==2)*(ns==2)*(nt==1.5) \
s11=(bm==2)*(ns==2)*(nt==2.5) \
s12=(bm==2)*(ns==2)*(nt==3.5) \
s13=(bm==2)*(ns==2)*(nt==4.5) \
s14=(bm==2)*(ns==2)*(nt==5.5) \
s15=(bm==2)*(ns==3)*(nt==1.5) \
s16=(bm==2)*(ns==3)*(nt==2.5) \
s17=(bm==2)*(ns==3)*(nt==3.5) \
s18=(bm==2)*(ns==3)*(nt==4.5) \
s19=(bm==2)*(ns==3)*(nt==5.5) \
s20=(bm==2)*(ns==4)*(nt==1.5) \
s21=(bm==2)*(ns==4)*(nt==2.5) \
s22=(bm==2)*(ns==4)*(nt==3.5) \
s23=(bm==2)*(ns==4)*(nt==4.5) \
s24=(bm==2)*(ns==4)*(nt==5.5) \
s25=(bm==3)*(ns==2)*(nt==1.5) \
s26=(bm==3)*(ns==2)*(nt==2.5) \
s27=(bm==3)*(ns==2)*(nt==3.5) \
s28=(bm==3)*(ns==2)*(nt==4.5) \
s29=(bm==3)*(ns==2)*(nt==5.5) \
s30=(bm==3)*(ns==3)*(nt==1.5) \
s31=(bm==3)*(ns==3)*(nt==2.5) \
s32=(bm==3)*(ns==3)*(nt==3.5) \
s33=(bm==3)*(ns==3)*(nt==4.5) \
s34=(bm==3)*(ns==3)*(nt==5.5) \
s35=(bm==4)*(ns==2)*(nt==1.5) \
s36=(bm==4)*(ns==2)*(nt==2.5) \
s37=(bm==4)*(ns==2)*(nt==3.5) \
s38=(bm==4)*(ns==2)*(nt==4.5) \
s39=(bm==4)*(ns==2)*(nt==5.5) \
v0_part1=(-1.385131e+01)*s0+4.649310e+00*s1+5.516655e+00*s2+1.852097e+01*s3+2.070581e+01*s4+2.087951e+00*s5+3.767722e+00*s6+1.520077e-01*s7+4.299867e+00*s8+(-1.453089e-01)*s9 \
v0_part2=v0_part1+1.548547e+00*s10+1.967000e+00*s11+8.359594e+00*s12+7.704217e+00*s13+1.607237e+01*s14+(-1.562861e+00)*s15+(-1.013008e+00)*s16+5.088592e+00*s17+9.211439e+00*s18+1.329297e+01*s19 \
v0_part3=v0_part2+(-2.734850e-01)*s20+6.440883e+00*s21+5.276681e+00*s22+7.310168e+00*s23+9.774831e+00*s24+1.342404e+01*s25+1.354726e+00*s26+5.991294e+00*s27+1.052895e+01*s28+2.193139e+01*s29 \
v0=v0_part3+1.000926e+00*s30+(-3.356801e+00)*s31+4.057266e+00*s32+1.472314e+01*s33+1.063956e+01*s34+4.960681e+00*s35+4.525767e+00*s36+5.159577e+00*s37+9.160409e+00*s38+2.420771e+01*s39 \
v1_part1=8.887739e+00*s0+(-3.730027e+00)*s1+(-1.189661e+01)*s2+(-1.249504e+01)*s3+(-1.190958e+01)*s4+(-3.380257e+00)*s5+(-4.311560e+00)*s6+1.861835e+00*s7+2.640422e+00*s8+1.019144e+01*s9 \
v1_part2=v1_part1+(-3.792575e+00)*s10+2.324527e+00*s11+(-3.692572e+00)*s12+9.655669e-01*s13+(-3.356960e+00)*s14+5.041407e+00*s15+2.928307e+00*s16+(-1.559313e+00)*s17+(-4.945971e+00)*s18+(-6.229231e+00)*s19 \
v1_part3=v1_part2+5.082313e+00*s20+(-5.531461e+00)*s21+(-1.273546e+00)*s22+(-1.942527e+00)*s23+(-1.723397e+00)*s24+(-1.269120e+01)*s25+3.387216e+00*s26+1.457610e+00*s27+1.239229e-02*s28+(-1.046951e+01)*s29 \
v1=v1_part3+1.218246e+00*s30+7.135655e+00*s31+1.124932e+00*s32+(-9.613330e+00)*s33+(-1.752680e+00)*s34+(-3.577524e+00)*s35+2.377670e+00*s36+3.423683e+00*s37+3.559447e+00*s38+(-1.160514e+01)*s39 \
v2_part1=8.749984e-01*s0+(-1.615636e+01)*s1+(-2.082595e+00)*s2+(-2.439629e+01)*s3+(-2.993792e+01)*s4+(-6.142956e-01)*s5+(-3.226872e+00)*s6+(-1.450386e+00)*s7+(-7.229795e+00)*s8+(-2.131872e+00)*s9 \
v2_part2=v2_part1+1.927356e-01*s10+(-3.836771e+00)*s11+(-1.364986e+01)*s12+(-1.454806e+01)*s13+(-2.914044e+01)*s14+3.912005e-01*s15+1.577584e+00*s16+(-6.347795e+00)*s17+(-1.309146e+01)*s18+(-2.143121e+01)*s19 \
v2_part3=v2_part2+(-2.492140e+00)*s20+(-6.731257e+00)*s21+(-6.764791e+00)*s22+(-1.195576e+01)*s23+(-1.808098e+01)*s24+(-1.814799e+01)*s25+(-3.896262e+00)*s26+(-1.173893e+01)*s27+(-2.031865e+01)*s28+(-3.878254e+01)*s29 \
v2=v2_part3+(-4.859621e+00)*s30+3.922163e+00*s31+(-6.180062e+00)*s32+(-2.148240e+01)*s33+(-1.995314e+01)*s34+(-7.780458e+00)*s35+(-9.162395e+00)*s36+(-1.199944e+01)*s37+(-1.968997e+01)*s38+(-4.156257e+01)*s39 \
v3_part1=1.732397e+01*s0+4.210413e+01*s1+4.578415e+01*s2+6.455068e+01*s3+7.508402e+01*s4+9.152033e+00*s5+1.927762e+01*s6+2.676744e+01*s7+2.776787e+01*s8+2.343720e+01*s9 \
v3_part2=v3_part1+1.357440e+01*s10+2.317786e+01*s11+4.446391e+01*s12+5.040753e+01*s13+6.886282e+01*s14+9.774109e+00*s15+1.413642e+01*s16+2.913149e+01*s17+4.302019e+01*s18+5.517953e+01*s19 \
v3_part3=v3_part2+5.769621e+00*s20+2.432097e+01*s21+2.762233e+01*s22+3.784957e+01*s23+4.638901e+01*s24+3.235359e+01*s25+2.659194e+01*s26+4.333127e+01*s27+5.887938e+01*s28+8.518593e+01*s29 \
v3=v3_part3+1.348512e+01*s30+1.271236e+01*s31+3.056776e+01*s32+5.432670e+01*s33+5.560368e+01*s34+2.296685e+01*s35+3.111084e+01*s36+4.466302e+01*s37+5.809551e+01*s38+9.348473e+01*s39 \
v4_part1=7.887104e+00*s0+8.950161e-01*s1+(-1.810998e+00)*s2+(-3.655960e+00)*s3+1.196288e+00*s4+9.701333e-02*s5+(-8.794109e-01)*s6+(-1.500352e+00)*s7+(-8.493107e-01)*s8+3.471194e-01*s9 \
v4_part2=v4_part1+(-2.934997e-01)*s10+1.829078e+00*s11+1.708169e-01*s12+1.002512e+00*s13+(-3.838064e-01)*s14+(-3.085964e+00)*s15+2.078218e-01*s16+(-2.398212e-01)*s17+2.356367e-01*s18+1.013322e-01*s19 \
v4_part3=v4_part2+(-9.731228e-01)*s20+(-4.746210e+00)*s21+(-1.130297e-01)*s22+1.918028e-02*s23+5.490854e-02*s24+(-7.599954e-01)*s25+6.761098e-01*s26+(-3.227976e-01)*s27+(-3.628512e-01)*s28+(-2.105398e-01)*s29 \
v4=v4_part3+3.244865e-01*s30+5.811957e-01*s31+1.511098e+00*s32+(-4.021685e-01)*s33+7.683930e-01*s34+1.484279e+01*s35+(-2.146109e-01)*s36+1.143552e+00*s37+(-6.504322e-01)*s38+(-3.878057e+00)*s39 \
v5_part1=(-6.773461e+00)*s0+(-7.653779e+00)*s1+3.086211e+00*s2+3.623971e+00*s3+2.933862e+00*s4+(-6.368155e-01)*s5+8.405592e-01*s6+4.885548e+00*s7+7.195169e-01*s8+3.465813e-02*s9 \
v5_part2=v5_part1+(-2.629298e-01)*s10+(-2.759464e+00)*s11+1.156649e+00*s12+1.812619e+00*s13+3.760711e+00*s14+4.000919e-01*s15+3.396891e-01*s16+1.934655e+00*s17+1.921816e+00*s18+2.889517e+00*s19 \
v5_part3=v5_part2+(-2.044589e+00)*s20+7.435687e+00*s21+1.082099e+00*s22+2.214664e+00*s23+2.172733e+00*s24+(-1.040955e+00)*s25+(-2.973076e-01)*s26+2.042529e+00*s27+2.421367e+00*s28+3.515766e+00*s29 \
v5=v5_part3+6.436573e-01*s30+2.038196e-01*s31+3.891932e-01*s32+2.428734e+00*s33+3.598155e+00*s34+(-1.060766e+01)*s35+1.099860e-01*s36+1.772635e+00*s37+3.448160e+00*s38+1.381791e+01*s39 \
v6_part1=(-3.781383e+00)*s0+5.092000e+00*s1+(-2.009359e+00)*s2+6.662031e-01*s3+(-4.713308e+00)*s4+3.406316e-01*s5+3.290966e-01*s6+(-3.809893e-01)*s7+2.395062e-01*s8+(-1.245707e+00)*s9 \
v6_part2=v6_part1+(-1.850084e-03)*s10+7.840843e-01*s11+(-9.823037e-01)*s12+(-2.657134e+00)*s13+(-3.558353e+00)*s14+3.253939e+00*s15+(-1.172539e-01)*s16+(-1.143055e+00)*s17+(-8.907458e-01)*s18+(-1.852381e+00)*s19 \
v6_part3=v6_part2+3.330732e+00*s20+(-6.448285e-01)*s21+(-2.375254e-01)*s22+(-1.286353e+00)*s23+(-1.278104e+00)*s24+1.046124e+00*s25+(-1.771510e-01)*s26+(-1.067108e+00)*s27+(-1.494224e+00)*s28+(-3.021492e+00)*s29 \
v6=v6_part3+(-1.008745e+00)*s30+(-8.517049e-01)*s31+(-1.525715e+00)*s32+(-9.240131e-01)*s33+(-3.163170e+00)*s34+(-8.515285e+00)*s35+6.225174e-02*s36+(-2.357723e+00)*s37+(-1.943856e+00)*s38+(-6.427854e+00)*s39 \
v7_part1=(-1.793827e+00)*s0+(-8.184488e+00)*s1+8.207195e+03*s2+(-2.396433e+01)*s3+(-1.237389e+02)*s4+(-7.062379e+00)*s5+(-1.478473e+02)*s6+(-2.548547e+02)*s7+(-1.008137e+03)*s8+(-7.043113e+01)*s9 \
v7_part2=v7_part1+5.324620e+01*s10+(-5.849166e+00)*s11+(-1.453688e+02)*s12+(-1.000000e+04)*s13+(-1.871336e+02)*s14+(-5.902518e-01)*s15+(-7.579223e+02)*s16+(-4.586272e+01)*s17+(-5.168068e+01)*s18+(-7.208464e+01)*s19 \
v7_part3=v7_part2+(-1.504008e+01)*s20+1.366650e+03*s21+(-3.509773e+01)*s22+(-2.950664e+01)*s23+(-5.658506e+02)*s24+(-1.944875e+00)*s25+(-6.654736e+01)*s26+(-1.306765e+01)*s27+(-6.775657e+01)*s28+(-1.421084e+02)*s29 \
v7=v7_part3+(-2.833019e+00)*s30+(-1.360540e+02)*s31+(-2.036205e+01)*s32+(-3.436941e+01)*s33+(-9.446793e+00)*s34+(-6.298213e-01)*s35+(-6.654508e+00)*s36+(-7.143521e+01)*s37+(-1.420217e+01)*s38+(-1.250136e+02)*s39 \
v8_part1=(-7.208723e+00)*s0+(-2.384583e-01)*s1+8.429200e+03*s2+6.665794e+00*s3+3.940129e+01*s4+(-2.339922e+01)*s5+(-1.905837e+01)*s6+9.077559e+02*s7+8.370073e+01*s8+6.453895e+01*s9 \
v8_part2=v8_part1+3.413380e+01*s10+(-1.004570e+01)*s11+(-2.094652e+02)*s12+(-1.000000e+04)*s13+1.609991e+02*s14+(-6.870192e+00)*s15+(-1.606326e+03)*s16+(-3.218232e+01)*s17+(-2.182022e+02)*s18+(-2.110785e+02)*s19 \
v8_part3=v8_part2+1.521840e+02*s20+4.985778e+03*s21+(-4.465684e+01)*s22+(-1.084254e+02)*s23+(-1.201269e+03)*s24+(-7.362987e+00)*s25+3.317237e+02*s26+(-4.263079e+00)*s27+(-1.218879e+02)*s28+(-7.106991e+01)*s29 \
v8=v8_part3+(-1.364880e+01)*s30+(-3.803796e+02)*s31+(-1.393832e+01)*s32+(-3.992665e+01)*s33+2.841409e+02*s34+(-7.449644e+00)*s35+(-7.552278e+00)*s36+(-1.000713e+02)*s37+(-1.853858e+00)*s38+2.696751e+02*s39 \
v9_part1=(-1.621835e+00)*s0+(-8.083874e-01)*s1+8.878172e+03*s2+(-3.968124e+00)*s3+2.812742e+01*s4+1.404290e+00*s5+2.480507e+00*s6+6.569127e+01*s7+4.550135e+02*s8+(-2.791872e+01)*s9 \
v9_part2=v9_part1+4.735052e+01*s10+(-1.765914e+00)*s11+6.302009e+01*s12+(-1.000000e+04)*s13+6.286563e+01*s14+(-1.034343e+00)*s15+5.162465e+02*s16+2.461426e+01*s17+1.222097e+01*s18+1.249204e+01*s19 \
v9_part3=v9_part2+1.323963e+02*s20+(-4.094065e+03)*s21+4.030415e+00*s22+(-4.241171e+01)*s23+1.362042e+02*s24+(-5.771192e-01)*s25+(-1.898667e+01)*s26+(-1.242151e+00)*s27+1.650564e+01*s28+1.002405e+02*s29 \
v9=v9_part3+(-1.465421e+00)*s30+5.443383e+01*s31+(-2.271532e+00)*s32+(-1.114123e+00)*s33+(-1.160702e+02)*s34+(-2.046374e+00)*s35+(-1.005505e+00)*s36+(-6.701511e+01)*s37+(-1.534068e+01)*s38+2.812572e+02*s39 \
v10_part1=4.470010e+00*s0+(-4.407451e-02)*s1+9.405636e+03*s2+(-8.537193e-01)*s3+(-9.127516e+00)*s4+1.441730e+01*s5+7.853380e+00*s6+(-4.835517e+02)*s7+(-4.543437e+02)*s8+2.966725e+01*s9 \
v10_part2=v10_part1+2.068644e+02*s10+5.825865e+00*s11+(-7.317553e+00)*s12+(-1.000000e+04)*s13+(-1.237982e+02)*s14+4.015647e+00*s15+3.226599e+02*s16+(-1.887738e+01)*s17+6.266922e+01*s18+6.580583e+01*s19 \
v10_part3=v10_part2+(-1.300848e+02)*s20+1.279070e+02*s21+2.508308e+01*s22+9.531625e-01*s23+5.905693e+02*s24+3.581053e+00*s25+(-1.730056e+02)*s26+2.316856e+00*s27+4.782476e+01*s28+(-2.978038e+01)*s29 \
v10=v10_part3+7.582270e+00*s30+2.146121e+02*s31+1.562300e+01*s32+1.268247e+01*s33+(-3.398027e+01)*s34+4.510069e+00*s35+4.051643e+00*s36+1.696622e+02*s37+4.441275e+00*s38+(-1.066666e+02)*s39 \
v11_part1=4.907154e+01*s0+7.784777e+01*s1+9.988722e+03*s2+1.448199e+02*s3+2.894406e+02*s4+1.140948e+02*s5+6.094355e+02*s6+3.418202e+02*s7+1.993335e+03*s8+3.007793e+02*s9 \
v11_part2=v11_part1+1.546997e+02*s10+7.217242e+01*s11+5.710812e+02*s12+(-1.000000e+04)*s13+3.735944e+02*s14+6.691860e+01*s15+2.270240e+03*s16+2.613537e+02*s17+4.208650e+02*s18+4.308102e+02*s19 \
v11_part3=v11_part2+7.963023e+02*s20+8.007220e+03*s21+2.583090e+02*s22+5.116690e+02*s23+1.915751e+03*s24+4.458756e+01*s25+2.669377e+02*s26+9.395374e+01*s27+2.937125e+02*s28+3.024136e+02*s29 \
v11=v11_part3+6.789221e+01*s30+5.729331e+02*s31+1.666497e+02*s32+2.184671e+02*s33+3.485589e+02*s34+4.389661e+01*s35+7.139957e+01*s36+4.002444e+02*s37+1.948689e+02*s38+3.448133e+02*s39 \
v12_part1=(-3.486444e-01)*s0+(-2.337247e+00)*s1+(-2.063227e+01)*s2+(-8.997615e+00)*s3+(-5.297829e-01)*s4+(-7.644578e-01)*s5+(-2.182806e+00)*s6+(-3.703114e+00)*s7+(-2.419449e+00)*s8+(-2.267029e+01)*s9 \
v12_part2=v12_part1+(-1.841552e+00)*s10+(-1.281846e+00)*s11+(-7.047313e+00)*s12+(-1.000000e+04)*s13+(-1.450493e+01)*s14+(-8.616495e-01)*s15+(-5.610322e+00)*s16+2.566630e+01*s17+(-1.209150e+01)*s18+(-2.207436e+01)*s19 \
v12_part3=v12_part2+1.390515e+00*s20+(-8.910528e+03)*s21+(-9.103319e+00)*s22+(-1.976603e+00)*s23+3.987991e+02*s24+(-2.088714e-01)*s25+(-2.867674e+01)*s26+(-2.975228e+00)*s27+(-7.843354e-01)*s28+(-1.687318e+01)*s29 \
v12=v12_part3+(-4.472811e-01)*s30+1.363767e+01*s31+(-5.980353e+00)*s32+(-7.727166e+00)*s33+(-6.257292e+01)*s34+(-4.863470e-01)*s35+(-1.119158e+00)*s36+(-6.537978e-01)*s37+(-1.548868e+01)*s38+(-3.642185e+01)*s39 \
v13_part1=2.413429e-04*s0+5.352014e-01*s1+(-1.548497e+01)*s2+2.748884e+00*s3+(-1.784744e+00)*s4+4.994439e-02*s5+(-3.300410e-01)*s6+(-2.783924e+00)*s7+4.550917e+01*s8+1.955132e+00*s9 \
v13_part2=v13_part1+(-1.485346e+00)*s10+(-1.589168e-01)*s11+(-9.213250e-01)*s12+(-1.000000e+04)*s13+(-1.819649e+00)*s14+4.747986e-01*s15+(-1.634673e-02)*s16+9.800067e+00*s17+(-1.922553e-01)*s18+(-6.189640e+00)*s19 \
v13_part3=v13_part2+3.878788e-02*s20+(-9.854023e+03)*s21+1.979135e+00*s22+(-1.466069e+00)*s23+(-4.394179e+02)*s24+(-7.078588e-02)*s25+(-5.392572e+01)*s26+1.053859e-01*s27+(-1.930188e+00)*s28+6.132274e+00*s29 \
v13=v13_part3+1.580643e-02*s30+(-6.229984e+01)*s31+6.050283e-01*s32+5.271233e-01*s33+6.649122e+01*s34+1.034447e-01*s35+(-1.125251e-01)*s36+(-9.861978e+00)*s37+4.188977e-01*s38+2.250962e+01*s39 \
v14_part1=1.829492e-01*s0+1.363044e+00*s1+(-2.625724e+01)*s2+2.286700e+00*s3+(-3.367219e-01)*s4+1.811063e+00*s5+9.020440e+00*s6+9.447214e-01*s7+(-1.151262e+01)*s8+1.064095e+01*s9 \
v14_part2=v14_part1+(-5.439843e+00)*s10+7.847860e-01*s11+1.226548e+01*s12+(-8.760802e+03)*s13+4.402262e+00*s14+1.576809e-01*s15+(-5.659216e+00)*s16+(-3.905015e+01)*s17+6.374595e+00*s18+1.820535e+01*s19 \
v14_part3=v14_part2+(-2.031943e+01)*s20+1.000000e+04*s21+4.543141e-01*s22+4.819302e+00*s23+(-1.860494e+02)*s24+1.125011e-01*s25+5.251646e+01*s26+1.707575e+00*s27+5.436493e+00*s28+1.096358e+01*s29 \
v14=v14_part3+2.439116e-01*s30+(-5.364887e+00)*s31+2.556762e+00*s32+3.345828e+00*s33+(-1.782274e+01)*s34+2.577316e-01*s35+5.926321e-01*s36+9.990183e+00*s37+1.127849e+01*s38+(-2.288284e+01)*s39 \
v15_part1=(-3.656025e-01)*s0+(-9.424412e-01)*s1+7.696819e+02*s2+(-3.457406e+00)*s3+(-3.592081e+00)*s4+(-3.233848e-01)*s5+1.754975e+00*s6+(-1.787951e+01)*s7+(-8.061742e+01)*s8+(-1.491472e+01)*s9 \
v15_part2=v15_part1+1.849976e-02*s10+(-1.078300e+00)*s11+1.876007e+00*s12+1.000000e+04*s13+4.625779e-01*s14+(-8.504644e-01)*s15+2.591506e+01*s16+(-1.191060e+00)*s17+2.659780e+00*s18+(-6.501511e+00)*s19 \
v15_part3=v15_part2+1.468020e+01*s20+4.581879e+02*s21+(-4.826618e+00)*s22+2.244429e+00*s23+2.532900e+01*s24+(-3.806229e-01)*s25+(-2.777625e+00)*s26+(-1.557357e+00)*s27+(-3.025074e+00)*s28+(-4.538158e-01)*s29 \
v15=v15_part3+(-8.112273e-01)*s30+(-7.172962e+00)*s31+(-4.729138e+00)*s32+(-9.154246e+00)*s33+(-2.186028e+01)*s34+(-3.773472e-01)*s35+(-1.083695e+00)*s36+1.965619e+00*s37+(-1.343717e+00)*s38+(-3.928564e+01)*s39 \
v16_part1=2.275400e+00*s0+5.554796e+00*s1+(-6.705404e+02)*s2+1.626239e+01*s3+2.150869e+01*s4+6.874995e+00*s5+3.073245e+01*s6+6.972961e+01*s7+2.686254e+02*s8+7.927732e+01*s9 \
v16_part2=v16_part1+5.055204e+00*s10+5.829905e+00*s11+1.177133e+01*s12+1.000000e+04*s13+2.166572e+01*s14+4.936025e+00*s15+(-5.802828e+00)*s16+2.119692e+01*s17+2.384824e+01*s18+4.384930e+01*s19 \
v16_part3=v16_part2+5.558251e+01*s20+(-4.026904e+02)*s21+3.503544e+01*s22+4.731449e+01*s23+5.937266e+01*s24+2.289351e+00*s25+1.133303e+01*s26+1.326429e+01*s27+1.861347e+01*s28+1.660609e+01*s29 \
v16=v16_part3+4.822605e+00*s30+2.298490e+01*s31+2.303812e+01*s32+3.845424e+01*s33+7.811035e+01*s34+2.289381e+00*s35+5.829619e+00*s36+8.999695e+00*s37+1.539002e+01*s38+8.000885e+01*s39 \
v17_part1=(-6.941131e-02)*s0+(-3.550215e-01)*s1+(-1.337131e+03)*s2+(-6.293222e-01)*s3+(-2.367523e+00)*s4+(-1.477839e+00)*s5+(-1.118640e+01)*s6+2.581993e+00*s7+3.936942e+01*s8+(-1.047793e+01)*s9 \
v17_part2=v17_part1+2.419026e+00*s10+(-1.994174e-01)*s11+(-6.712330e+00)*s12+1.000000e+04*s13+(-1.102968e+01)*s14+(-1.418996e-01)*s15+(-3.281843e+01)*s16+(-5.121551e+00)*s17+(-1.267605e+01)*s18+(-6.752987e+00)*s19 \
v17_part3=v17_part2+(-2.823538e+01)*s20+(-4.637338e+01)*s21+(-5.194451e+00)*s22+(-2.083259e+01)*s23+(-7.047193e+01)*s24+(-5.614993e-02)*s25+6.707079e-01*s26+(-2.658151e+00)*s27+(-1.980093e+00)*s28+(-6.374110e+00)*s29 \
v17=v17_part3+(-2.048912e-01)*s30+4.597112e+00*s31+(-9.537203e-01)*s32+4.141775e-02*s33+9.292554e-01*s34+(-5.669726e-02)*s35+(-1.992064e-01)*s36+(-5.870928e+00)*s37+(-3.871434e+00)*s38+3.802112e+01*s39 \
v18_part1=(-4.781994e-01)*s0+(-1.079056e+00)*s1+1.252815e+03*s2+(-4.774850e+00)*s3+(-4.880503e+00)*s4+4.933314e-01*s5+5.370564e+00*s6+(-1.551819e+01)*s7+(-1.376708e+02)*s8+(-1.682843e+01)*s9 \
v18_part2=v18_part1+(-3.435829e+00)*s10+(-1.436113e+00)*s11+4.126764e+00*s12+1.000000e+04*s13+4.205241e+00*s14+(-9.140825e-01)*s15+4.118893e+01*s16+(-8.728833e-01)*s17+5.254182e+00*s18+(-8.937151e+00)*s19 \
v18_part3=v18_part2+4.909780e+00*s20+2.101293e+01*s21+(-3.471577e+00)*s22+6.970354e+00*s23+5.605425e+01*s24+(-4.871951e-01)*s25+7.319196e-01*s26+1.408626e+00*s27+(-4.155108e+00)*s28+8.336795e-01*s29 \
v18=v18_part3+(-8.905347e-01)*s30+(-7.766529e+00)*s31+(-5.250558e+00)*s32+(-1.369221e+01)*s33+(-2.175552e+01)*s34+(-4.890293e-01)*s35+(-1.427779e+00)*s36+6.634951e+00*s37+(-4.082696e-01)*s38+(-6.108160e+01)*s39 \
v19_part1=(-2.207972e-02)*s0+(-1.054007e-01)*s1+(-1.323831e+00)*s2+(-5.853615e-01)*s3+(-5.551729e-01)*s4+(-1.341508e-01)*s5+(-2.035470e+00)*s6+1.731194e-01*s7+(-1.154679e+01)*s8+(-3.088678e+00)*s9 \
v19_part2=v19_part1+6.968077e-02*s10+(-1.109013e-01)*s11+7.066072e-01*s12+1.495367e+02*s13+(-1.013140e+00)*s14+(-6.683531e-02)*s15+5.870740e-01*s16+(-1.664837e+00)*s17+(-2.195708e+00)*s18+(-6.771734e-01)*s19 \
v19_part3=v19_part2+1.245754e-01*s20+(-7.596797e+01)*s21+(-4.701945e-01)*s22+(-2.816374e-01)*s23+1.882207e+01*s24+(-2.335653e-02)*s25+1.238710e-01*s26+(-1.944529e-01)*s27+(-7.638828e-01)*s28+(-1.403941e+00)*s29 \
v19=v19_part3+(-3.745457e-02)*s30+(-3.994613e+00)*s31+(-4.466574e-01)*s32+(-8.154427e-01)*s33+(-3.029768e+00)*s34+(-3.441014e-03)*s35+(-9.809844e-02)*s36+(-2.610412e+00)*s37+8.228206e-01*s38+5.811160e-01*s39 \
v20_part1=(-3.565913e-02)*s0+(-1.011634e-01)*s1+(-8.868758e+00)*s2+(-3.955452e-01)*s3+(-2.582781e+00)*s4+(-1.309487e-01)*s5+(-6.295114e-02)*s6+(-1.686837e+00)*s7+9.497788e-01*s8+(-3.705344e+00)*s9 \
v20_part2=v20_part1+1.060564e-01*s10+(-1.322845e-01)*s11+(-1.246763e+00)*s12+1.000000e+04*s13+(-3.010391e+00)*s14+(-6.037096e-02)*s15+(-4.232213e+00)*s16+6.316550e-02*s17+(-3.013498e-01)*s18+(-3.549753e+00)*s19 \
v20_part3=v20_part2+2.764829e+00*s20+3.242232e+01*s21+(-5.958348e-01)*s22+(-8.699181e-01)*s23+(-5.989618e+01)*s24+(-3.441144e-02)*s25+(-1.434959e+00)*s26+(-4.871459e-01)*s27+1.707781e-01*s28+(-1.679598e+00)*s29 \
v20=v20_part3+(-6.534214e-02)*s30+5.234606e+00*s31+(-3.102924e-01)*s32+(-1.625219e+00)*s33+(-8.799951e+00)*s34+(-5.916601e-02)*s35+(-1.431526e-01)*s36+2.242522e+00*s37+(-2.237971e+00)*s38+(-2.485274e+01)*s39 \
v21_part1=2.349009e-02*s0+7.930470e-02*s1+1.252499e+01*s2+5.103026e-01*s3+1.505895e+00*s4+1.602346e-01*s5+(-2.671440e-02)*s6+(-9.638414e-01)*s7+1.429640e+00*s8+3.288860e+00*s9 \
v21_part2=v21_part1+(-2.194717e-01)*s10+1.041507e-01*s11+(-1.764005e-01)*s12+4.715813e+03*s13+2.740546e+00*s14+7.467038e-02*s15+1.949648e+00*s16+1.029380e+00*s17+1.224557e+00*s18+1.568353e+00*s19 \
v21_part3=v21_part2+1.465894e+00*s20+2.733923e+01*s21+(-3.590387e-02)*s22+(-1.755207e+00)*s23+1.738766e+01*s24+2.434812e-02*s25+(-6.816341e-02)*s26+1.036516e-01*s27+1.424459e-01*s28+1.819951e+00*s29 \
v21=v21_part3+3.297618e-02*s30+1.197049e+00*s31+1.871691e-01*s32+1.111543e+00*s33+4.523942e+00*s34+2.475599e-02*s35+1.013436e-01*s36+(-4.290674e-01)*s37+1.331214e-01*s38+2.460562e+01*s39 \
v22_part1=1.193186e+03*s0+(-1.013179e+02)*s1+(-2.023689e+01)*s2+(-1.266968e+03)*s3+(-1.500971e+01)*s4+(-3.090760e+01)*s5+(-1.970034e+01)*s6+(-1.707332e+01)*s7+(-5.670069e+01)*s8+(-1.744347e+03)*s9 \
v22_part2=v22_part1+(-3.886604e+00)*s10+9.999983e+03*s11+(-1.448972e+01)*s12+(-2.316805e+01)*s13+(-3.959149e+01)*s14+(-4.628412e+02)*s15+(-6.110798e+00)*s16+(-2.388680e+01)*s17+(-6.396404e+01)*s18+(-8.873159e+01)*s19 \
v22_part3=v22_part2+(-2.583277e+00)*s20+(-1.638838e+01)*s21+(-2.473991e+02)*s22+(-1.602685e+02)*s23+(-8.792113e+01)*s24+4.820496e+02*s25+(-6.874229e+00)*s26+(-1.000000e+04)*s27+(-3.609669e+01)*s28+2.129876e+02*s29 \
v22=v22_part3+1.000000e+04*s30+2.505625e+00*s31+(-4.631389e+02)*s32+(-9.881358e+02)*s33+(-1.533171e+02)*s34+(-7.545097e+01)*s35+7.435517e+03*s36+(-1.577527e+01)*s37+(-1.238189e+02)*s38+(-8.656696e+01)*s39 \
v23_part1=4.712188e+03*s0+1.542458e+03*s1+3.844722e+00*s2+8.381649e+02*s3+5.843679e+01*s4+(-5.209706e+01)*s5+(-1.116910e+01)*s6+(-1.745980e+02)*s7+5.045682e+00*s8+(-7.076601e+03)*s9 \
v23_part2=v23_part1+(-2.574011e+01)*s10+6.773354e+03*s11+(-1.252561e+01)*s12+3.658728e+00*s13+(-2.155645e+01)*s14+(-2.121526e+03)*s15+(-5.373119e+00)*s16+3.369543e+00*s17+2.599541e+02*s18+6.050091e+02*s19 \
v23_part3=v23_part2+(-2.518142e+01)*s20+(-1.205039e+01)*s21+4.719683e+02*s22+(-3.340975e+01)*s23+1.671535e+02*s24+(-2.327390e+02)*s25+(-2.701041e+01)*s26+(-1.000000e+04)*s27+2.085742e+02*s28+4.297273e+02*s29 \
v23=v23_part3+(-1.000000e+04)*s30+4.671996e+01*s31+(-2.988768e+01)*s32+3.121558e+03*s33+(-7.627196e+01)*s34+1.723805e+03*s35+4.541025e+03*s36+2.332084e+00*s37+4.952515e+01*s38+(-3.471561e+01)*s39 \
v24_part1=1.185108e+02*s0+(-1.184476e+03)*s1+2.357693e+00*s2+7.711478e+02*s3+(-4.374543e+01)*s4+(-4.274847e+01)*s5+1.040106e+01*s6+(-1.739811e+01)*s7+8.782152e+00*s8+1.257705e+03*s9 \
v24_part2=v24_part1+3.769014e-01*s10+9.999965e+03*s11+(-8.192808e-01)*s12+(-6.063111e-01)*s13+(-7.958855e+00)*s14+1.904872e+02*s15+(-3.095014e+00)*s16+(-7.550791e+01)*s17+(-9.505546e+01)*s18+(-2.407597e+02)*s19 \
v24_part3=v24_part2+(-5.008466e+00)*s20+(-2.084418e-01)*s21+1.594262e+01*s22+7.097573e+00*s23+4.066298e+00*s24+3.276389e+02*s25+(-4.816583e-01)*s26+(-1.000000e+04)*s27+(-8.991222e+00)*s28+(-3.868778e+02)*s29 \
v24=v24_part3+1.000000e+04*s30+(-1.131595e+01)*s31+2.383853e+02*s32+(-1.833195e+02)*s33+5.801636e+01*s34+1.560052e+02*s35+8.371556e+02*s36+5.497885e+00*s37+4.240020e+01*s38+3.234565e+01*s39 \
v25_part1=4.221115e+03*s0+(-1.431871e+02)*s1+(-3.702116e+00)*s2+(-9.769355e+02)*s3+(-6.368030e+01)*s4+(-8.934450e+00)*s5+(-1.144468e+00)*s6+9.534033e+01*s7+(-6.112351e-01)*s8+2.192311e+03*s9 \
v25_part2=v25_part1+1.090451e+01*s10+2.987626e+02*s11+1.909881e+01*s12+(-2.055745e+00)*s13+1.528116e+01*s14+9.201299e+02*s15+7.942774e+00*s16+9.715354e+01*s17+4.564217e+01*s18+9.664632e+01*s19 \
v25_part3=v25_part2+1.541208e+01*s20+5.907320e+00*s21+(-3.039240e+02)*s22+1.471280e+02*s23+(-9.419042e+01)*s24+1.968334e+03*s25+1.443516e+01*s26+(-1.000000e+04)*s27+(-9.393573e+01)*s28+3.695717e+01*s29 \
v25=v25_part3+(-3.429982e+03)*s30+(-2.739919e+01)*s31+(-2.862410e+02)*s32+(-2.923849e+02)*s33+(-7.773125e+00)*s34+2.600773e+03*s35+1.615764e+03*s36+(-1.453362e+01)*s37+(-4.477689e+01)*s38+(-1.006955e+01)*s39 \
v26_part1=4.583863e+03*s0+4.420060e+03*s1+1.076393e+02*s2+1.610514e+03*s3+3.491077e+02*s4+5.525030e+02*s5+1.978175e+02*s6+3.518931e+02*s7+2.968165e+02*s8+6.552845e+03*s9 \
v26_part2=v26_part1+5.987627e+01*s10+9.831718e+03*s11+1.213118e+02*s12+1.163371e+02*s13+2.360933e+02*s14+2.179343e+03*s15+1.094891e+02*s16+3.264786e+02*s17+2.651345e+02*s18+2.865114e+02*s19 \
v26_part3=v26_part2+1.000138e+02*s20+1.439025e+02*s21+7.390152e+02*s22+5.011477e+02*s23+3.093435e+02*s24+5.906889e+03*s25+9.294804e+01*s26+(-1.000000e+04)*s27+1.571006e+02*s28+7.406563e+01*s29 \
v26=v26_part3+4.363357e+03*s30+1.137427e+02*s31+1.208513e+03*s32+5.159759e+02*s33+4.392394e+02*s34+7.358041e+03*s35+1.509466e+02*s36+1.267804e+02*s37+3.037396e+02*s38+2.318735e+02*s39 \
v27_part1=8.131578e+00*s0+(-3.959603e+01)*s1+(-3.119778e+00)*s2+1.377026e+01*s3+(-6.964759e+01)*s4+(-1.808788e+01)*s5+(-5.456856e+00)*s6+(-1.461018e+01)*s7+(-1.685613e+01)*s8+(-6.948154e+00)*s9 \
v27_part2=v27_part1+(-2.948474e-01)*s10+(-7.676231e-01)*s11+(-3.840930e+00)*s12+(-5.226011e+00)*s13+(-1.633772e+01)*s14+4.507245e+00*s15+(-2.402919e+00)*s16+(-8.453600e+01)*s17+(-2.364693e+01)*s18+(-4.177301e+01)*s19 \
v27_part3=v27_part2+(-5.914084e-01)*s20+7.380414e-01*s21+(-4.876115e+00)*s22+(-2.120636e+01)*s23+(-8.752243e+01)*s24+8.497319e+00*s25+(-5.662187e-01)*s26+(-5.726711e+02)*s27+(-2.281493e+01)*s28+(-2.648982e+00)*s29 \
v27=v27_part3+2.232181e+00*s30+(-5.895894e+00)*s31+(-7.501973e+00)*s32+(-6.400226e+00)*s33+(-1.161137e+01)*s34+(-6.267070e+01)*s35+5.138966e+00*s36+(-5.847246e+00)*s37+(-3.469456e+00)*s38+(-9.082924e+00)*s39 \
v28_part1=1.237510e+01*s0+(-5.376112e+00)*s1+(-2.552397e-01)*s2+(-2.103311e+00)*s3+1.058282e+01*s4+(-5.988648e+00)*s5+1.404029e+00*s6+2.136570e+00*s7+6.408037e-02*s8+(-1.029685e+00)*s9 \
v28_part2=v28_part1+5.705425e-02*s10+(-2.445532e+00)*s11+5.503482e-01*s12+9.693294e-01*s13+2.299187e+00*s14+(-6.865283e-01)*s15+(-1.753532e-01)*s16+(-2.517135e+01)*s17+1.178229e-01*s18+4.209061e+01*s19 \
v28_part3=v28_part2+(-6.005334e-02)*s20+(-2.210290e+00)*s21+3.378347e+00*s22+(-8.324843e+00)*s23+4.920620e+01*s24+4.464580e+00*s25+2.333847e+00*s26+(-1.054384e+03)*s27+7.534984e+00*s28+(-3.360776e+01)*s29 \
v28=v28_part3+(-2.213830e+00)*s30+9.480670e+00*s31+1.069545e+00*s32+(-1.216419e+01)*s33+(-1.348350e+01)*s34+(-7.364075e+01)*s35+8.838480e+00*s36+1.799204e+00*s37+4.819837e-01*s38+6.717750e-01*s39 \
v29_part1=1.012221e+01*s0+(-7.673931e+00)*s1+1.844261e+00*s2+6.036685e+01*s3+4.266895e+01*s4+(-3.441571e+00)*s5+7.255169e-01*s6+8.558549e+00*s7+7.669554e+00*s8+(-4.397652e+00)*s9 \
v29_part2=v29_part1+1.394445e-01*s10+(-5.067087e-01)*s11+7.913411e-02*s12+2.596589e+00*s13+1.072832e+01*s14+5.610629e+00*s15+1.783730e+00*s16+1.050997e+02*s17+1.633286e+01*s18+1.428265e+00*s19 \
v29_part3=v29_part2+4.091863e-01*s20+1.166914e+00*s21+2.746861e+01*s22+7.479345e-01*s23+5.364346e+01*s24+1.409980e+00*s25+(-1.209599e+00)*s26+(-1.090237e+02)*s27+(-1.797490e+00)*s28+(-2.214290e-01)*s29 \
v29=v29_part3+5.525282e+00*s30+5.030381e+00*s31+1.097174e+01*s32+(-2.278886e+01)*s33+1.835634e+01*s34+(-6.023443e+01)*s35+4.470843e+00*s36+2.304592e+00*s37+(-2.135772e+00)*s38+5.396099e+00*s39 \
v30_part1=1.480293e+02*s0+2.636689e+02*s1+(-1.957233e+00)*s2+4.606526e+01*s3+(-6.793140e+00)*s4+(-6.349307e+00)*s5+(-3.926420e+00)*s6+(-9.041486e-02)*s7+(-7.219215e+00)*s8+(-2.517621e+01)*s9 \
v30_part2=v30_part1+(-2.530059e-01)*s10+(-2.878073e+01)*s11+(-1.888320e+00)*s12+(-3.689853e+00)*s13+(-5.809660e+00)*s14+8.466591e+00*s15+(-1.967249e+00)*s16+(-7.410583e+00)*s17+(-1.549101e+01)*s18+(-1.846774e+01)*s19 \
v30_part3=v30_part2+(-1.619625e+00)*s20+(-4.466867e+00)*s21+(-3.199510e+00)*s22+(-2.041778e+01)*s23+(-2.095767e+01)*s24+2.831569e+02*s25+(-4.331330e-01)*s26+1.000000e+04*s27+(-2.498244e+00)*s28+(-1.455308e+01)*s29 \
v30=v30_part3+6.753664e+02*s30+5.528143e-01*s31+8.388055e+00*s32+(-2.136298e+01)*s33+(-3.649531e+00)*s34+3.317449e+02*s35+2.511653e+02*s36+(-1.775930e+00)*s37+(-5.486939e+00)*s38+(-3.095312e+00)*s39 \
v31_part1=8.578109e+02*s0+(-3.883104e+01)*s1+1.037221e+01*s2+(-3.560350e+01)*s3+3.331699e+01*s4+2.031382e+01*s5+2.262629e+01*s6+3.041715e+01*s7+5.403797e+01*s8+1.822701e+02*s9 \
v31_part2=v31_part1+2.057780e+00*s10+1.831814e+02*s11+1.016853e+01*s12+2.390614e+01*s13+2.461087e+01*s14+2.139440e-01*s15+1.162600e+01*s16+3.216109e+01*s17+5.220801e+01*s18+7.535574e+01*s19 \
v31_part3=v31_part2+9.009532e+00*s20+2.190794e+01*s21+5.918554e+01*s22+8.172087e+01*s23+8.904500e+01*s24+5.439193e+02*s25+5.153027e+00*s26+1.000000e+04*s27+1.800547e+01*s28+4.318090e+01*s29 \
v31=v31_part3+(-5.787421e+01)*s30+8.903399e+00*s31+3.918457e+01*s32+2.199445e+02*s33+3.957467e+01*s34+(-1.222735e+02)*s35+2.460476e+03*s36+1.057847e+01*s37+2.363202e+01*s38+1.916496e+01*s39 \
v32_part1=7.991793e+02*s0+(-1.518428e+02)*s1+(-6.728913e-01)*s2+(-6.509990e+01)*s3+(-4.948430e+00)*s4+5.504254e+00*s5+(-1.456889e+00)*s6+(-1.078159e+01)*s7+(-1.191372e+01)*s8+(-3.423145e+01)*s9 \
v32_part2=v32_part1+(-1.227241e-01)*s10+2.567263e+03*s11+(-7.257331e-01)*s12+(-3.876622e+00)*s13+(-5.090452e-01)*s14+(-1.078092e+01)*s15+(-8.871244e-01)*s16+(-1.463521e+00)*s17+1.802355e+00*s18+(-5.614361e+00)*s19 \
v32_part3=v32_part2+(-5.832977e-02)*s20+(-2.972769e-01)*s21+(-1.471947e+01)*s22+(-2.326732e+00)*s23+(-4.148568e+00)*s24+(-1.514656e+02)*s25+(-8.648995e-01)*s26+1.000000e+04*s27+(-3.896210e+00)*s28+6.000411e+00*s29 \
v32=v32_part3+(-3.018811e+03)*s30+(-3.981433e+00)*s31+(-2.548276e+01)*s32+(-5.629708e+00)*s33+(-1.067255e+01)*s34+4.885178e+01*s35+8.742501e+01*s36+(-9.900975e-01)*s37+(-3.728617e-01)*s38+(-2.751282e+00)*s39 \
v33_part1=4.290702e+02*s0+8.412793e+00*s1+(-2.587662e+00)*s2+9.101442e+01*s3+(-4.874627e+00)*s4+(-6.200408e+00)*s5+(-2.910119e+00)*s6+3.641876e+00*s7+(-2.961148e+00)*s8+(-1.167319e+01)*s9 \
v33_part2=v33_part1+(-3.209701e-01)*s10+(-2.665710e+03)*s11+(-1.493049e+00)*s12+(-1.168358e+00)*s13+(-6.945417e+00)*s14+2.069120e+01*s15+(-1.657949e+00)*s16+(-3.441777e+00)*s17+(-1.270834e+01)*s18+(-1.164039e+01)*s19 \
v33_part3=v33_part2+(-2.067474e+00)*s20+(-5.548985e+00)*s21+3.674053e+00*s22+(-1.756207e+01)*s23+(-2.415856e+01)*s24+(-8.193895e+01)*s25+(-4.171832e-01)*s26+1.000000e+04*s27+3.659562e-01*s28+(-1.866103e+01)*s29 \
v33=v33_part3+3.039373e+03*s30+2.647416e+00*s31+1.623801e+01*s32+(-1.104132e+02)*s33+(-2.550893e+00)*s34+(-2.160443e+02)*s35+2.650336e+02*s36+(-1.945008e+00)*s37+(-6.493604e+00)*s38+(-4.248782e+00)*s39 \
v34_part1=(-1.415064e+01)*s0+(-2.831747e+00)*s1+(-1.678401e-01)*s2+7.472365e+00*s3+(-4.086945e-01)*s4+2.443504e+00*s5+1.830458e-01*s6+(-1.106239e+00)*s7+(-5.913584e-01)*s8+5.523597e+00*s9 \
v34_part2=v34_part1+(-2.275050e-02)*s10+2.242665e-01*s11+(-1.950973e-01)*s12+(-4.293353e-01)*s13+2.239788e-02*s14+3.492064e+00*s15+(-1.025141e-01)*s16+2.301092e+00*s17+6.555997e-01*s18+(-3.759392e-01)*s19 \
v34_part3=v34_part2+(-2.324438e-01)*s20+(-3.268671e-01)*s21+(-1.027830e+00)*s22+(-2.209591e+00)*s23+(-6.960189e+00)*s24+(-5.269790e+00)*s25+(-8.289477e-02)*s26+1.303006e+03*s27+3.881453e-01*s28+2.629308e+00*s29 \
v34=v34_part3+(-3.749236e+00)*s30+1.137481e+00*s31+(-6.756407e-01)*s32+(-1.867800e+00)*s33+5.012805e-01*s34+(-8.369970e+01)*s35+(-2.844020e+00)*s36+4.322868e-01*s37+(-1.522916e+00)*s38+(-2.161078e+00)*s39 \
v35_part1=(-1.991406e+01)*s0+(-2.406991e+00)*s1+(-4.217952e-01)*s2+(-1.365956e+01)*s3+(-2.890090e+00)*s4+5.454498e+00*s5+(-2.769859e+00)*s6+(-7.990854e-01)*s7+(-4.151010e+00)*s8+(-3.979137e+01)*s9 \
v35_part2=v35_part1+(-2.663348e-02)*s10+8.611288e-01*s11+(-8.016873e-02)*s12+(-4.586550e-01)*s13+(-1.860048e-01)*s14+(-2.921184e+00)*s15+(-3.019984e-01)*s16+(-7.845732e+00)*s17+(-6.345968e+00)*s18+(-1.092478e+01)*s19 \
v35_part3=v35_part2+(-5.033896e-02)*s20+(-1.730112e-01)*s21+(-2.859721e+00)*s22+(-7.744282e+00)*s23+9.261557e+00*s24+(-4.718078e+00)*s25+(-9.241021e-02)*s26+3.868092e+02*s27+(-3.028533e+00)*s28+(-4.156923e+00)*s29 \
v35=v35_part3+(-1.106215e+00)*s30+(-9.241706e-01)*s31+(-7.148739e+00)*s32+(-1.367944e+01)*s33+(-3.361767e+00)*s34+1.454421e+00*s35+(-1.583870e+00)*s36+(-6.835619e-01)*s37+1.160438e+00*s38+2.491296e+00*s39 \
v36_part1=(-1.791416e+01)*s0+7.590889e+00*s1+2.361237e-01*s2+(-3.338481e+00)*s3+8.152155e-01*s4+(-4.730407e+00)*s5+1.103144e+00*s6+9.556627e-01*s7+2.004137e+00*s8+8.310190e+00*s9 \
v36_part2=v36_part1+1.757680e-02*s10+6.053151e-01*s11+(-4.107183e-02)*s12+1.623957e-01*s13+(-1.069217e+00)*s14+(-2.271223e+00)*s15+5.046688e-02*s16+1.030702e+00*s17+2.334188e+00*s18+4.333900e+00*s19 \
v36_part3=v36_part2+1.919501e-01*s20+1.495714e-01*s21+1.912353e+00*s22+5.729167e+00*s23+(-2.092064e+00)*s24+(-4.775575e+00)*s25+6.976903e-02*s26+1.279101e+03*s27+9.080224e-01*s28+(-1.586843e+00)*s29 \
v36=v36_part3+(-4.274051e+00)*s30+(-8.370166e-01)*s31+3.308625e+00*s32+1.294150e-01*s33+8.116733e-01*s34+1.308359e+00*s35+(-3.654113e+00)*s36+(-4.407523e-03)*s37+1.817029e-01*s38+1.913808e-03*s39 \
v37_part1=(-2.038876e+00)*s0+4.140029e+01*s1+1.000000e+04*s2+9.622123e-01*s3+6.683558e-01*s4+1.364894e-02*s5+2.053085e-02*s6+(-1.681754e-02)*s7+2.086390e+00*s8+8.410403e-01*s9 \
v37_part2=v37_part1+1.472485e-01*s10+(-1.553333e+00)*s11+3.873168e-01*s12+1.031058e-01*s13+5.510892e-01*s14+4.730795e-01*s15+2.584498e-01*s16+3.331527e-01*s17+1.889499e-01*s18+6.603474e-01*s19 \
v37_part3=v37_part2+(-4.588624e+01)*s20+(-6.371986e+00)*s21+1.201262e-02*s22+1.628292e-01*s23+4.054440e-01*s24+(-4.107872e+02)*s25+4.608334e-01*s26+5.602101e-02*s27+4.046316e-01*s28+6.611774e-01*s29 \
v37=v37_part3+(-3.520761e+00)*s30+1.436831e-01*s31+7.270445e-01*s32+(-3.325803e+00)*s33+6.526892e-01*s34+6.204626e+03*s35+(-3.253889e+01)*s36+2.383448e-01*s37+4.215260e-01*s38+2.161511e+00*s39 \
v38_part1=3.002377e+02*s0+(-4.101453e+01)*s1+1.000000e+04*s2+(-8.752836e-02)*s3+(-1.468880e-01)*s4+3.518790e-01*s5+2.058624e-01*s6+6.207173e-01*s7+(-1.741909e+00)*s8+(-1.162171e-01)*s9 \
v38_part2=v38_part1+1.160965e-01*s10+1.058612e+00*s11+2.344794e-01*s12+(-1.706490e-02)*s13+1.745524e-01*s14+(-2.521852e-01)*s15+4.569482e-01*s16+9.512790e-02*s17+5.661699e-01*s18+(-2.375021e-04)*s19 \
v38_part3=v38_part2+4.220446e+01*s20+6.560516e+00*s21+5.373358e-01*s22+4.463001e-01*s23+3.939074e-01*s24+7.645484e+00*s25+3.003038e-02*s26+(-7.584737e-02)*s27+6.566463e-02*s28+5.475730e-02*s29 \
v38=v38_part3+5.456413e+01*s30+4.746656e-01*s31+(-4.182193e-01)*s32+2.584931e+00*s33+5.061164e-02*s34+(-6.205989e+03)*s35+3.249626e+01*s36+3.714847e-01*s37+1.945710e-02*s38+(-1.706519e+00)*s39 \
v39_part1=(-4.641105e+02)*s0+(-6.973185e+01)*s1+1.000000e+04*s2+(-3.139979e+00)*s3+(-1.679443e+00)*s4+(-9.904324e-01)*s5+(-1.228576e+00)*s6+(-1.012497e+00)*s7+(-5.356243e+00)*s8+(-2.789062e+00)*s9 \
v39_part2=v39_part1+(-1.390834e+00)*s10+(-8.806956e+00)*s11+(-1.382925e+00)*s12+6.332647e-01*s13+(-1.713479e+00)*s14+(-2.706821e+00)*s15+(-1.884604e+00)*s16+(-1.285819e+00)*s17+(-1.142029e+00)*s18+(-1.955629e+00)*s19 \
v39_part3=v39_part2+4.068615e+01*s20+(-9.029453e+00)*s21+(-1.027486e+00)*s22+(-1.087372e+00)*s23+(-1.826695e+00)*s24+(-2.082784e+03)*s25+(-1.744053e+00)*s26+5.906486e-01*s27+(-1.404292e+00)*s28+(-1.799182e+00)*s29 \
v39=v39_part3+(-1.360609e+02)*s30+(-9.416048e-01)*s31+(-2.449355e+00)*s32+8.050796e-01*s33+(-1.782654e+00)*s34+(-9.969941e+03)*s35+(-6.567557e+01)*s36+(-1.217455e+00)*s37+(-1.423900e+00)*s38+(-3.940353e+00)*s39 \
v40_part1=7.163236e+00*s0+6.811857e+01*s1+1.000000e+04*s2+1.906450e+00*s3+9.973036e-01*s4+3.710645e-01*s5+6.344653e-01*s6+2.410576e-01*s7+4.409547e+00*s8+1.810649e+00*s9 \
v40_part2=v40_part1+1.244791e+00*s10+9.155817e+00*s11+5.157203e-01*s12+(-2.740316e-01)*s13+8.646001e-01*s14+2.008690e+00*s15+7.696610e-01*s16+6.575821e-01*s17+3.045928e-01*s18+1.267308e+00*s19 \
v40_part3=v40_part2+(-3.825452e+01)*s20+1.035056e+01*s21+3.215416e-01*s22+3.820206e-01*s23+8.860688e-01*s24+5.814506e+02*s25+9.020378e-01*s26+(-1.627349e-01)*s27+7.323721e-01*s28+1.039237e+00*s29 \
v40=v40_part3+5.560172e+01*s30+1.423290e-01*s31+1.753852e+00*s32+(-2.785056e-01)*s33+1.026019e+00*s34+9.970802e+03*s35+2.375439e+01*s36+3.919152e-01*s37+8.058880e-01*s38+3.860163e+00*s39 \
v41_part1=(-4.710607e+00)*s0+(-4.718984e+00)*s1+1.922122e+01*s2+(-2.701176e-02)*s3+3.788452e-02*s4+(-3.774034e-01)*s5+1.530341e-01*s6+(-6.484508e-02)*s7+(-1.381528e-01)*s8+3.554721e-02*s9 \
v41_part2=v41_part1+(-4.266414e-02)*s10+(-7.494984e-01)*s11+(-1.902837e-01)*s12+6.712663e-02*s13+(-1.982545e-01)*s14+2.040846e-01*s15+(-1.264236e-01)*s16+1.082614e-01*s17+7.173565e-02*s18+(-7.720803e-02)*s19 \
v41_part3=v41_part2+(-6.280883e+00)*s20+5.951875e+00*s21+(-1.371160e-01)*s22+(-4.886016e-02)*s23+(-1.705901e-01)*s24+6.243353e+00*s25+(-1.651204e-02)*s26+2.590812e-02*s27+(-4.674731e-02)*s28+(-5.811159e-02)*s29 \
v41=v41_part3+(-3.859064e+00)*s30+(-3.135906e-01)*s31+(-1.610805e-01)*s32+(-1.114091e-01)*s33+(-9.921695e-02)*s34+2.722503e+01*s35+1.787000e+00*s36+(-1.687963e-01)*s37+(-1.977456e-01)*s38+4.539614e-01*s39 \
v42_part1=1.643694e+00*s0+5.534177e+00*s1+2.603181e+01*s2+2.073587e-01*s3+5.885861e-02*s4+2.081602e-01*s5+(-2.512428e-02)*s6+6.730154e-02*s7+1.074703e-01*s8+3.741033e-02*s9 \
v42_part2=v42_part1+(-4.793896e-02)*s10+1.428862e+00*s11+4.129013e-02*s12+(-3.219099e-02)*s13+7.456567e-02*s14+1.865739e-01*s15+8.192149e-02*s16+1.845584e-02*s17+6.788420e-02*s18+2.331214e-01*s19 \
v42_part3=v42_part2+6.243701e+00*s20+(-6.364300e+00)*s21+5.552586e-02*s22+5.814242e-02*s23+4.539277e-03*s24+4.423298e+00*s25+(-1.421631e-02)*s26+(-1.138654e-02)*s27+7.513985e-02*s28+1.537682e-01*s29 \
v42=v42_part3+8.030073e-01*s30+4.728930e-02*s31+9.448847e-02*s32+6.312447e-02*s33+2.220734e-01*s34+(-2.853926e+01)*s35+3.801554e+00*s36+2.935276e-02*s37+1.269257e-01*s38+5.601430e-02*s39 \
v43_part1=3.819216e+00*s0+(-1.347234e+00)*s1+5.523804e+00*s2+(-1.503586e-01)*s3+2.153247e-02*s4+(-3.659814e-02)*s5+6.765108e-02*s6+(-4.008738e-02)*s7+1.053270e-01*s8+1.020442e-02*s9 \
v43_part2=v43_part1+7.599727e-02*s10+(-4.817042e-01)*s11+1.312932e-01*s12+(-1.224772e-02)*s13+1.172978e-01*s14+(-4.238746e-01)*s15+8.792126e-02*s16+1.052773e-02*s17+(-1.170185e-01)*s18+(-3.968460e-02)*s19 \
v43_part3=v43_part2+(-6.030393e-01)*s20+(-8.312244e-02)*s21+4.796240e-02*s22+1.883419e-02*s23+1.605057e-01*s24+3.637750e+00*s25+6.020503e-02*s26+(-1.045294e-02)*s27+(-1.362014e-03)*s28+3.177277e-02*s29 \
v43=v43_part3+3.789581e+00*s30+1.405677e-01*s31+6.397039e-02*s32+1.325190e-01*s33+(-3.909005e-02)*s34+2.862619e+00*s35+1.154631e+00*s36+9.131136e-02*s37+8.159004e-02*s38+(-1.165177e+00)*s39 \
v44_part1=1.781898e+00*s0+5.288195e-01*s1+1.568086e+00*s2+(-9.519674e-01)*s3+(-8.582063e-02)*s4+(-2.504344e-01)*s5+(-2.225997e-01)*s6+(-5.010297e-01)*s7+2.908812e-01*s8+2.683189e-01*s9 \
v44_part2=v44_part1+(-1.937790e-01)*s10+2.367382e-01*s11+(-3.113431e-01)*s12+2.299274e-01*s13+(-1.191641e-01)*s14+3.077968e-02*s15+5.471632e-01*s16+(-3.489427e-01)*s17+6.579803e-02*s18+(-3.622541e-01)*s19 \
v44_part3=v44_part2+5.280694e-01*s20+(-2.520064e-01)*s21+(-2.016570e-01)*s22+(-1.679850e-01)*s23+(-5.380144e-01)*s24+(-3.694188e-01)*s25+4.325810e-01*s26+(-1.080208e-01)*s27+6.141949e-03*s28+(-4.645290e-01)*s29 \
v44=v44_part3+3.107374e-01*s30+8.047712e-01*s31+(-1.340987e-01)*s32+(-4.878029e-01)*s33+(-1.164632e-01)*s34+(-1.959037e-01)*s35+2.184143e-01*s36+(-9.062569e-02)*s37+1.550227e-01*s38+(-9.726302e-02)*s39 \
v45_part1=6.630813e-01*s0+1.747490e+00*s1+2.322115e+00*s2+3.842338e+00*s3+3.334595e+00*s4+2.059535e+00*s5+2.297171e+00*s6+3.296448e+00*s7+1.756938e+00*s8+1.862780e+00*s9 \
v45_part2=v45_part1+1.614078e+00*s10+1.141747e+00*s11+2.070295e+00*s12+1.676769e+00*s13+2.098732e+00*s14+1.417690e+00*s15+1.053236e+00*s16+2.073803e+00*s17+1.915918e+00*s18+2.451309e+00*s19 \
v45_part3=v45_part2+1.964948e-01*s20+1.916419e+00*s21+1.833584e+00*s22+1.976236e+00*s23+2.872003e+00*s24+1.366027e+00*s25+7.345412e-01*s26+1.481411e+00*s27+1.573356e+00*s28+2.336463e+00*s29 \
v45=v45_part3+8.262734e-01*s30+4.716697e-01*s31+1.626308e+00*s32+2.292693e+00*s33+1.814879e+00*s34+1.138833e+00*s35+6.622734e-01*s36+1.319454e+00*s37+1.111866e+00*s38+1.652129e+00*s39 \
v46_part1=(-1.299651e-01)*s0+5.819180e-02*s1+(-4.086897e+00)*s2+(-6.457524e-01)*s3+(-1.905531e+00)*s4+(-2.083699e-01)*s5+(-2.910818e-01)*s6+(-2.546969e-01)*s7+(-1.394288e+00)*s8+(-1.653616e+00)*s9 \
v46_part2=v46_part1+(-1.972188e-01)*s10+(-1.341852e+00)*s11+(-3.229533e-01)*s12+(-1.093534e+00)*s13+(-1.013110e+00)*s14+(-3.136081e-01)*s15+(-1.168173e+00)*s16+(-2.113741e-01)*s17+(-8.694362e-01)*s18+(-5.113493e-01)*s19 \
v46_part3=v46_part2+(-5.210066e-01)*s20+(-2.872862e-01)*s21+(-3.200435e-01)*s22+(-4.954499e-01)*s23+(-4.734638e-01)*s24+6.794229e-02*s25+(-8.895110e-01)*s26+(-4.257249e-01)*s27+(-4.160217e-01)*s28+(-2.041617e-01)*s29 \
v46=v46_part3+(-7.899916e-01)*s30+(-1.358066e+00)*s31+(-2.856752e-01)*s32+3.264341e-02*s33+(-5.562508e-01)*s34+(-4.858781e-02)*s35+(-9.452518e-01)*s36+(-3.128751e-01)*s37+(-5.795153e-01)*s38+(-4.282719e-01)*s39 \
v47_part1=5.095949e-01*s0+9.608056e-01*s1+3.933032e+00*s2+2.105597e+00*s3+3.259403e+00*s4+7.566742e-01*s5+7.989953e-01*s6+2.508632e-01*s7+2.571894e+00*s8+2.595312e+00*s9 \
v47_part2=v47_part1+1.013957e+00*s10+2.643526e+00*s11+1.275864e+00*s12+2.039138e+00*s13+2.050384e+00*s14+1.022825e+00*s15+1.969374e+00*s16+1.007134e+00*s17+1.460675e+00*s18+1.078988e+00*s19 \
v47_part3=v47_part2+1.843850e+00*s20+5.671073e-01*s21+6.826150e-01*s22+7.557735e-01*s23+6.043996e-01*s24+7.545477e-01*s25+1.676878e+00*s26+1.211929e+00*s27+1.006585e+00*s28+5.702561e-01*s29 \
v47=v47_part3+1.596209e+00*s30+1.994356e+00*s31+7.546811e-01*s32+1.348496e-01*s33+9.122837e-01*s34+5.570530e-01*s35+1.946842e+00*s36+9.154111e-01*s37+1.215914e+00*s38+8.135036e-01*s39 \
v48_part1=(-1.314080e+00)*s0+(-6.946343e-02)*s1+1.004394e-01*s2+6.230794e-02*s3+(-2.775586e-01)*s4+(-8.136450e-02)*s5+8.098913e-02*s6+(-1.201372e-01)*s7+1.095600e-01*s8+(-2.375655e-02)*s9 \
v48_part2=v48_part1+1.477613e-02*s10+(-9.671400e-02)*s11+(-1.169556e-01)*s12+(-9.814883e-02)*s13+5.357336e-03*s14+(-1.332476e-01)*s15+(-9.612776e-02)*s16+1.559151e-01*s17+(-8.998633e-02)*s18+(-7.661581e-02)*s19 \
v48_part3=v48_part2+1.402798e-01*s20+(-6.525054e-02)*s21+(-1.833452e-02)*s22+(-6.342170e-02)*s23+(-2.793265e-02)*s24+(-1.816130e-01)*s25+(-5.517721e-02)*s26+(-2.062724e-03)*s27+(-7.255774e-02)*s28+3.235521e-02*s29 \
v48=v48_part3+1.417792e-02*s30+(-1.685850e-01)*s31+(-1.112108e-01)*s32+(-2.017913e-03)*s33+8.743891e-02*s34+(-3.805226e-01)*s35+(-1.368975e-02)*s36+(-1.626535e-01)*s37+9.869009e-02*s38+(-6.837178e-01)*s39 \
v49_part1=1.174771e+00*s0+1.624726e+00*s1+1.424134e-01*s2+(-3.829529e-02)*s3+5.438735e-01*s4+2.334719e-01*s5+1.354132e-01*s6+7.864919e-02*s7+3.756670e-01*s8+4.493834e-01*s9 \
v49_part2=v49_part1+7.167005e-02*s10+1.695983e-01*s11+2.643374e-01*s12+2.786526e-01*s13+3.008169e-01*s14+2.459106e-01*s15+1.757913e-01*s16+(-8.755851e-05)*s17+2.817858e-01*s18+2.963157e-01*s19 \
v49_part3=v49_part2+3.839682e-01*s20+1.722227e-01*s21+1.700008e-01*s22+1.361750e-01*s23+3.425172e-02*s24+4.511418e-01*s25+2.183040e-01*s26+1.063549e-01*s27+3.454133e-01*s28+1.883208e-01*s29 \
v49=v49_part3+7.040241e-02*s30+2.121907e-01*s31+1.508106e-01*s32+1.370432e-01*s33+9.562774e-02*s34+3.986790e-01*s35+2.018003e-01*s36+1.283350e-01*s37+8.841866e-02*s38+1.240504e-01*s39 \
v50_part1=5.620696e-01*s0+(-1.290912e+00)*s1+1.001164e-01*s2+2.639188e-01*s3+(-3.121481e-02)*s4+(-3.262226e-02)*s5+(-1.073638e-01)*s6+1.336100e-01*s7+(-3.307959e-01)*s8+(-1.640224e-01)*s9 \
v50_part2=v50_part1+(-4.674310e-03)*s10+(-4.198883e-04)*s11+(-3.241971e-03)*s12+(-3.084272e-02)*s13+(-1.214722e-01)*s14+(-9.753667e-02)*s15+(-6.352435e-03)*s16+(-3.315554e-02)*s17+(-1.315296e-01)*s18+(-1.389716e-01)*s19 \
v50_part3=v50_part2+(-5.101961e-01)*s20+1.247295e-01*s21+(-8.601384e-02)*s22+(-7.732048e-03)*s23+(-2.352503e-02)*s24+(-1.197987e-01)*s25+(-1.114288e-01)*s26+(-8.119304e-03)*s27+(-1.265446e-01)*s28+(-1.257491e-01)*s29 \
v50=v50_part3+(-1.143100e-03)*s30+1.021929e-01*s31+5.771473e-02*s32+(-5.955911e-02)*s33+(-1.291286e-01)*s34+2.000139e-01*s35+(-9.958668e-02)*s36+1.248108e-01*s37+(-1.260697e-01)*s38+5.968156e-01*s39 \
v51_part1=6.209293e+03*s0+3.205749e+01*s1+3.205701e+01*s2+1.735708e+01*s3+2.167042e+01*s4+1.900417e+01*s5+1.382696e+01*s6+9.545987e+01*s7+9.342288e+01*s8+1.511646e+01*s9 \
v51_part2=v51_part1+2.065170e+02*s10+1.400648e+01*s11+1.324653e+01*s12+1.747177e+01*s13+1.400114e+01*s14+3.060148e+01*s15+2.021191e+01*s16+1.091569e+01*s17+1.682701e+01*s18+1.117821e+01*s19 \
v51_part3=v51_part2+(-9.291735e+00)*s20+8.067803e+01*s21+1.134594e+01*s22+1.382250e+01*s23+9.053730e+03*s24+1.609562e+01*s25+1.651572e+01*s26+1.260030e+01*s27+1.825213e+01*s28+2.147803e+01*s29 \
v51=v51_part3+2.970646e+01*s30+2.151234e+01*s31+1.105165e+01*s32+1.281887e+01*s33+1.171224e+01*s34+(-1.416325e+01)*s35+2.461044e+01*s36+5.347645e+00*s37+3.106261e+01*s38+2.423691e+01*s39 \
v52_part1=(-2.911142e+01)*s0+(-2.293216e+01)*s1+(-2.179259e+01)*s2+(-6.301533e+00)*s3+(-1.252841e+01)*s4+(-1.007293e+01)*s5+(-2.434429e+00)*s6+(-5.533732e+01)*s7+(-7.197115e+01)*s8+(-7.337498e+00)*s9 \
v52_part2=v52_part1+(-3.199938e+00)*s10+(-6.255422e+00)*s11+(-5.816977e+00)*s12+(-9.679467e+00)*s13+(-4.517732e+00)*s14+(-1.598528e+01)*s15+(-1.345970e+01)*s16+(-4.045948e+00)*s17+(-9.748906e+00)*s18+(-4.000972e+00)*s19 \
v52_part3=v52_part2+1.225682e+01*s20+(-5.486357e+01)*s21+(-4.921358e+00)*s22+(-6.927451e+00)*s23+(-9.557627e+02)*s24+(-9.211316e+00)*s25+(-1.089459e+01)*s26+(-4.417537e+00)*s27+(-6.989944e+00)*s28+(-1.233847e+01)*s29 \
v52=v52_part3+(-7.251109e+00)*s30+(-1.656459e+01)*s31+(-5.163511e+00)*s32+(-6.151605e+00)*s33+(-5.577886e+00)*s34+1.979677e+01*s35+(-1.506532e+01)*s36+6.409808e+00*s37+(-2.218595e+01)*s38+(-3.824739e+00)*s39 \
v53_part1=1.387720e+02*s0+(-3.800004e+00)*s1+(-2.015862e+01)*s2+4.603308e+00*s3+(-4.226791e-01)*s4+1.257047e+00*s5+1.645610e+01*s6+3.471253e+00*s7+2.143805e+01*s8+3.189107e+00*s9 \
v53_part2=v53_part1+1.738399e+01*s10+2.886302e-01*s11+4.416934e+00*s12+1.087106e+00*s13+9.447266e+00*s14+1.676229e+01*s15+(-5.003275e+00)*s16+6.381465e+00*s17+(-4.173440e-01)*s18+6.236219e+00*s19 \
v53_part3=v53_part2+3.724082e+01*s20+1.020849e+02*s21+4.362811e+00*s22+2.105450e+00*s23+8.323689e+02*s24+1.253990e+01*s25+(-1.688001e+00)*s26+5.390518e+00*s27+6.491133e+00*s28+1.420986e+00*s29 \
v53=v53_part3+4.791980e+01*s30+(-9.048888e+00)*s31+3.916032e+00*s32+2.662020e+00*s33+3.401089e+00*s34+3.347538e+01*s35+1.246490e+01*s36+1.885724e+01*s37+(-5.309233e+00)*s38+3.993939e+01*s39 \
v54_part1=(-2.485553e+03)*s0+4.788924e+00*s1+1.834019e+01*s2+(-4.851830e+00)*s3+9.437135e-01*s4+(-8.202815e-01)*s5+(-1.468705e+01)*s6+(-4.416770e+00)*s7+(-4.468246e-01)*s8+(-2.354667e+00)*s9 \
v54_part2=v54_part1+1.799651e+00*s10+8.590157e-01*s11+(-3.887176e+00)*s12+(-8.216474e-05)*s13+(-6.847926e+00)*s14+(-8.989189e+00)*s15+5.883211e+00*s16+(-5.851810e+00)*s17+5.223190e-01*s18+(-6.250974e+00)*s19 \
v54_part3=v54_part2+(-3.186643e+01)*s20+(-9.709891e+01)*s21+(-3.633186e+00)*s22+(-1.669448e+00)*s23+(-5.985322e+03)*s24+(-1.445376e+00)*s25+3.598781e+00*s26+(-3.990884e+00)*s27+(-6.792216e+00)*s28+3.008875e+00*s29 \
v54=v54_part3+(-2.381851e+01)*s30+1.113733e+01*s31+(-3.118383e+00)*s32+(-2.825076e+00)*s33+(-2.945252e+00)*s34+(-2.989506e+01)*s35+(-5.990456e+00)*s36+(-1.899838e+01)*s37+1.210147e+01*s38+(-3.456921e+01)*s39 \
v55_part1=(-1.453913e+01)*s0+4.624142e+00*s1+1.162221e+00*s2+3.152610e+00*s3+1.242964e+00*s4+4.788813e+00*s5+5.362533e+00*s6+(-4.996321e+00)*s7+(-1.504461e+00)*s8+1.036428e+00*s9 \
v55_part2=v55_part1+2.586559e+00*s10+(-5.342914e-01)*s11+(-4.353727e-01)*s12+4.186236e-01*s13+6.247322e-01*s14+(-3.385390e+00)*s15+(-8.015795e-01)*s16+3.087901e+00*s17+(-1.283300e+00)*s18+(-3.954327e-01)*s19 \
v55_part3=v55_part2+2.268089e+00*s20+(-2.693726e+02)*s21+4.532892e-01*s22+(-1.194460e-02)*s23+(-1.567488e+03)*s24+5.034244e+00*s25+(-1.488483e+00)*s26+4.490342e+00*s27+(-7.565056e-01)*s28+8.045644e-02*s29 \
v55=v55_part3+(-6.202469e+00)*s30+9.029567e-01*s31+5.672930e-01*s32+1.162969e+00*s33+2.879180e+00*s34+6.337873e+00*s35+(-2.056874e+00)*s36+(-2.465309e-02)*s37+5.264314e+00*s38+(-1.477663e+01)*s39 \
v56_part1=(-1.386380e+01)*s0+2.045718e+00*s1+(-1.967961e+00)*s2+(-1.405544e+00)*s3+(-2.856341e-01)*s4+2.985462e-01*s5+(-3.456868e+00)*s6+(-1.230304e+01)*s7+4.131314e+01*s8+(-7.301626e-01)*s9 \
v56_part2=v56_part1+8.102168e+00*s10+2.382478e-01*s11+2.290713e-01*s12+(-7.822318e-02)*s13+1.862325e-01*s14+2.767312e+00*s15+6.998970e-01*s16+(-2.340848e+00)*s17+1.471991e+00*s18+7.061609e-01*s19 \
v56_part3=v56_part2+6.738939e-01*s20+2.576045e+02*s21+9.391377e-02*s22+(-1.702436e-01)*s23+(-1.573444e+02)*s24+2.793520e+00*s25+2.564293e+00*s26+(-2.884490e+00)*s27+2.547540e+00*s28+6.802778e-01*s29 \
v56=v56_part3+(-2.996109e-01)*s30+(-9.251963e-01)*s31+(-1.024731e+00)*s32+(-9.006470e-01)*s33+(-2.216406e+00)*s34+(-3.078677e+00)*s35+2.540692e+00*s36+(-1.025837e+00)*s37+(-2.804382e+00)*s38+(-1.126945e+01)*s39 \
v57_part1=(-3.487645e-01)*s0+(-1.039773e+01)*s1+1.091608e+00*s2+(-1.686698e+00)*s3+(-5.991210e-01)*s4+(-2.514403e+00)*s5+(-5.441332e-01)*s6+1.890152e+01*s7+(-4.194647e+01)*s8+7.867029e-04*s9 \
v57_part2=v57_part1+3.886486e+00*s10+4.989868e-02*s11+3.689853e-01*s12+1.730140e-01*s13+(-5.800167e-01)*s14+(-4.689893e-02)*s15+1.218558e-01*s16+(-7.795795e-01)*s17+(-1.212570e-01)*s18+(-2.119048e-01)*s19 \
v57_part3=v57_part2+(-3.001354e+00)*s20+1.549588e+01*s21+(-4.685494e-01)*s22+3.012412e-01*s23+1.394975e+00*s24+(-3.129610e-01)*s25+(-9.639756e-01)*s26+(-1.702197e+00)*s27+(-6.954329e-01)*s28+(-1.371766e+00)*s29 \
v57=v57_part3+(-5.101147e+00)*s30+6.868505e-01*s31+7.420175e-01*s32+(-8.719945e-02)*s33+(-7.278419e-01)*s34+(-1.592795e+00)*s35+(-1.547208e+00)*s36+1.451251e+00*s37+(-2.923809e+00)*s38+2.615227e+01*s39 \
v58_part1=(-2.114815e+00)*s0+6.012152e+00*s1+(-2.814886e+01)*s2+(-2.977208e+00)*s3+(-2.201513e+01)*s4+1.178025e+01*s5+5.525787e+00*s6+1.432053e+01*s7+1.243808e+01*s8+1.728204e+01*s9 \
v58_part2=v58_part1+6.531544e+00*s10+5.178123e+00*s11+1.480662e+01*s12+(-1.640547e+00)*s13+(-8.898140e+00)*s14+3.150976e+00*s15+5.644210e+00*s16+1.045659e+01*s17+1.459775e+00*s18+1.859652e+00*s19 \
v58_part3=v58_part2+8.131889e-01*s20+5.898868e+00*s21+7.541067e+00*s22+(-6.722834e+00)*s23+(-1.292995e+01)*s24+1.174342e+01*s25+1.298329e+01*s26+4.136369e+00*s27+1.324064e+01*s28+(-5.197136e+01)*s29 \
v58=v58_part3+1.044335e+00*s30+1.045512e+01*s31+1.590615e+01*s32+6.878229e+00*s33+(-2.521232e+01)*s34+(-5.806993e+00)*s35+(-2.617183e+01)*s36+1.200614e+01*s37+8.932626e+00*s38+4.239222e+00*s39 \
v59_part1=3.264437e+01*s0+3.277924e+01*s1+8.214374e+01*s2+2.640136e+01*s3+5.929654e+01*s4+2.548462e+01*s5+3.176453e+01*s6+3.654207e+00*s7+1.897199e+01*s8+(-1.738101e+01)*s9 \
v59_part2=v59_part1+2.712991e+01*s10+3.384152e+01*s11+7.739916e-01*s12+2.197119e+01*s13+3.065828e+01*s14+1.513699e+01*s15+3.426682e+01*s16+3.061619e+01*s17+4.137581e+01*s18+4.324828e+01*s19 \
v59_part3=v59_part2+2.418212e+01*s20+3.196814e+01*s21+3.685105e+01*s22+5.559640e+01*s23+5.643577e+01*s24+9.913664e+00*s25+4.742506e+00*s26+1.374326e+01*s27+2.236241e+00*s28+9.862992e+01*s29 \
v59=v59_part3+1.992206e+01*s30+1.032445e+01*s31+2.737276e+00*s32+1.646919e+01*s33+5.688004e+01*s34+1.266410e+02*s35+9.700463e+01*s36+6.785158e+00*s37+9.072686e+00*s38+1.328474e+01*s39 \
v60_part1=(-7.501004e-01)*s0+(-4.289679e+00)*s1+2.252123e+01*s2+(-3.538694e+00)*s3+1.929818e+00*s4+(-9.250109e+00)*s5+(-4.389932e+00)*s6+(-1.525761e+01)*s7+(-1.557993e+01)*s8+(-6.317019e+00)*s9 \
v60_part2=v60_part1+(-3.296062e+00)*s10+(-1.258377e+01)*s11+(-1.004787e+01)*s12+5.453624e+00*s13+1.024365e+01*s14+(-1.848841e+00)*s15+(-4.940346e+00)*s16+(-1.147510e+01)*s17+1.977270e+00*s18+(-7.567223e+00)*s19 \
v60_part3=v60_part2+(-1.223171e+01)*s20+9.155104e-01*s21+(-7.867678e-01)*s22+5.094276e+00*s23+1.568285e+01*s24+(-8.852241e+00)*s25+(-3.985213e+00)*s26+5.844734e+00*s27+(-7.782329e+00)*s28+6.296660e+01*s29 \
v60=v60_part3+6.767206e-03*s30+8.187582e+00*s31+(-2.858591e+00)*s32+1.258798e+01*s33+3.349205e+01*s34+(-7.890023e+01)*s35+5.026988e+01*s36+(-2.348450e+00)*s37+(-5.154845e+00)*s38+(-8.878962e+00)*s39 \
v61_part1=1.844194e+00*s0+(-1.555279e+01)*s1+(-6.089373e+01)*s2+4.390350e+00*s3+(-5.749522e+00)*s4+9.174556e+00*s5+4.751899e+00*s6+1.522493e+01*s7+2.171264e+01*s8+3.623401e+01*s9 \
v61_part2=v61_part1+2.729185e+00*s10+1.676017e+00*s11+1.478659e+01*s12+(-5.732693e+00)*s13+(-9.235846e+00)*s14+(-1.923728e-01)*s15+4.167815e+00*s16+1.076266e+01*s17+(-5.021780e+00)*s18+6.219386e+00*s19 \
v61_part3=v61_part2+2.410540e+01*s20+5.985838e-01*s21+(-5.230243e+00)*s22+(-1.125963e+01)*s23+(-2.242655e+01)*s24+6.691804e+00*s25+5.118377e+00*s26+(-4.927538e+00)*s27+1.111702e+01*s28+(-9.235516e+01)*s29 \
v61=v61_part3+(-1.322387e+00)*s30+2.551679e+00*s31+1.187557e+01*s32+(-4.599179e+00)*s33+(-3.516181e+01)*s34+(-4.224174e+01)*s35+(-9.796335e+01)*s36+2.278139e+00*s37+7.176668e+00*s38+8.262845e+00*s39 \
v62_part1=1.013490e+00*s0+3.453386e+00*s1+(-8.949531e-01)*s2+9.442850e+00*s3+(-3.659194e+00)*s4+(-8.417848e-01)*s5+(-1.435751e+00)*s6+(-4.685578e-03)*s7+(-1.228917e+00)*s8+(-1.886339e+01)*s9 \
v62_part2=v62_part1+(-1.317313e+00)*s10+(-1.012792e+00)*s11+(-3.168612e+00)*s12+1.098271e+00*s13+1.779334e-01*s14+(-7.158442e-02)*s15+(-2.249309e-01)*s16+(-3.081067e+00)*s17+1.313344e+00*s18+2.212082e+00*s19 \
v62_part3=v62_part2+1.617098e+00*s20+6.199188e+01*s21+(-3.209223e+00)*s22+(-4.408656e-01)*s23+1.346454e+00*s24+3.864788e-01*s25+(-4.775487e-01)*s26+(-1.136679e+00)*s27+4.550450e-01*s28+4.772935e+00*s29 \
v62=v62_part3+(-2.413501e+00)*s30+(-1.756760e+00)*s31+2.780497e+01*s32+(-5.366228e+00)*s33+4.655551e+01*s34+(-7.811049e+00)*s35+(-4.483232e-01)*s36+(-1.107501e+01)*s37+(-3.937379e-01)*s38+1.625932e+01*s39 \
v63_part1=(-6.363457e+00)*s0+1.005879e+00*s1+3.219057e+00*s2+(-1.259693e+01)*s3+1.236941e+00*s4+(-8.025253e-01)*s5+7.128123e-01*s6+(-3.162634e+00)*s7+(-6.636978e-01)*s8+5.450029e+01*s9 \
v63_part2=v63_part1+1.003696e+00*s10+2.375246e+00*s11+1.253998e+00*s12+(-2.754473e+00)*s13+1.198131e+00*s14+1.135376e+00*s15+1.162958e+00*s16+3.972716e+00*s17+(-8.737522e-01)*s18+(-4.233024e+00)*s19 \
v63_part3=v63_part2+(-5.684108e+00)*s20+(-9.912052e+01)*s21+3.338214e+00*s22+(-1.200060e+00)*s23+(-4.380960e+00)*s24+(-2.556262e+00)*s25+5.606249e-01*s26+3.927638e-01*s27+(-2.967220e-03)*s28+(-6.411639e+00)*s29 \
v63=v63_part3+(-2.846485e-01)*s30+7.624010e+00*s31+(-3.052701e+01)*s32+(-7.420113e-01)*s33+(-2.689178e+01)*s34+7.992710e+00*s35+1.959306e+00*s36+8.347854e+00*s37+(-1.369548e+00)*s38+(-1.335891e+01)*s39 \
v64_part1=5.525360e+00*s0+(-7.530162e+00)*s1+(-7.503190e-03)*s2+(-3.714744e-01)*s3+1.511252e+00*s4+1.238725e+00*s5+5.044104e-01*s6+1.224408e-01*s7+2.007429e+00*s8+(-1.512988e+01)*s9 \
v64_part2=v64_part1+4.283435e-01*s10+(-2.686036e+00)*s11+2.710828e+00*s12+1.151710e+00*s13+6.994391e-01*s14+(-1.012977e+00)*s15+(-1.138443e+00)*s16+(-9.750684e-01)*s17+(-6.128776e-01)*s18+1.014314e+00*s19 \
v64_part3=v64_part2+4.274507e+00*s20+(-5.819747e+00)*s21+1.103067e+00*s22+1.442597e+00*s23+2.221345e+00*s24+3.927961e+00*s25+(-1.101808e+00)*s26+9.160049e-01*s27+1.192859e-01*s28+1.516927e+00*s29 \
v64=v64_part3+2.505955e+00*s30+1.230936e-01*s31+(-5.251171e+00)*s32+9.664495e+00*s33+(-2.045601e+01)*s34+1.474871e-01*s35+(-5.338380e+00)*s36+4.951632e+00*s37+1.815113e+00*s38+(-7.391333e+00)*s39 \
v65_part1=1.772007e-01*s0+5.174117e-01*s1+2.086639e+00*s2+(-1.059250e+00)*s3+1.929742e+00*s4+1.014206e+00*s5+3.021111e-01*s6+1.259084e+00*s7+(-8.292586e-01)*s8+5.803698e+00*s9 \
v65_part2=v65_part1+(-1.642507e-01)*s10+6.752849e-01*s11+(-4.759519e-01)*s12+1.242987e+00*s13+(-1.543328e-01)*s14+6.663356e-01*s15+1.787411e-01*s16+8.196536e-01*s17+1.128208e+00*s18+8.158416e-01*s19 \
v65_part3=v65_part2+6.391735e-01*s20+(-3.946555e-01)*s21+5.432003e-01*s22+1.225102e+00*s23+1.500510e+00*s24+4.028421e-01*s25+6.257621e-01*s26+3.224202e-02*s27+(-2.817449e-01)*s28+1.430491e+00*s29 \
v65=v65_part3+5.204044e-01*s30+1.149655e+00*s31+1.101943e-01*s32+(-1.353327e+00)*s33+3.672009e-01*s34+(-1.635162e+00)*s35+6.927117e-01*s36+(-2.885341e-01)*s37+2.208027e-01*s38+6.098264e-01*s39 \
v66_part1=2.612874e+00*s0+1.209805e+00*s1+1.587199e+00*s2+4.609731e+00*s3+2.098091e+00*s4+6.949905e-01*s5+2.045652e+00*s6+1.709727e+00*s7+4.255344e+00*s8+(-2.049856e+00)*s9 \
v66_part2=v66_part1+1.600576e+00*s10+6.085317e-01*s11+2.708905e+00*s12+1.105730e+00*s13+2.912473e+00*s14+2.370573e-01*s15+1.569737e+00*s16+1.078070e+00*s17+1.253922e+00*s18+2.089597e+00*s19 \
v66_part3=v66_part2+(-1.572202e-01)*s20+2.514969e+00*s21+1.651434e+00*s22+1.437829e+00*s23+1.746373e+00*s24+4.138004e-01*s25+6.048406e-01*s26+1.550484e+00*s27+2.364164e+00*s28+3.168359e-01*s29 \
v66=v66_part3+4.888822e-01*s30+4.089134e-02*s31+1.590931e+00*s32+3.210565e+00*s33+1.930711e+00*s34+2.766511e+00*s35+(-7.409360e-02)*s36+1.649159e+00*s37+1.288018e+00*s38+1.669766e+00*s39 \
v67_part1=2.292595e+00*s0+(-6.990743e-02)*s1+(-7.082475e+00)*s2+(-3.940552e+00)*s3+(-8.367302e+00)*s4+(-2.838708e+00)*s5+(-3.326037e+00)*s6+(-5.091279e+00)*s7+(-3.741371e+00)*s8+(-1.356737e+01)*s9 \
v67_part2=v67_part1+(-3.759857e-01)*s10+(-2.029496e+00)*s11+(-1.600455e+00)*s12+(-4.514344e+00)*s13+(-3.366532e+00)*s14+(-1.666289e+00)*s15+(-1.784846e+00)*s16+(-3.140912e+00)*s17+(-4.050469e+00)*s18+(-4.353787e+00)*s19 \
v67_part3=v67_part2+(-7.267297e-01)*s20+(-1.649453e+00)*s21+(-2.678256e+00)*s22+(-4.060779e+00)*s23+(-5.276877e+00)*s24+(-1.018539e+00)*s25+(-1.655726e+00)*s26+(-1.610920e+00)*s27+(-1.224249e+00)*s28+(-4.012947e+00)*s29 \
v67=v67_part3+(-1.268594e+00)*s30+(-2.368383e+00)*s31+(-1.492002e+00)*s32+1.364596e-01*s33+(-2.540264e+00)*s34+1.639683e+00*s35+(-1.945578e+00)*s36+(-7.570181e-01)*s37+(-1.544720e+00)*s38+(-2.424635e+00)*s39 \
v68_part1=(-1.185233e+00)*s0+4.126768e+00*s1+1.177313e+01*s2+1.065429e+01*s3+1.608318e+01*s4+6.958680e+00*s5+9.230580e+00*s6+1.227198e+01*s7+1.249332e+01*s8+2.373132e+01*s9 \
v68_part2=v68_part1+2.064312e+00*s10+5.231636e+00*s11+4.863040e+00*s12+8.790434e+00*s13+7.922811e+00*s14+4.466602e+00*s15+4.824568e+00*s16+7.253288e+00*s17+8.667383e+00*s18+9.300275e+00*s19 \
v68_part3=v68_part2+4.085230e+00*s20+4.926755e+00*s21+6.986665e+00*s22+8.897291e+00*s23+1.058754e+01*s24+2.640233e+00*s25+3.682578e+00*s26+4.063468e+00*s27+3.652933e+00*s28+7.393765e+00*s29 \
v68=v68_part3+2.871000e+00*s30+4.580916e+00*s31+3.851126e+00*s32+2.765210e+00*s33+5.540548e+00*s34+(-9.511845e-01)*s35+4.023752e+00*s36+2.593692e+00*s37+3.660790e+00*s38+3.888044e+00*s39 \
v69_part1=(-1.891883e+00)*s0+(-2.083810e-01)*s1+5.508633e-01*s2+3.247233e-01*s3+(-9.184008e-02)*s4+(-1.728494e-01)*s5+1.558549e-01*s6+(-3.172361e-01)*s7+8.309709e-01*s8+(-5.327658e-02)*s9 \
v69_part2=v69_part1+1.244986e-02*s10+(-4.226106e-02)*s11+(-1.397342e-01)*s12+(-2.208335e-01)*s13+(-6.950980e-02)*s14+(-7.055372e-01)*s15+(-2.797381e-01)*s16+(-1.248713e-01)*s17+(-1.695285e-01)*s18+(-2.151144e-01)*s19 \
v69_part3=v69_part2+(-9.354596e-02)*s20+1.546848e+00*s21+(-5.196126e-02)*s22+(-9.660700e-02)*s23+(-2.571915e-01)*s24+(-1.628891e-01)*s25+(-1.241777e-01)*s26+(-8.527250e-02)*s27+(-1.601991e-01)*s28+(-1.507935e-01)*s29 \
v69=v69_part3+(-1.562413e-01)*s30+(-2.713956e-01)*s31+(-9.870506e-02)*s32+(-1.183674e-01)*s33+(-1.507679e-01)*s34+(-2.624080e-01)*s35+(-1.163430e-01)*s36+(-1.978206e-02)*s37+8.690408e-02*s38+3.948467e-01*s39 \
v70_part1=1.322808e+00*s0+1.929292e+00*s1+(-8.840007e-02)*s2+8.973059e-01*s3+6.161062e-01*s4+4.102594e-01*s5+5.847742e-01*s6+1.022016e+00*s7+5.072381e-01*s8+1.461438e+00*s9 \
v70_part2=v70_part1+8.651458e-02*s10+(-7.088755e-02)*s11+5.396350e-01*s12+7.552320e-01*s13+7.438733e-01*s14+6.417099e-01*s15+4.390698e-01*s16+3.673122e-01*s17+8.714012e-01*s18+8.126372e-01*s19 \
v70_part3=v70_part2+9.179270e-01*s20+(-2.348698e+00)*s21+6.458828e-01*s22+7.681316e-01*s23+8.508252e-01*s24+4.943157e-01*s25+4.033144e-01*s26+2.843043e-01*s27+5.447660e-01*s28+7.538749e-01*s29 \
v70=v70_part3+1.478599e-01*s30+2.976335e-01*s31+4.397871e-01*s32+5.312911e-01*s33+3.899700e-01*s34+3.628772e-01*s35+2.962212e-01*s36+9.157125e-02*s37+3.162141e-01*s38+2.101207e-02*s39 \
v71_part1=1.151288e+00*s0+(-9.551741e-01)*s1+(-1.218073e-01)*s2+(-8.732122e-01)*s3+(-2.863289e-01)*s4+1.780984e-03*s5+(-4.188889e-01)*s6+(-2.434602e-01)*s7+(-9.029371e-01)*s8+(-8.705316e-01)*s9 \
v71_part2=v71_part1+4.738718e-03*s10+1.917310e-01*s11+(-1.406140e-01)*s12+(-2.336309e-01)*s13+(-4.318207e-01)*s14+4.051373e-01*s15+8.617039e-02*s16+6.699438e-02*s17+(-3.810052e-01)*s18+(-2.602063e-01)*s19 \
v71_part3=v71_part2+(-6.822107e-01)*s20+6.852794e-01*s21+(-2.875735e-01)*s22+(-3.272806e-01)*s23+(-2.635547e-01)*s24+(-1.531947e-01)*s25+(-1.416806e-01)*s26+(-3.317638e-03)*s27+(-1.330752e-01)*s28+(-3.807785e-01)*s29 \
v71=v71_part3+1.983338e-01*s30+1.812989e-01*s31+(-7.329063e-02)*s32+(-1.404880e-01)*s33+3.390506e-02*s34+1.266082e-01*s35+9.359076e-03*s36+4.611132e-02*s37+(-2.584860e-01)*s38+(-1.827987e-01)*s39 \
v72_part1=2.316201e+01*s0+6.005218e+01*s1+1.000000e+04*s2+1.073952e+02*s3+1.971150e+02*s4+6.401494e+01*s5+7.638590e+01*s6+2.348722e+01*s7+1.962256e+01*s8+4.313483e+02*s9 \
v72_part2=v72_part1+1.785562e+01*s10+2.976402e+02*s11+1.000000e+04*s12+3.861011e+02*s13+1.001523e+02*s14+1.729251e+01*s15+1.000000e+04*s16+1.000000e+04*s17+1.000000e+04*s18+1.000000e+04*s19 \
v72_part3=v72_part2+1.031800e+02*s20+1.394850e+01*s21+1.000000e+04*s22+1.000000e+04*s23+2.023943e+01*s24+2.535758e+01*s25+7.059375e+03*s26+3.577550e+01*s27+4.877003e+01*s28+4.694160e+01*s29 \
v72=v72_part3+1.975952e+01*s30+1.000000e+04*s31+1.000000e+04*s32+1.000000e+04*s33+1.000000e+04*s34+(-3.894636e+01)*s35+9.411568e+00*s36+4.869810e+01*s37+1.799263e+01*s38+3.417348e+01*s39 \
v73_part1=(-1.154608e+01)*s0+(-6.031374e+00)*s1+1.000000e+04*s2+(-6.383303e+01)*s3+(-5.600548e+01)*s4+(-2.259854e+01)*s5+(-4.962953e+01)*s6+(-1.138113e+01)*s7+(-6.637367e+00)*s8+(-1.881959e+02)*s9 \
v73_part2=v73_part1+(-9.286813e+00)*s10+5.390429e+01*s11+1.000000e+04*s12+(-2.772220e+02)*s13+(-6.579258e+01)*s14+(-5.743915e+00)*s15+1.000000e+04*s16+1.000000e+04*s17+(-3.530611e+02)*s18+1.000000e+04*s19 \
v73_part3=v73_part2+3.722161e+02*s20+(-1.929189e+00)*s21+1.000000e+04*s22+(-6.611465e+03)*s23+(-1.035147e+01)*s24+(-1.181560e+01)*s25+(-6.690976e+03)*s26+9.127695e-01*s27+(-2.777232e+01)*s28+(-1.857487e+01)*s29 \
v73=v73_part3+(-1.251022e+01)*s30+1.000000e+04*s31+1.167186e+03*s32+9.558514e+03*s33+9.256140e+02*s34+7.469425e+01*s35+1.094094e+00*s36+(-3.527454e+01)*s37+(-2.732632e-01)*s38+(-1.994161e+01)*s39 \
v74_part1=4.824008e+00*s0+2.482231e+01*s1+1.000000e+04*s2+6.194972e+01*s3+1.697727e+02*s4+2.888450e+01*s5+(-3.000139e+01)*s6+2.889914e+00*s7+8.550180e+00*s8+1.370721e+02*s9 \
v74_part2=v74_part1+(-4.500593e-01)*s10+1.068809e+01*s11+1.000000e+04*s12+3.776085e+01*s13+(-4.155576e+00)*s14+1.154555e+01*s15+1.000000e+04*s16+1.000000e+04*s17+1.000000e+04*s18+1.000000e+04*s19 \
v74_part3=v74_part2+1.582942e+01*s20+2.562800e+00*s21+1.000000e+04*s22+1.000000e+04*s23+2.790188e+00*s24+(-1.198260e+01)*s25+3.958846e+03*s26+1.240584e+02*s27+3.182605e+01*s28+2.075405e+01*s29 \
v74=v74_part3+(-2.980936e+00)*s30+1.000000e+04*s31+5.282418e+03*s32+5.353536e+03*s33+1.000000e+04*s34+8.350407e+01*s35+1.577208e-01*s36+8.586081e+00*s37+3.603881e+01*s38+(-1.433274e+01)*s39 \
v75_part1=(-8.609481e+00)*s0+(-3.927834e+01)*s1+1.000000e+04*s2+(-5.743461e+01)*s3+(-1.880286e+02)*s4+(-2.127832e+01)*s5+2.568684e+01*s6+(-3.448169e+00)*s7+(-9.493700e+00)*s8+(-1.185828e+02)*s9 \
v75_part2=v75_part1+3.204359e-01*s10+1.861986e-01*s11+1.000000e+04*s12+(-4.102946e+01)*s13+(-1.037286e+00)*s14+(-8.603445e+00)*s15+1.000000e+04*s16+1.000000e+04*s17+(-8.353078e+03)*s18+1.000000e+04*s19 \
v75_part3=v75_part2+(-1.791486e+02)*s20+(-2.805402e+00)*s21+1.000000e+04*s22+(-2.864465e+03)*s23+(-2.789971e+00)*s24+1.397499e+01*s25+(-3.635950e+03)*s26+(-1.139231e+02)*s27+(-2.567608e+01)*s28+(-2.863860e+01)*s29 \
v75=v75_part3+6.193206e+00*s30+1.000000e+04*s31+8.167977e+02*s32+1.166256e+00*s33+6.415031e+00*s34+(-9.876644e+01)*s35+9.747416e+00*s36+3.261543e+00*s37+(-3.618935e+01)*s38+1.230420e+01*s39 \
v76_part1=(-5.989109e+00)*s0+1.535243e+01*s1+1.451961e+01*s2+(-4.040920e+01)*s3+(-3.112191e+02)*s4+(-4.022649e+01)*s5+(-1.047792e+01)*s6+(-2.438119e-01)*s7+2.729500e+00*s8+2.208612e+02*s9 \
v76_part2=v76_part1+5.345134e-01*s10+2.522517e+00*s11+1.000000e+04*s12+(-2.258068e+02)*s13+6.207848e+00*s14+(-1.047157e+00)*s15+1.593133e+02*s16+1.000000e+04*s17+9.082544e+02*s18+4.607764e+02*s19 \
v76_part3=v76_part2+(-4.474296e+00)*s20+1.990078e+01*s21+1.000000e+04*s22+2.998492e+02*s23+(-9.426272e-01)*s24+(-7.270939e-01)*s25+(-4.434256e+02)*s26+(-8.602097e+01)*s27+2.918251e+00*s28+1.393928e+01*s29 \
v76=v76_part3+2.876855e+00*s30+3.187349e+03*s31+1.000000e+04*s32+2.402037e+01*s33+1.672519e+03*s34+(-3.996385e+01)*s35+2.283332e-01*s36+(-7.609632e+00)*s37+1.370248e+00*s38+1.186323e+01*s39 \
v77_part1=4.462457e+00*s0+2.982588e+01*s1+1.082686e+01*s2+8.444636e+00*s3+1.523996e+02*s4+(-1.177167e+00)*s5+5.923418e+00*s6+8.764493e-01*s7+(-4.959305e+00)*s8+(-2.052261e+02)*s9 \
v77_part2=v77_part1+(-7.498041e-01)*s10+5.543491e+00*s11+8.841337e+03*s12+1.803765e+02*s13+(-8.302487e+00)*s14+6.884972e-02*s15+1.403467e+02*s16+1.000000e+04*s17+(-1.002090e+03)*s18+7.393000e+02*s19 \
v77_part3=v77_part2+(-6.028609e+00)*s20+(-1.941796e+01)*s21+1.000000e+04*s22+4.263467e+01*s23+2.069545e-01*s24+(-7.804748e-01)*s25+(-2.368051e+02)*s26+5.618630e+01*s27+(-1.020262e+01)*s28+(-1.054317e+01)*s29 \
v77=v77_part3+(-2.053143e+00)*s30+3.667823e+03*s31+1.000000e+04*s32+2.046833e+00*s33+3.149661e+02*s34+3.075041e+01*s35+6.309235e+00*s36+1.958696e+00*s37+(-3.225066e-01)*s38+(-1.055356e+01)*s39 \
v78_part1=2.492334e+00*s0+2.833237e+01*s1+8.955369e+00*s2+2.855264e+01*s3+1.143660e+02*s4+5.697771e+00*s5+2.098786e+00*s6+(-8.069410e-01)*s7+2.038120e+00*s8+7.861043e+01*s9 \
v78_part2=v78_part1+2.311118e-01*s10+3.651092e+00*s11+1.000000e+04*s12+3.220290e+00*s13+2.891299e+00*s14+1.787176e+00*s15+1.626220e+02*s16+1.000000e+04*s17+1.602853e+03*s18+5.883911e+02*s19 \
v78_part3=v78_part2+(-6.985446e+00)*s20+(-8.155840e-01)*s21+2.619235e+03*s22+2.035837e+02*s23+7.576516e-01*s24+(-4.936630e-01)*s25+(-1.744996e+02)*s26+3.492022e+01*s27+5.595839e+00*s28+(-1.721215e+00)*s29 \
v78=v78_part3+8.107725e-01*s30+3.876681e+03*s31+1.000000e+04*s32+1.016113e+01*s33+2.654255e+03*s34+1.969893e+01*s35+(-2.860343e+00)*s36+5.963603e+00*s37+(-6.985202e-01)*s38+(-2.139953e+00)*s39 \
v79_part1=(-2.420253e+01)*s0+(-1.676912e+01)*s1+1.956747e+01*s2+6.023625e+00*s3+2.047371e+01*s4+2.915812e+00*s5+(-1.000000e+04)*s6+(-1.091750e+01)*s7+(-4.558069e+02)*s8+(-2.123346e+00)*s9 \
v79_part2=v79_part1+6.559408e-01*s10+4.189591e+00*s11+(-7.845141e+00)*s12+3.030233e+00*s13+1.238482e+01*s14+4.959327e+00*s15+(-6.759484e+01)*s16+2.625021e+00*s17+(-9.130114e+00)*s18+(-4.479859e+00)*s19 \
v79_part3=v79_part2+(-8.084093e+00)*s20+(-8.760570e+00)*s21+4.942956e+00*s22+8.530260e+00*s23+1.760213e+01*s24+7.182399e+00*s25+(-7.501509e+00)*s26+3.615291e+00*s27+(-7.723730e+00)*s28+4.734587e+01*s29 \
v79=v79_part3+6.331843e+00*s30+(-1.091540e+01)*s31+(-4.615075e+00)*s32+(-1.152270e+00)*s33+1.529517e+01*s34+2.875311e+02*s35+2.525296e+01*s36+(-1.402423e+00)*s37+(-2.609007e+00)*s38+(-1.058757e+01)*s39 \
v80_part1=2.482902e+01*s0+1.195872e+01*s1+(-3.799775e+01)*s2+3.236341e+00*s3+(-2.265705e+01)*s4+(-7.727146e+00)*s5+(-1.000000e+04)*s6+2.611415e+01*s7+(-1.895376e+00)*s8+2.772078e+01*s9 \
v80_part2=v80_part1+1.837356e+01*s10+(-6.396953e+00)*s11+2.652692e+01*s12+1.223609e+01*s13+7.569152e-01*s14+1.407190e+01*s15+1.228844e+01*s16+(-1.461404e+00)*s17+1.094521e+01*s18+4.588357e+00*s19 \
v80_part3=v80_part2+2.936847e+01*s20+1.410416e+01*s21+(-7.995794e+00)*s22+(-1.206319e+01)*s23+(-2.504262e+01)*s24+1.092515e+01*s25+2.828251e+01*s26+1.590017e+01*s27+2.915845e+01*s28+(-5.251405e+01)*s29 \
v80=v80_part3+1.406396e+01*s30+3.187221e+01*s31+2.533518e+01*s32+1.888846e+01*s33+(-2.686822e+00)*s34+(-3.721078e+02)*s35+(-5.034564e+01)*s36+2.240644e+01*s37+2.411764e+01*s38+3.848401e+01*s39 \
v81_part1=2.832375e+01*s0+1.627151e+01*s1+(-1.064256e+01)*s2+(-6.673123e-01)*s3+(-2.727289e+00)*s4+(-2.805256e+00)*s5+(-1.000000e+04)*s6+1.341470e+01*s7+4.044439e+01*s8+(-1.319705e+01)*s9 \
v81_part2=v81_part1+7.389050e-03*s10+9.672713e+00*s11+4.299474e+00*s12+(-6.623983e+00)*s13+(-1.430574e+01)*s14+(-3.435102e+00)*s15+(-8.757749e+01)*s16+(-7.105231e+00)*s17+4.219651e+00*s18+1.119077e+01*s19 \
v81_part3=v81_part2+1.895286e+01*s20+6.063216e+00*s21+(-1.267958e+01)*s22+(-1.208951e+01)*s23+(-2.370450e+01)*s24+(-5.211593e+00)*s25+3.287598e+00*s26+(-1.101231e+01)*s27+2.531868e+00*s28+(-5.638346e+01)*s29 \
v81=v81_part3+(-3.512970e+00)*s30+(-1.885237e-01)*s31+(-5.289229e+00)*s32+(-1.317969e+01)*s33+(-2.144489e+01)*s34+(-2.844526e+02)*s35+(-3.933301e+01)*s36+(-6.201341e+00)*s37+(-2.302237e+00)*s38+1.720193e+01*s39 \
v82_part1=(-2.987483e+01)*s0+1.452376e+00*s1+4.474657e+01*s2+(-2.142298e-01)*s3+5.062578e+00*s4+(-1.984779e+02)*s5+(-1.000000e+04)*s6+(-1.305247e+01)*s7+1.932790e+01*s8+(-3.118816e+00)*s9 \
v82_part2=v82_part1+(-2.840166e+01)*s10+(-2.165896e+00)*s11+(-9.561499e+00)*s12+5.300266e+00*s13+1.269930e+01*s14+2.676220e+00*s15+3.537457e+01*s16+6.341797e+00*s17+(-4.290024e+00)*s18+(-1.408673e+01)*s19 \
v82_part3=v82_part2+(-4.035087e+01)*s20+(-1.061555e+01)*s21+1.922428e+01*s22+1.695592e+01*s23+3.330183e+01*s24+2.893771e+00*s25+(-7.299524e+00)*s26+7.884931e+00*s27+(-7.378873e+00)*s28+7.946957e+01*s29 \
v82=v82_part3+(-2.558656e-01)*s30+(-1.222344e+01)*s31+(-2.844301e+00)*s32+6.225813e+00*s33+2.151909e+01*s34+4.099062e+02*s35+7.678721e+01*s36+2.984610e+00*s37+(-2.067332e+00)*s38+(-2.713888e+01)*s39 \
v83_part1=(-9.029164e+00)*s0+(-2.480209e+00)*s1+7.958423e-01*s2+(-8.955882e+00)*s3+3.128323e+00*s4+(-1.237773e+02)*s5+(-1.652322e+02)*s6+3.454720e-01*s7+2.268509e+01*s8+1.734542e+01*s9 \
v83_part2=v83_part1+(-9.386554e-02)*s10+1.080235e+00*s11+2.833257e+00*s12+(-9.523623e-01)*s13+(-5.885626e-01)*s14+(-1.975045e-01)*s15+(-1.623143e+02)*s16+(-5.162933e+00)*s17+2.265674e+00*s18+4.424446e+00*s19 \
v83_part3=v83_part2+(-2.331576e+00)*s20+(-4.498416e+01)*s21+2.246256e+00*s22+1.832960e-01*s23+(-1.402009e-02)*s24+1.668877e-01*s25+6.051727e-01*s26+6.180174e-02*s27+(-1.740281e+00)*s28+(-4.429371e+00)*s29 \
v83=v83_part3+2.116701e+00*s30+(-5.696553e-01)*s31+(-2.164777e+01)*s32+1.916081e+00*s33+(-3.306244e+01)*s34+(-9.121382e+00)*s35+2.691207e+00*s36+1.044791e+01*s37+(-9.987617e-01)*s38+(-9.774874e+00)*s39 \
v84_part1=1.514620e+00*s0+(-3.376366e+00)*s1+(-3.079651e+00)*s2+1.238321e+01*s3+(-1.720294e+00)*s4+(-2.651705e+01)*s5+(-1.166676e+03)*s6+2.726287e+00*s7+(-3.624624e+01)*s8+(-4.011250e+01)*s9 \
v84_part2=v84_part1+7.112004e-01*s10+(-1.038176e+00)*s11+(-1.179107e+00)*s12+2.091988e+00*s13+(-7.846875e-01)*s14+5.554536e-02*s15+(-2.537815e+02)*s16+2.297038e+00*s17+(-2.834900e+00)*s18+(-5.619851e+00)*s19 \
v84_part3=v84_part2+1.074195e+00*s20+7.006445e+01*s21+(-2.918004e+00)*s22+(-4.307790e-01)*s23+1.354820e-01*s24+(-1.407636e+00)*s25+(-1.523937e+00)*s26+2.281490e-01*s27+1.179084e+00*s28+6.260258e+00*s29 \
v84=v84_part3+1.231217e-01*s30+(-4.467698e+00)*s31+2.413168e+01*s32+2.537147e+00*s33+2.128090e+01*s34+3.317230e+00*s35+(-4.409057e+00)*s36+(-8.064092e+00)*s37+1.649946e+00*s38+2.410226e+00*s39 \
v85_part1=1.746389e-01*s0+8.537971e+00*s1+(-2.604502e-02)*s2+(-3.806947e-01)*s3+(-8.868978e-01)*s4+(-3.483410e+02)*s5+(-3.879971e+02)*s6+(-6.915592e-01)*s7+(-5.356619e+00)*s8+6.356080e+00*s9 \
v85_part2=v85_part1+(-7.780890e-01)*s10+8.879140e-01*s11+(-2.545022e+00)*s12+(-9.857373e-01)*s13+(-9.055118e-01)*s14+2.453310e-02*s15+(-2.156332e+02)*s16+3.066691e+00*s17+(-1.542732e-01)*s18+(-1.660131e+00)*s19 \
v85_part3=v85_part2+9.930397e-01*s20+6.043032e+00*s21+(-3.777207e-01)*s22+(-3.732022e-02)*s23+9.463468e-02*s24+(-1.388788e+00)*s25+1.695157e+00*s26+(-6.326750e-01)*s27+5.275357e-02*s28+(-1.993270e+00)*s29 \
v85=v85_part3+(-2.521720e+00)*s30+(-7.355941e-01)*s31+3.221147e+00*s32+(-6.881419e+00)*s33+1.238664e+01*s34+5.150841e+00*s35+4.784001e+00*s36+(-4.752584e+00)*s37+(-8.979426e-01)*s38+9.588025e+00*s39 \
v86_part1=2.144025e+01*s0+(-9.629245e+00)*s1+(-7.135081e+00)*s2+3.276534e+00*s3+2.594963e+00*s4+1.140306e+01*s5+2.178598e+00*s6+6.908614e+00*s7+1.526684e+01*s8+1.102295e+01*s9 \
v86_part2=v86_part1+1.870946e+00*s10+1.580875e+00*s11+1.699200e+00*s12+2.163514e+00*s13+1.573644e+00*s14+1.000000e+04*s15+(-1.756184e+00)*s16+8.731500e+00*s17+3.570592e+00*s18+8.434155e+00*s19 \
v86_part3=v86_part2+(-3.024741e+00)*s20+1.565123e+02*s21+7.170034e+00*s22+7.114192e+00*s23+5.933389e+01*s24+(-1.885377e+02)*s25+9.596300e-01*s26+1.750175e+00*s27+(-5.280595e+00)*s28+1.495477e+01*s29 \
v86=v86_part3+(-1.144553e+01)*s30+(-1.588578e+00)*s31+4.800074e+00*s32+(-6.167163e+00)*s33+7.066794e+00*s34+9.371228e+01*s35+(-1.193593e+00)*s36+(-1.077043e+01)*s37+(-1.965454e+00)*s38+5.153555e+01*s39 \
v87_part1=3.656345e+01*s0+1.014248e+01*s1+7.603936e+00*s2+(-1.177064e+00)*s3+(-8.612591e-01)*s4+(-9.509336e+00)*s5+1.156320e+00*s6+4.491035e+01*s7+1.427299e+00*s8+(-9.244001e+00)*s9 \
v87_part2=v87_part1+2.098612e+00*s10+(-6.469476e-01)*s11+6.876712e-01*s12+7.734802e-01*s13+2.627170e+00*s14+1.000000e+04*s15+3.825632e+00*s16+(-6.407405e+00)*s17+(-1.096635e+00)*s18+(-5.868208e+00)*s19 \
v87_part3=v87_part2+4.958518e+00*s20+(-4.557978e+01)*s21+(-4.431109e+00)*s22+(-4.681794e+00)*s23+(-3.987070e+01)*s24+(-6.148313e+01)*s25+1.333779e+00*s26+2.239995e+00*s27+1.363567e+01*s28+(-1.415582e+01)*s29 \
v87=v87_part3+1.219051e+02*s30+3.744366e+00*s31+(-2.062048e+00)*s32+8.528354e+00*s33+(-3.905014e+00)*s34+6.346496e+02*s35+1.269496e+00*s36+1.878634e+01*s37+1.242841e+01*s38+1.000000e+04*s39 \
v88_part1=1.061070e+02*s0+1.291267e+01*s1+1.278249e+01*s2+(-1.470275e+00)*s3+(-1.177455e-01)*s4+(-6.680923e+00)*s5+3.515466e+00*s6+1.416683e+02*s7+4.139408e+00*s8+(-5.858111e+00)*s9 \
v88_part2=v88_part1+1.546709e+00*s10+3.949753e+00*s11+(-6.913157e-01)*s12+(-1.186948e+00)*s13+5.603432e-01*s14+1.000000e+04*s15+4.773246e+00*s16+(-6.034959e+00)*s17+2.211581e+00*s18+(-2.364780e+00)*s19 \
v88_part3=v88_part2+5.313449e+00*s20+4.393695e+01*s21+(-1.943689e+00)*s22+(-1.477821e+00)*s23+(-1.997685e+01)*s24+2.569703e+02*s25+8.223674e-01*s26+(-1.351883e+00)*s27+6.931351e+00*s28+(-1.609198e+01)*s29 \
v88=v88_part3+(-7.406231e+01)*s30+4.739789e+00*s31+(-1.533694e+00)*s32+1.517026e+01*s33+7.337276e-01*s34+(-8.621694e+02)*s35+8.708798e+00*s36+1.156605e+01*s37+(-2.634245e+00)*s38+1.206251e+02*s39 \
v89_part1=1.570121e+02*s0+(-1.239244e+01)*s1+(-1.225313e+01)*s2+6.225565e-01*s3+(-7.703790e-01)*s4+7.417358e+00*s5+(-2.676068e+00)*s6+(-1.046557e+02)*s7+(-1.402911e+01)*s8+5.644473e+00*s9 \
v89_part2=v89_part1+2.410836e+00*s10+(-4.279474e+00)*s11+(-3.665078e-01)*s12+9.663911e-03*s13+(-2.448274e+00)*s14+1.000000e+04*s15+(-4.964831e+00)*s16+6.155377e+00*s17+(-1.912289e+00)*s18+2.748172e+00*s19 \
v89_part3=v89_part2+(-6.474487e+00)*s20+(-1.003021e+02)*s21+1.603757e+00*s22+1.341091e+00*s23+1.946801e+01*s24+5.516535e+01*s25+(-1.557024e+00)*s26+(-4.583900e-01)*s27+(-1.238986e+01)*s28+2.026235e+01*s29 \
v89=v89_part3+1.415512e+01*s30+(-4.743119e+00)*s31+1.520948e+00*s32+(-1.432314e+01)*s33+(-5.156419e-01)*s34+(-4.880012e+02)*s35+(-7.773189e+00)*s36+(-1.653143e+01)*s37+(-2.052110e+00)*s38+9.948271e+02*s39 \
v90_part1=(-1.536747e+01)*s0+1.984017e+00*s1+(-1.405814e-01)*s2+(-8.740257e-01)*s3+4.877147e-01*s4+1.104990e+00*s5+(-9.744634e-01)*s6+(-4.201809e+01)*s7+(-9.364658e+00)*s8+(-1.584551e+00)*s9 \
v90_part2=v90_part1+(-6.117965e+00)*s10+8.119955e-02*s11+1.740585e-01*s12+(-2.504583e-01)*s13+(-1.566389e+00)*s14+1.157705e+02*s15+(-3.867273e-01)*s16+(-3.372782e+00)*s17+8.290332e-01*s18+2.400124e-01*s19 \
v90_part3=v90_part2+(-1.350843e-01)*s20+(-6.802445e+02)*s21+(-4.101953e-01)*s22+1.450867e-02*s23+4.911328e+01*s24+7.471945e+00*s25+(-9.022431e-02)*s26+5.996632e-01*s27+(-3.669892e+00)*s28+(-2.299671e+00)*s29 \
v90=v90_part3+(-4.566946e+00)*s30+(-1.230920e+00)*s31+4.047120e-01*s32+(-6.834567e-01)*s33+(-2.785926e+00)*s34+9.505510e+01*s35+3.892100e-02*s36+4.291567e+00*s37+(-2.090675e-01)*s38+1.225826e+02*s39 \
v91_part1=(-1.157704e+01)*s0+(-2.106449e+00)*s1+6.599006e-01*s2+2.022540e+00*s3+(-5.385844e-01)*s4+6.572056e-03*s5+1.226126e+00*s6+(-4.853082e+00)*s7+5.071128e+00*s8+1.335716e+00*s9 \
v91_part2=v91_part1+(-7.999671e+00)*s10+(-3.146251e-01)*s11+(-1.238258e-01)*s12+2.750412e-01*s13+9.903102e-01*s14+8.721540e+01*s15+7.464149e-02*s16+2.028411e+00*s17+(-9.058622e-01)*s18+(-6.887386e-01)*s19 \
v91_part3=v91_part2+(-2.800571e-01)*s20+3.110113e+02*s21+(-7.232286e-02)*s22+5.436723e-02*s23+(-2.858542e+01)*s24+7.123253e+00*s25+2.038082e-01*s26+(-1.418470e-01)*s27+2.106166e+00*s28+2.032337e+00*s29 \
v91=v91_part3+7.224649e-01*s30+5.946213e-01*s31+3.937568e-01*s32+1.028736e+00*s33+1.819549e+00*s34+7.160952e+01*s35+(-4.260563e-01)*s36+(-3.118533e+00)*s37+(-8.772518e-01)*s38+7.466440e+01*s39 \
v92_part1=(-1.935343e+01)*s0+(-1.738528e-01)*s1+(-8.674435e-01)*s2+(-1.181560e+00)*s3+(-6.376162e-02)*s4+(-5.735162e-01)*s5+(-3.640326e-03)*s6+2.463228e+02*s7+3.928108e+00*s8+(-4.747260e-02)*s9 \
v92_part2=v92_part1+(-5.735996e+00)*s10+8.449360e-02*s11+(-2.162850e-01)*s12+(-5.108346e-02)*s13+1.445123e-01*s14+1.457987e+02*s15+3.398040e-01*s16+1.390101e+00*s17+(-9.601063e-03)*s18+3.305048e-01*s19 \
v92_part3=v92_part2+4.819911e-01*s20+2.877653e+02*s21+3.708036e-01*s22+(-1.900389e-01)*s23+(-1.819920e+01)*s24+6.385908e+00*s25+1.462364e-02*s26+(-6.561111e-01)*s27+2.026076e+00*s28+(-3.156324e-01)*s29 \
v92=v92_part3+7.806314e-01*s30+7.145479e-02*s31+(-9.095887e-01)*s32+(-4.931620e-01)*s33+1.149341e+00*s34+1.197102e+02*s35+4.875145e-01*s36+(-2.102761e+00)*s37+6.058354e-01*s38+8.211311e+01*s39 \
v93_part1=4.438094e+02*s0+(-4.899856e+01)*s1+(-3.810713e+01)*s2+1.748267e+02*s3+(-1.000000e+04)*s4+(-4.629924e-01)*s5+2.796431e-01*s6+6.707783e-01*s7+1.557240e-02*s8+2.250232e+00*s9 \
v93_part2=v93_part1+2.773637e+01*s10+2.233509e+00*s11+(-1.000000e+04)*s12+(-1.000000e+04)*s13+1.100441e+01*s14+1.504849e+01*s15+(-1.821557e+00)*s16+3.967260e-01*s17+7.931219e-01*s18+8.877712e-01*s19 \
v93_part3=v93_part2+(-3.232838e+01)*s20+1.230136e+00*s21+(-2.804433e-01)*s22+8.155871e-01*s23+8.425054e-01*s24+(-2.315840e+03)*s25+(-1.000000e+04)*s26+(-1.000000e+04)*s27+9.083388e+00*s28+(-1.000000e+04)*s29 \
v93=v93_part3+2.404823e+00*s30+2.636203e-01*s31+2.238544e-01*s32+1.764589e+00*s33+8.167692e-01*s34+(-2.045339e+03)*s35+(-1.308584e+03)*s36+(-1.184812e+01)*s37+(-1.000000e+04)*s38+1.039519e+02*s39 \
v94_part1=3.086345e+02*s0+1.436146e+02*s1+(-9.624798e+00)*s2+5.236889e+02*s3+(-1.000000e+04)*s4+1.648029e+00*s5+6.278544e-01*s6+(-4.404949e-01)*s7+7.537023e-01*s8+(-3.680779e+00)*s9 \
v94_part2=v94_part1+1.671431e+01*s10+(-1.571556e+00)*s11+(-1.000000e+04)*s12+(-1.000000e+04)*s13+(-2.096727e+01)*s14+(-2.490309e+01)*s15+2.951670e+00*s16+4.124507e-02*s17+(-6.279986e-01)*s18+(-8.189379e-01)*s19 \
v94_part3=v94_part2+3.112148e+01*s20+(-6.351427e-01)*s21+1.168898e+00*s22+(-6.498158e-01)*s23+(-1.862239e-01)*s24+7.530570e+01*s25+(-1.000000e+04)*s26+(-1.000000e+04)*s27+(-1.515805e+01)*s28+(-1.000000e+04)*s29 \
v94=v94_part3+(-2.186189e+00)*s30+(-5.543256e-01)*s31+(-4.945202e-01)*s32+(-3.117806e+00)*s33+(-1.630043e+00)*s34+(-1.449785e+03)*s35+(-3.893030e+03)*s36+6.286855e+00*s37+(-1.000000e+04)*s38+1.865198e+02*s39 \
v95_part1=4.900870e+02*s0+(-1.266127e+02)*s1+(-4.319098e+01)*s2+(-8.624580e+02)*s3+(-1.000000e+04)*s4+5.166441e-01*s5+(-2.637452e-01)*s6+(-8.374466e-01)*s7+2.281758e-03*s8+(-7.631432e-01)*s9 \
v95_part2=v95_part1+2.637653e+01*s10+(-3.405619e+00)*s11+(-1.000000e+04)*s12+(-1.000000e+04)*s13+(-9.845339e+00)*s14+1.030853e+01*s15+2.311940e+00*s16+(-1.479126e-01)*s17+(-6.016501e-01)*s18+(-8.133009e-01)*s19 \
v95_part3=v95_part2+2.845049e+01*s20+(-1.190517e+00)*s21+6.446336e-01*s22+(-3.603173e-01)*s23+(-9.127314e-01)*s24+1.987521e+02*s25+(-1.000000e+04)*s26+(-1.000000e+04)*s27+(-7.512024e+00)*s28+(-1.000000e+04)*s29 \
v95=v95_part3+(-3.539192e+00)*s30+4.257885e-01*s31+4.520109e-01*s32+(-1.167976e+00)*s33+(-3.582282e-01)*s34+3.385318e+02*s35+(-2.533292e+03)*s36+1.636842e+01*s37+(-1.000000e+04)*s38+(-9.042953e+02)*s39 \
v96_part1=4.494388e+02*s0+(-3.850099e+01)*s1+(-9.096972e+00)*s2+(-1.848925e+02)*s3+(-1.000000e+04)*s4+(-6.194611e-01)*s5+4.298300e-01*s6+9.003102e-01*s7+4.881901e-01*s8+2.174537e+00*s9 \
v96_part2=v96_part1+3.097817e+00*s10+3.391514e+00*s11+(-1.000000e+04)*s12+(-1.000000e+04)*s13+1.964305e+01*s14+(-1.732456e+01)*s15+(-2.598299e+00)*s16+4.314431e-01*s17+1.042485e+00*s18+1.317774e+00*s19 \
v96_part3=v96_part2+(-2.625490e+01)*s20+1.567893e+00*s21+(-8.934909e-01)*s22+7.410145e-01*s23+1.393319e+00*s24+6.297334e+03*s25+(-1.000000e+04)*s26+(-1.000000e+04)*s27+1.308010e+01*s28+(-1.000000e+04)*s29 \
v96=v96_part3+4.012936e+00*s30+2.839794e-01*s31+(-9.959268e-02)*s32+2.758271e+00*s33+1.168920e+00*s34+(-9.019038e+02)*s35+(-1.670531e+03)*s36+(-1.218814e+01)*s37+(-1.000000e+04)*s38+3.870856e+02*s39 \
v97_part1=(-2.365028e+01)*s0+7.770391e+00*s1+1.976237e+01*s2+(-1.077609e+01)*s3+(-1.962583e+03)*s4+7.475464e-02*s5+1.143521e-01*s6+(-1.467534e-02)*s7+2.095858e-01*s8+(-3.407691e-01)*s9 \
v97_part2=v97_part1+(-1.928145e+00)*s10+3.815742e-01*s11+(-1.000000e+04)*s12+(-1.000000e+04)*s13+(-1.096752e+00)*s14+(-1.066580e+01)*s15+1.174177e-01*s16+7.596293e-02*s17+(-1.066990e-01)*s18+(-4.051832e-02)*s19 \
v97_part3=v97_part2+1.963107e+00*s20+1.927361e+00*s21+1.616644e-02*s22+6.240598e-02*s23+(-1.816097e-01)*s24+1.116100e+00*s25+(-8.772547e+02)*s26+(-6.991093e+02)*s27+1.399188e+00*s28+(-1.144474e+03)*s29 \
v97=v97_part3+(-4.260060e-01)*s30+9.555173e-02*s31+1.282158e+00*s32+(-1.610199e-02)*s33+1.048820e+00*s34+1.134020e+02*s35+(-2.063325e+00)*s36+1.090827e+01*s37+(-9.668361e+01)*s38+4.229243e+01*s39 \
v98_part1=(-1.245074e+01)*s0+3.093380e+01*s1+2.768346e+01*s2+1.106918e+01*s3+(-1.000000e+04)*s4+1.614055e-01*s5+(-1.818874e-02)*s6+(-1.738052e-01)*s7+2.211211e-01*s8+6.324045e-01*s9 \
v98_part2=v98_part1+(-1.936365e+00)*s10+(-1.176322e+00)*s11+(-2.709052e+03)*s12+(-1.000000e+04)*s13+(-2.305375e+00)*s14+1.792696e+01*s15+(-3.278175e-01)*s16+(-2.052401e-01)*s17+1.813130e-01*s18+(-5.878512e-02)*s19 \
v98_part3=v98_part2+(-1.303089e+00)*s20+(-3.081395e+00)*s21+3.416384e-02*s22+8.279371e-02*s23+4.937922e-01*s24+4.974307e+00*s25+(-8.809946e+02)*s26+(-1.119566e+02)*s27+(-2.761280e+00)*s28+(-1.398465e+03)*s29 \
v98=v98_part3+(-2.679969e-01)*s30+(-1.257726e-01)*s31+(-1.521804e+00)*s32+(-9.209178e-02)*s33+(-6.009885e-01)*s34+5.970070e+01*s35+(-2.592469e+00)*s36+1.138207e+01*s37+(-4.821208e+01)*s38+5.607704e+01*s39 \
v99_part1=(-4.135426e+00)*s0+9.905756e+00*s1+1.141278e+01*s2+(-3.967580e-01)*s3+(-7.291282e+03)*s4+(-1.570360e-01)*s5+(-4.375428e-02)*s6+6.401082e-02*s7+(-3.750024e-01)*s8+8.669197e-02*s9 \
v99_part2=v99_part1+(-7.381524e+00)*s10+5.853917e-01*s11+(-6.401303e+03)*s12+(-3.070936e+03)*s13+2.826749e+00*s14+(-1.419068e-01)*s15+2.454651e-01*s16+1.292395e-01*s17+(-5.557660e-03)*s18+1.137153e-01*s19 \
v99_part3=v99_part2+(-6.599432e-01)*s20+(-1.557722e-01)*s21+(-3.270467e-02)*s22+(-1.326478e-01)*s23+(-1.797411e-01)*s24+6.601409e-01*s25+(-1.783397e+03)*s26+(-2.645458e+02)*s27+6.370956e-01*s28+(-1.078095e+03)*s29 \
v99=v99_part3+6.059966e-01*s30+2.924135e-01*s31+(-1.278933e-01)*s32+1.852934e-01*s33+(-4.046092e-01)*s34+6.562078e-01*s35+(-3.376718e+00)*s36+(-1.912804e+01)*s37+(-1.263837e+02)*s38+3.257971e+01*s39 \
_p0=v0+v1*od_+v2*w_+v3*od_*w_ \
_p1=_p0+v4*(s_-0.7)+v5*(s_-0.7)*od_+v6*(s_-0.7)*w_ \
_p2=0.5*(_p1+sqrt(_p1*_p1+0.001)) \
_p3=1e-15*_p2 \
_p4=v7+v8*od_+v9*w_+v10*od_*w_+v11*od_/w_ \
_p5=_p4+v12*(s_-0.7)+v13*(s_-0.7)*od_+v14*(s_-0.7)*w_ \
_p6=sqsk_drs_1p7m0t1f1u*0.5*(_p5+sqrt(_p5*_p5+0.001)) \
_p7=v15+v16*od_+v17*w_+v18*od_*w_ \
_p8=_p7+v19*(s_-0.7)+v20*(s_-0.7)*od_+v21*(s_-0.7)*w_ \
_p9=0.5*(_p8+sqrt(_p8*_p8+0.001)) \
_p10=sqsk_dls_1p7m0t1f1u*1e-09*_p9 \
_p11=v22+v23*od_+v24*w_+v25*od_*w_+v26*od_/w_ \
_p12=_p11+v27*(s_-0.7)+v28*(s_-0.7)*od_+v29*(s_-0.7)*w_ \
_p13=sqsk_drs_1p7m0t1f1u*0.5*(_p12+sqrt(_p12*_p12+0.001)) \
_p14=v30+v31*od_+v32*w_+v33*od_*w_ \
_p15=_p14+v34*(s_-0.7)+v35*(s_-0.7)*od_+v36*(s_-0.7)*w_ \
_p16=0.5*(_p15+sqrt(_p15*_p15+0.001)) \
_p17=sqsk_dls_1p7m0t1f1u*1e-09*_p16 \
_p18=v37+v38*od_+v39*w_+v40*od_*w_ \
_p19=_p18+v41*(s_-0.7)+v42*(s_-0.7)*od_+v43*(s_-0.7)*w_ \
_p20=0.5*(atan(2*_p19)/1.5708+1) \
_p21=v44+v45*od_+v46*w_+v47*od_*w_ \
_p22=_p21+v48*(s_-0.7)+v49*(s_-0.7)*od_+v50*(s_-0.7)*w_ \
_p23=0.5*(_p22+sqrt(_p22*_p22+0.001)) \
_p24=v51+v52*od_+v53*w_+v54*od_*w_ \
_p25=_p24+v55*(s_-0.7)+v56*(s_-0.7)*od_+v57*(s_-0.7)*w_ \
_p26=0.5*(_p25+sqrt(_p25*_p25+0.001)) \
_p27=v58+v59*od_+v60*w_+v61*od_*w_ \
_p28=_p27+v62*(s_-0.7)+v63*(s_-0.7)*od_+v64*(s_-0.7)*w_ \
_p29=0.5*(_p28+sqrt(_p28*_p28+0.001)) \
_p30=v65+v66*od_+v67*w_+v68*od_*w_ \
_p31=_p30+v69*(s_-0.7)+v70*(s_-0.7)*od_+v71*(s_-0.7)*w_ \
_p32=0.5*(_p31+sqrt(_p31*_p31+0.001)) \
_p33=v72+v73*od_+v74*w_+v75*od_*w_ \
_p34=_p33+v76*(s_-0.7)+v77*(s_-0.7)*od_+v78*(s_-0.7)*w_ \
_p35=0.5*(_p34+sqrt(_p34*_p34+0.001)) \
_p36=v79+v80*od_+v81*w_+v82*od_*w_ \
_p37=_p36+v83*(s_-0.7)+v84*(s_-0.7)*od_+v85*(s_-0.7)*w_ \
_p38=0.5*(_p37+sqrt(_p37*_p37+0.001)) \
_p39=1e-14*_p23 \
_p40=sqsk_drs_sub_1p7m0t1f1u*100*_p26 \
_p41=1e-15*_p29 \
_p42=1e-14*_p32 \
_p43=sqsk_drs_sub_1p7m0t1f1u*100*_p35 \
_p44=1e-15*_p38 \
_p45=v86+v87*od_+v88*w_+v89*od_*w_ \
_p46=_p45+v90*(s_-0.7)+v91*(s_-0.7)*od_+v92*(s_-0.7)*w_ \
_p47=0.5*(_p46+sqrt(_p46*_p46+0.001)) \
_p48=v93+v94*od_+v95*w_+v96*od_*w_ \
_p49=_p48+v97*(s_-0.7)+v98*(s_-0.7)*od_+v99*(s_-0.7)*w_ \
_p50=0.5*(_p49+sqrt(_p49*_p49+0.001)) \
_p51=sqsk_drs_sub_1p7m0t1f1u*100*_p47 \
_p52=1e-13*_p50
cs (top bottom) capacitor c=_p3
rs1_1 (top n1_1) resistor r=_p6
ls1_1 (n1_1 bottom) inductor l=_p10
rs1_2 (top n1_2) resistor r=_p13
ls1_2 (n1_2 bottom) inductor l=_p17
k1 mutual_inductor coupling=_p20 ind1=ls1_1 ind2=ls1_2
c_1_sub (top _n1_1_sub) capacitor c=_p39
rs_1_sub (_n1_1_sub sub) resistor r=_p40
cs_1_sub (_n1_1_sub sub) capacitor c=_p41
c_2_sub (bottom _n1_2_sub) capacitor c=_p42
rs_2_sub (_n1_2_sub sub) resistor r=_p43
cs_2_sub (_n1_2_sub sub) capacitor c=_p44
rx_1_2_sub (_n1_1_sub _n1_2_sub) resistor r=_p51
cx_1_2_sub (_n1_1_sub _n1_2_sub) capacitor c=_p52
ends l_sqsk_rfvil_1p7m0t1f1u
