//  ********************************************************************
//     P+/Nwell Junction Varactor RF subcircuit model Library
//     UMC 0.11um RFCMOS process
//     Feb. 2010
//
//     Case Definition:
//     typ: Typical case
//     min: Mimimum capacitance case
//     max: Maximum capacitance case
//
//  ********************************************************************
//
simulator lang=spectre insensitive=yes
library mylib

section typ
parameters d_re_unit=0
parameters d_rsh_nw=0
parameters d_cf_m1=0
parameters d_cjo_ppnw=0
parameters d_cjsw_ppnw=0
parameters d_cjo_nwpsub=0
parameters d_cjsw_nwpsub=0
include "l110ae_vardiop_rf_v021.mdl.scs"
endsection typ
//
//
section min
parameters d_re_unit=0.2
parameters d_rsh_nw=0.2
parameters d_cf_m1=-0.2
parameters d_cjo_ppnw=-0.1
parameters d_cjsw_ppnw=-0.1
parameters d_cjo_nwpsub=-0.1
parameters d_cjsw_nwpsub=-0.1
include "l110ae_vardiop_rf_v021.mdl.scs"
endsection min
//
section max
parameters d_re_unit=-0.2
parameters d_rsh_nw=-0.2
parameters d_cf_m1=0.2
parameters d_cjo_ppnw=0.1
parameters d_cjsw_ppnw=0.1
parameters d_cjo_nwpsub=0.1
parameters d_cjsw_nwpsub=0.1
include "l110ae_vardiop_rf_v021.mdl.scs"
endsection max
//
//
endlibrary mylib
