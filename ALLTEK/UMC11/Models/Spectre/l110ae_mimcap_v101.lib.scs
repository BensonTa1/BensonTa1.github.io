simulator lang=spectre insensitive=yes
library mylib

section mimcaps_tt
parameters
+ d_ca_mimcaps_10f_mml110e    =   0.0000e+00
+ d_ca_mimcaps_15f_mml110e		=   0.0000e+00
+ d_ca_mimcaps_20f_mml110e		=   0.0000e+00
include "./l110ae_mimcap_v101.mdl.scs"
endsection mimcaps_tt

section mimcaps_ss
parameters
+ d_ca_mimcaps_10f_mml110e    =   0.15
+ d_ca_mimcaps_15f_mml110e		=   0.15
+ d_ca_mimcaps_20f_mml110e		=   0.15
include "./l110ae_mimcap_v101.mdl.scs"
endsection mimcaps_ss

section mimcaps_ff
parameters
+ d_ca_mimcaps_10f_mml110e    =   -0.15
+ d_ca_mimcaps_15f_mml110e		=   -0.15
+ d_ca_mimcaps_20f_mml110e		=   -0.15
include "./l110ae_mimcap_v101.mdl.scs"
endsection mimcaps_ff
endlibrary mylib
