//******************************************************************************
simulator lang=spectre insensitive=yes
//TT: Typical n-ch MOSFET and Typical p-ch MOSFET
//FF: Fast n-ch MOSFET and Fast p-ch MOSFET
//SS: Slow n-ch MOSFET and Slow p-ch MOSFET
//FNSP: Fast n-ch MOSFET and Slow p-ch MOSFET
//SNFP: Slow n-ch MOSFET and Fast p-ch MOSFET
//******************************************************************************
//
library mylib
section tt
parameters dtox_n_nvt_33_l110e=0.0000000e+000
parameters dxl_n_nvt_33_l110e=0.0000000e+000
parameters dvth0_n_nvt_33_l110e=0.0000000e+000
parameters du0_n_nvt_33_l110e=0.0000000e+000
parameters drdsw_n_nvt_33_l110e=0.0000000e+000
parameters dlvth0_n_nvt_33_l110e=0.0000000e+000
parameters dk3_n_nvt_33_l110e=0.0000000e+000
parameters dxw_n_nvt_33_l110e=0.0000000e+000
parameters dwwl_n_nvt_33_l110e=0.0000000e+000
parameters dcj_n_nvt_33_l110e=0.0000000e+000
parameters dcjsw_n_nvt_33_l110e=0.0000000e+000
parameters dcjswg_n_nvt_33_l110e=0.0000000e+000
parameters dcgdo_n_nvt_33_l110e=0.0000000e+000
parameters dcgso_n_nvt_33_l110e=0.0000000e+000
parameters dpvth0_n_nvt_33_l110e=0.0000000e+000
parameters dwu0_n_nvt_33_l110e=0.0000000e+000
parameters dags_n_nvt_33_l110e=0.0000000e+000
parameters dvsat_n_nvt_33_l110e=0.0000000e+000
parameters dwags_n_nvt_33_l110e=0.0000000e+000
parameters dpags_n_nvt_33_l110e=0.0000000e+000
parameters dlu0_n_nvt_33_l110e=0.0000000e+000
parameters dpu0_n_nvt_33_l110e=0.0000000e+000
+
include "l110ae_nvt_33_v031.mdl.scs"
+
endsection tt
//
section ff
parameters dtox_n_nvt_33_l110e=-1.5000000e-010
parameters dxl_n_nvt_33_l110e=-1.0000000e-008
parameters dvth0_n_nvt_33_l110e=-6.8241738e-002
parameters du0_n_nvt_33_l110e=1.5362355e-003
parameters drdsw_n_nvt_33_l110e=-3.3791421e+002
parameters dlvth0_n_nvt_33_l110e=-4.1457609e-008
parameters dk3_n_nvt_33_l110e=-5.2078634e+000
parameters dxw_n_nvt_33_l110e=6.7710000e-009
parameters dwwl_n_nvt_33_l110e=3.0182042e-023
parameters dcj_n_nvt_33_l110e=-1.2064000e-005
parameters dcjsw_n_nvt_33_l110e=-3.4543000e-011
parameters dcjswg_n_nvt_33_l110e=-1.1260000e-011
parameters dcgdo_n_nvt_33_l110e=2.1620000e-011
parameters dcgso_n_nvt_33_l110e=2.1620000e-011
parameters dpvth0_n_nvt_33_l110e=4.0654000e-014
parameters dwu0_n_nvt_33_l110e=2.7425966e-010
parameters dags_n_nvt_33_l110e=-2.9680866e-002
parameters dvsat_n_nvt_33_l110e=-3.0667473e+003
parameters dwags_n_nvt_33_l110e=-1.2762955e-007
parameters dpags_n_nvt_33_l110e=6.3932063e-013
parameters dlu0_n_nvt_33_l110e=3.7319258e-011
parameters dpu0_n_nvt_33_l110e=-4.2179631e-016
+
include "l110ae_nvt_33_v031.mdl.scs"
+
endsection ff
//
section ss
parameters dtox_n_nvt_33_l110e=1.5000000e-010
parameters dxl_n_nvt_33_l110e=1.0000000e-008
parameters dvth0_n_nvt_33_l110e=6.8165293e-002
parameters du0_n_nvt_33_l110e=-1.4878105e-003
parameters drdsw_n_nvt_33_l110e=4.2018477e+002
parameters dlvth0_n_nvt_33_l110e=3.6984510e-008
parameters dk3_n_nvt_33_l110e=4.8206537e+000
parameters dxw_n_nvt_33_l110e=-1.1190000e-008
parameters dwwl_n_nvt_33_l110e=-4.4320597e-023
parameters dcj_n_nvt_33_l110e=1.2064000e-005
parameters dcjsw_n_nvt_33_l110e=3.4543000e-011
parameters dcjswg_n_nvt_33_l110e=1.1260000e-011
parameters dcgdo_n_nvt_33_l110e=-2.1620000e-011
parameters dcgso_n_nvt_33_l110e=-2.1620000e-011
parameters dpvth0_n_nvt_33_l110e=-3.9811332e-014
parameters dwu0_n_nvt_33_l110e=-3.4903452e-010
parameters dags_n_nvt_33_l110e=7.6731390e-003
parameters dvsat_n_nvt_33_l110e=9.9354206e+003
parameters dwags_n_nvt_33_l110e=1.3112506e-007
parameters dpags_n_nvt_33_l110e=-6.1048787e-013
parameters dlu0_n_nvt_33_l110e=-4.1020381e-009
parameters dpu0_n_nvt_33_l110e=1.2739422e-015
+
include "l110ae_nvt_33_v031.mdl.scs"
+
endsection ss
//
//
endlibrary mylib
