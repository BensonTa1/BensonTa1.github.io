simulator lang=spectre insensitive=yes
// Model: l_sqctout_trans_rfvil
// UMC 0.11um 1P8M top metal 41K transformer, secondary tapped
// Date: 2009-12-26
// Model coverage:
// od: (75 - 300) * 1e-06 (Before shrinkage)
// w: (5.2 - 11.9) * 1e-06 (Before shrinkage)
// nt_in: 1 - 9 (Integer)
// nt_out: 1 - 9 (Integer)
// Frequency range: 1 MHz - 0.8 * resonance (maximum 30.0 GHz)
subckt l_sqctout_trans_rfvil (p1 p2 s1 s2 cts gnd)
parameters od=0.00025 od_=0.00333333*(od/1e-06-0) w=6e-06 w_=0.0833333*(w/1e-06-0) nt_in=4 nt_out=4  \
t0=(nt_in==1) \
t1=(nt_out==1) \
t2=(od_+3.275000e-01*w_>=0.833028) \
t3=(od_+3.638889e-01*w_>=0.821742) \
t4=(od_+5.458333e-01*w_>=0.832113) \
t5=(w_+8.791209e-01*od_>=0.829425) \
t6=(od_+4.093750e-01*w_>=0.815985) \
t7=(od_+4.678571e-01*w_>=0.818125) \
t8=(w_+8.791209e-01*od_>=0.829156) \
t9=(od_+4.275000e-01*w_>=0.809643) \
t10=(od_+5.343750e-01*w_>=0.845237) \
t11=(w_+8.888889e-01*od_>=0.967356) \
t12=(w_+8.888889e-01*od_>=0.967088) \
t13=(od_+3.375000e-01*w_>=0.76404) \
t14=(od_+5.062500e-01*w_>=0.845894) \
t15=(w_+9.876543e-01*od_>=1.14396) \
t16=(w_+9.876543e-01*od_>=1.14369) \
t17=(od_>=0.5334) \
t18=(od_>=0.533267) \
t19=(od_+5.062500e-01*w_>=0.845559) \
t20=(od_>=0.600067) \
t21=(od_+3.375000e-01*w_>=0.763595) \
t22=(od_+5.343750e-01*w_>=0.844552) \
t23=(od_>=0.666733) \
t24=(od_>=0.599933) \
t25=(od_+4.275000e-01*w_>=0.808855) \
t26=(od_+5.458333e-01*w_>=0.831075) \
t27=(od_>=0.7334) \
t28=(od_>=0.6666) \
t29=(od_>=0.733267) \
t30=(od_+4.678571e-01*w_>=0.816988) \
t31=(od_>=0.800067) \
t32=(od_+4.093750e-01*w_>=0.814739) \
t33=(od_>=0.866733) \
t34=(od_>=0.799933) \
t35=(od_+3.638889e-01*w_>=0.820383) \
t36=(od_>=0.9334) \
t37=(od_>=0.8666) \
t38=(od_>=0.933267) \
t39=(od_+3.275000e-01*w_>=0.831551) \
t40=(nt_out==2) \
t41=(od_+3.537500e-01*w_>=0.845891) \
t42=(od_+3.930556e-01*w_>=0.836035) \
t43=(od_+5.053571e-01*w_>=0.836502) \
t44=(w_+8.791209e-01*od_>=0.811925) \
t45=(od_+4.421875e-01*w_>=0.832064) \
t46=(w_+8.791209e-01*od_>=0.811656) \
t47=(od_+4.000000e-01*w_>=0.821797) \
t48=(od_+6.000000e-01*w_>=0.882363) \
t49=(w_+8.791209e-01*od_>=0.946366) \
t50=(od_+4.800000e-01*w_>=0.839343) \
t51=(w_+8.791209e-01*od_>=0.946097) \
t52=(od_+4.208333e-01*w_>=0.817456) \
t53=(od_+6.312500e-01*w_>=0.926017) \
t54=(w_+8.791209e-01*od_>=1.08081) \
t55=(w_+8.791209e-01*od_>=1.08054) \
t56=(od_+1.250000e-01*w_>=0.622464) \
t57=(od_+1.250000e-01*w_>=0.622328) \
t58=(od_+6.312500e-01*w_>=0.925644) \
t59=(od_+4.208333e-01*w_>=0.816985) \
t60=(od_+6.000000e-01*w_>=0.881637) \
t61=(od_+4.800000e-01*w_>=0.838523) \
t62=(od_+4.000000e-01*w_>=0.820869) \
t63=(od_+5.053571e-01*w_>=0.83533) \
t64=(od_+4.421875e-01*w_>=0.830789) \
t65=(od_+3.930556e-01*w_>=0.834649) \
t66=(od_+3.537500e-01*w_>=0.844391) \
t67=(nt_out==3) \
t68=(od_+4.125000e-01*w_>=0.950874) \
t69=(od_+8.375000e-01*w_>=0.906119) \
t70=(od_+8.375000e-01*w_>=0.905892) \
t71=(od_+3.517857e-01*w_>=0.957095) \
t72=(od_+4.104167e-01*w_>=0.960911) \
t73=(od_+8.375000e-01*w_>=1.01955) \
t74=(od_+8.375000e-01*w_>=1.01932) \
t75=(od_+3.250000e-01*w_>=0.949014) \
t76=(od_+4.062500e-01*w_>=0.969451) \
t77=(od_+8.250000e-01*w_>=1.12467) \
t78=(od_+8.250000e-01*w_>=1.12445) \
t79=(od_+2.666667e-01*w_>=0.917548) \
t80=(od_+4.000000e-01*w_>=0.976155) \
t81=(od_+8.000000e-01*w_>=1.21878) \
t82=(od_+8.000000e-01*w_>=1.21856) \
t83=(od_+4.000000e-01*w_>=0.975845) \
t84=(od_+4.062500e-01*w_>=0.96883) \
t85=(od_+2.666667e-01*w_>=0.917119) \
t86=(od_+4.104167e-01*w_>=0.959976) \
t87=(od_+3.250000e-01*w_>=0.948277) \
t88=(od_+3.517857e-01*w_>=0.956046) \
t89=(od_+4.125000e-01*w_>=0.949626) \
t90=(nt_out==4) \
t91=(od_+5.270833e-01*w_>=1.08936) \
t92=(od_+6.625000e-01*w_>=0.949841) \
t93=(od_+6.625000e-01*w_>=0.949649) \
t94=(od_+5.000000e-01*w_>=1.11708) \
t95=(od_+6.500000e-01*w_>=1.03834) \
t96=(od_+6.562500e-01*w_>=1.08984) \
t97=(od_+6.583333e-01*w_>=1.13904) \
t98=(od_+6.500000e-01*w_>=1.03816) \
t99=(od_+4.625000e-01*w_>=1.13659) \
t100=(od_+6.625000e-01*w_>=1.14114) \
t101=(od_+6.625000e-01*w_>=1.14095) \
t102=(od_+3.958333e-01*w_>=1.13491) \
t103=(od_+6.625000e-01*w_>=1.23707) \
t104=(od_+6.562500e-01*w_>=1.08946) \
t105=(od_+6.583333e-01*w_>=1.13847) \
t106=(od_+6.625000e-01*w_>=1.23688) \
t107=(od_+2.625000e-01*w_>=1.08367) \
t108=(od_+5.250000e-01*w_>=1.23381) \
t109=(od_+5.250000e-01*w_>=1.23364) \
t110=(od_+5.000000e-01*w_>=1.11625) \
t111=(od_+5.270833e-01*w_>=1.08834) \
t112=(od_+4.625000e-01*w_>=1.13595) \
t113=(od_+3.958333e-01*w_>=1.13445) \
t114=(od_+2.625000e-01*w_>=1.08339) \
t115=(nt_out==5) \
t116=(od_+5.375000e-01*w_>=0.932143) \
t117=(od_+5.437500e-01*w_>=0.978618) \
t118=(od_+5.500000e-01*w_>=1.02492) \
t119=(od_+5.375000e-01*w_>=0.931971) \
t120=(od_+5.437500e-01*w_>=1.06477) \
t121=(od_+5.416667e-01*w_>=1.10675) \
t122=(od_+5.437500e-01*w_>=0.978273) \
t123=(od_+5.500000e-01*w_>=1.02475) \
t124=(od_+5.375000e-01*w_>=1.10445) \
t125=(od_+5.416667e-01*w_>=1.19328) \
t126=(od_+5.375000e-01*w_>=1.10427) \
t127=(od_+5.437500e-01*w_>=1.06442) \
t128=(od_+5.375000e-01*w_>=1.19037) \
t129=(od_+5.437500e-01*w_>=1.23752) \
t130=(od_+5.375000e-01*w_>=1.1902) \
t131=(od_+5.416667e-01*w_>=1.10623) \
t132=(od_+5.500000e-01*w_>=1.2845) \
t133=(od_+5.437500e-01*w_>=1.23718) \
t134=(od_+5.500000e-01*w_>=1.28433) \
t135=(od_+5.416667e-01*w_>=1.19276) \
t136=(nt_out==6) \
t137=(od_+4.625000e-01*w_>=1.11261) \
t138=(od_+4.625000e-01*w_>=1.07207) \
t139=(od_+4.625000e-01*w_>=1.03152) \
t140=(od_+4.625000e-01*w_>=1.03136) \
t141=(od_+4.625000e-01*w_>=1.11245) \
t142=(od_+4.625000e-01*w_>=1.07174) \
t143=(od_+4.625000e-01*w_>=1.19338) \
t144=(od_+4.625000e-01*w_>=1.11229) \
t145=(od_+4.625000e-01*w_>=1.19322) \
t146=(od_+4.625000e-01*w_>=1.11213) \
t147=(nt_out==7) \
t148=(od_+4.000000e-01*w_>=1.13574) \
t149=(od_+4.000000e-01*w_>=1.13559) \
t150=(nt_out==8) \
t151=(nt_out==9) \
t152=(nt_in==2) \
t153=(nt_in==3) \
t154=(nt_in==4) \
t155=(nt_in==5) \
t156=(nt_in==6) \
t157=(nt_in==7) \
t158=(nt_in==8) \
t159=(nt_in==9) \
s0=t0*t1*(1-t2)*(1-t3)*(1-t4)*(1-t5)*(1-t6)*(1-t7) \
nos0=(1-s0) \
s1=t0*t1*t8*(1-t9)*(1-t10)*(1-t11)*nos0 \
nos1=(1-s1)*nos0 \
s2=t0*t1*t12*(1-t13)*(1-t14)*(1-t15)*nos1 \
nos2=(1-s2)*nos1 \
s3=t0*t1*t16*(1-t17)*nos2 \
nos3=(1-s3)*nos2 \
s4=t0*t1*t18*t19*(1-t20)*nos3 \
nos4=(1-s4)*nos3 \
s5=t0*t1*t21*t22*(1-t23)*t24*nos4 \
nos5=(1-s5)*nos4 \
s6=t0*t1*t25*t26*(1-t27)*t28*nos5 \
nos6=(1-s6)*nos5 \
s7=t0*t1*t29*t30*(1-t31)*nos6 \
nos7=(1-s7)*nos6 \
s8=t0*t1*t32*(1-t33)*t34*nos7 \
nos8=(1-s8)*nos7 \
s9=t0*t1*t35*(1-t36)*t37*nos8 \
nos9=(1-s9)*nos8 \
s10=t0*t1*t38*t39*nos9 \
nos10=(1-s10)*nos9 \
s11=t0*t40*(1-t41)*(1-t42)*(1-t43)*(1-t44)*(1-t45)*nos10 \
nos11=(1-s11)*nos10 \
s12=t0*t40*t46*(1-t47)*(1-t48)*(1-t49)*(1-t50)*nos11 \
nos12=(1-s12)*nos11 \
s13=t0*t40*t51*(1-t52)*(1-t53)*(1-t54)*nos12 \
nos13=(1-s13)*nos12 \
s14=t0*t40*t55*(1-t56)*nos13 \
nos14=(1-s14)*nos13 \
s15=t0*t40*t57*t58*(1-t20)*nos14 \
nos15=(1-s15)*nos14 \
s16=t0*t40*t59*t60*(1-t23)*t24*nos15 \
nos16=(1-s16)*nos15 \
s17=t0*t40*t61*(1-t27)*t28*nos16 \
nos17=(1-s17)*nos16 \
s18=t0*t40*t62*t63*(1-t31)*t29*nos17 \
nos18=(1-s18)*nos17 \
s19=t0*t40*t64*(1-t33)*t34*nos18 \
nos19=(1-s19)*nos18 \
s20=t0*t40*t65*(1-t36)*t37*nos19 \
nos20=(1-s20)*nos19 \
s21=t0*t40*t38*t66*nos20 \
nos21=(1-s21)*nos20 \
s22=t0*t67*(1-t68)*(1-t69)*nos21 \
nos22=(1-s22)*nos21 \
s23=t0*t67*t70*(1-t71)*(1-t72)*(1-t73)*nos22 \
nos23=(1-s23)*nos22 \
s24=t0*t67*t74*(1-t75)*(1-t76)*(1-t77)*nos23 \
nos24=(1-s24)*nos23 \
s25=t0*t67*t78*(1-t79)*(1-t80)*(1-t81)*nos24 \
nos25=(1-s25)*nos24 \
s26=t0*t67*t82*(1-t27)*nos25 \
nos26=(1-s26)*nos25 \
s27=t0*t67*t83*(1-t31)*t29*nos26 \
nos27=(1-s27)*nos26 \
s28=t0*t67*t84*(1-t33)*t85*t34*nos27 \
nos28=(1-s28)*nos27 \
s29=t0*t67*t86*(1-t36)*t87*t37*nos28 \
nos29=(1-s29)*nos28 \
s30=t0*t67*t88*t89*t38*nos29 \
nos30=(1-s30)*nos29 \
s31=t0*t90*(1-t91)*(1-t92)*nos30 \
nos31=(1-s31)*nos30 \
s32=t0*t90*t93*(1-t94)*(1-t95)*(1-t96)*(1-t97)*nos31 \
nos32=(1-s32)*nos31 \
s33=t0*t90*t98*(1-t99)*(1-t100)*nos32 \
nos33=(1-s33)*nos32 \
s34=t0*t90*t101*(1-t102)*(1-t103)*t104*nos33 \
nos34=(1-s34)*nos33 \
s35=t0*t90*t105*t106*(1-t107)*(1-t108)*nos34 \
nos35=(1-s35)*nos34 \
s36=t0*t90*t109*(1-t36)*nos35 \
nos36=(1-s36)*nos35 \
s37=t0*t90*t110*t111*t112*t113*t38*t114*nos36 \
nos37=(1-s37)*nos36 \
s38=t0*t115*(1-t116)*(1-t117)*nos37 \
nos38=(1-s38)*nos37 \
s39=t0*t115*(1-t118)*t119*(1-t120)*(1-t121)*nos38 \
nos39=(1-s39)*nos38 \
s40=t0*t115*t122*t123*(1-t124)*(1-t125)*nos39 \
nos40=(1-s40)*nos39 \
s41=t0*t115*t126*t127*(1-t128)*(1-t129)*nos40 \
nos41=(1-s41)*nos40 \
s42=t0*t115*t130*t131*(1-t132)*nos41 \
nos42=(1-s42)*nos41 \
s43=t0*t115*t133*t134*t135*nos42 \
nos43=(1-s43)*nos42 \
s44=t0*t136*(1-t137)*(1-t138)*(1-t139)*nos43 \
nos44=(1-s44)*nos43 \
s45=t0*t136*t140*(1-t141)*nos44 \
nos45=(1-s45)*nos44 \
s46=t0*t136*t142*(1-t143)*t144*nos45 \
nos46=(1-s46)*nos45 \
s47=t0*t136*t145*t146*nos46 \
nos47=(1-s47)*nos46 \
s48=t0*t147*(1-t148)*nos47 \
nos48=(1-s48)*nos47 \
s49=t0*t147*t149*nos48 \
nos49=(1-s49)*nos48 \
s50=t0*t150*nos49 \
nos50=(1-s50)*nos49 \
s51=t0*t151*nos50 \
nos51=(1-s51)*nos50 \
s52=t152*t40*(1-t41)*(1-t42)*(1-t43)*(1-t44)*(1-t45)*nos51 \
nos52=(1-s52)*nos51 \
s53=t152*t40*t46*(1-t47)*(1-t48)*(1-t49)*(1-t50)*nos52 \
nos53=(1-s53)*nos52 \
s54=t152*t40*t51*(1-t52)*(1-t53)*(1-t54)*nos53 \
nos54=(1-s54)*nos53 \
s55=t152*t40*t55*(1-t56)*nos54 \
nos55=(1-s55)*nos54 \
s56=t152*t40*t57*t58*(1-t20)*nos55 \
nos56=(1-s56)*nos55 \
s57=t152*t40*t59*t60*(1-t23)*t24*nos56 \
nos57=(1-s57)*nos56 \
s58=t152*t40*t61*(1-t27)*t28*nos57 \
nos58=(1-s58)*nos57 \
s59=t152*t40*t62*t63*(1-t31)*t29*nos58 \
nos59=(1-s59)*nos58 \
s60=t152*t40*t64*(1-t33)*t34*nos59 \
nos60=(1-s60)*nos59 \
s61=t152*t40*t65*(1-t36)*t37*nos60 \
nos61=(1-s61)*nos60 \
s62=t152*t40*t38*t66*nos61 \
nos62=(1-s62)*nos61 \
s63=t152*t90*(1-t91)*(1-t92)*nos62 \
nos63=(1-s63)*nos62 \
s64=t152*t90*t93*(1-t94)*(1-t95)*(1-t96)*(1-t97)*nos63 \
nos64=(1-s64)*nos63 \
s65=t152*t90*t98*(1-t99)*(1-t100)*nos64 \
nos65=(1-s65)*nos64 \
s66=t152*t90*t101*(1-t102)*(1-t103)*t104*nos65 \
nos66=(1-s66)*nos65 \
s67=t152*t90*t105*t106*(1-t107)*(1-t108)*nos66 \
nos67=(1-s67)*nos66 \
s68=t152*t90*t109*(1-t36)*nos67 \
nos68=(1-s68)*nos67 \
s69=t152*t90*t110*t111*t112*t113*t38*t114*nos68 \
nos69=(1-s69)*nos68 \
s70=t153*t67*(1-t68)*(1-t69)*nos69 \
nos70=(1-s70)*nos69 \
s71=t153*t67*t70*(1-t71)*(1-t72)*(1-t73)*nos70 \
nos71=(1-s71)*nos70 \
s72=t153*t67*t74*(1-t75)*(1-t76)*(1-t77)*nos71 \
nos72=(1-s72)*nos71 \
s73=t153*t67*t78*(1-t79)*(1-t80)*(1-t81)*nos72 \
nos73=(1-s73)*nos72 \
s74=t153*t67*t82*(1-t27)*nos73 \
nos74=(1-s74)*nos73 \
s75=t153*t67*t83*(1-t31)*t29*nos74 \
nos75=(1-s75)*nos74 \
s76=t153*t67*t84*(1-t33)*t85*t34*nos75 \
nos76=(1-s76)*nos75 \
s77=t153*t67*t86*(1-t36)*t87*t37*nos76 \
nos77=(1-s77)*nos76 \
s78=t153*t67*t88*t89*t38*nos77 \
nos78=(1-s78)*nos77 \
s79=t153*t136*(1-t137)*(1-t138)*(1-t139)*nos78 \
nos79=(1-s79)*nos78 \
s80=t153*t136*t140*(1-t141)*nos79 \
nos80=(1-s80)*nos79 \
s81=t153*t136*t142*(1-t143)*t144*nos80 \
nos81=(1-s81)*nos80 \
s82=t153*t136*t145*t146*nos81 \
nos82=(1-s82)*nos81 \
s83=t154*t90*(1-t91)*(1-t92)*nos82 \
nos83=(1-s83)*nos82 \
s84=t154*t90*t93*(1-t94)*(1-t95)*(1-t96)*(1-t97)*nos83 \
nos84=(1-s84)*nos83 \
s85=t154*t90*t98*(1-t99)*(1-t100)*nos84 \
nos85=(1-s85)*nos84 \
s86=t154*t90*t101*(1-t102)*(1-t103)*t104*nos85 \
nos86=(1-s86)*nos85 \
s87=t154*t90*t105*t106*(1-t107)*(1-t108)*nos86 \
nos87=(1-s87)*nos86 \
s88=t154*t90*t109*(1-t36)*nos87 \
nos88=(1-s88)*nos87 \
s89=t154*t90*t110*t111*t112*t113*t38*t114*nos88 \
nos89=(1-s89)*nos88 \
s90=t154*t150*nos89 \
nos90=(1-s90)*nos89 \
s91=t155*t115*(1-t116)*(1-t117)*nos90 \
nos91=(1-s91)*nos90 \
s92=t155*t115*(1-t118)*t119*(1-t120)*(1-t121)*nos91 \
nos92=(1-s92)*nos91 \
s93=t155*t115*t122*t123*(1-t124)*(1-t125)*nos92 \
nos93=(1-s93)*nos92 \
s94=t155*t115*t126*t127*(1-t128)*(1-t129)*nos93 \
nos94=(1-s94)*nos93 \
s95=t155*t115*t130*t131*(1-t132)*nos94 \
nos95=(1-s95)*nos94 \
s96=t155*t115*t133*t134*t135*nos95 \
nos96=(1-s96)*nos95 \
s97=t156*t136*(1-t137)*(1-t138)*(1-t139)*nos96 \
nos97=(1-s97)*nos96 \
s98=t156*t136*t140*(1-t141)*nos97 \
nos98=(1-s98)*nos97 \
s99=t156*t136*t142*(1-t143)*t144*nos98 \
nos99=(1-s99)*nos98 \
s100=t156*t136*t145*t146*nos99 \
nos100=(1-s100)*nos99 \
s101=t157*t147*(1-t148)*nos100 \
nos101=(1-s101)*nos100 \
s102=t157*t147*t149*nos101 \
nos102=(1-s102)*nos101 \
s103=t158*t150*nos102 \
nos103=(1-s103)*nos102 \
s104=t159*t151*nos103 \
nos104=(1-s104)*nos103 \
v0_part1=(-1.027794e-01)*s0+(-1.048060e-02)*s1+8.969227e-03*s2+(-3.939464e-02)*s3+(-2.278940e-03)*s4+(-1.933827e-03)*s5+(-2.988243e-03)*s6+(-3.932664e-04)*s7+(-5.934851e-03)*s8+6.773794e-03*s9 \
v0_part2=v0_part1+(-3.372756e-02)*s10+(-1.836676e-02)*s11+(-2.419873e-02)*s12+(-4.987484e-02)*s13+1.106899e-02*s14+1.774184e-02*s15+(-5.091126e-02)*s16+2.698414e-02*s17+2.119330e-02*s18+8.728812e-03*s19 \
v0_part3=v0_part2+3.027491e-02*s20+3.300437e-02*s21+(-2.572297e-02)*s22+1.082003e-02*s23+(-7.307560e-03)*s24+(-6.570799e-02)*s25+(-3.735485e-03)*s26+(-3.843533e-03)*s27+(-8.290649e-02)*s28+(-1.538052e-02)*s29 \
v0_part4=v0_part3+(-4.919870e-02)*s30+3.252381e-02*s31+4.488171e-02*s32+(-1.034425e-01)*s33+(-1.031608e-01)*s34+(-1.494273e-01)*s35+4.191071e-03*s36+(-4.257905e-02)*s37+(-3.802457e-05)*s38+3.135815e-02*s39 \
v0_part5=v0_part4+2.125412e-03*s40+3.201680e-04*s41+(-1.085589e-01)*s42+1.209476e-05*s43+(-3.761465e-03)*s44+(-4.846927e-02)*s45+(-1.937887e-02)*s46+1.128200e-02*s47+(-4.339416e-02)*s48+(-5.883193e-02)*s49 \
v0_part6=v0_part5+(-6.348568e-04)*s50+(-5.772118e-03)*s51+2.564488e-04*s52+(-1.796808e-01)*s53+(-8.176783e-04)*s54+(-2.285534e-02)*s55+1.420003e-03*s56+9.025969e-02*s57+(-7.067672e-03)*s58+2.849717e-02*s59 \
v0_part7=v0_part6+4.319309e-02*s60+(-5.983110e-03)*s61+2.596641e-02*s62+(-1.635928e-03)*s63+(-4.799870e-02)*s64+(-3.332364e-01)*s65+(-5.488056e-01)*s66+(-4.040467e-01)*s67+(-2.672884e-02)*s68+(-2.102795e-01)*s69 \
v0_part8=v0_part7+(-1.177263e-01)*s70+(-2.252263e-01)*s71+8.173851e-02*s72+(-1.759512e-01)*s73+3.285394e-02*s74+3.865303e-01*s75+(-5.182456e-01)*s76+(-6.096012e-02)*s77+(-2.384398e-02)*s78+(-5.624598e-02)*s79 \
v0_part9=v0_part8+(-3.121766e-01)*s80+(-1.257478e-01)*s81+(-1.468411e-02)*s82+(-4.084159e-01)*s83+(-4.300372e-01)*s84+(-1.193719e+00)*s85+(-9.090677e-01)*s86+(-2.402263e-01)*s87+(-6.552829e-02)*s88+(-9.557516e-01)*s89 \
v0_part10=v0_part9+(-2.029430e+00)*s90+(-1.664256e+00)*s91+(-1.089976e+00)*s92+(-1.966179e+00)*s93+(-1.813447e+00)*s94+(-3.183260e+00)*s95+(-1.359233e+00)*s96+(-2.927765e+00)*s97+(-3.150851e+00)*s98+(-2.756956e+00)*s99 \
v0=v0_part10+(-2.727104e+00)*s100+(-5.106061e+00)*s101+(-3.716733e-01)*s102+(-1.795003e+00)*s103+(-5.863716e+00)*s104 \
v1_part1=7.520948e-01*s0+7.450662e-01*s1+3.508219e-01*s2+6.724935e-01*s3+5.713461e-01*s4+6.564180e-01*s5+7.460569e-01*s6+7.183720e-01*s7+5.305750e-01*s8+5.058318e-01*s9 \
v1_part2=v1_part1+5.348223e-01*s10+1.864555e-01*s11+2.548685e-01*s12+3.945563e-01*s13+1.551429e-01*s14+2.255889e-01*s15+4.280048e-01*s16+3.715419e-01*s17+3.926419e-01*s18+4.407045e-01*s19 \
v1_part3=v1_part2+4.347467e-01*s20+4.435796e-01*s21+4.708108e-01*s22+3.941777e-01*s23+4.607897e-01*s24+5.223986e-01*s25+3.021859e-01*s26+3.388414e-01*s27+5.521061e-01*s28+4.997635e-01*s29 \
v1_part4=v1_part3+5.446554e-01*s30+2.003466e-01*s31+2.143436e-01*s32+2.852465e-01*s33+3.127999e-01*s34+7.427922e-01*s35+1.275701e-01*s36+2.971181e-01*s37+2.512426e-01*s38+2.845344e-01*s39 \
v1_part5=v1_part4+3.400062e-01*s40+3.727323e-01*s41+4.712374e-01*s42+3.649152e-01*s43+2.430638e-01*s44+1.746919e-01*s45+2.664205e-01*s46+1.742849e-01*s47+3.755669e-01*s48+3.969799e-01*s49 \
v1_part6=v1_part5+2.188720e-01*s50+1.923863e-02*s51+1.747457e+00*s52+1.967854e+00*s53+1.838503e+00*s54+1.578585e+00*s55+1.688980e+00*s56+1.588136e+00*s57+1.804472e+00*s58+1.756560e+00*s59 \
v1_part7=v1_part6+1.659236e+00*s60+1.815613e+00*s61+1.985861e+00*s62+1.426568e+00*s63+1.727067e+00*s64+2.110770e+00*s65+2.436566e+00*s66+2.126107e+00*s67+1.818036e+00*s68+2.083581e+00*s69 \
v1_part8=v1_part7+2.536111e+00*s70+2.884332e+00*s71+3.291390e+00*s72+3.375756e+00*s73+2.708494e+00*s74+2.753746e+00*s75+4.175474e+00*s76+4.132913e+00*s77+4.279242e+00*s78+3.522698e+00*s79 \
v1_part9=v1_part8+4.509768e+00*s80+4.171892e+00*s81+3.318393e+00*s82+5.086767e+00*s83+6.638074e+00*s84+7.808928e+00*s85+7.701072e+00*s86+6.888542e+00*s87+6.456378e+00*s88+7.858983e+00*s89 \
v1_part10=v1_part9+9.891169e+00*s90+1.101718e+01*s91+1.090275e+01*s92+1.215803e+01*s93+1.244794e+01*s94+1.338107e+01*s95+1.236537e+01*s96+1.730014e+01*s97+1.832392e+01*s98+1.795988e+01*s99 \
v1=v1_part10+1.838418e+01*s100+2.556278e+01*s101+2.096283e+01*s102+2.574530e+01*s103+3.910878e+01*s104 \
v2_part1=(-6.558924e-02)*s0+(-2.394430e-01)*s1+(-2.201563e-02)*s2+(-1.144035e-01)*s3+(-1.015539e-01)*s4+(-1.717682e-01)*s5+(-2.102679e-01)*s6+(-2.003921e-01)*s7+(-2.213306e-01)*s8+(-1.784950e-01)*s9 \
v2_part2=v2_part1+(-1.857700e-01)*s10+1.326555e-02*s11+6.133599e-03*s12+(-6.534558e-02)*s13+(-2.874010e-02)*s14+(-8.040544e-02)*s15+(-1.268519e-01)*s16+(-1.700332e-01)*s17+(-1.843327e-01)*s18+(-2.054525e-01)*s19 \
v2_part3=v2_part2+(-2.166049e-01)*s20+(-2.118737e-01)*s21+(-3.196376e-01)*s22+(-3.438720e-01)*s23+(-3.605708e-01)*s24+(-3.310977e-01)*s25+(-1.174059e-01)*s26+(-1.471774e-01)*s27+(-2.707870e-01)*s28+(-3.510929e-01)*s29 \
v2_part4=v2_part3+(-3.707897e-01)*s30+(-1.822816e-01)*s31+(-2.099442e-01)*s32+(-7.393344e-02)*s33+(-8.102758e-02)*s34+(-3.235392e-01)*s35+(-6.320227e-02)*s36+(-1.528937e-01)*s37+(-2.657217e-01)*s38+(-3.393115e-01)*s39 \
v2_part5=v2_part4+(-3.470051e-01)*s40+(-3.932607e-01)*s41+(-3.291460e-01)*s42+(-3.857468e-01)*s43+(-2.353707e-01)*s44+(-7.529922e-02)*s45+(-1.930357e-01)*s46+(-1.028853e-01)*s47+(-2.517776e-01)*s48+(-2.648948e-01)*s49 \
v2_part6=v2_part5+(-1.524587e-01)*s50+2.054467e-01*s51+(-5.845242e-01)*s52+(-4.775864e-01)*s53+(-6.554445e-01)*s54+(-5.052578e-01)*s55+(-5.766880e-01)*s56+(-5.991977e-01)*s57+(-6.035609e-01)*s58+(-6.651745e-01)*s59 \
v2_part7=v2_part6+(-6.406303e-01)*s60+(-7.736582e-01)*s61+(-9.545001e-01)*s62+(-9.599508e-01)*s63+(-1.135332e+00)*s64+(-1.068037e+00)*s65+(-1.106185e+00)*s66+(-1.022144e+00)*s67+(-1.178946e+00)*s68+(-1.236405e+00)*s69 \
v2_part8=v2_part7+(-8.445806e-01)*s70+(-1.064113e+00)*s71+(-1.736523e+00)*s72+(-1.501797e+00)*s73+(-1.331281e+00)*s74+(-1.709318e+00)*s75+(-1.775609e+00)*s76+(-2.256123e+00)*s77+(-2.322413e+00)*s78+(-3.732325e+00)*s79 \
v2_part9=v2_part8+(-4.419600e+00)*s80+(-4.330490e+00)*s81+(-3.203634e+00)*s82+(-2.336078e+00)*s83+(-3.793986e+00)*s84+(-3.849978e+00)*s85+(-4.053181e+00)*s86+(-4.060727e+00)*s87+(-3.885491e+00)*s88+(-4.231522e+00)*s89 \
v2_part10=v2_part9+(-1.165442e+01)*s90+(-6.955547e+00)*s91+(-7.585096e+00)*s92+(-7.493752e+00)*s93+(-8.095446e+00)*s94+(-7.139747e+00)*s95+(-8.826730e+00)*s96+(-1.286199e+01)*s97+(-1.375877e+01)*s98+(-1.365722e+01)*s99 \
v2=v2_part10+(-1.451897e+01)*s100+(-2.169784e+01)*s101+(-2.212748e+01)*s102+(-2.830535e+01)*s103+(-4.745544e+01)*s104 \
v3_part1=3.151944e-01*s0+0.000000e+00*s1+0.000000e+00*s2+0.000000e+00*s3+0.000000e+00*s4+0.000000e+00*s5+0.000000e+00*s6+0.000000e+00*s7+0.000000e+00*s8+(-8.406559e-01)*s9 \
v3_part2=v3_part1+0.000000e+00*s10+4.052435e-01*s11+2.928144e-01*s12+2.008045e-02*s13+(-1.189362e+00)*s14+(-2.960471e-01)*s15+(-1.180113e-01)*s16+5.135010e-01*s17+5.772889e-01*s18+5.660774e-01*s19 \
v3_part3=v3_part2+3.725673e-01*s20+0.000000e+00*s21+0.000000e+00*s22+1.441478e-01*s23+0.000000e+00*s24+0.000000e+00*s25+0.000000e+00*s26+(-5.248453e-01)*s27+9.874890e-03*s28+(-1.252979e-01)*s29 \
v3_part4=v3_part3+0.000000e+00*s30+7.165345e-02*s31+2.514417e-01*s32+1.294147e+00*s33+(-1.960419e-01)*s34+(-3.888159e-01)*s35+(-8.596214e-01)*s36+9.011176e-03*s37+0.000000e+00*s38+3.197328e-01*s39 \
v3_part5=v3_part4+3.457618e-01*s40+0.000000e+00*s41+1.076094e-01*s42+0.000000e+00*s43+7.090067e-01*s44+2.088758e+00*s45+3.150046e-01*s46+0.000000e+00*s47+(-9.960444e-01)*s48+(-2.682296e+00)*s49 \
v3_part6=v3_part5+(-2.833082e-01)*s50+0.000000e+00*s51+(-2.069992e+00)*s52+6.980778e+00*s53+(-8.642835e-01)*s54+0.000000e+00*s55+2.054405e+00*s56+0.000000e+00*s57+9.191465e-02*s58+5.584537e-01*s59 \
v3_part7=v3_part6+(-3.153414e+00)*s60+(-3.396940e+00)*s61+(-3.395138e+00)*s62+(-1.074644e-03)*s63+(-4.039731e-01)*s64+(-2.664958e-01)*s65+(-1.371070e+00)*s66+(-1.559874e+00)*s67+(-1.242008e+00)*s68+(-1.535747e+00)*s69 \
v3_part8=v3_part7+0.000000e+00*s70+5.281350e-02*s71+0.000000e+00*s72+0.000000e+00*s73+5.427910e+00*s74+0.000000e+00*s75+0.000000e+00*s76+0.000000e+00*s77+0.000000e+00*s78+(-1.044091e+00)*s79 \
v3_part9=v3_part8+(-3.660227e+00)*s80+(-1.517346e+00)*s81+0.000000e+00*s82+0.000000e+00*s83+0.000000e+00*s84+0.000000e+00*s85+0.000000e+00*s86+(-6.070967e+00)*s87+(-4.820738e+00)*s88+0.000000e+00*s89 \
v3_part10=v3_part9+0.000000e+00*s90+0.000000e+00*s91+0.000000e+00*s92+0.000000e+00*s93+0.000000e+00*s94+3.507954e+01*s95+0.000000e+00*s96+0.000000e+00*s97+0.000000e+00*s98+0.000000e+00*s99 \
v3=v3_part10+0.000000e+00*s100+0.000000e+00*s101+0.000000e+00*s102+0.000000e+00*s103+0.000000e+00*s104 \
v4_part1=1.260980e+00*s0+0.000000e+00*s1+0.000000e+00*s2+0.000000e+00*s3+0.000000e+00*s4+0.000000e+00*s5+0.000000e+00*s6+0.000000e+00*s7+0.000000e+00*s8+1.345947e+00*s9 \
v4_part2=v4_part1+0.000000e+00*s10+6.084150e-02*s11+1.801612e-01*s12+5.855687e-01*s13+1.845779e+00*s14+7.646214e-02*s15+2.886017e-01*s16+9.975959e-02*s17+3.306623e-01*s18+(-9.817465e-04)*s19 \
v4_part3=v4_part2+1.743586e-01*s20+0.000000e+00*s21+0.000000e+00*s22+7.013352e-01*s23+0.000000e+00*s24+0.000000e+00*s25+0.000000e+00*s26+4.791776e-01*s27+2.312850e-01*s28+3.800065e-01*s29 \
v4_part4=v4_part3+0.000000e+00*s30+5.703458e-01*s31+5.322914e-01*s32+1.183736e-01*s33+7.375714e-01*s34+6.145281e-01*s35+6.176536e-01*s36+2.731595e-01*s37+0.000000e+00*s38+(-2.562521e-01)*s39 \
v4_part5=v4_part4+(-8.276166e-02)*s40+0.000000e+00*s41+4.722228e-01*s42+0.000000e+00*s43+(-2.782250e-01)*s44+(-5.721891e-01)*s45+(-6.711830e-02)*s46+0.000000e+00*s47+1.439868e-01*s48+1.156886e+00*s49 \
v4_part6=v4_part5+6.328175e-02*s50+0.000000e+00*s51+2.550611e+00*s52+(-1.808844e+00)*s53+(-3.410753e-01)*s54+0.000000e+00*s55+1.689379e-01*s56+0.000000e+00*s57+9.770879e-01*s58+5.725493e-01*s59 \
v4_part7=v4_part6+3.222715e+00*s60+3.247726e+00*s61+3.056470e+00*s62+3.793037e-01*s63+8.910956e-01*s64+3.728902e-01*s65+1.663477e+00*s66+1.788492e+00*s67+1.168982e+00*s68+1.559468e+00*s69 \
v4_part8=v4_part7+0.000000e+00*s70+3.694508e+00*s71+0.000000e+00*s72+0.000000e+00*s73+(-2.797630e+00)*s74+0.000000e+00*s75+0.000000e+00*s76+0.000000e+00*s77+0.000000e+00*s78+8.750782e-01*s79 \
v4_part9=v4_part8+3.738036e+00*s80+4.517763e+00*s81+0.000000e+00*s82+0.000000e+00*s83+0.000000e+00*s84+0.000000e+00*s85+0.000000e+00*s86+5.821431e+00*s87+4.104009e+00*s88+0.000000e+00*s89 \
v4_part10=v4_part9+0.000000e+00*s90+0.000000e+00*s91+0.000000e+00*s92+0.000000e+00*s93+0.000000e+00*s94+(-3.622946e+01)*s95+0.000000e+00*s96+0.000000e+00*s97+0.000000e+00*s98+0.000000e+00*s99 \
v4=v4_part10+0.000000e+00*s100+0.000000e+00*s101+0.000000e+00*s102+0.000000e+00*s103+0.000000e+00*s104 \
v5_part1=2.796882e-01*s0+0.000000e+00*s1+0.000000e+00*s2+0.000000e+00*s3+0.000000e+00*s4+0.000000e+00*s5+0.000000e+00*s6+0.000000e+00*s7+0.000000e+00*s8+8.659168e-01*s9 \
v5_part2=v5_part1+0.000000e+00*s10+2.334659e-02*s11+1.691426e-02*s12+5.401428e-02*s13+5.700219e-01*s14+5.065129e-01*s15+3.743076e-01*s16+(-1.923183e-01)*s17+(-3.034912e-01)*s18+(-1.670859e-01)*s19 \
v5_part3=v5_part2+(-8.689581e-02)*s20+0.000000e+00*s21+0.000000e+00*s22+1.900128e-01*s23+0.000000e+00*s24+0.000000e+00*s25+0.000000e+00*s26+7.566268e-01*s27+4.530149e-01*s28+4.458071e-01*s29 \
v5_part4=v5_part3+0.000000e+00*s30+1.984224e-02*s31+(-7.966882e-02)*s32+(-4.403857e-01)*s33+(-5.760309e-02)*s34+5.142974e-01*s35+6.708747e-01*s36+7.845215e-03*s37+0.000000e+00*s38+(-6.567990e-02)*s39 \
v5_part5=v5_part4+(-1.335198e-01)*s40+0.000000e+00*s41+2.951554e-01*s42+0.000000e+00*s43+(-6.072281e-02)*s44+(-5.839655e-01)*s45+(-1.247666e-01)*s46+0.000000e+00*s47+4.968776e-01*s48+9.842158e-01*s49 \
v5_part6=v5_part5+2.338240e-01*s50+0.000000e+00*s51+1.889723e+00*s52+(-2.610364e+00)*s53+1.416228e+00*s54+0.000000e+00*s55+(-7.072783e-01)*s56+0.000000e+00*s57+8.303718e-01*s58+7.020796e-01*s59 \
v5_part7=v5_part6+2.256742e+00*s60+2.355264e+00*s61+2.418956e+00*s62+5.715977e-01*s63+1.025580e+00*s64+1.170385e+00*s65+1.241318e+00*s66+1.307702e+00*s67+1.447038e+00*s68+1.386991e+00*s69 \
v5_part8=v5_part7+0.000000e+00*s70+(-9.048614e-01)*s71+0.000000e+00*s72+0.000000e+00*s73+(-1.294834e+00)*s74+0.000000e+00*s75+0.000000e+00*s76+0.000000e+00*s77+0.000000e+00*s78+5.819505e-01*s79 \
v5_part9=v5_part8+1.983347e+00*s80+(-3.841780e-01)*s81+0.000000e+00*s82+0.000000e+00*s83+0.000000e+00*s84+0.000000e+00*s85+0.000000e+00*s86+1.196502e+00*s87+4.194195e+00*s88+0.000000e+00*s89 \
v5_part10=v5_part9+0.000000e+00*s90+0.000000e+00*s91+0.000000e+00*s92+0.000000e+00*s93+0.000000e+00*s94+7.705568e-02*s95+0.000000e+00*s96+0.000000e+00*s97+0.000000e+00*s98+0.000000e+00*s99 \
v5=v5_part10+0.000000e+00*s100+0.000000e+00*s101+0.000000e+00*s102+0.000000e+00*s103+0.000000e+00*s104 \
v6_part1=(-2.871018e-02)*s0+(-6.088225e-03)*s1+1.158480e-02*s2+1.610273e-02*s3+(-6.744198e-03)*s4+2.114138e-03*s5+2.884557e-02*s6+3.137536e-02*s7+(-1.449233e-02)*s8+3.094010e-03*s9 \
v6_part2=v6_part1+3.466515e-02*s10+(-6.742097e-02)*s11+(-1.179201e-01)*s12+(-8.317396e-02)*s13+(-3.079578e-02)*s14+2.331278e-02*s15+(-1.685747e-02)*s16+(-2.762764e-02)*s17+(-1.955243e-02)*s18+2.253719e-03*s19 \
v6_part3=v6_part2+1.733480e-02*s20+3.486386e-02*s21+(-1.226683e-01)*s22+(-2.842964e-01)*s23+(-1.949195e-02)*s24+(-1.785255e-01)*s25+2.825219e-04*s26+(-1.899678e-01)*s27+(-2.099319e-01)*s28+(-1.263632e-01)*s29 \
v6_part4=v6_part3+(-7.227590e-02)*s30+(-1.917262e-01)*s31+(-1.613215e-01)*s32+(-7.351201e-01)*s33+(-4.873199e-01)*s34+(-6.822261e-01)*s35+(-1.829310e-01)*s36+(-3.345860e-01)*s37+(-5.295508e-01)*s38+(-4.629550e-01)*s39 \
v6_part5=v6_part4+(-3.865389e-01)*s40+(-7.769206e-01)*s41+(-8.164757e-01)*s42+(-6.840900e-01)*s43+(-9.325515e-01)*s44+(-1.506086e+00)*s45+(-1.539928e+00)*s46+(-6.645084e-01)*s47+(-1.420225e+00)*s48+(-1.883217e+00)*s49 \
v6_part6=v6_part5+(-2.283167e+00)*s50+(-2.761333e+00)*s51+(-2.407191e-02)*s52+(-2.528859e-03)*s53+(-2.467496e-01)*s54+(-3.341736e-02)*s55+3.729315e-02*s56+(-3.473103e-02)*s57+(-4.534729e-03)*s58+6.432512e-03*s59 \
v6_part7=v6_part6+3.028282e-02*s60+5.058404e-02*s61+1.160941e-01*s62+(-2.556802e-01)*s63+(-1.716555e-01)*s64+(-5.275963e-01)*s65+(-4.533636e-01)*s66+(-6.817924e-01)*s67+(-2.091808e-01)*s68+(-3.789399e-01)*s69 \
v6_part8=v6_part7+(-1.283221e-01)*s70+(-3.654691e-01)*s71+4.148783e-02*s72+(-3.370011e-01)*s73+(-1.206801e-01)*s74+(-2.816729e-01)*s75+(-2.112049e-01)*s76+(-1.867414e-01)*s77+(-6.349216e-02)*s78+(-6.434735e-01)*s79 \
v6_part9=v6_part8+(-5.047840e-01)*s80+(-1.823399e+00)*s81+(-7.286067e-01)*s82+(-2.409671e-01)*s83+(-1.259553e-01)*s84+(-1.109646e+00)*s85+(-1.029967e+00)*s86+(-9.240001e-01)*s87+(-1.978258e-01)*s88+(-5.067851e-01)*s89 \
v6_part10=v6_part9+(-1.964418e+00)*s90+(-5.662607e-01)*s91+(-6.937169e-01)*s92+(-3.329716e-01)*s93+(-1.099729e+00)*s94+(-8.774641e-01)*s95+(-6.689439e-01)*s96+(-9.788240e-01)*s97+(-1.779790e+00)*s98+(-2.052046e+00)*s99 \
v6=v6_part10+(-1.573244e+00)*s100+(-1.191940e+00)*s101+(-1.502519e+00)*s102+(-1.605273e+00)*s103+(-2.285977e+00)*s104 \
v7_part1=3.972794e-01*s0+3.753606e-01*s1+1.799186e-01*s2+2.416497e-01*s3+2.482983e-01*s4+3.962021e-01*s5+2.930980e-01*s6+2.882522e-01*s7+3.066617e-01*s8+2.854082e-01*s9 \
v7_part2=v7_part1+2.592523e-01*s10+8.440411e-01*s11+8.690582e-01*s12+6.153847e-01*s13+6.424685e-01*s14+5.567492e-01*s15+6.498618e-01*s16+7.039350e-01*s17+7.345840e-01*s18+7.202792e-01*s19 \
v7_part3=v7_part2+7.393254e-01*s20+7.481918e-01*s21+1.354443e+00*s22+1.549226e+00*s23+1.413984e+00*s24+1.515176e+00*s25+1.151157e+00*s26+1.551287e+00*s27+1.733668e+00*s28+1.636674e+00*s29 \
v7_part4=v7_part3+1.670991e+00*s30+2.031847e+00*s31+2.199858e+00*s32+3.196952e+00*s33+2.878780e+00*s34+2.566805e+00*s35+2.580405e+00*s36+2.737707e+00*s37+3.225283e+00*s38+3.384712e+00*s39 \
v7_part5=v7_part4+3.456731e+00*s40+3.965977e+00*s41+3.887540e+00*s42+3.619535e+00*s43+5.054719e+00*s44+6.025854e+00*s45+6.054267e+00*s46+5.349125e+00*s47+7.134989e+00*s48+7.880407e+00*s49 \
v7_part6=v7_part5+9.159748e+00*s50+1.274378e+01*s51+6.882686e-01*s52+7.489968e-01*s53+9.686501e-01*s54+6.756863e-01*s55+6.047478e-01*s56+7.469137e-01*s57+7.556021e-01*s58+7.622639e-01*s59 \
v7_part7=v7_part6+7.800929e-01*s60+8.042722e-01*s61+8.011389e-01*s62+2.441592e+00*s63+2.402759e+00*s64+2.919197e+00*s65+2.812653e+00*s66+3.024847e+00*s67+2.548371e+00*s68+2.891764e+00*s69 \
v7_part8=v7_part7+1.330683e+00*s70+1.758574e+00*s71+1.458992e+00*s72+1.653987e+00*s73+1.486893e+00*s74+1.789592e+00*s75+1.780263e+00*s76+1.827007e+00*s77+1.821069e+00*s78+4.092985e+00*s79 \
v7_part9=v7_part8+3.257918e+00*s80+6.917698e+00*s81+4.149010e+00*s82+2.348501e+00*s83+2.563091e+00*s84+3.557992e+00*s85+3.456328e+00*s86+3.349828e+00*s87+2.562573e+00*s88+3.094619e+00*s89 \
v7_part10=v7_part9+9.807096e+00*s90+4.101314e+00*s91+4.238591e+00*s92+4.080196e+00*s93+4.823856e+00*s94+4.628044e+00*s95+4.343598e+00*s96+5.895567e+00*s97+7.029987e+00*s98+7.255303e+00*s99 \
v7=v7_part10+6.653624e+00*s100+7.790574e+00*s101+7.838640e+00*s102+9.656698e+00*s103+1.203810e+01*s104 \
v8_part1=(-3.154830e-02)*s0+(-5.776178e-02)*s1+6.795299e-04*s2+(-3.435182e-02)*s3+(-1.996930e-02)*s4+(-8.512901e-02)*s5+(-7.729821e-02)*s6+(-7.957355e-02)*s7+(-7.958313e-02)*s8+(-9.140712e-02)*s9 \
v8_part2=v8_part1+(-9.608443e-02)*s10+(-2.176448e-01)*s11+(-1.761762e-01)*s12+(-9.685208e-02)*s13+(-1.849333e-01)*s14+(-1.952674e-01)*s15+(-2.164070e-01)*s16+(-2.570477e-01)*s17+(-2.954314e-01)*s18+(-3.126813e-01)*s19 \
v8_part3=v8_part2+(-3.528467e-01)*s20+(-3.874688e-01)*s21+(-5.288113e-01)*s22+(-4.277353e-01)*s23+(-7.597278e-01)*s24+(-6.004690e-01)*s25+(-5.514326e-01)*s26+(-6.667951e-01)*s27+(-7.953826e-01)*s28+(-8.458276e-01)*s29 \
v8_part4=v8_part3+(-9.421454e-01)*s30+(-1.170310e+00)*s31+(-1.387229e+00)*s32+(-1.461536e+00)*s33+(-1.583956e+00)*s34+(-1.043495e+00)*s35+(-1.637131e+00)*s36+(-1.690741e+00)*s37+(-1.946775e+00)*s38+(-2.309667e+00)*s39 \
v8_part5=v8_part4+(-2.512716e+00)*s40+(-2.492468e+00)*s41+(-2.386054e+00)*s42+(-2.268479e+00)*s43+(-4.013708e+00)*s44+(-4.505459e+00)*s45+(-4.471508e+00)*s46+(-4.869466e+00)*s47+(-6.678166e+00)*s48+(-7.142198e+00)*s49 \
v8_part6=v8_part5+(-9.399120e+00)*s50+(-1.641680e+01)*s51+(-1.800132e-01)*s52+(-2.678921e-01)*s53+(-1.067882e-02)*s54+(-1.786691e-01)*s55+(-2.194077e-01)*s56+(-2.412184e-01)*s57+(-2.943370e-01)*s58+(-3.283851e-01)*s59 \
v8_part7=v8_part6+(-3.762195e-01)*s60+(-4.298466e-01)*s61+(-4.872990e-01)*s62+(-1.448341e+00)*s63+(-1.558757e+00)*s64+(-1.507161e+00)*s65+(-1.521949e+00)*s66+(-1.458484e+00)*s67+(-1.573273e+00)*s68+(-1.752846e+00)*s69 \
v8_part8=v8_part7+(-4.714368e-01)*s70+(-4.578820e-01)*s71+(-8.691482e-01)*s72+(-4.771258e-01)*s73+(-6.725150e-01)*s74+(-7.527679e-01)*s75+(-8.343952e-01)*s76+(-8.980796e-01)*s77+(-1.062829e+00)*s78+(-3.229359e+00)*s79 \
v8_part9=v8_part8+(-2.496963e+00)*s80+(-5.012852e+00)*s81+(-3.225536e+00)*s82+(-1.269792e+00)*s83+(-1.686289e+00)*s84+(-1.161400e+00)*s85+(-1.248348e+00)*s86+(-1.330473e+00)*s87+(-1.486545e+00)*s88+(-1.705209e+00)*s89 \
v8_part10=v8_part9+(-1.136377e+01)*s90+(-2.716011e+00)*s91+(-2.654596e+00)*s92+(-3.099712e+00)*s93+(-2.732811e+00)*s94+(-2.897463e+00)*s95+(-2.867588e+00)*s96+(-4.364289e+00)*s97+(-4.614487e+00)*s98+(-4.605160e+00)*s99 \
v8=v8_part10+(-4.576475e+00)*s100+(-7.049904e+00)*s101+(-6.563115e+00)*s102+(-9.578025e+00)*s103+(-1.297990e+01)*s104 \
v9_part1=(-2.000282e+00)*s0+(-1.772126e+00)*s1+(-7.505797e-01)*s2+8.393330e-02*s3+(-1.711393e-02)*s4+(-1.189668e+00)*s5+(-5.131842e-01)*s6+(-5.470071e-01)*s7+(-8.963397e-01)*s8+(-4.526576e-01)*s9 \
v9_part2=v9_part1+(-5.005716e-01)*s10+(-2.846235e+00)*s11+(-2.206249e+00)*s12+(-1.338795e+00)*s13+(-8.936230e-01)*s14+(-1.524511e-01)*s15+(-9.996931e-01)*s16+(-9.019163e-01)*s17+(-1.042454e+00)*s18+(-5.970532e-01)*s19 \
v9_part3=v9_part2+(-1.272063e+00)*s20+(-1.321417e+00)*s21+(-1.924448e+00)*s22+(-2.824720e+00)*s23+(-2.033999e+00)*s24+(-9.692058e-01)*s25+1.064858e+00*s26+(-1.586023e-01)*s27+(-2.187652e+00)*s28+(-2.178546e+00)*s29 \
v9_part4=v9_part3+(-1.638015e+00)*s30+(-2.687359e+00)*s31+8.390974e-01*s32+(-1.823747e+00)*s33+(-1.266276e+00)*s34+(-4.321641e+00)*s35+4.063688e+00*s36+(-1.163040e+00)*s37+(-6.766593e+00)*s38+(-2.831144e+00)*s39 \
v9_part5=v9_part4+(-2.826989e+00)*s40+2.260961e-02*s41+(-3.213519e+00)*s42+1.366022e+01*s43+4.111121e+00*s44+(-5.051612e+00)*s45+(-4.877301e+00)*s46+8.954101e+00*s47+1.828153e+00*s48+(-2.957622e+00)*s49 \
v9_part6=v9_part5+5.965678e+00*s50+(-1.308924e+01)*s51+(-2.469164e+00)*s52+(-2.410875e+00)*s53+(-1.740736e+00)*s54+(-7.960102e-01)*s55+(-4.467180e-01)*s56+(-1.240481e+00)*s57+(-1.172089e+00)*s58+(-1.089377e+00)*s59 \
v9_part7=v9_part6+(-1.526714e+00)*s60+(-1.084273e+00)*s61+(-1.359229e+00)*s62+(-2.550355e+00)*s63+(-1.502855e+00)*s64+(-1.851543e+00)*s65+(-8.456471e-01)*s66+(-6.978632e+00)*s67+2.091422e+00*s68+(-7.643796e+00)*s69 \
v9_part8=v9_part7+(-5.574602e+00)*s70+(-6.420911e+00)*s71+(-3.394052e+00)*s72+(-4.154485e+00)*s73+(-1.820632e+00)*s74+(-1.389645e+00)*s75+(-3.358460e+00)*s76+(-3.291755e+00)*s77+(-2.267556e+00)*s78+1.421915e+00*s79 \
v9_part9=v9_part8+(-1.179045e+01)*s80+(-9.108508e+00)*s81+1.516487e+00*s82+(-6.361129e+00)*s83+(-2.656379e+00)*s84+(-2.979378e+00)*s85+(-5.279023e+00)*s86+(-5.156174e+00)*s87+(-2.215481e+00)*s88+(-4.003322e+00)*s89 \
v9_part10=v9_part9+(-7.895690e+00)*s90+(-1.009743e+01)*s91+(-6.555555e+00)*s92+(-3.503674e+00)*s93+(-5.428732e+00)*s94+(-7.251087e+00)*s95+(-4.558781e+00)*s96+(-1.134670e+01)*s97+(-1.387283e+01)*s98+(-1.601089e+01)*s99 \
v9=v9_part10+(-1.128505e+01)*s100+(-1.158324e+01)*s101+(-9.046909e+00)*s102+(-9.359398e+00)*s103+1.555019e+00*s104 \
v10_part1=1.902932e+00*s0+1.133950e+00*s1+2.826682e-01*s2+(-2.555471e-01)*s3+5.164441e-02*s4+1.130806e+00*s5+1.412214e-01*s6+1.729872e-01*s7+5.725624e-01*s8+3.847437e-02*s9 \
v10_part2=v10_part1+7.036933e-02*s10+1.569985e+00*s11+1.921907e+00*s12+1.409568e+00*s13+1.267378e+00*s14+7.648963e-02*s15+9.775945e-01*s16+5.843312e-01*s17+6.391921e-01*s18+5.541573e-02*s19 \
v10_part3=v10_part2+7.918860e-01*s20+7.495733e-01*s21+(-1.881544e-01)*s22+6.650186e+00*s23+5.705759e-02*s24+(-8.436397e-01)*s25+(-1.286877e+00)*s26+4.450842e-01*s27+1.728831e+00*s28+1.407881e+00*s29 \
v10_part4=v10_part3+6.842168e-01*s30+1.165645e+00*s31+1.244921e-02*s32+(-9.027145e-01)*s33+(-2.213391e+00)*s34+4.743878e+00*s35+(-1.649552e+00)*s36+1.565921e+00*s37+8.788686e-01*s38+1.235877e+00*s39 \
v10_part5=v10_part4+6.653018e-02*s40+(-2.398525e+00)*s41+(-1.611559e-02)*s42+(-5.197670e+00)*s43+(-6.077780e+00)*s44+7.909346e+00*s45+1.072556e+01*s46+(-5.612557e+00)*s47+(-4.046209e+00)*s48+7.688020e+00*s49 \
v10_part6=v10_part5+(-9.893737e-01)*s50+1.783862e+01*s51+1.314825e+00*s52+1.364125e+00*s53+3.431661e+00*s54+1.100590e+00*s55+4.719914e-01*s56+1.025196e+00*s57+6.312577e-01*s58+5.565442e-01*s59 \
v10_part7=v10_part6+1.028801e+00*s60+4.135735e-01*s61+6.461866e-01*s62+(-6.750914e-02)*s63+4.411900e-01*s64+(-3.372505e-01)*s65+(-3.419672e+00)*s66+8.798253e+00*s67+(-1.921137e+00)*s68+6.495050e+00*s69 \
v10_part8=v10_part7+4.059682e+00*s70+9.157747e+00*s71+7.403554e-01*s72+6.118090e+00*s73+1.455424e+00*s74+1.105162e+00*s75+2.617978e+00*s76+2.127692e+00*s77+8.752009e-01*s78+(-4.779199e+00)*s79 \
v10_part9=v10_part8+1.040300e+01*s80+7.489257e+00*s81+(-2.098342e+00)*s82+2.592985e+00*s83+(-3.079445e-01)*s84+(-4.593229e-03)*s85+4.040036e+00*s86+5.473960e+00*s87+1.863553e+00*s88+2.673982e+00*s89 \
v10_part10=v10_part9+2.067612e+00*s90+2.490186e+00*s91+2.262246e+00*s92+(-2.702875e+00)*s93+7.733732e-01*s94+4.548988e+00*s95+3.010982e+00*s96+4.665105e+00*s97+1.143730e+01*s98+1.391758e+01*s99 \
v10=v10_part10+7.826055e+00*s100+4.598952e+00*s101+4.696559e+00*s102+(-3.214437e-02)*s103+4.266468e+00*s104 \
v11_part1=1.651545e+00*s0+1.755233e+00*s1+9.340558e-01*s2+5.377664e-01*s3+4.917888e-01*s4+1.494528e+00*s5+8.866650e-01*s6+8.926414e-01*s7+9.324437e-01*s8+9.210068e-01*s9 \
v11_part2=v11_part1+9.620200e-01*s10+1.957210e+00*s11+1.547858e+00*s12+1.166290e+00*s13+9.213186e-01*s14+7.983530e-01*s15+1.039372e+00*s16+1.170907e+00*s17+1.241358e+00*s18+1.268193e+00*s19 \
v11_part3=v11_part2+1.299073e+00*s20+1.337316e+00*s21+2.511991e+00*s22+1.086608e+00*s23+2.478656e+00*s24+2.308314e+00*s25+9.064003e-01*s26+8.911320e-01*s27+1.765866e+00*s28+1.924239e+00*s29 \
v11_part4=v11_part3+2.042857e+00*s30+2.968265e+00*s31+1.765823e+00*s32+3.722764e+00*s33+4.341472e+00*s34+1.709573e+00*s35+1.430352e-01*s36+2.212353e+00*s37+5.451551e+00*s38+3.301729e+00*s39 \
v11_part5=v11_part4+3.713486e+00*s40+3.647748e+00*s41+3.952090e+00*s42+(-3.577636e+00)*s43+3.997471e+00*s44+3.653870e+00*s45+7.371895e-01*s46+1.496466e+00*s47+6.604017e+00*s48+3.600532e+00*s49 \
v11_part6=v11_part5+4.173662e+00*s50+4.356758e+00*s51+1.822640e+00*s52+1.832349e+00*s53+9.711267e-01*s54+9.067425e-01*s55+8.555638e-01*s56+1.280224e+00*s57+1.453621e+00*s58+1.351598e+00*s59 \
v11_part7=v11_part6+1.398504e+00*s60+1.459155e+00*s61+1.508342e+00*s62+3.018107e+00*s63+2.660737e+00*s64+3.181898e+00*s65+4.275502e+00*s66+2.207957e+00*s67+1.141389e+00*s68+3.516467e+00*s69 \
v11_part8=v11_part7+3.237099e+00*s70+2.307933e+00*s71+3.095883e+00*s72+1.527540e+00*s73+1.711180e+00*s74+1.553685e+00*s75+2.246003e+00*s76+2.492092e+00*s77+2.588495e+00*s78+3.767007e+00*s79 \
v11_part9=v11_part8+4.512534e+00*s80+3.931163e+00*s81+2.698047e+00*s82+4.417040e+00*s83+3.544489e+00*s84+3.733737e+00*s85+3.133824e+00*s86+2.230022e+00*s87+1.895381e+00*s88+2.824558e+00*s89 \
v11_part10=v11_part9+8.737375e+00*s90+6.446187e+00*s91+4.931115e+00*s92+5.462525e+00*s93+5.074389e+00*s94+4.221517e+00*s95+3.288428e+00*s96+6.564707e+00*s97+5.058018e+00*s98+4.743812e+00*s99 \
v11=v11_part10+5.014101e+00*s100+7.110886e+00*s101+5.799851e+00*s102+8.421534e+00*s103+2.500281e+00*s104 \
v12_part1=0.000000e+00*s0+0.000000e+00*s1+0.000000e+00*s2+(-2.354757e+01)*s3+(-3.614371e+01)*s4+3.099869e-03*s5+(-4.572781e-01)*s6+(-1.281271e+00)*s7+(-4.792644e+00)*s8+1.653350e-02*s9 \
v12_part2=v12_part1+(-2.147445e+01)*s10+0.000000e+00*s11+6.513601e+00*s12+(-2.299568e+01)*s13+(-1.101226e+01)*s14+(-5.893135e+01)*s15+(-4.540818e+00)*s16+(-7.120366e+00)*s17+(-8.722057e+00)*s18+(-8.388790e+00)*s19 \
v12_part3=v12_part2+(-1.260501e+01)*s20+(-2.041806e+01)*s21+(-2.911733e+01)*s22+(-3.468879e+01)*s23+(-3.688494e+01)*s24+(-1.934247e+01)*s25+(-2.602696e+01)*s26+(-1.331750e+01)*s27+0.000000e+00*s28+(-4.471815e+01)*s29 \
v12_part4=v12_part3+(-3.178551e+01)*s30+(-4.407752e+01)*s31+(-1.856799e+01)*s32+(-2.484331e+01)*s33+(-1.110381e+01)*s34+(-1.489256e+01)*s35+(-4.277027e+01)*s36+(-3.072913e+01)*s37+(-5.772312e+01)*s38+(-1.081055e+02)*s39 \
v12_part5=v12_part4+(-7.955354e+01)*s40+(-7.947546e+01)*s41+(-6.228042e+00)*s42+(-9.942724e+01)*s43+0.000000e+00*s44+0.000000e+00*s45+0.000000e+00*s46+(-1.178076e+02)*s47+0.000000e+00*s48+0.000000e+00*s49 \
v12_part6=v12_part5+0.000000e+00*s50+0.000000e+00*s51+(-1.623140e+01)*s52+0.000000e+00*s53+(-2.645915e+01)*s54+(-3.332011e+00)*s55+(-2.275071e+01)*s56+(-1.342947e-02)*s57+(-1.724604e+01)*s58+(-1.199408e+01)*s59 \
v12_part7=v12_part6+(-2.718499e+01)*s60+(-3.858691e+01)*s61+(-8.867493e+00)*s62+(-3.250963e+01)*s63+2.706531e+01*s64+(-6.506176e+01)*s65+(-1.254637e+01)*s66+(-4.646638e+01)*s67+(-6.077507e+00)*s68+(-4.085031e+01)*s69 \
v12_part8=v12_part7+(-6.404032e+00)*s70+(-2.333674e-01)*s71+(-5.852374e+00)*s72+(-1.180960e+01)*s73+(-3.733826e+01)*s74+(-1.558331e-01)*s75+(-1.086134e+01)*s76+(-1.153466e+00)*s77+(-8.140265e+00)*s78+(-8.979693e+01)*s79 \
v12_part9=v12_part8+(-7.970827e+01)*s80+(-6.741911e+01)*s81+(-9.733558e+01)*s82+(-5.175780e+01)*s83+(-1.153772e+00)*s84+(-2.056249e+01)*s85+(-2.861932e+00)*s86+3.663540e+00*s87+(-3.703471e+01)*s88+(-5.438243e+00)*s89 \
v12_part10=v12_part9+7.994933e+01*s90+(-1.146080e+01)*s91+(-7.792154e+00)*s92+(-4.309875e+01)*s93+(-3.433268e+01)*s94+2.905323e-01*s95+(-2.820932e+01)*s96+(-5.106666e+01)*s97+(-9.856385e+01)*s98+(-2.979051e+01)*s99 \
v12=v12_part10+(-1.669052e+01)*s100+(-4.308893e+01)*s101+(-7.098726e+01)*s102+(-2.371317e+01)*s103+(-4.339563e+01)*s104 \
v13_part1=0.000000e+00*s0+0.000000e+00*s1+0.000000e+00*s2+8.355366e+01*s3+9.343845e+01*s4+2.059496e+01*s5+3.276921e+01*s6+3.522010e+01*s7+3.848465e+01*s8+3.332227e+01*s9 \
v13_part2=v13_part1+5.015923e+01*s10+0.000000e+00*s11+2.756425e+00*s12+1.995051e+02*s13+5.928604e+01*s14+1.726325e+02*s15+6.670208e+01*s16+6.263308e+01*s17+6.108414e+01*s18+5.946077e+01*s19 \
v13_part3=v13_part2+6.192236e+01*s20+7.484571e+01*s21+2.085446e+02*s22+1.988110e+02*s23+1.619633e+02*s24+1.491316e+02*s25+8.257176e+01*s26+2.707212e+01*s27+0.000000e+00*s28+1.514990e+02*s29 \
v13_part4=v13_part3+1.492233e+02*s30+1.562763e+02*s31+1.410640e+02*s32+2.659025e+02*s33+8.858765e+01*s34+1.215991e+02*s35+1.640738e+02*s36+1.814573e+02*s37+2.807505e+02*s38+2.943479e+02*s39 \
v13_part5=v13_part4+2.591513e+02*s40+2.807051e+02*s41+2.246546e+02*s42+1.815739e+02*s43+0.000000e+00*s44+0.000000e+00*s45+0.000000e+00*s46+5.079269e+02*s47+0.000000e+00*s48+0.000000e+00*s49 \
v13_part6=v13_part5+0.000000e+00*s50+0.000000e+00*s51+1.564441e+02*s52+0.000000e+00*s53+8.310609e+01*s54+4.875247e+01*s55+1.144462e+02*s56+4.732174e+01*s57+5.344549e+01*s58+5.544043e+01*s59 \
v13_part7=v13_part6+6.379908e+01*s60+7.019618e+01*s61+3.170914e+01*s62+1.900629e+02*s63+2.019123e+01*s64+6.901410e+01*s65+8.350808e+01*s66+6.669133e+01*s67+7.618181e+01*s68+8.914655e+01*s69 \
v13_part8=v13_part7+2.950893e+01*s70+7.886043e+01*s71+6.365146e+01*s72+8.457220e+01*s73+1.093943e+02*s74+(-6.506155e+00)*s75+5.357116e+01*s76+5.371638e+01*s77+5.664906e+01*s78+2.823149e+02*s79 \
v13_part9=v13_part8+2.450360e+02*s80+9.782643e+01*s81+3.034834e+02*s82+1.547961e+02*s83+4.877865e+01*s84+6.786718e+01*s85+8.201824e+01*s86+6.838535e+01*s87+1.102823e+02*s88+8.838821e+01*s89 \
v13_part10=v13_part9+(-2.423367e+02)*s90+1.133086e+02*s91+9.940373e+01*s92+1.218942e+02*s93+1.308722e+02*s94+1.182504e+02*s95+1.094323e+02*s96+1.412770e+02*s97+2.193907e+02*s98+1.504945e+02*s99 \
v13=v13_part10+1.613020e+02*s100+1.799846e+02*s101+2.347643e+02*s102+2.093955e+02*s103+2.772492e+02*s104 \
v14_part1=0.000000e+00*s0+0.000000e+00*s1+0.000000e+00*s2+(-1.138029e+01)*s3+(-3.468387e+00)*s4+4.476893e-03*s5+(-2.220363e+00)*s6+(-1.477861e+00)*s7+(-5.029863e+00)*s8+(-1.569180e+01)*s9 \
v14_part2=v14_part1+6.665622e+00*s10+0.000000e+00*s11+4.342806e-01*s12+(-7.139563e+01)*s13+(-1.775616e+01)*s14+(-1.256523e+01)*s15+(-6.810868e+00)*s16+1.966408e-01*s17+4.099815e+00*s18+4.663777e+00*s19 \
v14_part3=v14_part2+6.327449e+00*s20+2.473207e-01*s21+(-6.772052e+01)*s22+(-4.977629e+01)*s23+(-1.363659e+01)*s24+(-2.331926e+01)*s25+(-9.345024e+00)*s26+2.283912e+01*s27+0.000000e+00*s28+(-9.488440e-01)*s29 \
v14_part4=v14_part3+7.274981e-03*s30+(-6.416423e+01)*s31+(-7.302908e+01)*s32+(-1.940081e+02)*s33+(-1.876545e-01)*s34+(-6.955296e+01)*s35+(-5.147555e+01)*s36+(-6.487910e+01)*s37+(-1.571860e+02)*s38+(-9.927185e+01)*s39 \
v14_part5=v14_part4+(-1.145615e+02)*s40+(-9.610932e+01)*s41+(-2.131730e+02)*s42+3.007467e+01*s43+0.000000e+00*s44+0.000000e+00*s45+0.000000e+00*s46+(-4.994570e+02)*s47+0.000000e+00*s48+0.000000e+00*s49 \
v14_part6=v14_part5+0.000000e+00*s50+0.000000e+00*s51+(-4.679535e+01)*s52+0.000000e+00*s53+(-2.056334e+00)*s54+(-2.127154e+01)*s55+(-3.631262e+01)*s56+(-1.407321e+01)*s57+6.203286e+00*s58+1.582925e+00*s59 \
v14_part7=v14_part6+1.189809e+01*s60+2.015946e+01*s61+2.574956e+01*s62+(-2.912968e+01)*s63+(-3.497528e+01)*s64+6.505157e+01*s65+(-2.725555e+01)*s66+3.474896e+01*s67+(-2.991641e+01)*s68+(-4.098654e+00)*s69 \
v14_part8=v14_part7+3.997211e+01*s70+(-2.948819e+01)*s71+(-6.942799e-01)*s72+(-1.162820e+01)*s73+4.081038e+00*s74+5.979313e+01*s75+1.892732e+01*s76+4.847206e+00*s77+1.686482e+01*s78+(-1.201408e+02)*s79 \
v14_part9=v14_part8+(-9.780562e+01)*s80+(-1.033398e+01)*s81+(-1.639314e+02)*s82+1.825066e+01*s83+3.192536e+01*s84+4.974993e+01*s85+(-3.705684e+00)*s86+2.797980e+00*s87+1.215387e+01*s88+(-1.029695e-01)*s89 \
v14_part10=v14_part9+4.288661e+02*s90+(-2.167282e+01)*s91+(-9.348971e+00)*s92+2.853634e+01*s93+(-3.032079e+00)*s94+(-4.575978e+01)*s95+1.283251e+01*s96+3.647398e+01*s97+5.678655e-01*s98+(-4.199233e+01)*s99 \
v14=v14_part10+(-5.894402e+01)*s100+(-3.775420e+01)*s101+(-8.582525e+01)*s102+(-1.301337e+02)*s103+(-2.277118e+02)*s104 \
v15_part1=0.000000e+00*s0+0.000000e+00*s1+0.000000e+00*s2+0.000000e+00*s3+0.000000e+00*s4+0.000000e+00*s5+0.000000e+00*s6+0.000000e+00*s7+0.000000e+00*s8+0.000000e+00*s9 \
v15_part2=v15_part1+0.000000e+00*s10+0.000000e+00*s11+0.000000e+00*s12+0.000000e+00*s13+0.000000e+00*s14+0.000000e+00*s15+0.000000e+00*s16+0.000000e+00*s17+0.000000e+00*s18+0.000000e+00*s19 \
v15_part3=v15_part2+0.000000e+00*s20+0.000000e+00*s21+(-2.490027e+01)*s22+(-2.093461e+01)*s23+(-9.124866e+01)*s24+(-6.602294e+01)*s25+0.000000e+00*s26+0.000000e+00*s27+0.000000e+00*s28+(-5.490140e+01)*s29 \
v15_part4=v15_part3+(-5.248269e+01)*s30+0.000000e+00*s31+0.000000e+00*s32+0.000000e+00*s33+0.000000e+00*s34+0.000000e+00*s35+0.000000e+00*s36+0.000000e+00*s37+(-2.474718e+01)*s38+(-3.727340e+01)*s39 \
v15_part5=v15_part4+(-7.720863e+01)*s40+4.311633e-02*s41+(-4.560117e+01)*s42+(-1.349118e+01)*s43+5.058254e+01*s44+0.000000e+00*s45+(-3.284756e+01)*s46+1.154330e+02*s47+(-1.557262e+01)*s48+(-1.285700e+02)*s49 \
v15_part6=v15_part5+(-6.493862e+01)*s50+8.250272e+00*s51+0.000000e+00*s52+0.000000e+00*s53+0.000000e+00*s54+0.000000e+00*s55+0.000000e+00*s56+(-5.567036e+00)*s57+(-4.651737e+00)*s58+7.270460e+00*s59 \
v15_part7=v15_part6+1.981507e-01*s60+4.939783e+00*s61+(-1.479884e+01)*s62+(-8.578249e+00)*s63+0.000000e+00*s64+0.000000e+00*s65+(-9.315059e+01)*s66+0.000000e+00*s67+(-3.852069e+00)*s68+(-3.683755e+01)*s69 \
v15_part8=v15_part7+0.000000e+00*s70+0.000000e+00*s71+1.171910e+01*s72+0.000000e+00*s73+0.000000e+00*s74+8.782115e+01*s75+4.183349e+01*s76+1.485797e+01*s77+1.241543e+01*s78+0.000000e+00*s79 \
v15_part9=v15_part8+0.000000e+00*s80+0.000000e+00*s81+0.000000e+00*s82+0.000000e+00*s83+2.437129e+01*s84+1.152333e+02*s85+(-9.314072e+01)*s86+3.031134e+00*s87+(-1.720278e+01)*s88+6.133065e+01*s89 \
v15_part10=v15_part9+(-1.386649e+02)*s90+1.320981e+01*s91+9.992242e+00*s92+5.847869e+00*s93+(-2.355281e+01)*s94+(-3.364591e+01)*s95+1.092075e+01*s96+9.002450e+01*s97+1.271632e-01*s98+(-6.397221e+01)*s99 \
v15=v15_part10+(-1.117558e+02)*s100+4.116295e+01*s101+3.337022e+00*s102+1.635167e+02*s103+(-5.775646e-02)*s104 \
v16_part1=0.000000e+00*s0+0.000000e+00*s1+0.000000e+00*s2+0.000000e+00*s3+0.000000e+00*s4+0.000000e+00*s5+0.000000e+00*s6+0.000000e+00*s7+0.000000e+00*s8+0.000000e+00*s9 \
v16_part2=v16_part1+0.000000e+00*s10+0.000000e+00*s11+0.000000e+00*s12+0.000000e+00*s13+0.000000e+00*s14+0.000000e+00*s15+0.000000e+00*s16+0.000000e+00*s17+0.000000e+00*s18+0.000000e+00*s19 \
v16_part3=v16_part2+0.000000e+00*s20+0.000000e+00*s21+2.474872e+02*s22+2.545690e+02*s23+2.727102e+02*s24+2.659846e+02*s25+0.000000e+00*s26+0.000000e+00*s27+0.000000e+00*s28+2.184746e+02*s29 \
v16_part4=v16_part3+2.183838e+02*s30+0.000000e+00*s31+0.000000e+00*s32+0.000000e+00*s33+0.000000e+00*s34+0.000000e+00*s35+0.000000e+00*s36+0.000000e+00*s37+3.670611e+02*s38+3.372144e+02*s39 \
v16_part5=v16_part4+3.679854e+02*s40+2.797401e+02*s41+3.100757e+02*s42+2.190294e+02*s43+(-5.442074e+01)*s44+0.000000e+00*s45+(-1.878166e+01)*s46+1.253595e+00*s47+2.952469e+02*s48+5.257608e+02*s49 \
v16_part6=v16_part5+4.332689e+02*s50+2.245005e+02*s51+0.000000e+00*s52+0.000000e+00*s53+0.000000e+00*s54+0.000000e+00*s55+0.000000e+00*s56+2.877377e+01*s57+2.239929e+01*s58+6.150084e-01*s59 \
v16_part7=v16_part6+(-2.970918e+00)*s60+(-9.607746e+00)*s61+4.778831e+01*s62+2.204669e+02*s63+0.000000e+00*s64+0.000000e+00*s65+2.173724e+02*s66+0.000000e+00*s67+2.732176e+02*s68+9.796460e+01*s69 \
v16_part8=v16_part7+0.000000e+00*s70+0.000000e+00*s71+(-3.662300e+00)*s72+0.000000e+00*s73+0.000000e+00*s74+(-1.626710e-01)*s75+(-3.689469e+01)*s76+(-2.821616e-02)*s77+1.328824e+01*s78+0.000000e+00*s79 \
v16_part9=v16_part8+0.000000e+00*s80+0.000000e+00*s81+0.000000e+00*s82+0.000000e+00*s83+6.666457e+01*s84+(-1.633353e+01)*s85+1.402570e+02*s86+3.821910e+01*s87+8.732078e+01*s88+(-4.067764e+00)*s89 \
v16_part10=v16_part9+4.565854e+02*s90+3.285188e+01*s91+9.162490e+01*s92+8.456562e+01*s93+9.386992e+01*s94+9.585702e+01*s95+1.414602e+02*s96+1.956405e+02*s97+1.256455e+02*s98+2.376115e+02*s99 \
v16=v16_part10+2.768737e+02*s100+3.672675e+02*s101+2.817808e+02*s102+1.617716e+02*s103+3.662079e+02*s104 \
v17_part1=0.000000e+00*s0+0.000000e+00*s1+0.000000e+00*s2+0.000000e+00*s3+0.000000e+00*s4+0.000000e+00*s5+0.000000e+00*s6+0.000000e+00*s7+0.000000e+00*s8+0.000000e+00*s9 \
v17_part2=v17_part1+0.000000e+00*s10+0.000000e+00*s11+0.000000e+00*s12+0.000000e+00*s13+0.000000e+00*s14+0.000000e+00*s15+0.000000e+00*s16+0.000000e+00*s17+0.000000e+00*s18+0.000000e+00*s19 \
v17_part3=v17_part2+0.000000e+00*s20+0.000000e+00*s21+(-9.906764e+01)*s22+(-1.079241e+02)*s23+(-1.098463e+01)*s24+(-4.525065e+01)*s25+0.000000e+00*s26+0.000000e+00*s27+0.000000e+00*s28+(-2.234843e+01)*s29 \
v17_part4=v17_part3+1.417469e-01*s30+0.000000e+00*s31+0.000000e+00*s32+0.000000e+00*s33+0.000000e+00*s34+0.000000e+00*s35+0.000000e+00*s36+0.000000e+00*s37+(-2.318158e+02)*s38+(-1.586185e+02)*s39 \
v17_part5=v17_part4+(-1.293680e+02)*s40+(-1.617348e+02)*s41+(-9.793418e+01)*s42+(-2.363789e+01)*s43+1.218971e+02*s44+0.000000e+00*s45+3.179483e+02*s46+1.559187e+02*s47+(-3.414878e+02)*s48+(-5.084136e+02)*s49 \
v17_part6=v17_part5+(-1.193702e+02)*s50+5.419569e+00*s51+0.000000e+00*s52+0.000000e+00*s53+0.000000e+00*s54+0.000000e+00*s55+0.000000e+00*s56+(-1.254287e+01)*s57+(-2.968911e+00)*s58+2.438874e+01*s59 \
v17_part7=v17_part6+2.093910e+01*s60+2.193323e+01*s61+(-1.785539e+01)*s62+(-5.275987e+01)*s63+0.000000e+00*s64+0.000000e+00*s65+(-6.751319e+01)*s66+0.000000e+00*s67+(-2.485867e+02)*s68+(-1.093511e+01)*s69 \
v17_part8=v17_part7+0.000000e+00*s70+0.000000e+00*s71+1.635110e+01*s72+0.000000e+00*s73+0.000000e+00*s74+(-1.013725e+02)*s75+1.241269e+01*s76+1.960771e+01*s77+9.401180e+00*s78+0.000000e+00*s79 \
v17_part9=v17_part8+0.000000e+00*s80+0.000000e+00*s81+0.000000e+00*s82+0.000000e+00*s83+(-9.182835e+01)*s84+(-1.462684e+02)*s85+2.790532e+01*s86+(-7.935643e+00)*s87+(-4.365551e+01)*s88+(-3.154165e+01)*s89 \
v17_part10=v17_part9+(-1.881027e+02)*s90+(-7.547665e+00)*s91+(-5.924731e+01)*s92+(-3.810708e+01)*s93+1.366110e+01*s94+3.215760e+01*s95+(-1.068540e+02)*s96+(-3.707362e+02)*s97+(-4.122999e+01)*s98+(-7.920800e+01)*s99 \
v17=v17_part10+(-8.661979e+01)*s100+(-5.279295e+02)*s101+(-2.688821e+02)*s102+(-3.259045e+02)*s103+(-3.634838e+02)*s104 \
v18_part1=4.240510e-02*s0+(-7.345176e-03)*s1+(-5.794637e-02)*s2+2.956192e-02*s3+(-3.152596e-02)*s4+1.123811e-04*s5+6.843145e-03*s6+1.474910e-02*s7+2.211127e-02*s8+(-5.728051e-05)*s9 \
v18_part2=v18_part1+4.789515e-02*s10+(-2.665283e-02)*s11+(-2.163732e-02)*s12+(-2.793597e-02)*s13+(-3.595730e-02)*s14+5.566250e-02*s15+9.195614e-03*s16+(-1.338080e-02)*s17+(-1.159130e-02)*s18+1.003010e-02*s19 \
v18_part3=v18_part2+5.710884e-04*s20+3.366447e-03*s21+(-1.839392e-02)*s22+(-2.414780e-03)*s23+9.981529e-02*s24+1.141958e-01*s25+(-2.769057e-04)*s26+1.141562e-01*s27+8.149280e-02*s28+3.008502e-02*s29 \
v18_part4=v18_part3+3.062751e-02*s30+(-7.922103e-02)*s31+(-4.475273e-02)*s32+7.902109e-02*s33+6.707025e-02*s34+0.000000e+00*s35+(-2.087713e-02)*s36+2.817214e-02*s37+(-2.412470e-02)*s38+3.770012e-02*s39 \
v18_part5=v18_part4+2.147169e-02*s40+9.690230e-02*s41+1.047705e-01*s42+(-2.917438e-02)*s43+(-5.124200e-02)*s44+(-5.177846e-02)*s45+(-2.398676e-02)*s46+1.780038e-01*s47+(-1.363215e-01)*s48+(-1.010353e-01)*s49 \
v18_part6=v18_part5+(-2.267331e-01)*s50+(-3.219512e-02)*s51+(-1.806254e-01)*s52+(-7.373547e-02)*s53+5.665049e-03*s54+(-2.888425e-02)*s55+2.022427e-02*s56+(-8.884475e-02)*s57+(-3.887842e-03)*s58+(-1.464669e-02)*s59 \
v18_part7=v18_part6+2.762965e-02*s60+2.335095e-02*s61+(-2.505091e-02)*s62+(-1.128643e-01)*s63+(-2.379015e-04)*s64+(-2.406158e-01)*s65+(-1.787554e-01)*s66+(-9.856501e-02)*s67+(-2.058280e-02)*s68+(-8.159639e-02)*s69 \
v18_part8=v18_part7+(-1.195872e-01)*s70+(-1.005503e-01)*s71+2.302532e-01*s72+(-1.178632e-01)*s73+(-1.436111e-02)*s74+3.592359e-01*s75+(-9.339852e-02)*s76+(-1.763666e-01)*s77+(-1.846755e-01)*s78+(-1.150880e-01)*s79 \
v18_part9=v18_part8+(-1.818001e-01)*s80+(-1.945820e-01)*s81+(-5.451827e-02)*s82+(-1.708197e-01)*s83+(-6.940263e-02)*s84+(-1.766088e-01)*s85+(-5.947219e-01)*s86+(-2.545240e-01)*s87+(-2.516972e-01)*s88+(-1.675738e-01)*s89 \
v18_part10=v18_part9+3.703806e-03*s90+(-2.988682e-01)*s91+(-9.483406e-02)*s92+(-4.638196e-01)*s93+(-5.209743e-01)*s94+(-1.312038e+00)*s95+(-5.291274e-01)*s96+(-7.345246e-01)*s97+(-1.099360e+00)*s98+(-9.362194e-01)*s99 \
v18=v18_part10+(-1.014998e+00)*s100+(-2.061870e+00)*s101+2.932518e-02*s102+(-3.075656e-01)*s103+(-2.307318e+00)*s104 \
v19_part1=2.252631e-01*s0+2.196872e-01*s1+5.192141e-01*s2+2.895055e-01*s3+2.841033e-01*s4+4.142687e-01*s5+4.071259e-01*s6+4.186873e-01*s7+2.093627e-01*s8+2.420172e-01*s9 \
v19_part2=v19_part1+1.972909e-01*s10+3.769495e-01*s11+3.087661e-01*s12+2.706921e-01*s13+3.861738e-01*s14+1.647821e-01*s15+1.857844e-01*s16+2.091233e-01*s17+2.109012e-01*s18+2.320295e-01*s19 \
v19_part3=v19_part2+2.804331e-01*s20+2.943261e-01*s21+(-2.960238e-03)*s22+1.310986e-01*s23+3.860134e-02*s24+(-2.647519e-02)*s25+2.056888e-01*s26+4.455004e-02*s27+7.204714e-02*s28+1.480298e-01*s29 \
v19_part4=v19_part3+1.729041e-01*s30+2.700130e-01*s31+2.903953e-01*s32+2.236672e-01*s33+3.439994e-01*s34+0.000000e+00*s35+3.731948e-01*s36+3.743955e-01*s37+1.522719e-01*s38+1.259457e-01*s39 \
v19_part5=v19_part4+1.478423e-01*s40+2.835808e-02*s41+4.283977e-02*s42+2.215649e-01*s43+3.792992e-01*s44+5.973418e-01*s45+5.214451e-01*s46+2.674244e-01*s47+5.108922e-01*s48+3.767758e-01*s49 \
v19_part6=v19_part5+7.180912e-01*s50+4.184113e-01*s51+8.540386e-01*s52+9.261667e-01*s53+8.772848e-01*s54+8.111164e-01*s55+7.006378e-01*s56+1.074842e+00*s57+1.030569e+00*s58+9.898202e-01*s59 \
v19_part7=v19_part6+9.046429e-01*s60+9.536336e-01*s61+1.071665e+00*s62+1.047417e+00*s63+6.899923e-01*s64+9.385929e-01*s65+9.020930e-01*s66+7.851197e-01*s67+7.259790e-01*s68+8.289147e-01*s69 \
v19_part8=v19_part7+1.973601e+00*s70+1.771066e+00*s71+1.683189e+00*s72+1.766093e+00*s73+1.572070e+00*s74+1.525302e+00*s75+2.160909e+00*s76+2.323877e+00*s77+2.513097e+00*s78+2.601018e+00*s79 \
v19_part9=v19_part8+1.672183e+00*s80+1.702476e+00*s81+2.950669e+00*s82+2.969641e+00*s83+3.464665e+00*s84+3.710945e+00*s85+4.101229e+00*s86+3.613655e+00*s87+3.562694e+00*s88+3.813579e+00*s89 \
v19_part10=v19_part9+7.140807e+00*s90+4.514231e+00*s91+4.876253e+00*s92+5.450538e+00*s93+5.499544e+00*s94+5.860997e+00*s95+5.687793e+00*s96+7.942805e+00*s97+8.396516e+00*s98+7.962214e+00*s99 \
v19=v19_part10+8.341807e+00*s100+1.144059e+01*s101+9.429429e+00*s102+1.166821e+01*s103+1.707289e+01*s104 \
v20_part1=(-8.218081e-03)*s0+1.038763e-01*s1+(-4.946288e-02)*s2+(-6.557889e-02)*s3+(-1.119670e-02)*s4+(-4.579703e-02)*s5+(-9.581420e-02)*s6+(-1.157834e-01)*s7+(-3.424578e-02)*s8+(-8.053251e-02)*s9 \
v20_part2=v20_part1+(-7.558639e-02)*s10+(-1.276791e-01)*s11+(-1.318523e-01)*s12+(-8.123145e-02)*s13+(-1.060687e-01)*s14+(-9.860129e-02)*s15+(-7.566810e-02)*s16+(-7.152367e-02)*s17+(-7.569201e-02)*s18+(-1.146799e-01)*s19 \
v20_part3=v20_part2+(-1.388616e-01)*s20+(-1.670327e-01)*s21+1.889564e-01*s22+8.092365e-02*s23+6.480133e-03*s24+4.709083e-02*s25+(-9.910034e-02)*s26+(-9.474516e-02)*s27+(-4.788280e-02)*s28+2.254371e-02*s29 \
v20_part4=v20_part3+1.390256e-03*s30+(-1.158639e-03)*s31+(-1.041842e-01)*s32+(-2.014828e-01)*s33+(-3.168956e-01)*s34+0.000000e+00*s35+(-2.040203e-01)*s36+(-2.706663e-01)*s37+9.599774e-02*s38+8.816374e-03*s39 \
v20_part5=v20_part4+1.350129e-02*s40+3.360866e-02*s41+1.539833e-02*s42+3.018994e-03*s43+(-2.201445e-01)*s44+(-5.150801e-01)*s45+(-4.213207e-01)*s46+(-3.633220e-01)*s47+(-2.036307e-01)*s48+(-3.742190e-02)*s49 \
v20_part6=v20_part5+(-4.034801e-01)*s50+(-1.917911e-01)*s51+1.078215e-01*s52+(-1.004144e-01)*s53+(-2.011016e-01)*s54+(-1.457382e-01)*s55+(-1.452842e-01)*s56+(-2.894163e-01)*s57+(-3.800529e-01)*s58+(-3.666391e-01)*s59 \
v20_part7=v20_part6+(-3.449430e-01)*s60+(-3.549832e-01)*s61+(-4.274225e-01)*s62+(-5.514503e-01)*s63+(-4.710945e-01)*s64+(-3.200571e-01)*s65+(-4.076492e-01)*s66+(-4.129342e-01)*s67+(-4.591552e-01)*s68+(-5.002546e-01)*s69 \
v20_part8=v20_part7+(-9.966534e-01)*s70+(-7.928874e-01)*s71+(-1.090147e+00)*s72+(-6.812331e-01)*s73+(-7.645492e-01)*s74+(-1.080293e+00)*s75+(-9.974244e-01)*s76+(-1.034210e+00)*s77+(-1.242839e+00)*s78+(-2.844814e+00)*s79 \
v20_part9=v20_part8+(-1.062043e+00)*s80+(-1.371711e+00)*s81+(-3.289464e+00)*s82+(-1.585732e+00)*s83+(-2.206668e+00)*s84+(-2.214165e+00)*s85+(-1.981127e+00)*s86+(-1.969096e+00)*s87+(-1.984714e+00)*s88+(-2.235884e+00)*s89 \
v20_part10=v20_part9+(-9.639227e+00)*s90+(-2.932983e+00)*s91+(-3.665688e+00)*s92+(-3.671158e+00)*s93+(-3.547842e+00)*s94+(-2.798492e+00)*s95+(-3.872176e+00)*s96+(-6.671732e+00)*s97+(-6.529088e+00)*s98+(-5.996635e+00)*s99 \
v20=v20_part10+(-6.556375e+00)*s100+(-9.514151e+00)*s101+(-9.700815e+00)*s102+(-1.319107e+01)*s103+(-2.013149e+01)*s104 \
v21_part1=0.000000e+00*s0+2.053662e-01*s1+4.283520e-01*s2+(-1.306102e+00)*s3+(-7.171964e-01)*s4+(-1.932967e-01)*s5+(-4.532283e-01)*s6+(-6.251131e-01)*s7+(-7.148263e-01)*s8+0.000000e+00*s9 \
v21_part2=v21_part1+(-9.227656e-01)*s10+(-6.490253e-02)*s11+(-4.396019e-02)*s12+2.764527e-01*s13+(-2.645502e-02)*s14+(-1.416504e-01)*s15+3.778984e-02*s16+(-7.236250e-01)*s17+(-8.985510e-01)*s18+(-9.663789e-01)*s19 \
v21_part3=v21_part2+(-8.076918e-01)*s20+(-5.318512e-01)*s21+1.467080e-01*s22+0.000000e+00*s23+1.695538e-01*s24+(-4.267560e-02)*s25+(-8.941417e-01)*s26+0.000000e+00*s27+0.000000e+00*s28+0.000000e+00*s29 \
v21_part4=v21_part3+(-2.582141e-01)*s30+4.926605e-02*s31+(-1.578201e-03)*s32+(-1.054299e+00)*s33+(-5.791584e-02)*s34+0.000000e+00*s35+2.007505e-01*s36+(-1.326172e-02)*s37+6.427256e-02*s38+1.242174e-05*s39 \
v21_part5=v21_part4+8.648163e-07*s40+2.826657e-01*s41+0.000000e+00*s42+(-1.024093e+00)*s43+(-1.782439e-01)*s44+(-1.783713e+00)*s45+1.400693e-02*s46+1.028411e+00*s47+1.162641e+00*s48+2.758686e+00*s49 \
v21_part6=v21_part5+7.325519e-02*s50+(-4.785930e-02)*s51+0.000000e+00*s52+(-8.854634e+00)*s53+(-6.032285e-01)*s54+(-2.298283e+00)*s55+(-3.521408e+00)*s56+(-1.678790e+00)*s57+(-2.302028e+00)*s58+(-3.534576e+00)*s59 \
v21_part7=v21_part6+0.000000e+00*s60+0.000000e+00*s61+0.000000e+00*s62+(-9.416541e-01)*s63+0.000000e+00*s64+0.000000e+00*s65+0.000000e+00*s66+0.000000e+00*s67+0.000000e+00*s68+0.000000e+00*s69 \
v21_part8=v21_part7+(-4.403545e+00)*s70+(-4.613838e+00)*s71+(-3.989156e+00)*s72+(-3.703951e+00)*s73+(-9.118325e+00)*s74+(-2.677737e+00)*s75+(-4.293859e+00)*s76+(-4.630630e+00)*s77+(-5.319078e+00)*s78+4.097245e-02*s79 \
v21_part9=v21_part8+0.000000e+00*s80+(-2.350920e+00)*s81+9.248961e-01*s82+(-9.867094e+00)*s83+(-6.056793e+00)*s84+(-5.952083e+00)*s85+(-7.570026e+00)*s86+(-2.232097e+00)*s87+0.000000e+00*s88+(-7.336512e+00)*s89 \
v21_part10=v21_part9+(-4.128288e+00)*s90+(-1.511598e+01)*s91+(-1.122851e+01)*s92+(-1.135407e+01)*s93+(-8.817700e+00)*s94+(-4.701919e+01)*s95+(-1.020796e+01)*s96+(-1.942692e+01)*s97+(-1.739192e+01)*s98+(-2.029447e+01)*s99 \
v21=v21_part10+(-9.996234e+00)*s100+(-2.182619e+01)*s101+(-1.794575e+01)*s102+(-2.067089e+01)*s103+(-8.020716e+00)*s104 \
v22_part1=0.000000e+00*s0+1.285841e+00*s1+9.030065e-01*s2+2.292228e+00*s3+9.903620e-01*s4+7.985675e-01*s5+1.167140e+00*s6+1.287754e+00*s7+1.312096e+00*s8+0.000000e+00*s9 \
v22_part2=v22_part1+1.321862e+00*s10+5.680830e-01*s11+5.074860e-01*s12+(-9.059909e-02)*s13+2.820276e-01*s14+3.640205e-01*s15+3.416342e-02*s16+4.548055e-01*s17+3.355582e-01*s18+7.164274e-01*s19 \
v22_part3=v22_part2+5.408799e-01*s20+7.258440e-01*s21+7.618374e-01*s22+0.000000e+00*s23+5.562449e-01*s24+2.189478e-02*s25+1.067127e+00*s26+0.000000e+00*s27+0.000000e+00*s28+0.000000e+00*s29 \
v22_part4=v22_part3+4.911419e-01*s30+7.969436e-02*s31+4.540297e-02*s32+4.837350e-01*s33+2.558449e-01*s34+0.000000e+00*s35+1.373399e-01*s36+1.249989e-02*s37+7.222453e-01*s38+7.333392e-01*s39 \
v22_part5=v22_part4+5.327122e-01*s40+4.690505e-01*s41+0.000000e+00*s42+1.039700e+00*s43+6.202238e-01*s44+1.260498e+00*s45+7.151433e-01*s46+(-5.950550e-01)*s47+3.503085e-01*s48+(-6.853030e-01)*s49 \
v22_part6=v22_part5+7.535512e-01*s50+5.366672e-01*s51+0.000000e+00*s52+4.596981e+00*s53+2.881830e+00*s54+3.803262e+00*s55+1.810199e+00*s56+2.081379e+00*s57+1.428361e+00*s58+2.544591e+00*s59 \
v22_part7=v22_part6+0.000000e+00*s60+0.000000e+00*s61+0.000000e+00*s62+8.431424e-01*s63+0.000000e+00*s64+0.000000e+00*s65+0.000000e+00*s66+0.000000e+00*s67+0.000000e+00*s68+0.000000e+00*s69 \
v22_part8=v22_part7+4.186478e+00*s70+1.450124e+00*s71+2.817779e+00*s72+2.996594e+00*s73+6.571914e+00*s74+2.728894e+00*s75+3.763802e+00*s76+3.887858e+00*s77+4.327557e+00*s78+(-6.066966e-02)*s79 \
v22_part9=v22_part8+0.000000e+00*s80+(-1.750130e-01)*s81+(-1.052337e+00)*s82+6.902459e+00*s83+3.777486e+00*s84+3.608084e+00*s85+6.179167e+00*s86+1.362121e+00*s87+0.000000e+00*s88+5.829983e+00*s89 \
v22_part10=v22_part9+2.101566e+00*s90+7.106606e+00*s91+8.210939e+00*s92+7.393333e+00*s93+4.676191e+00*s94+4.298965e+01*s95+7.841080e+00*s96+1.067058e+01*s97+1.278673e+01*s98+1.732483e+01*s99 \
v22=v22_part10+4.863278e+00*s100+1.069841e+01*s101+1.041912e+01*s102+7.369849e+00*s103+1.524249e+01*s104 \
v23_part1=0.000000e+00*s0+3.498021e-01*s1+3.060435e-01*s2+1.035703e+00*s3+1.090255e+00*s4+7.293390e-01*s5+7.244782e-01*s6+7.708338e-01*s7+8.093257e-01*s8+0.000000e+00*s9 \
v23_part2=v23_part1+9.096221e-01*s10+1.430009e-01*s11+1.915251e-01*s12+1.802430e-01*s13+1.548688e-01*s14+2.720899e-01*s15+1.510520e-01*s16+6.842913e-01*s17+8.140058e-01*s18+6.918094e-01*s19 \
v23_part3=v23_part2+6.231184e-01*s20+5.859318e-01*s21+1.817020e-01*s22+0.000000e+00*s23+2.200412e-01*s24+5.424525e-01*s25+7.186722e-01*s26+0.000000e+00*s27+0.000000e+00*s28+0.000000e+00*s29 \
v23_part4=v23_part3+4.653874e-01*s30+2.104303e-01*s31+2.742119e-01*s32+6.154132e-01*s33+3.154871e-01*s34+0.000000e+00*s35+(-4.734926e-03)*s36+4.646407e-01*s37+2.193984e-01*s38+2.332170e-01*s39 \
v23_part5=v23_part4+2.998426e-01*s40+2.261021e-01*s41+0.000000e+00*s42+6.662408e-01*s43+1.964052e-01*s44+7.067174e-01*s45+2.030362e-01*s46+3.241064e-01*s47+(-2.720361e-01)*s48+(-7.021889e-01)*s49 \
v23_part6=v23_part5+3.274110e-02*s50+2.963094e-01*s51+0.000000e+00*s52+4.398626e+00*s53+2.516937e-01*s54+1.794545e+00*s55+2.526879e+00*s56+1.896227e+00*s57+1.251215e+00*s58+1.527673e+00*s59 \
v23_part7=v23_part6+0.000000e+00*s60+0.000000e+00*s61+0.000000e+00*s62+5.110697e-01*s63+0.000000e+00*s64+0.000000e+00*s65+0.000000e+00*s66+0.000000e+00*s67+0.000000e+00*s68+0.000000e+00*s69 \
v23_part8=v23_part7+3.363886e+00*s70+4.145195e+00*s71+3.658469e+00*s72+3.505285e+00*s73+4.455716e+00*s74+2.878377e+00*s75+3.497820e+00*s76+3.646406e+00*s77+3.785021e+00*s78+1.241845e+00*s79 \
v23_part9=v23_part8+0.000000e+00*s80+2.212429e+00*s81+1.890502e+00*s82+5.887121e+00*s83+5.147097e+00*s84+5.225270e+00*s85+5.044567e+00*s86+3.794516e+00*s87+0.000000e+00*s88+4.933356e+00*s89 \
v23_part10=v23_part9+3.218867e+00*s90+8.794578e+00*s91+6.798240e+00*s92+7.164312e+00*s93+7.081108e+00*s94+7.698918e+00*s95+6.171147e+00*s96+1.032857e+01*s97+8.535809e+00*s98+7.864076e+00*s99 \
v23=v23_part10+8.504879e+00*s100+1.195380e+01*s101+1.034199e+01*s102+1.356305e+01*s103+5.605842e+00*s104 \
v24_part1=(-4.880108e-03)*s0+(-1.097984e-02)*s1+(-3.192467e-02)*s2+(-2.768627e-03)*s3+(-1.141367e-02)*s4+(-1.385296e-02)*s5+(-1.350475e-03)*s6+4.883855e-03*s7+1.162234e-05*s8+(-1.088045e-02)*s9 \
v24_part2=v24_part1+1.959343e-02*s10+2.062977e-04*s11+1.764451e-04*s12+(-3.797486e-02)*s13+(-6.497475e-03)*s14+(-1.016561e-02)*s15+9.474271e-03*s16+9.391734e-05*s17+2.372290e-04*s18+(-1.180069e-04)*s19 \
v24_part3=v24_part2+2.091624e-02*s20+5.917046e-03*s21+(-8.859865e-02)*s22+5.340623e-02*s23+1.654424e-01*s24+(-3.357261e-03)*s25+(-1.777636e-01)*s26+2.477117e-01*s27+1.430873e-02*s28+2.982590e-03*s29 \
v24_part4=v24_part3+(-8.921853e-02)*s30+(-2.601658e-02)*s31+3.389266e-02*s32+(-8.096801e-02)*s33+(-6.701845e-01)*s34+(-2.356109e-01)*s35+(-1.908574e-01)*s36+(-2.944127e-01)*s37+1.579104e-02*s38+1.922252e-01*s39 \
v24_part5=v24_part4+2.137778e-02*s40+(-7.687592e-04)*s41+(-7.229533e-01)*s42+(-1.255470e-01)*s43+(-3.901133e-01)*s44+(-2.594140e-01)*s45+(-6.909209e-01)*s46+(-8.013600e-01)*s47+(-1.214199e+00)*s48+(-6.018320e-01)*s49 \
v24_part6=v24_part5+(-1.587327e+00)*s50+9.026802e-01*s51+(-6.580453e-02)*s52+(-1.362669e-01)*s53+1.718749e-01*s54+9.051567e-04*s55+(-2.469297e-02)*s56+9.662165e-04*s57+(-1.960517e-02)*s58+(-3.890319e-03)*s59 \
v24_part7=v24_part6+1.488231e-02*s60+(-2.572972e-02)*s61+(-7.060132e-02)*s62+1.948717e-03*s63+(-3.171624e-02)*s64+(-4.106561e-01)*s65+(-7.139592e-01)*s66+(-2.268039e-01)*s67+(-4.675283e-02)*s68+(-1.310162e-01)*s69 \
v24_part8=v24_part7+(-6.105013e-02)*s70+1.003989e-01*s71+7.857158e-03*s72+1.653695e-01*s73+5.089038e-02*s74+2.812282e-01*s75+1.676278e-02*s76+(-1.048814e-03)*s77+(-8.224834e-02)*s78+(-3.269639e-01)*s79 \
v24_part9=v24_part8+(-1.715745e+00)*s80+(-1.932245e-01)*s81+(-1.105420e-01)*s82+(-1.389690e-01)*s83+(-1.156576e-01)*s84+1.302175e-01*s85+2.949519e-01*s86+2.881031e-01*s87+(-1.203152e-01)*s88+7.078519e-03*s89 \
v24_part10=v24_part9+(-1.272066e+00)*s90+(-2.814613e-01)*s91+5.629768e-02*s92+(-5.458656e-01)*s93+(-2.300912e-02)*s94+(-5.467024e-01)*s95+(-2.132303e-01)*s96+(-4.160742e-01)*s97+(-3.299248e-01)*s98+(-6.954483e-01)*s99 \
v24=v24_part10+1.392803e-02*s100+(-1.072149e+00)*s101+8.324598e-03*s102+(-3.952467e-01)*s103+(-1.249187e+00)*s104 \
v25_part1=3.776788e-01*s0+3.847151e-01*s1+2.701806e-01*s2+3.264987e-01*s3+3.019110e-01*s4+4.021439e-01*s5+3.944085e-01*s6+3.963997e-01*s7+3.722872e-01*s8+4.354915e-01*s9 \
v25_part2=v25_part1+3.852431e-01*s10+6.913336e-01*s11+8.324787e-01*s12+1.336945e+00*s13+7.790606e-01*s14+8.521831e-01*s15+1.000345e+00*s16+1.112268e+00*s17+1.115532e+00*s18+1.196394e+00*s19 \
v25_part3=v25_part2+1.199171e+00*s20+1.247727e+00*s21+1.660827e+00*s22+1.664958e+00*s23+1.727489e+00*s24+1.786263e+00*s25+1.830926e+00*s26+1.293560e+00*s27+1.864960e+00*s28+2.084193e+00*s29 \
v25_part4=v25_part3+2.191466e+00*s30+2.649397e+00*s31+2.883923e+00*s32+2.592619e+00*s33+3.389569e+00*s34+4.180831e+00*s35+2.401943e+00*s36+3.200006e+00*s37+3.678195e+00*s38+3.823723e+00*s39 \
v25_part5=v25_part4+4.155059e+00*s40+4.473839e+00*s41+5.299233e+00*s42+4.294118e+00*s43+5.444032e+00*s44+4.857482e+00*s45+6.266345e+00*s46+5.888346e+00*s47+7.906867e+00*s48+7.609132e+00*s49 \
v25_part6=v25_part5+9.739981e+00*s50+3.051244e+00*s51+8.582869e-01*s52+9.857588e-01*s53+7.308888e-01*s54+7.217074e-01*s55+8.045650e-01*s56+9.208675e-01*s57+9.513376e-01*s58+9.219027e-01*s59 \
v25_part7=v25_part6+8.838279e-01*s60+9.601215e-01*s61+1.041750e+00*s62+2.128190e+00*s63+2.662252e+00*s64+3.047872e+00*s65+3.569175e+00*s66+2.922709e+00*s67+2.379932e+00*s68+2.793482e+00*s69 \
v25_part8=v25_part7+1.627559e+00*s70+1.481836e+00*s71+1.760106e+00*s72+1.513466e+00*s73+1.313834e+00*s74+1.180574e+00*s75+1.794944e+00*s76+1.885166e+00*s77+1.987790e+00*s78+7.025835e+00*s79 \
v25_part9=v25_part8+1.038481e+01*s80+4.870131e+00*s81+7.093741e+00*s82+2.438072e+00*s83+2.658416e+00*s84+2.596181e+00*s85+2.568929e+00*s86+2.389199e+00*s87+2.584824e+00*s88+2.706480e+00*s89 \
v25_part10=v25_part9+8.616273e+00*s90+3.457627e+00*s91+3.502567e+00*s92+4.132271e+00*s93+3.687253e+00*s94+4.103679e+00*s95+3.686980e+00*s96+4.912007e+00*s97+5.038977e+00*s98+5.387095e+00*s99 \
v25=v25_part10+4.785691e+00*s100+6.796308e+00*s101+6.135062e+00*s102+7.217974e+00*s103+9.358933e+00*s104 \
v26_part1=(-6.887781e-02)*s0+(-5.904053e-02)*s1+2.558376e-02*s2+(-4.940820e-02)*s3+(-3.568887e-02)*s4+(-7.925434e-02)*s5+(-9.003200e-02)*s6+(-1.034279e-01)*s7+(-1.256173e-01)*s8+(-1.591980e-01)*s9 \
v26_part2=v26_part1+(-1.611733e-01)*s10+(-2.260482e-01)*s11+(-2.835390e-01)*s12+(-5.044002e-01)*s13+(-2.383716e-01)*s14+(-2.862769e-01)*s15+(-3.832609e-01)*s16+(-4.510832e-01)*s17+(-4.588832e-01)*s18+(-5.238639e-01)*s19 \
v26_part3=v26_part2+(-5.355270e-01)*s20+(-5.457939e-01)*s21+(-7.585292e-01)*s22+(-9.990940e-01)*s23+(-1.180707e+00)*s24+(-9.660182e-01)*s25+(-7.535408e-01)*s26+(-7.876521e-01)*s27+(-1.049935e+00)*s28+(-1.186299e+00)*s29 \
v26_part4=v26_part3+(-1.219423e+00)*s30+(-1.741377e+00)*s31+(-2.065896e+00)*s32+(-1.620164e+00)*s33+(-1.530929e+00)*s34+(-2.720217e+00)*s35+(-1.287520e+00)*s36+(-1.859688e+00)*s37+(-3.036798e+00)*s38+(-3.374527e+00)*s39 \
v26_part5=v26_part4+(-3.444737e+00)*s40+(-3.793493e+00)*s41+(-3.757256e+00)*s42+(-3.464068e+00)*s43+(-4.763696e+00)*s44+(-4.103468e+00)*s45+(-5.213214e+00)*s46+(-4.513520e+00)*s47+(-6.896967e+00)*s48+(-7.470794e+00)*s49 \
v26_part6=v26_part5+(-9.849245e+00)*s50+(-1.315109e-01)*s51+(-1.786901e-01)*s52+(-1.566448e-01)*s53+(-4.891606e-01)*s54+(-2.328003e-01)*s55+(-2.438137e-01)*s56+(-3.451567e-01)*s57+(-3.366128e-01)*s58+(-3.568924e-01)*s59 \
v26_part7=v26_part6+(-3.553280e-01)*s60+(-3.794966e-01)*s61+(-4.197239e-01)*s62+(-1.158098e+00)*s63+(-1.653923e+00)*s64+(-1.443245e+00)*s65+(-1.633892e+00)*s66+(-1.611590e+00)*s67+(-1.296073e+00)*s68+(-1.622670e+00)*s69 \
v26_part8=v26_part7+(-7.964423e-01)*s70+(-9.206059e-01)*s71+(-9.448502e-01)*s72+(-9.552409e-01)*s73+(-6.243737e-01)*s74+(-7.402582e-01)*s75+(-9.420775e-01)*s76+(-1.017570e+00)*s77+(-1.014593e+00)*s78+(-6.705375e+00)*s79 \
v26_part9=v26_part8+(-8.307834e+00)*s80+(-4.290550e+00)*s81+(-6.642924e+00)*s82+(-1.338200e+00)*s83+(-1.582242e+00)*s84+(-1.871632e+00)*s85+(-2.049791e+00)*s86+(-1.799351e+00)*s87+(-1.490537e+00)*s88+(-1.714046e+00)*s89 \
v26_part10=v26_part9+(-8.817578e+00)*s90+(-2.196825e+00)*s91+(-2.856839e+00)*s92+(-2.547436e+00)*s93+(-2.813058e+00)*s94+(-2.537514e+00)*s95+(-2.520256e+00)*s96+(-3.919053e+00)*s97+(-4.207574e+00)*s98+(-4.055420e+00)*s99 \
v26=v26_part10+(-4.293351e+00)*s100+(-5.653455e+00)*s101+(-6.456568e+00)*s102+(-7.786955e+00)*s103+(-1.047279e+01)*s104 \
v27_part1=(-1.332538e+00)*s0+(-1.176696e+00)*s1+(-9.310549e-01)*s2+(-1.190866e+00)*s3+(-5.771693e-01)*s4+(-6.463407e-01)*s5+(-2.186438e+00)*s6+(-2.606751e+00)*s7+(-1.798175e+00)*s8+(-3.053737e+00)*s9 \
v27_part2=v27_part1+(-2.915207e+00)*s10+(-2.309392e+00)*s11+(-2.201231e+00)*s12+(-3.868393e+00)*s13+6.010727e-03*s14+(-1.402514e+00)*s15+(-1.947691e+00)*s16+(-2.992874e+00)*s17+(-4.105357e+00)*s18+(-5.964135e+00)*s19 \
v27_part3=v27_part2+(-4.968701e+00)*s20+(-5.330931e+00)*s21+(-6.797492e+00)*s22+(-6.201617e+00)*s23+(-5.433305e+00)*s24+(-5.923679e+00)*s25+(-7.799039e+00)*s26+(-2.622136e+00)*s27+(-3.623387e+00)*s28+(-4.897611e+00)*s29 \
v27_part4=v27_part3+(-7.317222e+00)*s30+(-1.219094e+01)*s31+(-9.712290e+00)*s32+(-5.466210e+00)*s33+(-6.490060e+00)*s34+1.197905e+00*s35+(-5.113859e+00)*s36+(-6.055166e+00)*s37+(-1.281295e+01)*s38+(-1.357084e+01)*s39 \
v27_part5=v27_part4+(-1.534069e+01)*s40+(-9.598481e+00)*s41+(-9.220901e+00)*s42+(-1.940273e+01)*s43+(-2.115306e+01)*s44+(-1.118051e+01)*s45+(-1.842443e+01)*s46+(-1.606296e+01)*s47+(-1.675442e+01)*s48+(-1.172983e+01)*s49 \
v27_part6=v27_part5+(-1.238862e+01)*s50+1.887186e+00*s51+(-4.052786e+00)*s52+(-2.374357e+00)*s53+(-2.060708e+00)*s54+(-3.408933e-01)*s55+(-5.078669e-01)*s56+(-1.315189e+00)*s57+(-1.965238e+00)*s58+(-3.779711e+00)*s59 \
v27_part7=v27_part6+(-3.513148e+00)*s60+(-4.541358e+00)*s61+(-4.475614e+00)*s62+(-1.492489e+01)*s63+(-8.262484e+00)*s64+(-7.066490e+00)*s65+(-8.419726e+00)*s66+(-2.553190e+00)*s67+(-9.666797e+00)*s68+(-1.188763e+00)*s69 \
v27_part8=v27_part7+(-2.061117e+00)*s70+(-1.365467e+00)*s71+(-3.026850e+00)*s72+(-8.284773e-01)*s73+2.335920e-01*s74+5.424938e-01*s75+(-1.263144e+00)*s76+(-2.071374e+00)*s77+(-4.214090e+00)*s78+(-3.156951e+01)*s79 \
v27_part9=v27_part8+(-7.498112e+00)*s80+(-1.592692e+01)*s81+(-2.178080e+01)*s82+(-7.784547e+00)*s83+(-5.847043e+00)*s84+(-4.638723e+00)*s85+(-2.915348e+00)*s86+(-2.396116e+00)*s87+(-5.935036e-01)*s88+(-3.034323e+00)*s89 \
v27_part10=v27_part9+(-1.066579e+01)*s90+(-9.128424e+00)*s91+(-7.117126e+00)*s92+(-1.152223e+01)*s93+(-4.868442e+00)*s94+(-3.642345e+00)*s95+(-4.091751e+00)*s96+(-1.043641e+01)*s97+(-5.065631e+00)*s98+(-7.610332e+00)*s99 \
v27=v27_part10+2.176712e+00*s100+(-1.245123e+01)*s101+(-9.466197e+00)*s102+(-1.103546e+01)*s103+(-4.303315e+00)*s104 \
v28_part1=3.913380e-01*s0+2.938239e-01*s1+1.396022e+00*s2+1.732486e+00*s3+1.036671e+00*s4+4.333128e-01*s5+2.438889e+00*s6+2.792913e+00*s7+1.594715e+00*s8+2.898643e+00*s9 \
v28_part2=v28_part1+2.599599e+00*s10+9.181733e-01*s11+6.040273e-01*s12+1.189329e+00*s13+(-5.097729e-01)*s14+2.531086e+00*s15+1.510850e+00*s16+2.404002e+00*s17+4.031420e+00*s18+5.844171e+00*s19 \
v28_part3=v28_part2+4.427108e+00*s20+4.681394e+00*s21+6.225733e+00*s22+1.313238e+00*s23+3.677633e+00*s24+7.417583e+00*s25+8.083612e+00*s26+1.585853e+00*s27+2.190616e+00*s28+3.636382e+00*s29 \
v28_part4=v28_part3+6.124961e+00*s30+7.018672e+00*s31+3.549377e+00*s32+2.714942e+00*s33+5.576481e+00*s34+(-1.027888e+01)*s35+3.493967e+00*s36+3.879921e+00*s37+5.778552e+00*s38+9.596082e+00*s39 \
v28_part5=v28_part4+1.142150e+01*s40+4.563835e+00*s41+7.101268e+00*s42+1.165340e+01*s43+1.283675e+01*s44+5.538274e+00*s45+9.056588e+00*s46+8.056804e+00*s47+8.396389e+00*s48+4.932555e+00*s49 \
v28_part6=v28_part5+1.553365e+00*s50+3.026047e+00*s51+2.457513e+00*s52+2.991079e+00*s53+(-1.722373e+00)*s54+(-2.180434e-01)*s55+1.381867e+00*s56+1.503230e+00*s57+2.008899e+00*s58+4.156065e+00*s59 \
v28_part7=v28_part6+3.480816e+00*s60+4.555552e+00*s61+4.260179e+00*s62+1.067369e+01*s63+3.369960e+00*s64+3.516931e+00*s65+9.024928e+00*s66+(-6.546167e-01)*s67+8.449286e+00*s68+(-3.012162e-02)*s69 \
v28_part8=v28_part7+1.934621e-01*s70+(-1.156959e+00)*s71+2.187019e+00*s72+(-3.152190e+00)*s73+5.074898e-01*s74+2.906998e-02*s75+6.661480e-01*s76+1.574052e+00*s77+3.821465e+00*s78+2.105998e+01*s79 \
v28_part9=v28_part8+(-3.683575e-01)*s80+1.239569e+01*s81+1.224032e+01*s82+4.595073e+00*s83+3.798686e+00*s84+2.202543e+00*s85+3.813863e-01*s86+(-1.840886e-01)*s87+5.434521e-01*s88+2.475968e+00*s89 \
v28_part10=v28_part9+1.579437e+00*s90+2.951231e+00*s91+5.853896e+00*s92+1.206369e+01*s93+2.626995e+00*s94+(-1.197447e-02)*s95+3.698002e+00*s96+4.326244e+00*s97+9.289092e-02*s98+4.994519e+00*s99 \
v28=v28_part10+(-5.221731e+00)*s100+4.506396e+00*s101+4.213502e+00*s102+3.884201e+00*s103+8.865764e+00*s104 \
v29_part1=1.260132e+00*s0+1.211030e+00*s1+1.153501e+00*s2+1.264055e+00*s3+1.027200e+00*s4+8.525472e-01*s5+1.658387e+00*s6+1.736981e+00*s7+1.668110e+00*s8+1.828418e+00*s9 \
v29_part2=v29_part1+1.762014e+00*s10+2.411645e+00*s11+2.606186e+00*s12+3.658844e+00*s13+1.461734e+00*s14+1.334161e+00*s15+2.468994e+00*s16+2.865482e+00*s17+2.739634e+00*s18+2.901301e+00*s19 \
v29_part3=v29_part2+2.946063e+00*s20+2.991639e+00*s21+3.547881e+00*s22+4.698183e+00*s23+3.835489e+00*s24+2.642873e+00*s25+3.917871e+00*s26+3.425664e+00*s27+3.871459e+00*s28+4.036785e+00*s29 \
v29_part4=v29_part3+3.898007e+00*s30+5.898554e+00*s31+5.953221e+00*s32+3.867151e+00*s33+3.051121e+00*s34+8.525244e+00*s35+3.294879e+00*s36+3.628134e+00*s37+6.711841e+00*s38+6.377861e+00*s39 \
v29_part5=v29_part4+6.598626e+00*s40+6.107117e+00*s41+5.430483e+00*s42+8.793572e+00*s43+7.997794e+00*s44+5.682527e+00*s45+8.775912e+00*s46+7.929586e+00*s47+7.028531e+00*s48+6.211751e+00*s49 \
v29_part6=v29_part5+8.375698e+00*s50+2.593016e+00*s51+3.062408e+00*s52+2.071085e+00*s53+3.075879e+00*s54+1.655664e+00*s55+1.162843e+00*s56+1.779214e+00*s57+2.031632e+00*s58+2.467323e+00*s59 \
v29_part7=v29_part6+2.483186e+00*s60+2.473076e+00*s61+2.493594e+00*s62+6.494777e+00*s63+5.327064e+00*s64+4.694426e+00*s65+2.830488e+00*s66+3.862916e+00*s67+4.266155e+00*s68+2.705460e+00*s69 \
v29_part8=v29_part7+2.678363e+00*s70+2.763050e+00*s71+2.766070e+00*s72+3.583176e+00*s73+1.387613e+00*s74+1.405272e+00*s75+2.564125e+00*s76+2.557947e+00*s77+2.549225e+00*s78+1.070802e+01*s79 \
v29_part9=v29_part8+6.913936e+00*s80+5.921692e+00*s81+1.009724e+01*s82+4.347058e+00*s83+3.824013e+00*s84+3.716573e+00*s85+3.826270e+00*s86+4.041901e+00*s87+2.440442e+00*s88+2.940736e+00*s89 \
v29_part10=v29_part9+7.403069e+00*s90+5.665503e+00*s91+3.963467e+00*s92+3.587213e+00*s93+4.091303e+00*s94+4.809196e+00*s95+2.997127e+00*s96+6.252839e+00*s97+5.441508e+00*s98+4.752078e+00*s99 \
v29=v29_part10+4.747956e+00*s100+7.264712e+00*s101+6.154928e+00*s102+7.293548e+00*s103+2.588217e+00*s104 \
v30_part1=0.000000e+00*s0+0.000000e+00*s1+0.000000e+00*s2+0.000000e+00*s3+0.000000e+00*s4+0.000000e+00*s5+0.000000e+00*s6+0.000000e+00*s7+(-7.312002e+00)*s8+(-8.969963e+00)*s9 \
v30_part2=v30_part1+0.000000e+00*s10+0.000000e+00*s11+0.000000e+00*s12+0.000000e+00*s13+(-4.560106e+01)*s14+0.000000e+00*s15+0.000000e+00*s16+0.000000e+00*s17+0.000000e+00*s18+0.000000e+00*s19 \
v30_part3=v30_part2+0.000000e+00*s20+0.000000e+00*s21+4.450493e-01*s22+0.000000e+00*s23+0.000000e+00*s24+0.000000e+00*s25+0.000000e+00*s26+0.000000e+00*s27+(-4.275892e+01)*s28+0.000000e+00*s29 \
v30_part4=v30_part3+0.000000e+00*s30+0.000000e+00*s31+0.000000e+00*s32+0.000000e+00*s33+0.000000e+00*s34+0.000000e+00*s35+0.000000e+00*s36+0.000000e+00*s37+0.000000e+00*s38+0.000000e+00*s39 \
v30_part5=v30_part4+0.000000e+00*s40+0.000000e+00*s41+0.000000e+00*s42+0.000000e+00*s43+0.000000e+00*s44+0.000000e+00*s45+0.000000e+00*s46+0.000000e+00*s47+(-3.079928e+01)*s48+(-1.347257e+01)*s49 \
v30_part6=v30_part5+0.000000e+00*s50+0.000000e+00*s51+0.000000e+00*s52+(-1.899398e+01)*s53+6.723888e+00*s54+(-2.584406e+01)*s55+(-2.108563e+01)*s56+(-3.023947e+01)*s57+(-7.496542e+00)*s58+(-1.776082e+01)*s59 \
v30_part7=v30_part6+(-7.965613e+00)*s60+(-1.677521e+00)*s61+2.130521e+01*s62+(-3.860724e+01)*s63+0.000000e+00*s64+(-1.218065e+01)*s65+0.000000e+00*s66+0.000000e+00*s67+0.000000e+00*s68+0.000000e+00*s69 \
v30_part8=v30_part7+(-1.513954e+01)*s70+(-1.270781e+01)*s71+(-4.967649e+01)*s72+(-1.133744e+01)*s73+(-1.868716e+01)*s74+(-2.479368e+01)*s75+1.062965e-03*s76+(-1.565898e+01)*s77+(-2.033513e+01)*s78+0.000000e+00*s79 \
v30_part9=v30_part8+0.000000e+00*s80+(-8.171422e+01)*s81+0.000000e+00*s82+(-5.364790e+00)*s83+(-1.858747e+01)*s84+(-7.551952e+01)*s85+(-3.112293e+00)*s86+(-4.369816e+01)*s87+(-3.366970e+01)*s88+(-3.317494e+00)*s89 \
v30_part10=v30_part9+(-5.415043e+01)*s90+(-1.630448e+01)*s91+(-2.674581e+01)*s92+(-1.279327e+01)*s93+(-2.951556e+00)*s94+1.548009e-01*s95+(-2.425429e+01)*s96+(-3.242439e+00)*s97+(-2.027830e-01)*s98+(-9.923751e+01)*s99 \
v30=v30_part10+(-2.198360e+01)*s100+(-2.740907e+01)*s101+(-6.881790e+01)*s102+(-1.191576e+02)*s103+(-7.564519e+01)*s104 \
v31_part1=0.000000e+00*s0+0.000000e+00*s1+0.000000e+00*s2+0.000000e+00*s3+0.000000e+00*s4+0.000000e+00*s5+0.000000e+00*s6+0.000000e+00*s7+6.226854e+00*s8+1.649144e+01*s9 \
v31_part2=v31_part1+0.000000e+00*s10+0.000000e+00*s11+0.000000e+00*s12+0.000000e+00*s13+1.502618e+02*s14+0.000000e+00*s15+0.000000e+00*s16+0.000000e+00*s17+0.000000e+00*s18+0.000000e+00*s19 \
v31_part3=v31_part2+0.000000e+00*s20+0.000000e+00*s21+7.708205e+00*s22+0.000000e+00*s23+0.000000e+00*s24+0.000000e+00*s25+0.000000e+00*s26+0.000000e+00*s27+5.176543e+01*s28+0.000000e+00*s29 \
v31_part4=v31_part3+0.000000e+00*s30+0.000000e+00*s31+0.000000e+00*s32+0.000000e+00*s33+0.000000e+00*s34+0.000000e+00*s35+0.000000e+00*s36+0.000000e+00*s37+0.000000e+00*s38+0.000000e+00*s39 \
v31_part5=v31_part4+0.000000e+00*s40+0.000000e+00*s41+0.000000e+00*s42+0.000000e+00*s43+0.000000e+00*s44+0.000000e+00*s45+0.000000e+00*s46+0.000000e+00*s47+1.738542e+02*s48+6.001851e+01*s49 \
v31_part6=v31_part5+0.000000e+00*s50+0.000000e+00*s51+0.000000e+00*s52+9.147896e+01*s53+6.556852e+01*s54+1.210400e+02*s55+6.596988e+01*s56+1.010633e+02*s57+6.263707e+01*s58+5.410715e+01*s59 \
v31_part7=v31_part6+4.956943e+01*s60+4.203807e+01*s61+1.812568e+01*s62+1.050893e+02*s63+0.000000e+00*s64+6.497019e+01*s65+0.000000e+00*s66+0.000000e+00*s67+0.000000e+00*s68+0.000000e+00*s69 \
v31_part8=v31_part7+1.961408e+02*s70+1.335333e+02*s71+1.458672e+02*s72+9.781050e+01*s73+1.156257e+02*s74+1.273570e+02*s75+8.174510e+01*s76+8.925014e+01*s77+9.694767e+01*s78+0.000000e+00*s79 \
v31_part9=v31_part8+0.000000e+00*s80+2.444620e+02*s81+0.000000e+00*s82+1.545003e+02*s83+1.301013e+02*s84+1.691325e+02*s85+1.111908e+02*s86+1.454048e+02*s87+1.315285e+02*s88+9.417372e+01*s89 \
v31_part10=v31_part9+2.582413e+02*s90+1.227860e+02*s91+1.463989e+02*s92+1.570292e+02*s93+1.362422e+02*s94+1.478659e+02*s95+1.459808e+02*s96+1.851390e+02*s97+1.817853e+02*s98+2.872152e+02*s99 \
v31=v31_part10+1.828816e+02*s100+2.514701e+02*s101+2.804536e+02*s102+3.546621e+02*s103+3.378749e+02*s104 \
v32_part1=0.000000e+00*s0+0.000000e+00*s1+0.000000e+00*s2+0.000000e+00*s3+0.000000e+00*s4+0.000000e+00*s5+0.000000e+00*s6+0.000000e+00*s7+8.358713e+00*s8+5.057198e-01*s9 \
v32_part2=v32_part1+0.000000e+00*s10+0.000000e+00*s11+0.000000e+00*s12+0.000000e+00*s13+(-2.273232e+01)*s14+0.000000e+00*s15+0.000000e+00*s16+0.000000e+00*s17+0.000000e+00*s18+0.000000e+00*s19 \
v32_part3=v32_part2+0.000000e+00*s20+0.000000e+00*s21+(-6.916872e+00)*s22+0.000000e+00*s23+0.000000e+00*s24+0.000000e+00*s25+0.000000e+00*s26+0.000000e+00*s27+1.998126e+01*s28+0.000000e+00*s29 \
v32_part4=v32_part3+0.000000e+00*s30+0.000000e+00*s31+0.000000e+00*s32+0.000000e+00*s33+0.000000e+00*s34+0.000000e+00*s35+0.000000e+00*s36+0.000000e+00*s37+0.000000e+00*s38+0.000000e+00*s39 \
v32_part5=v32_part4+0.000000e+00*s40+0.000000e+00*s41+0.000000e+00*s42+0.000000e+00*s43+0.000000e+00*s44+0.000000e+00*s45+0.000000e+00*s46+0.000000e+00*s47+(-8.104195e+01)*s48+7.058374e+01*s49 \
v32_part6=v32_part5+0.000000e+00*s50+0.000000e+00*s51+0.000000e+00*s52+(-4.620043e+00)*s53+(-3.237849e+01)*s54+(-9.475283e+00)*s55+1.601546e+01*s56+4.222423e-01*s57+(-2.458868e+00)*s58+9.972633e+00*s59 \
v32_part7=v32_part6+1.058834e-01*s60+(-1.492209e+00)*s61+(-7.550600e-02)*s62+(-2.726622e+01)*s63+0.000000e+00*s64+(-3.920774e+01)*s65+0.000000e+00*s66+0.000000e+00*s67+0.000000e+00*s68+0.000000e+00*s69 \
v32_part8=v32_part7+(-1.159076e+02)*s70+(-4.621814e+01)*s71+3.054202e+00*s72+(-1.341008e+01)*s73+(-2.046905e+01)*s74+(-2.235810e+01)*s75+(-1.582468e+01)*s76+(-5.174280e+00)*s77+(-1.559323e+01)*s78+0.000000e+00*s79 \
v32_part9=v32_part8+0.000000e+00*s80+(-6.405701e+01)*s81+0.000000e+00*s82+(-7.721708e+01)*s83+(-2.977357e+01)*s84+2.021510e+01*s85+(-3.696763e+01)*s86+(-1.870817e+01)*s87+(-2.614294e+01)*s88+(-1.711910e+01)*s89 \
v32_part10=v32_part9+(-1.862666e+02)*s90+1.864854e-01*s91+(-1.913354e+01)*s92+(-6.682118e+01)*s93+(-5.388903e+01)*s94+(-8.382481e+01)*s95+(-3.323058e+01)*s96+(-1.094389e+02)*s97+(-1.084838e+02)*s98+(-9.733244e+01)*s99 \
v32=v32_part10+(-7.106088e+01)*s100+(-1.643926e+02)*s101+(-1.393738e+02)*s102+(-1.418049e+02)*s103+(-2.075374e+02)*s104 \
v33_part1=0.000000e+00*s0+0.000000e+00*s1+0.000000e+00*s2+2.565776e+00*s3+(-7.426153e-01)*s4+3.081582e-01*s5+(-2.750706e+00)*s6+5.865547e+00*s7+5.198715e+00*s8+2.006869e+01*s9 \
v33_part2=v33_part1+2.268950e+01*s10+0.000000e+00*s11+0.000000e+00*s12+1.000000e+04*s13+0.000000e+00*s14+0.000000e+00*s15+1.000000e+04*s16+1.000000e+04*s17+6.084163e+02*s18+5.913397e+02*s19 \
v33_part3=v33_part2+1.000000e+04*s20+5.395704e+01*s21+(-1.207965e+01)*s22+(-4.061423e+00)*s23+5.390762e+00*s24+(-5.710331e+01)*s25+(-3.023494e+01)*s26+(-6.378241e+01)*s27+(-5.990038e+01)*s28+0.000000e+00*s29 \
v33_part4=v33_part3+(-5.942729e+01)*s30+2.452233e+02*s31+(-9.089184e+02)*s32+(-1.159955e+03)*s33+(-9.389103e-01)*s34+1.092323e+02*s35+0.000000e+00*s36+(-5.302437e+00)*s37+0.000000e+00*s38+0.000000e+00*s39 \
v33_part5=v33_part4+0.000000e+00*s40+0.000000e+00*s41+0.000000e+00*s42+0.000000e+00*s43+(-2.428877e+03)*s44+0.000000e+00*s45+2.945270e+02*s46+(-1.471682e+03)*s47+0.000000e+00*s48+0.000000e+00*s49 \
v33_part6=v33_part5+(-1.361354e+03)*s50+0.000000e+00*s51+9.325904e+01*s52+2.198620e+01*s53+1.247586e+00*s54+(-8.657155e+00)*s55+2.278730e+01*s56+9.720804e+00*s57+2.447912e+01*s58+5.192632e+01*s59 \
v33_part7=v33_part6+(-1.363029e+00)*s60+0.000000e+00*s61+0.000000e+00*s62+1.887638e+01*s63+5.060064e+01*s64+(-3.213525e+01)*s65+8.321017e+01*s66+(-5.516298e+01)*s67+2.399197e+01*s68+(-1.091131e+01)*s69 \
v33_part8=v33_part7+4.298496e+01*s70+9.208035e+00*s71+1.452612e-01*s72+4.342991e+01*s73+(-5.582378e+00)*s74+(-6.685596e+01)*s75+(-1.815149e+01)*s76+2.085653e+01*s77+4.728446e+01*s78+2.479454e+03*s79 \
v33_part9=v33_part8+0.000000e+00*s80+9.780903e+01*s81+1.767105e+03*s82+1.356310e+01*s83+(-1.820830e+01)*s84+(-1.013236e+01)*s85+(-1.560648e+01)*s86+(-3.837180e+01)*s87+(-4.414051e+01)*s88+(-2.216573e+01)*s89 \
v33_part10=v33_part9+0.000000e+00*s90+2.071166e+01*s91+(-2.760589e-02)*s92+1.052863e+00*s93+(-1.130016e+01)*s94+3.622465e+01*s95+(-1.419273e+01)*s96+(-2.521156e-01)*s97+(-5.334429e+01)*s98+(-2.693084e+01)*s99 \
v33=v33_part10+(-4.176651e-01)*s100+1.840670e+01*s101+(-4.043043e+01)*s102+(-3.840928e+01)*s103+(-2.544976e+01)*s104 \
v34_part1=0.000000e+00*s0+0.000000e+00*s1+0.000000e+00*s2+8.741985e-01*s3+1.364301e+01*s4+4.005908e+01*s5+6.628626e+01*s6+5.943886e+01*s7+7.703963e+01*s8+6.001119e+01*s9 \
v34_part2=v34_part1+4.819846e+01*s10+0.000000e+00*s11+0.000000e+00*s12+1.000000e+04*s13+0.000000e+00*s14+0.000000e+00*s15+1.000000e+04*s16+(-1.990461e+03)*s17+(-2.528116e+03)*s18+5.695249e+03*s19 \
v34_part3=v34_part2+1.000000e+04*s20+3.610251e+03*s21+1.791146e+02*s22+1.233298e+02*s23+6.409786e+01*s24+1.681795e+02*s25+2.152840e+02*s26+2.321914e+02*s27+2.403581e+02*s28+0.000000e+00*s29 \
v34_part4=v34_part3+1.665691e+02*s30+8.703445e+02*s31+2.693813e+02*s32+1.820943e+03*s33+2.784021e+03*s34+(-2.302312e+03)*s35+0.000000e+00*s36+(-7.718297e+01)*s37+0.000000e+00*s38+0.000000e+00*s39 \
v34_part5=v34_part4+0.000000e+00*s40+0.000000e+00*s41+0.000000e+00*s42+0.000000e+00*s43+7.749741e+03*s44+0.000000e+00*s45+4.523440e+03*s46+6.469432e+03*s47+0.000000e+00*s48+0.000000e+00*s49 \
v34_part6=v34_part5+6.693860e+03*s50+0.000000e+00*s51+8.103089e+01*s52+1.611100e+01*s53+4.866663e+01*s54+5.961791e+01*s55+3.749179e+01*s56+2.899513e+01*s57+(-1.239181e+01)*s58+(-1.083135e+02)*s59 \
v34_part7=v34_part6+(-3.499099e-01)*s60+0.000000e+00*s61+0.000000e+00*s62+5.906946e-01*s63+(-9.544323e+01)*s64+(-1.055660e+01)*s65+(-7.554979e+01)*s66+(-1.633347e+01)*s67+(-1.759991e+02)*s68+(-4.579356e+01)*s69 \
v34_part8=v34_part7+(-1.397080e+02)*s70+(-1.886466e+01)*s71+1.983294e+01*s72+1.440393e+00*s73+(-5.984269e+01)*s74+(-4.603498e-01)*s75+3.726781e+01*s76+9.680154e-01*s77+(-3.229110e+01)*s78+1.086776e+03*s79 \
v34_part9=v34_part8+0.000000e+00*s80+1.509607e+02*s81+6.250000e+02*s82+(-1.778430e+00)*s83+8.139488e+00*s84+1.460835e-01*s85+2.075166e+01*s86+5.485467e+01*s87+2.777601e+01*s88+2.478547e+01*s89 \
v34_part10=v34_part9+0.000000e+00*s90+(-2.114829e+01)*s91+1.436396e+01*s92+(-3.658217e-01)*s93+2.661440e+01*s94+8.159670e+00*s95+(-8.711154e+00)*s96+(-2.627023e+01)*s97+4.493796e+01*s98+5.319143e+01*s99 \
v34=v34_part10+(-3.176971e-02)*s100+3.217560e+00*s101+5.550769e+01*s102+5.333554e+01*s103+4.909144e+01*s104 \
v35_part1=0.000000e+00*s0+0.000000e+00*s1+0.000000e+00*s2+2.212438e+01*s3+7.609439e+00*s4+2.893590e-02*s5+(-1.964202e-01)*s6+(-5.499138e-03)*s7+1.037143e+01*s8+1.914496e+01*s9 \
v35_part2=v35_part1+2.319946e+01*s10+0.000000e+00*s11+0.000000e+00*s12+1.000000e+04*s13+0.000000e+00*s14+0.000000e+00*s15+1.000000e+04*s16+8.888234e+03*s17+1.000000e+04*s18+1.109977e+03*s19 \
v35_part3=v35_part2+1.000000e+04*s20+1.109683e+00*s21+(-7.402739e+01)*s22+(-7.181251e+01)*s23+(-4.888005e+01)*s24+(-4.409941e+01)*s25+3.960990e+01*s26+5.840305e+01*s27+7.804466e+00*s28+0.000000e+00*s29 \
v35_part4=v35_part3+(-5.308123e+01)*s30+4.737606e+02*s31+8.508093e+03*s32+4.499597e+02*s33+(-1.945341e+01)*s34+7.316588e+03*s35+0.000000e+00*s36+7.582761e+03*s37+0.000000e+00*s38+0.000000e+00*s39 \
v35_part5=v35_part4+0.000000e+00*s40+0.000000e+00*s41+0.000000e+00*s42+0.000000e+00*s43+(-3.922769e+02)*s44+0.000000e+00*s45+(-2.206561e+03)*s46+(-1.025655e+03)*s47+0.000000e+00*s48+0.000000e+00*s49 \
v35_part6=v35_part5+(-2.482629e+02)*s50+0.000000e+00*s51+(-1.608849e+02)*s52+2.841874e+00*s53+1.907817e+01*s54+2.159906e+01*s55+(-6.899936e-01)*s56+2.386768e+01*s57+4.288403e+01*s58+6.264657e+01*s59 \
v35_part7=v35_part6+1.757864e+01*s60+0.000000e+00*s61+0.000000e+00*s62+2.178261e+02*s63+1.257344e+02*s64+1.903003e+02*s65+6.096190e+01*s66+2.132012e+02*s67+2.812941e+02*s68+1.664356e+02*s69 \
v35_part8=v35_part7+1.603265e+02*s70+9.819169e+01*s71+3.232160e+01*s72+7.295701e+00*s73+1.537390e+02*s74+1.548321e+02*s75+3.246934e+01*s76+1.964176e+01*s77+2.912336e+01*s78+5.541038e+02*s79 \
v35_part9=v35_part8+0.000000e+00*s80+6.083248e+02*s81+3.209410e+02*s82+3.681887e+01*s83+7.862094e+01*s84+7.143853e+01*s85+5.010759e+01*s86+4.723985e+01*s87+8.160614e+01*s88+5.017523e+01*s89 \
v35_part10=v35_part9+0.000000e+00*s90+2.852000e+01*s91+1.670617e+01*s92+3.658508e+01*s93+1.993971e+01*s94+(-3.584630e+01)*s95+6.506384e+01*s96+7.618737e+01*s97+6.148474e+01*s98+(-1.433352e+01)*s99 \
v35=v35_part10+3.214590e+01*s100+(-1.761700e+01)*s101+2.025867e-02*s102+(-3.769115e+00)*s103+(-2.181522e+01)*s104 \
v36_part1=0.000000e+00*s0+0.000000e+00*s1+0.000000e+00*s2+0.000000e+00*s3+0.000000e+00*s4+0.000000e+00*s5+0.000000e+00*s6+0.000000e+00*s7+0.000000e+00*s8+0.000000e+00*s9 \
v36_part2=v36_part1+0.000000e+00*s10+0.000000e+00*s11+0.000000e+00*s12+0.000000e+00*s13+0.000000e+00*s14+0.000000e+00*s15+0.000000e+00*s16+0.000000e+00*s17+0.000000e+00*s18+0.000000e+00*s19 \
v36_part3=v36_part2+0.000000e+00*s20+0.000000e+00*s21+8.912686e-01*s22+4.002595e+01*s23+(-1.038687e+01)*s24+(-1.694917e+01)*s25+0.000000e+00*s26+0.000000e+00*s27+0.000000e+00*s28+4.981547e+01*s29 \
v36_part4=v36_part3+0.000000e+00*s30+0.000000e+00*s31+0.000000e+00*s32+0.000000e+00*s33+0.000000e+00*s34+0.000000e+00*s35+0.000000e+00*s36+0.000000e+00*s37+0.000000e+00*s38+5.900689e+01*s39 \
v36_part5=v36_part4+2.874273e+00*s40+(-5.026110e-02)*s41+(-6.157229e+01)*s42+3.498711e+01*s43+0.000000e+00*s44+0.000000e+00*s45+0.000000e+00*s46+0.000000e+00*s47+(-1.101737e+02)*s48+(-1.267911e+02)*s49 \
v36_part6=v36_part5+(-2.452929e+00)*s50+(-3.732254e+02)*s51+0.000000e+00*s52+0.000000e+00*s53+0.000000e+00*s54+0.000000e+00*s55+0.000000e+00*s56+0.000000e+00*s57+0.000000e+00*s58+0.000000e+00*s59 \
v36_part7=v36_part6+0.000000e+00*s60+0.000000e+00*s61+0.000000e+00*s62+4.629756e+01*s63+0.000000e+00*s64+0.000000e+00*s65+0.000000e+00*s66+0.000000e+00*s67+0.000000e+00*s68+0.000000e+00*s69 \
v36_part8=v36_part7+0.000000e+00*s70+0.000000e+00*s71+0.000000e+00*s72+0.000000e+00*s73+0.000000e+00*s74+0.000000e+00*s75+0.000000e+00*s76+0.000000e+00*s77+0.000000e+00*s78+0.000000e+00*s79 \
v36_part9=v36_part8+0.000000e+00*s80+0.000000e+00*s81+0.000000e+00*s82+0.000000e+00*s83+0.000000e+00*s84+0.000000e+00*s85+0.000000e+00*s86+0.000000e+00*s87+0.000000e+00*s88+0.000000e+00*s89 \
v36_part10=v36_part9+0.000000e+00*s90+0.000000e+00*s91+0.000000e+00*s92+0.000000e+00*s93+0.000000e+00*s94+0.000000e+00*s95+0.000000e+00*s96+0.000000e+00*s97+0.000000e+00*s98+0.000000e+00*s99 \
v36=v36_part10+0.000000e+00*s100+0.000000e+00*s101+0.000000e+00*s102+0.000000e+00*s103+0.000000e+00*s104 \
v37_part1=0.000000e+00*s0+0.000000e+00*s1+0.000000e+00*s2+0.000000e+00*s3+0.000000e+00*s4+0.000000e+00*s5+0.000000e+00*s6+0.000000e+00*s7+0.000000e+00*s8+0.000000e+00*s9 \
v37_part2=v37_part1+0.000000e+00*s10+0.000000e+00*s11+0.000000e+00*s12+0.000000e+00*s13+0.000000e+00*s14+0.000000e+00*s15+0.000000e+00*s16+0.000000e+00*s17+0.000000e+00*s18+0.000000e+00*s19 \
v37_part3=v37_part2+0.000000e+00*s20+0.000000e+00*s21+3.543911e+01*s22+(-5.007995e+01)*s23+6.284926e+01*s24+5.790674e+01*s25+0.000000e+00*s26+0.000000e+00*s27+0.000000e+00*s28+7.845916e-02*s29 \
v37_part4=v37_part3+0.000000e+00*s30+0.000000e+00*s31+0.000000e+00*s32+0.000000e+00*s33+0.000000e+00*s34+0.000000e+00*s35+0.000000e+00*s36+0.000000e+00*s37+0.000000e+00*s38+1.099970e+02*s39 \
v37_part5=v37_part4+1.673534e+02*s40+9.468215e+01*s41+8.248809e+01*s42+4.321984e+02*s43+0.000000e+00*s44+0.000000e+00*s45+0.000000e+00*s46+0.000000e+00*s47+6.236797e+02*s48+6.371740e+02*s49 \
v37_part6=v37_part5+(-1.932661e+01)*s50+1.228237e+03*s51+0.000000e+00*s52+0.000000e+00*s53+0.000000e+00*s54+0.000000e+00*s55+0.000000e+00*s56+0.000000e+00*s57+0.000000e+00*s58+0.000000e+00*s59 \
v37_part7=v37_part6+0.000000e+00*s60+0.000000e+00*s61+0.000000e+00*s62+5.709925e-01*s63+0.000000e+00*s64+0.000000e+00*s65+0.000000e+00*s66+0.000000e+00*s67+0.000000e+00*s68+0.000000e+00*s69 \
v37_part8=v37_part7+0.000000e+00*s70+0.000000e+00*s71+0.000000e+00*s72+0.000000e+00*s73+0.000000e+00*s74+0.000000e+00*s75+0.000000e+00*s76+0.000000e+00*s77+0.000000e+00*s78+0.000000e+00*s79 \
v37_part9=v37_part8+0.000000e+00*s80+0.000000e+00*s81+0.000000e+00*s82+0.000000e+00*s83+0.000000e+00*s84+0.000000e+00*s85+0.000000e+00*s86+0.000000e+00*s87+0.000000e+00*s88+0.000000e+00*s89 \
v37_part10=v37_part9+0.000000e+00*s90+0.000000e+00*s91+0.000000e+00*s92+0.000000e+00*s93+0.000000e+00*s94+0.000000e+00*s95+0.000000e+00*s96+0.000000e+00*s97+0.000000e+00*s98+0.000000e+00*s99 \
v37=v37_part10+0.000000e+00*s100+0.000000e+00*s101+0.000000e+00*s102+0.000000e+00*s103+0.000000e+00*s104 \
v38_part1=0.000000e+00*s0+0.000000e+00*s1+0.000000e+00*s2+0.000000e+00*s3+0.000000e+00*s4+0.000000e+00*s5+0.000000e+00*s6+0.000000e+00*s7+0.000000e+00*s8+0.000000e+00*s9 \
v38_part2=v38_part1+0.000000e+00*s10+0.000000e+00*s11+0.000000e+00*s12+0.000000e+00*s13+0.000000e+00*s14+0.000000e+00*s15+0.000000e+00*s16+0.000000e+00*s17+0.000000e+00*s18+0.000000e+00*s19 \
v38_part3=v38_part2+0.000000e+00*s20+0.000000e+00*s21+(-4.001472e+00)*s22+1.508506e+01*s23+3.225132e-01*s24+(-5.569799e-01)*s25+0.000000e+00*s26+0.000000e+00*s27+0.000000e+00*s28+4.063970e-01*s29 \
v38_part4=v38_part3+0.000000e+00*s30+0.000000e+00*s31+0.000000e+00*s32+0.000000e+00*s33+0.000000e+00*s34+0.000000e+00*s35+0.000000e+00*s36+0.000000e+00*s37+0.000000e+00*s38+(-4.701603e+01)*s39 \
v38_part5=v38_part4+(-1.086249e+01)*s40+(-3.306309e+00)*s41+2.317124e+00*s42+(-4.384780e+02)*s43+0.000000e+00*s44+0.000000e+00*s45+0.000000e+00*s46+0.000000e+00*s47+(-3.579219e+02)*s48+(-3.501177e+02)*s49 \
v38_part6=v38_part5+1.882670e+02*s50+(-1.154651e+03)*s51+0.000000e+00*s52+0.000000e+00*s53+0.000000e+00*s54+0.000000e+00*s55+0.000000e+00*s56+0.000000e+00*s57+0.000000e+00*s58+0.000000e+00*s59 \
v38_part7=v38_part6+0.000000e+00*s60+0.000000e+00*s61+0.000000e+00*s62+(-1.946334e+01)*s63+0.000000e+00*s64+0.000000e+00*s65+0.000000e+00*s66+0.000000e+00*s67+0.000000e+00*s68+0.000000e+00*s69 \
v38_part8=v38_part7+0.000000e+00*s70+0.000000e+00*s71+0.000000e+00*s72+0.000000e+00*s73+0.000000e+00*s74+0.000000e+00*s75+0.000000e+00*s76+0.000000e+00*s77+0.000000e+00*s78+0.000000e+00*s79 \
v38_part9=v38_part8+0.000000e+00*s80+0.000000e+00*s81+0.000000e+00*s82+0.000000e+00*s83+0.000000e+00*s84+0.000000e+00*s85+0.000000e+00*s86+0.000000e+00*s87+0.000000e+00*s88+0.000000e+00*s89 \
v38_part10=v38_part9+0.000000e+00*s90+0.000000e+00*s91+0.000000e+00*s92+0.000000e+00*s93+0.000000e+00*s94+0.000000e+00*s95+0.000000e+00*s96+0.000000e+00*s97+0.000000e+00*s98+0.000000e+00*s99 \
v38=v38_part10+0.000000e+00*s100+0.000000e+00*s101+0.000000e+00*s102+0.000000e+00*s103+0.000000e+00*s104 \
v39_part1=0.000000e+00*s0+0.000000e+00*s1+3.025121e-03*s2+0.000000e+00*s3+(-2.180225e-01)*s4+0.000000e+00*s5+0.000000e+00*s6+0.000000e+00*s7+2.647134e-01*s8+3.854848e-01*s9 \
v39_part2=v39_part1+1.582560e-01*s10+0.000000e+00*s11+(-1.177871e-02)*s12+(-7.169674e-01)*s13+0.000000e+00*s14+4.714423e-01*s15+(-4.600804e-01)*s16+(-8.479226e-02)*s17+9.896966e-02*s18+7.659000e-02*s19 \
v39_part3=v39_part2+(-4.244695e-02)*s20+1.439650e-01*s21+0.000000e+00*s22+0.000000e+00*s23+0.000000e+00*s24+0.000000e+00*s25+0.000000e+00*s26+0.000000e+00*s27+0.000000e+00*s28+0.000000e+00*s29 \
v39_part4=v39_part3+0.000000e+00*s30+3.784481e-03*s31+(-7.984314e-01)*s32+0.000000e+00*s33+3.120520e-01*s34+(-1.973656e+00)*s35+0.000000e+00*s36+1.005956e-01*s37+0.000000e+00*s38+0.000000e+00*s39 \
v39_part5=v39_part4+0.000000e+00*s40+0.000000e+00*s41+0.000000e+00*s42+0.000000e+00*s43+0.000000e+00*s44+0.000000e+00*s45+0.000000e+00*s46+0.000000e+00*s47+0.000000e+00*s48+0.000000e+00*s49 \
v39_part6=v39_part5+0.000000e+00*s50+0.000000e+00*s51+0.000000e+00*s52+0.000000e+00*s53+0.000000e+00*s54+0.000000e+00*s55+0.000000e+00*s56+0.000000e+00*s57+0.000000e+00*s58+0.000000e+00*s59 \
v39_part7=v39_part6+9.789086e-02*s60+6.097248e-02*s61+7.528046e-01*s62+0.000000e+00*s63+0.000000e+00*s64+0.000000e+00*s65+0.000000e+00*s66+0.000000e+00*s67+0.000000e+00*s68+0.000000e+00*s69 \
v39_part8=v39_part7+6.972439e-01*s70+7.034694e-01*s71+0.000000e+00*s72+2.073407e-01*s73+(-7.072607e-01)*s74+(-1.236309e+00)*s75+0.000000e+00*s76+0.000000e+00*s77+0.000000e+00*s78+(-2.953627e+00)*s79 \
v39_part9=v39_part8+(-1.325112e+01)*s80+0.000000e+00*s81+(-2.934164e+00)*s82+0.000000e+00*s83+0.000000e+00*s84+0.000000e+00*s85+0.000000e+00*s86+0.000000e+00*s87+0.000000e+00*s88+0.000000e+00*s89 \
v39_part10=v39_part9+0.000000e+00*s90+0.000000e+00*s91+0.000000e+00*s92+0.000000e+00*s93+0.000000e+00*s94+0.000000e+00*s95+0.000000e+00*s96+0.000000e+00*s97+0.000000e+00*s98+0.000000e+00*s99 \
v39=v39_part10+0.000000e+00*s100+0.000000e+00*s101+0.000000e+00*s102+0.000000e+00*s103+0.000000e+00*s104 \
v40_part1=0.000000e+00*s0+0.000000e+00*s1+1.192539e+00*s2+0.000000e+00*s3+1.465274e+00*s4+0.000000e+00*s5+0.000000e+00*s6+0.000000e+00*s7+8.160400e-01*s8+6.284095e-01*s9 \
v40_part2=v40_part1+8.774702e-01*s10+0.000000e+00*s11+8.792824e-01*s12+2.797073e+00*s13+0.000000e+00*s14+9.566523e-01*s15+2.496030e+00*s16+2.111851e+00*s17+1.992507e+00*s18+1.981595e+00*s19 \
v40_part3=v40_part2+2.007213e+00*s20+2.123128e+00*s21+0.000000e+00*s22+0.000000e+00*s23+0.000000e+00*s24+0.000000e+00*s25+0.000000e+00*s26+0.000000e+00*s27+0.000000e+00*s28+0.000000e+00*s29 \
v40_part4=v40_part3+0.000000e+00*s30+2.307995e+00*s31+5.104757e+00*s32+0.000000e+00*s33+1.793864e-01*s34+6.347671e+00*s35+0.000000e+00*s36+1.389178e+00*s37+0.000000e+00*s38+0.000000e+00*s39 \
v40_part5=v40_part4+0.000000e+00*s40+0.000000e+00*s41+0.000000e+00*s42+0.000000e+00*s43+0.000000e+00*s44+0.000000e+00*s45+0.000000e+00*s46+0.000000e+00*s47+0.000000e+00*s48+0.000000e+00*s49 \
v40_part6=v40_part5+0.000000e+00*s50+0.000000e+00*s51+0.000000e+00*s52+0.000000e+00*s53+0.000000e+00*s54+0.000000e+00*s55+0.000000e+00*s56+0.000000e+00*s57+0.000000e+00*s58+0.000000e+00*s59 \
v40_part7=v40_part6+3.361772e-01*s60+3.778123e-01*s61+(-1.043121e+00)*s62+0.000000e+00*s63+0.000000e+00*s64+0.000000e+00*s65+0.000000e+00*s66+0.000000e+00*s67+0.000000e+00*s68+0.000000e+00*s69 \
v40_part8=v40_part7+(-4.684758e-01)*s70+(-3.601731e-01)*s71+0.000000e+00*s72+3.315813e-01*s73+2.127033e+00*s74+7.563666e-01*s75+0.000000e+00*s76+0.000000e+00*s77+0.000000e+00*s78+2.275170e+01*s79 \
v40_part9=v40_part8+5.169205e+01*s80+0.000000e+00*s81+2.693290e+01*s82+0.000000e+00*s83+0.000000e+00*s84+0.000000e+00*s85+0.000000e+00*s86+0.000000e+00*s87+0.000000e+00*s88+0.000000e+00*s89 \
v40_part10=v40_part9+0.000000e+00*s90+0.000000e+00*s91+0.000000e+00*s92+0.000000e+00*s93+0.000000e+00*s94+0.000000e+00*s95+0.000000e+00*s96+0.000000e+00*s97+0.000000e+00*s98+0.000000e+00*s99 \
v40=v40_part10+0.000000e+00*s100+0.000000e+00*s101+0.000000e+00*s102+0.000000e+00*s103+0.000000e+00*s104 \
v41_part1=0.000000e+00*s0+0.000000e+00*s1+(-6.190975e-01)*s2+0.000000e+00*s3+(-5.578549e-01)*s4+0.000000e+00*s5+0.000000e+00*s6+0.000000e+00*s7+(-4.284763e-01)*s8+(-3.861211e-01)*s9 \
v41_part2=v41_part1+(-4.084983e-01)*s10+0.000000e+00*s11+(-1.633626e-01)*s12+(-2.085400e-01)*s13+0.000000e+00*s14+(-8.912822e-01)*s15+(-7.372690e-01)*s16+(-8.494624e-01)*s17+(-9.862889e-01)*s18+(-8.898673e-01)*s19 \
v41_part3=v41_part2+(-7.597139e-01)*s20+(-1.080154e+00)*s21+0.000000e+00*s22+0.000000e+00*s23+0.000000e+00*s24+0.000000e+00*s25+0.000000e+00*s26+0.000000e+00*s27+0.000000e+00*s28+0.000000e+00*s29 \
v41_part4=v41_part3+0.000000e+00*s30+(-2.089692e+00)*s31+(-3.198741e+00)*s32+0.000000e+00*s33+1.943058e-01*s34+(-2.616175e+00)*s35+0.000000e+00*s36+1.724558e-03*s37+0.000000e+00*s38+0.000000e+00*s39 \
v41_part5=v41_part4+0.000000e+00*s40+0.000000e+00*s41+0.000000e+00*s42+0.000000e+00*s43+0.000000e+00*s44+0.000000e+00*s45+0.000000e+00*s46+0.000000e+00*s47+0.000000e+00*s48+0.000000e+00*s49 \
v41_part6=v41_part5+0.000000e+00*s50+0.000000e+00*s51+0.000000e+00*s52+0.000000e+00*s53+0.000000e+00*s54+0.000000e+00*s55+0.000000e+00*s56+0.000000e+00*s57+0.000000e+00*s58+0.000000e+00*s59 \
v41_part7=v41_part6+(-1.822558e-01)*s60+(-1.578390e-01)*s61+5.179365e-01*s62+0.000000e+00*s63+0.000000e+00*s64+0.000000e+00*s65+0.000000e+00*s66+0.000000e+00*s67+0.000000e+00*s68+0.000000e+00*s69 \
v41_part8=v41_part7+(-2.356129e-01)*s70+2.245985e-03*s71+0.000000e+00*s72+(-1.707768e-02)*s73+(-7.433666e-03)*s74+1.410836e+00*s75+0.000000e+00*s76+0.000000e+00*s77+0.000000e+00*s78+(-2.107620e+01)*s79 \
v41_part9=v41_part8+(-3.999011e+01)*s80+0.000000e+00*s81+(-2.699060e+01)*s82+0.000000e+00*s83+0.000000e+00*s84+0.000000e+00*s85+0.000000e+00*s86+0.000000e+00*s87+0.000000e+00*s88+0.000000e+00*s89 \
v41_part10=v41_part9+0.000000e+00*s90+0.000000e+00*s91+0.000000e+00*s92+0.000000e+00*s93+0.000000e+00*s94+0.000000e+00*s95+0.000000e+00*s96+0.000000e+00*s97+0.000000e+00*s98+0.000000e+00*s99 \
v41=v41_part10+0.000000e+00*s100+0.000000e+00*s101+0.000000e+00*s102+0.000000e+00*s103+0.000000e+00*s104 \
v42_part1=1.739841e-01*s0+(-1.781872e-02)*s1+1.863089e-01*s2+1.158064e-01*s3+4.450451e-01*s4+(-1.159509e-01)*s5+(-4.649725e-02)*s6+(-5.377587e-02)*s7+7.207676e-01*s8+1.033783e+00*s9 \
v42_part2=v42_part1+8.465463e-01*s10+6.447714e-01*s11+8.182268e-01*s12+1.392226e+00*s13+5.433761e-01*s14+(-3.935361e-01)*s15+1.669019e+00*s16+7.794225e-01*s17+8.999057e-01*s18+7.022610e-01*s19 \
v42_part3=v42_part2+6.056749e-01*s20+5.665073e-01*s21+7.388203e-01*s22+3.935601e-01*s23+4.461950e-02*s24+5.583444e-01*s25+5.695641e-01*s26+2.812807e-02*s27+7.651593e-01*s28+3.473368e-01*s29 \
v42_part4=v42_part3+6.069898e-01*s30+1.062379e+00*s31+1.124940e+00*s32+9.120312e-01*s33+6.644419e-01*s34+1.708231e+00*s35+8.996552e-01*s36+6.413000e-01*s37+6.832938e-01*s38+3.776574e-01*s39 \
v42_part5=v42_part4+7.141260e-01*s40+(-4.435623e-01)*s41+1.695293e-01*s42+7.003642e-01*s43+1.005331e+00*s44+1.096029e+00*s45+1.639379e+00*s46+9.635565e-01*s47+6.745014e-01*s48+8.021373e-01*s49 \
v42_part6=v42_part5+9.808785e-01*s50+1.742960e+00*s51+3.004801e-01*s52+3.692306e-01*s53+7.933744e-02*s54+2.203244e-01*s55+3.198417e-01*s56+3.300919e-01*s57+2.968153e-01*s58+4.016671e-01*s59 \
v42_part7=v42_part6+1.470137e-01*s60+5.060813e-01*s61+6.457854e-01*s62+3.706530e-01*s63+3.810776e-01*s64+5.573749e-01*s65+7.630485e-01*s66+6.641795e-01*s67+3.161202e-01*s68+5.850692e-01*s69 \
v42_part8=v42_part7+5.703989e-01*s70+7.405299e-01*s71+2.645265e-01*s72+7.530641e-01*s73+7.245899e-01*s74+3.504306e-02*s75+7.934949e-01*s76+4.378435e-01*s77+3.389568e-01*s78+2.322406e-01*s79 \
v42_part9=v42_part8+(-1.771810e-01)*s80+(-6.468267e-01)*s81+1.210698e-01*s82+3.777669e-01*s83+3.134987e-01*s84+2.875633e-01*s85+3.337361e-01*s86+(-2.393057e-02)*s87+1.808293e-01*s88+3.772133e-01*s89 \
v42_part10=v42_part9+1.041972e+00*s90+8.314508e-01*s91+2.757321e-01*s92+5.685698e-01*s93+3.748342e-01*s94+6.847870e-01*s95+3.240141e-01*s96+5.075404e-01*s97+(-3.211614e-03)*s98+(-3.989836e-01)*s99 \
v42=v42_part10+2.483686e-01*s100+5.364834e-01*s101+(-5.433910e-01)*s102+(-4.952880e-01)*s103+(-1.354854e-01)*s104 \
v43_part1=5.702295e-01*s0+6.833706e-01*s1+8.062982e-01*s2+7.780144e-02*s3+2.380172e-01*s4+4.104672e-01*s5+2.182918e-01*s6+2.663482e-01*s7+1.462901e-01*s8+(-1.299672e-01)*s9 \
v43_part2=v43_part1+1.378710e-01*s10+(-9.457519e-02)*s11+(-2.442097e-01)*s12+(-1.185688e+00)*s13+3.288487e-01*s14+9.135418e-01*s15+(-1.688036e+00)*s16+(-5.323606e-01)*s17+(-5.770186e-01)*s18+(-3.895846e-01)*s19 \
v43_part3=v43_part2+(-2.512554e-01)*s20+(-2.007321e-01)*s21+(-9.327409e-01)*s22+(-9.902454e-01)*s23+(-5.330742e-02)*s24+(-3.194890e-01)*s25+(-6.835433e-01)*s26+1.024789e-01*s27+(-6.820312e-01)*s28+(-1.190639e-01)*s29 \
v43_part4=v43_part3+(-4.268256e-01)*s30+(-1.354744e+00)*s31+(-1.573327e+00)*s32+(-1.053645e+00)*s33+(-6.612060e-01)*s34+(-1.602481e+00)*s35+(-1.034611e+00)*s36+(-5.584883e-01)*s37+(-2.606758e-01)*s38+(-3.450988e-01)*s39 \
v43_part5=v43_part4+(-6.158112e-01)*s40+4.018629e-01*s41+1.166364e-03*s42+(-1.294666e+00)*s43+(-9.843189e-01)*s44+(-1.556030e+00)*s45+(-1.485468e+00)*s46+(-5.461001e-01)*s47+(-7.563893e-01)*s48+(-9.915772e-01)*s49 \
v43_part6=v43_part5+(-8.669753e-01)*s50+(-1.227742e+00)*s51+4.626683e-01*s52+8.190352e-02*s53+4.258256e-01*s54+3.536243e-01*s55+9.387492e-02*s56+6.351070e-02*s57+4.877932e-02*s58+4.228239e-02*s59 \
v43_part7=v43_part6+4.741234e-01*s60+1.606295e-02*s61+(-2.551478e-01)*s62+(-9.664276e-01)*s63+(-7.586225e-01)*s64+(-8.191657e-01)*s65+(-9.448529e-01)*s66+(-6.674886e-01)*s67+(-8.543391e-01)*s68+(-6.971425e-01)*s69 \
v43_part8=v43_part7+(-4.405671e-01)*s70+(-6.700471e-01)*s71+(-5.090987e-02)*s72+(-3.937214e-01)*s73+(-1.276411e+00)*s74+(-3.707191e-01)*s75+(-6.189442e-01)*s76+(-2.837707e-01)*s77+(-2.183390e-01)*s78+(-1.375954e+00)*s79 \
v43_part9=v43_part8+(-2.270564e-01)*s80+(-1.393926e-01)*s81+(-5.980153e-01)*s82+(-7.710050e-02)*s83+(-5.184216e-01)*s84+(-5.073405e-01)*s85+(-3.420191e-01)*s86+(-1.127504e-02)*s87+(-4.021227e-01)*s88+(-4.173460e-01)*s89 \
v43_part10=v43_part9+(-3.684569e+00)*s90+(-1.710844e+00)*s91+(-7.621336e-01)*s92+(-9.555524e-01)*s93+(-7.111445e-01)*s94+(-7.720918e-01)*s95+(-1.096444e+00)*s96+(-1.594477e+00)*s97+(-7.550951e-01)*s98+(-2.303901e-01)*s99 \
v43=v43_part10+(-9.665532e-01)*s100+(-1.554392e+00)*s101+(-3.009716e-01)*s102+(-2.390721e-01)*s103+(-1.329395e+00)*s104 \
v44_part1=(-5.977103e-01)*s0+(-3.765043e-01)*s1+(-5.242526e-01)*s2+7.862383e-03*s3+(-3.616386e-01)*s4+(-1.341792e-01)*s5+1.094351e-04*s6+(-2.091305e-02)*s7+2.279464e-01*s8+2.316618e-01*s9 \
v44_part2=v44_part1+2.416986e-01*s10+1.741172e-01*s11+1.879805e-01*s12+7.734289e-02*s13+2.174769e-02*s14+1.073944e+00*s15+5.265027e-01*s16+7.650721e-01*s17+6.555355e-01*s18+5.626395e-01*s19 \
v44_part3=v44_part2+4.038858e-01*s20+3.491583e-01*s21+1.218123e+00*s22+1.759852e+00*s23+1.121581e+00*s24+6.176400e-01*s25+9.036706e-01*s26+7.932418e-01*s27+5.553932e-01*s28+2.774302e-01*s29 \
v44_part4=v44_part3+3.104207e-01*s30+1.128070e+00*s31+1.469948e+00*s32+1.460222e+00*s33+8.445874e-01*s34+6.946068e-01*s35+1.108327e+00*s36+5.840014e-01*s37+7.531142e-01*s38+1.183382e+00*s39 \
v44_part5=v44_part4+8.697005e-01*s40+1.486258e+00*s41+7.341240e-01*s42+1.800161e+00*s43+1.350600e+00*s44+1.882049e+00*s45+8.078380e-01*s46+6.260965e-01*s47+9.404255e-01*s48+1.081253e+00*s49 \
v44_part6=v44_part5+1.100362e+00*s50+4.002069e-02*s51+(-4.627390e-01)*s52+(-1.887803e-01)*s53+(-3.752557e-02)*s54+2.592048e-04*s55+2.130386e-02*s56+7.301591e-02*s57+1.101712e-01*s58+1.116141e-01*s59 \
v44_part7=v44_part6+5.623856e-02*s60+9.859871e-02*s61+1.981711e-01*s62+1.268331e+00*s63+8.610463e-01*s64+5.544445e-01*s65+3.253104e-01*s66+2.853769e-01*s67+9.020760e-01*s68+3.971291e-01*s69 \
v44_part8=v44_part7+6.125374e-01*s70+6.326539e-01*s71+3.721113e-01*s72+1.127824e-01*s73+1.280040e+00*s74+1.142208e+00*s75+2.176057e-01*s76+2.453762e-01*s77+2.320236e-01*s78+2.232226e+00*s79 \
v44_part9=v44_part8+1.033159e+00*s80+1.552112e+00*s81+1.133227e+00*s82+4.269274e-02*s83+5.020008e-01*s84+5.734338e-01*s85+1.645247e-01*s86+3.089397e-01*s87+5.225526e-01*s88+2.157449e-01*s89 \
v44_part10=v44_part9+4.801088e+00*s90+1.214056e+00*s91+8.775790e-01*s92+5.540046e-01*s93+5.696847e-01*s94+1.115377e-01*s95+1.181920e+00*s96+1.606910e+00*s97+1.207920e+00*s98+9.643102e-01*s99 \
v44=v44_part10+1.044897e+00*s100+1.459481e+00*s101+1.213174e+00*s102+1.031844e+00*s103+2.623192e+00*s104 \
v45_part1=4.737731e-01*s0+2.148538e-01*s1+5.524687e-01*s2+7.405125e-01*s3+6.826097e-02*s4+1.678885e-01*s5+6.564758e-01*s6+7.265944e-01*s7+4.587970e-01*s8+(-1.007493e+00)*s9 \
v45_part2=v45_part1+(-5.057091e+00)*s10+5.409330e-01*s11+1.023774e+00*s12+(-2.553818e+00)*s13+1.779281e-01*s14+1.945292e+00*s15+(-5.423127e+00)*s16+4.698666e-01*s17+(-6.820801e-02)*s18+(-5.307017e-03)*s19 \
v45_part3=v45_part2+(-7.745776e-01)*s20+(-9.364960e-01)*s21+2.502630e+00*s22+3.725021e+01*s23+(-1.456627e+01)*s24+(-2.606720e+01)*s25+1.296389e+00*s26+(-1.894706e+00)*s27+(-5.670693e+00)*s28+3.108177e-01*s29 \
v45_part4=v45_part3+(-6.300194e+00)*s30+9.762059e-02*s31+2.830118e-02*s32+4.450344e+00*s33+4.687455e+00*s34+(-6.950143e-01)*s35+9.086677e-01*s36+1.265233e-01*s37+(-1.000000e+04)*s38+(-1.000000e+04)*s39 \
v45_part5=v45_part4+(-1.000000e+04)*s40+(-1.000000e+04)*s41+(-2.360748e+03)*s42+(-1.000000e+04)*s43+(-1.028816e-01)*s44+1.815267e+00*s45+3.458001e+00*s46+1.273369e+00*s47+(-1.608462e-01)*s48+(-4.019008e-01)*s49 \
v45_part6=v45_part5+(-2.660736e-02)*s50+(-8.858336e+03)*s51+1.213937e-01*s52+(-2.176707e-01)*s53+(-2.494397e-02)*s54+2.658285e-03*s55+1.566183e-01*s56+6.499717e-01*s57+3.261764e-01*s58+2.184714e-01*s59 \
v45_part7=v45_part6+(-3.315174e-01)*s60+(-2.344839e+00)*s61+(-2.212449e+00)*s62+1.687891e+01*s63+6.437757e+00*s64+2.341062e+00*s65+1.280939e+01*s66+(-7.507576e+00)*s67+2.743631e+00*s68+(-4.589419e+01)*s69 \
v45_part8=v45_part7+2.644861e+00*s70+2.416776e+01*s71+(-2.594440e+00)*s72+1.696060e+00*s73+1.235989e+02*s74+(-9.245342e+01)*s75+(-1.217211e+03)*s76+6.678949e+00*s77+(-1.713532e+00)*s78+(-5.940954e-01)*s79 \
v45_part9=v45_part8+(-1.000000e+04)*s80+(-1.000000e+04)*s81+(-4.889132e+01)*s82+1.303776e+00*s83+2.035665e+00*s84+6.266151e+00*s85+2.458125e+01*s86+6.145764e+00*s87+2.324002e+00*s88+(-2.511402e+01)*s89 \
v45_part10=v45_part9+(-1.000000e+04)*s90+2.237227e-02*s91+1.114698e+03*s92+1.484310e+03*s93+(-1.000000e+04)*s94+(-8.539342e+03)*s95+(-1.000000e+04)*s96+(-1.000000e+04)*s97+(-1.000000e+04)*s98+(-1.000000e+04)*s99 \
v45=v45_part10+(-4.006397e+02)*s100+(-1.000000e+04)*s101+(-1.000000e+04)*s102+(-1.000000e+04)*s103+(-1.000000e+04)*s104 \
v46_part1=(-5.321045e+00)*s0+(-4.664319e+00)*s1+(-2.811155e+00)*s2+(-1.995482e+00)*s3+(-1.239979e+00)*s4+(-2.804842e+00)*s5+(-1.436498e+00)*s6+(-1.649013e+00)*s7+(-5.243489e+00)*s8+(-1.037978e+01)*s9 \
v46_part2=v46_part1+(-4.478186e+00)*s10+(-8.289668e+00)*s11+(-9.896469e+00)*s12+(-4.014053e+00)*s13+(-5.682099e+00)*s14+(-7.175915e+00)*s15+2.203664e-01*s16+(-1.101403e+01)*s17+(-1.522627e+01)*s18+(-1.157236e+01)*s19 \
v46_part3=v46_part2+(-1.124513e+01)*s20+(-1.062565e+01)*s21+(-8.872333e+00)*s22+(-1.909811e+02)*s23+(-2.202773e+02)*s24+(-1.089159e+02)*s25+(-8.023395e+00)*s26+(-3.832380e+00)*s27+(-3.402571e+00)*s28+(-5.578768e+02)*s29 \
v46_part4=v46_part3+(-6.218443e+02)*s30+(-8.554173e+00)*s31+(-1.206016e+01)*s32+(-5.098166e+01)*s33+(-1.362428e+01)*s34+(-9.879129e+00)*s35+(-1.954164e+01)*s36+(-7.742103e+00)*s37+(-1.000000e+04)*s38+(-1.000000e+04)*s39 \
v46_part5=v46_part4+(-1.000000e+04)*s40+(-1.000000e+04)*s41+(-1.000000e+04)*s42+(-1.000000e+04)*s43+(-1.316109e+01)*s44+(-2.172719e+01)*s45+(-1.654980e+01)*s46+(-1.001190e+01)*s47+(-2.476604e+00)*s48+(-3.045998e+00)*s49 \
v46_part6=v46_part5+(-9.317602e+00)*s50+(-9.293359e+03)*s51+(-3.906957e+00)*s52+(-3.612764e+00)*s53+(-3.180075e+00)*s54+(-3.333177e+00)*s55+(-3.115474e+00)*s56+(-4.651215e+00)*s57+(-4.613341e+00)*s58+(-9.178157e+00)*s59 \
v46_part7=v46_part6+(-1.282974e+01)*s60+(-2.011468e+01)*s61+(-1.541836e+01)*s62+(-1.030624e+02)*s63+(-5.003033e+01)*s64+(-3.675423e+01)*s65+(-4.188347e+01)*s66+(-4.245095e+01)*s67+(-2.818049e+01)*s68+(-1.284796e+01)*s69 \
v46_part8=v46_part7+(-2.871040e+01)*s70+(-9.116168e+01)*s71+(-2.355571e+01)*s72+(-3.618910e+01)*s73+(-1.101275e+03)*s74+(-2.499317e+02)*s75+(-2.132293e+01)*s76+(-1.166260e+02)*s77+(-7.094286e+01)*s78+(-6.578587e+00)*s79 \
v46_part9=v46_part8+(-1.000000e+04)*s80+(-1.000000e+04)*s81+(-3.855848e+01)*s82+(-2.097588e+01)*s83+(-3.123230e+01)*s84+(-6.374440e+01)*s85+(-6.989841e+01)*s86+(-3.332953e+01)*s87+(-3.198774e+01)*s88+(-2.269419e+01)*s89 \
v46_part10=v46_part9+(-1.000000e+04)*s90+(-5.611285e+02)*s91+(-1.000000e+04)*s92+(-1.000000e+04)*s93+(-1.000000e+04)*s94+(-1.000000e+04)*s95+(-1.000000e+04)*s96+(-1.000000e+04)*s97+(-1.000000e+04)*s98+(-1.000000e+04)*s99 \
v46=v46_part10+(-8.307740e+02)*s100+(-1.000000e+04)*s101+(-1.000000e+04)*s102+(-1.000000e+04)*s103+(-1.000000e+04)*s104 \
v47_part1=1.635618e+00*s0+1.821486e+00*s1+1.406077e+00*s2+7.333554e-01*s3+9.426859e-01*s4+1.093288e+00*s5+5.408779e-01*s6+6.296769e-01*s7+1.443942e+00*s8+7.477380e+00*s9 \
v47_part2=v47_part1+6.718467e+00*s10+3.374301e+00*s11+3.691715e+00*s12+5.179548e+00*s13+2.440395e+00*s14+1.070711e+00*s15+3.886950e+00*s16+5.821509e+00*s17+9.650062e+00*s18+7.630295e+00*s19 \
v47_part3=v47_part2+8.943265e+00*s20+9.137528e+00*s21+(-1.660279e+00)*s22+7.593085e+01*s23+1.767190e-01*s24+(-3.099605e+00)*s25+3.714679e+00*s26+3.983401e+00*s27+7.158763e+00*s28+1.573482e+00*s29 \
v47_part4=v47_part3+(-4.576561e+01)*s30+6.529651e+00*s31+9.926406e+00*s32+3.768882e+01*s33+5.732828e+00*s34+8.577224e+00*s35+1.495739e+01*s36+6.416330e+00*s37+(-1.000000e+04)*s38+(-1.000000e+04)*s39 \
v47_part5=v47_part4+(-1.000000e+04)*s40+(-1.000000e+04)*s41+(-5.575757e+03)*s42+(-1.000000e+04)*s43+1.307267e+01*s44+2.049053e+01*s45+1.430230e+01*s46+8.885944e+00*s47+3.056082e+00*s48+4.304869e+00*s49 \
v47_part6=v47_part5+1.312197e+01*s50+(-9.303509e+03)*s51+2.151031e+00*s52+2.139696e+00*s53+1.820310e+00*s54+1.403275e+00*s55+1.155862e+00*s56+1.662153e+00*s57+2.268242e+00*s58+5.316202e+00*s59 \
v47_part7=v47_part6+8.836286e+00*s60+1.706283e+01*s61+1.377841e+01*s62+6.538117e+01*s63+3.484881e+01*s64+2.863662e+01*s65+1.966609e+01*s66+4.597064e+01*s67+2.047405e+01*s68+5.578187e+01*s69 \
v47_part8=v47_part7+1.477669e+01*s70+2.607681e+01*s71+1.957824e+01*s72+2.112873e+01*s73+6.331433e+02*s74+2.699751e+02*s75+1.231055e+03*s76+8.929603e+01*s77+6.370339e+01*s78+(-8.284778e-03)*s79 \
v47_part9=v47_part8+(-1.000000e+04)*s80+(-8.873634e+00)*s81+(-5.467427e-01)*s82+1.532569e+01*s83+2.414735e+01*s84+4.821167e+01*s85+2.988274e+01*s86+2.073293e+01*s87+2.338480e+01*s88+4.382310e+01*s89 \
v47_part10=v47_part9+(-1.000000e+04)*s90+(-8.684148e+00)*s91+1.000000e+04*s92+9.318470e+03*s93+(-1.000000e+04)*s94+(-5.309053e+03)*s95+(-1.000000e+04)*s96+(-1.000000e+04)*s97+(-4.840486e+03)*s98+(-1.000000e+04)*s99 \
v47=v47_part10+(-2.988664e+03)*s100+(-1.000000e+04)*s101+(-1.547746e+03)*s102+(-1.000000e+04)*s103+(-1.000000e+04)*s104 \
v48_part1=7.502590e-01*s0+9.561817e-01*s1+1.350141e+00*s2+(-4.676250e+00)*s3+(-1.672501e-01)*s4+7.564431e-01*s5+(-1.480905e+00)*s6+(-2.300230e+00)*s7+(-2.659915e-01)*s8+(-4.841802e-01)*s9 \
v48_part2=v48_part1+1.530116e+00*s10+(-3.275113e-02)*s11+(-2.573768e-02)*s12+1.117668e+01*s13+6.301394e-01*s14+(-2.259693e+00)*s15+3.131327e+00*s16+(-1.000000e+04)*s17+(-5.601188e+02)*s18+(-4.817413e+02)*s19 \
v48_part3=v48_part2+(-1.000000e+04)*s20+(-1.000000e+04)*s21+(-4.173269e+01)*s22+(-1.000000e+04)*s23+(-2.947371e+03)*s24+(-3.559400e+02)*s25+(-3.535018e+02)*s26+(-1.017533e+03)*s27+(-2.098463e+03)*s28+(-1.000000e+04)*s29 \
v48_part4=v48_part3+(-1.000000e+04)*s30+(-1.000000e+04)*s31+(-1.000000e+04)*s32+(-1.000000e+04)*s33+(-1.000000e+04)*s34+(-1.000000e+04)*s35+(-1.000000e+04)*s36+(-1.000000e+04)*s37+(-1.000000e+04)*s38+(-1.000000e+04)*s39 \
v48_part5=v48_part4+(-1.000000e+04)*s40+(-1.000000e+04)*s41+(-1.000000e+04)*s42+(-1.000000e+04)*s43+(-1.000000e+04)*s44+(-1.000000e+04)*s45+(-1.000000e+04)*s46+(-1.000000e+04)*s47+(-1.000000e+04)*s48+(-1.000000e+04)*s49 \
v48_part6=v48_part5+(-1.000000e+04)*s50+(-1.000000e+04)*s51+3.289967e+00*s52+5.803106e+00*s53+3.366749e+00*s54+1.286668e+00*s55+(-3.736672e+00)*s56+(-1.777327e+01)*s57+(-3.093616e+02)*s58+(-4.567409e+02)*s59 \
v48_part7=v48_part6+(-6.814250e+01)*s60+(-1.000000e+04)*s61+(-5.237534e+03)*s62+(-1.000000e+04)*s63+(-1.000000e+04)*s64+(-1.000000e+04)*s65+(-5.993112e+02)*s66+(-1.000000e+04)*s67+(-1.000000e+04)*s68+(-1.000000e+04)*s69 \
v48_part8=v48_part7+2.628337e+01*s70+(-1.333560e+03)*s71+(-3.981491e+03)*s72+2.252240e+01*s73+(-1.000000e+04)*s74+(-3.653914e+03)*s75+(-1.000000e+04)*s76+(-1.000000e+04)*s77+(-1.000000e+04)*s78+(-1.000000e+04)*s79 \
v48_part9=v48_part8+(-1.000000e+04)*s80+(-1.000000e+04)*s81+(-1.000000e+04)*s82+(-1.000000e+04)*s83+(-1.000000e+04)*s84+(-1.825977e+03)*s85+(-1.000000e+04)*s86+(-1.000000e+04)*s87+(-1.000000e+04)*s88+(-4.966670e+03)*s89 \
v48_part10=v48_part9+(-1.000000e+04)*s90+(-1.000000e+04)*s91+(-7.442898e+03)*s92+(-3.513815e+03)*s93+1.350883e+02*s94+(-1.000000e+04)*s95+(-1.000000e+04)*s96+(-1.000000e+04)*s97+(-1.000000e+04)*s98+(-1.000000e+04)*s99 \
v48=v48_part10+(-1.000000e+04)*s100+(-1.000000e+04)*s101+(-1.000000e+04)*s102+(-1.000000e+04)*s103+(-1.000000e+04)*s104 \
v49_part1=(-1.415856e+00)*s0+(-1.744221e+00)*s1+(-4.886563e+00)*s2+8.203974e+00*s3+(-1.495585e+00)*s4+(-7.129199e-01)*s5+5.511662e-02*s6+1.602532e+00*s7+(-1.550456e+00)*s8+(-6.300995e-01)*s9 \
v49_part2=v49_part1+(-3.317649e+00)*s10+(-5.402688e+00)*s11+(-1.151357e+01)*s12+(-3.670390e+01)*s13+(-9.982999e+00)*s14+(-1.190909e+01)*s15+(-3.490149e+01)*s16+(-1.000000e+04)*s17+(-1.000000e+04)*s18+(-1.000000e+04)*s19 \
v49_part3=v49_part2+(-1.000000e+04)*s20+(-1.000000e+04)*s21+(-7.740468e+03)*s22+(-1.000000e+04)*s23+(-5.115584e+03)*s24+(-1.582684e+01)*s25+(-3.472729e+03)*s26+(-5.341599e+03)*s27+(-1.000000e+04)*s28+(-1.000000e+04)*s29 \
v49_part4=v49_part3+(-1.000000e+04)*s30+(-1.000000e+04)*s31+(-1.000000e+04)*s32+(-1.000000e+04)*s33+(-1.000000e+04)*s34+(-1.000000e+04)*s35+(-1.000000e+04)*s36+(-1.000000e+04)*s37+(-1.000000e+04)*s38+(-1.000000e+04)*s39 \
v49_part5=v49_part4+(-1.000000e+04)*s40+(-1.000000e+04)*s41+(-1.000000e+04)*s42+(-1.000000e+04)*s43+(-1.000000e+04)*s44+(-1.000000e+04)*s45+(-1.000000e+04)*s46+(-1.000000e+04)*s47+(-1.000000e+04)*s48+(-1.000000e+04)*s49 \
v49_part6=v49_part5+(-1.000000e+04)*s50+(-1.000000e+04)*s51+(-1.192005e+01)*s52+(-1.763462e+01)*s53+(-2.903501e+01)*s54+(-1.031239e+01)*s55+(-6.528704e+00)*s56+(-7.337826e+00)*s57+(-1.281706e+02)*s58+(-1.692222e+03)*s59 \
v49_part7=v49_part6+(-4.581962e+02)*s60+(-1.000000e+04)*s61+(-5.530076e+03)*s62+(-1.000000e+04)*s63+(-1.000000e+04)*s64+(-1.000000e+04)*s65+(-1.000000e+04)*s66+(-1.000000e+04)*s67+(-1.000000e+04)*s68+(-1.000000e+04)*s69 \
v49_part8=v49_part7+(-1.197181e+02)*s70+(-1.000000e+04)*s71+(-2.677840e+03)*s72+(-2.713191e+02)*s73+(-1.000000e+04)*s74+(-1.000000e+04)*s75+(-1.000000e+04)*s76+1.720704e+00*s77+(-1.000000e+04)*s78+(-1.000000e+04)*s79 \
v49_part9=v49_part8+(-1.000000e+04)*s80+(-1.000000e+04)*s81+(-1.000000e+04)*s82+(-1.000000e+04)*s83+(-1.000000e+04)*s84+(-1.000000e+04)*s85+(-1.000000e+04)*s86+(-1.000000e+04)*s87+(-1.000000e+04)*s88+(-8.620366e+03)*s89 \
v49_part10=v49_part9+(-1.000000e+04)*s90+(-1.000000e+04)*s91+(-1.000000e+04)*s92+(-1.000000e+04)*s93+(-2.536391e+03)*s94+(-1.000000e+04)*s95+(-1.000000e+04)*s96+(-1.000000e+04)*s97+(-1.000000e+04)*s98+(-1.000000e+04)*s99 \
v49=v49_part10+(-1.000000e+04)*s100+(-1.000000e+04)*s101+(-1.000000e+04)*s102+(-1.000000e+04)*s103+(-1.000000e+04)*s104 \
v50_part1=1.494693e+00*s0+1.349786e+00*s1+(-2.614432e+00)*s2+(-1.462111e+00)*s3+(-3.512782e-01)*s4+5.037538e-01*s5+1.702382e-01*s6+(-9.900015e-03)*s7+1.101685e+00*s8+4.552792e-01*s9 \
v50_part2=v50_part1+4.700201e-01*s10+1.743346e+00*s11+3.988009e+00*s12+2.588299e+00*s13+3.374770e+00*s14+7.411279e+00*s15+1.643008e+01*s16+(-1.000000e+04)*s17+(-6.816622e+02)*s18+(-4.306526e+02)*s19 \
v50_part3=v50_part2+(-1.000000e+04)*s20+(-1.104252e+03)*s21+(-1.691124e+03)*s22+(-1.000000e+04)*s23+(-3.086165e+03)*s24+(-1.343395e+01)*s25+(-4.320931e+02)*s26+(-2.395722e+03)*s27+(-7.921215e+03)*s28+(-1.000000e+04)*s29 \
v50_part4=v50_part3+(-1.000000e+04)*s30+(-1.000000e+04)*s31+(-1.000000e+04)*s32+(-1.000000e+04)*s33+(-1.000000e+04)*s34+(-1.000000e+04)*s35+(-1.000000e+04)*s36+(-1.000000e+04)*s37+(-1.000000e+04)*s38+(-1.000000e+04)*s39 \
v50_part5=v50_part4+(-1.000000e+04)*s40+(-9.119341e+03)*s41+(-1.000000e+04)*s42+(-1.000000e+04)*s43+(-1.000000e+04)*s44+(-1.000000e+04)*s45+(-1.000000e+04)*s46+(-1.000000e+04)*s47+(-1.000000e+04)*s48+(-1.000000e+04)*s49 \
v50_part6=v50_part5+(-1.000000e+04)*s50+(-1.000000e+04)*s51+(-2.202331e+00)*s52+(-2.111479e+00)*s53+6.555293e+00*s54+2.533119e+00*s55+5.659178e+00*s56+1.947045e+01*s57+5.435430e+00*s58+(-6.959483e+02)*s59 \
v50_part7=v50_part6+(-8.901873e+01)*s60+(-1.000000e+04)*s61+(-1.000000e+04)*s62+(-1.000000e+04)*s63+(-1.000000e+04)*s64+(-1.000000e+04)*s65+(-9.030865e+03)*s66+(-1.000000e+04)*s67+(-1.000000e+04)*s68+(-1.000000e+04)*s69 \
v50_part8=v50_part7+2.236196e+01*s70+(-5.404766e+02)*s71+(-8.012843e+02)*s72+1.642068e+02*s73+(-1.000000e+04)*s74+(-1.000000e+04)*s75+(-1.000000e+04)*s76+9.993049e+03*s77+(-1.000000e+04)*s78+(-1.000000e+04)*s79 \
v50_part9=v50_part8+(-1.000000e+04)*s80+(-6.211269e+02)*s81+(-1.000000e+04)*s82+(-1.000000e+04)*s83+(-2.706574e+03)*s84+(-4.985242e+03)*s85+(-1.000000e+04)*s86+(-1.000000e+04)*s87+(-1.000000e+04)*s88+(-4.633014e+03)*s89 \
v50_part10=v50_part9+(-1.000000e+04)*s90+(-1.000000e+04)*s91+(-1.000000e+04)*s92+(-1.000000e+04)*s93+2.693824e+03*s94+(-1.000000e+04)*s95+(-1.000000e+04)*s96+(-1.000000e+04)*s97+(-1.000000e+04)*s98+(-1.000000e+04)*s99 \
v50=v50_part10+(-1.000000e+04)*s100+(-1.000000e+04)*s101+(-1.000000e+04)*s102+(-1.000000e+04)*s103+(-1.000000e+04)*s104 \
v51_part1=1.000000e+04*s0+1.202079e+00*s1+0.000000e+00*s2+0.000000e+00*s3+0.000000e+00*s4+3.215000e+02*s5+0.000000e+00*s6+0.000000e+00*s7+0.000000e+00*s8+1.000000e+04*s9 \
v51_part2=v51_part1+0.000000e+00*s10+0.000000e+00*s11+(-6.479032e-01)*s12+0.000000e+00*s13+1.000000e+04*s14+8.254704e+03*s15+0.000000e+00*s16+0.000000e+00*s17+0.000000e+00*s18+1.043405e+01*s19 \
v51_part3=v51_part2+0.000000e+00*s20+0.000000e+00*s21+0.000000e+00*s22+0.000000e+00*s23+0.000000e+00*s24+0.000000e+00*s25+1.924778e+03*s26+0.000000e+00*s27+2.311748e-01*s28+0.000000e+00*s29 \
v51_part4=v51_part3+0.000000e+00*s30+0.000000e+00*s31+0.000000e+00*s32+6.796749e+03*s33+0.000000e+00*s34+0.000000e+00*s35+0.000000e+00*s36+0.000000e+00*s37+0.000000e+00*s38+0.000000e+00*s39 \
v51_part5=v51_part4+0.000000e+00*s40+5.035284e+01*s41+(-4.601769e-01)*s42+0.000000e+00*s43+1.329747e+03*s44+0.000000e+00*s45+0.000000e+00*s46+0.000000e+00*s47+1.000000e+04*s48+1.000000e+04*s49 \
v51_part6=v51_part5+1.000000e+04*s50+3.175646e+03*s51+0.000000e+00*s52+(-1.153379e-01)*s53+7.298600e+00*s54+1.000000e+04*s55+1.000000e+04*s56+0.000000e+00*s57+3.129861e-01*s58+0.000000e+00*s59 \
v51_part7=v51_part6+0.000000e+00*s60+0.000000e+00*s61+4.239926e+01*s62+0.000000e+00*s63+0.000000e+00*s64+8.793572e+00*s65+0.000000e+00*s66+0.000000e+00*s67+0.000000e+00*s68+0.000000e+00*s69 \
v51_part8=v51_part7+0.000000e+00*s70+0.000000e+00*s71+(-1.014474e+02)*s72+3.253888e+00*s73+0.000000e+00*s74+0.000000e+00*s75+0.000000e+00*s76+0.000000e+00*s77+0.000000e+00*s78+1.877415e+01*s79 \
v51_part9=v51_part8+1.000000e+04*s80+0.000000e+00*s81+0.000000e+00*s82+(-8.131807e+00)*s83+(-2.791908e+00)*s84+0.000000e+00*s85+0.000000e+00*s86+8.931839e+00*s87+5.033036e+00*s88+0.000000e+00*s89 \
v51_part10=v51_part9+(-2.080082e+01)*s90+0.000000e+00*s91+(-3.033067e+01)*s92+(-3.076163e+01)*s93+(-3.864492e+02)*s94+(-9.035149e+00)*s95+0.000000e+00*s96+0.000000e+00*s97+0.000000e+00*s98+(-3.560662e+01)*s99 \
v51=v51_part10+0.000000e+00*s100+7.096870e+00*s101+(-2.270926e+00)*s102+(-3.725351e+00)*s103+(-5.370837e-01)*s104 \
v52_part1=5.940455e+03*s0+(-1.862768e+03)*s1+0.000000e+00*s2+0.000000e+00*s3+0.000000e+00*s4+1.710106e+02*s5+0.000000e+00*s6+0.000000e+00*s7+0.000000e+00*s8+1.000000e+04*s9 \
v52_part2=v52_part1+0.000000e+00*s10+0.000000e+00*s11+1.774658e+01*s12+0.000000e+00*s13+1.000000e+04*s14+8.254704e+03*s15+0.000000e+00*s16+0.000000e+00*s17+0.000000e+00*s18+6.967578e+01*s19 \
v52_part3=v52_part2+0.000000e+00*s20+0.000000e+00*s21+0.000000e+00*s22+0.000000e+00*s23+0.000000e+00*s24+0.000000e+00*s25+1.000000e+04*s26+0.000000e+00*s27+3.373399e+00*s28+0.000000e+00*s29 \
v52_part4=v52_part3+0.000000e+00*s30+0.000000e+00*s31+0.000000e+00*s32+1.271359e+03*s33+0.000000e+00*s34+0.000000e+00*s35+0.000000e+00*s36+0.000000e+00*s37+0.000000e+00*s38+0.000000e+00*s39 \
v52_part5=v52_part4+0.000000e+00*s40+1.069707e+02*s41+(-5.970534e+02)*s42+0.000000e+00*s43+2.128130e+03*s44+0.000000e+00*s45+0.000000e+00*s46+0.000000e+00*s47+1.000000e+04*s48+1.000000e+04*s49 \
v52_part6=v52_part5+1.000000e+04*s50+4.307964e+03*s51+0.000000e+00*s52+6.819617e+00*s53+(-2.418519e+01)*s54+7.290992e+03*s55+6.120940e+03*s56+0.000000e+00*s57+1.401469e+00*s58+0.000000e+00*s59 \
v52_part7=v52_part6+0.000000e+00*s60+0.000000e+00*s61+(-9.572308e+01)*s62+0.000000e+00*s63+0.000000e+00*s64+(-1.308521e+01)*s65+0.000000e+00*s66+0.000000e+00*s67+0.000000e+00*s68+0.000000e+00*s69 \
v52_part8=v52_part7+0.000000e+00*s70+0.000000e+00*s71+7.020407e+00*s72+(-6.309090e+00)*s73+0.000000e+00*s74+0.000000e+00*s75+0.000000e+00*s76+0.000000e+00*s77+0.000000e+00*s78+1.265242e+01*s79 \
v52_part9=v52_part8+1.000000e+04*s80+0.000000e+00*s81+0.000000e+00*s82+7.733144e+00*s83+(-8.191208e+00)*s84+0.000000e+00*s85+0.000000e+00*s86+5.667806e-01*s87+(-6.489522e+00)*s88+0.000000e+00*s89 \
v52_part10=v52_part9+7.110400e+01*s90+0.000000e+00*s91+1.552666e+01*s92+2.232138e+01*s93+4.065614e+00*s94+(-6.180944e+01)*s95+0.000000e+00*s96+0.000000e+00*s97+0.000000e+00*s98+2.331804e+01*s99 \
v52=v52_part10+0.000000e+00*s100+2.892317e+00*s101+3.065826e+00*s102+6.593962e+00*s103+8.793456e+00*s104 \
v53_part1=1.000000e+04*s0+2.604503e+03*s1+0.000000e+00*s2+0.000000e+00*s3+0.000000e+00*s4+4.884092e+02*s5+0.000000e+00*s6+0.000000e+00*s7+0.000000e+00*s8+1.000000e+04*s9 \
v53_part2=v53_part1+0.000000e+00*s10+0.000000e+00*s11+(-8.862531e+00)*s12+0.000000e+00*s13+1.000000e+04*s14+8.254704e+03*s15+0.000000e+00*s16+0.000000e+00*s17+0.000000e+00*s18+1.244816e+01*s19 \
v53_part3=v53_part2+0.000000e+00*s20+0.000000e+00*s21+0.000000e+00*s22+0.000000e+00*s23+0.000000e+00*s24+0.000000e+00*s25+2.405629e+03*s26+0.000000e+00*s27+1.239323e+01*s28+0.000000e+00*s29 \
v53_part4=v53_part3+0.000000e+00*s30+0.000000e+00*s31+0.000000e+00*s32+6.859521e+03*s33+0.000000e+00*s34+0.000000e+00*s35+0.000000e+00*s36+0.000000e+00*s37+0.000000e+00*s38+0.000000e+00*s39 \
v53_part5=v53_part4+0.000000e+00*s40+7.704847e+01*s41+1.435740e+03*s42+0.000000e+00*s43+2.076508e+03*s44+0.000000e+00*s45+0.000000e+00*s46+0.000000e+00*s47+1.000000e+04*s48+1.000000e+04*s49 \
v53_part6=v53_part5+1.000000e+04*s50+7.226875e+03*s51+0.000000e+00*s52+(-3.839225e+00)*s53+2.019227e+01*s54+4.268416e+03*s55+9.842618e+03*s56+0.000000e+00*s57+8.882141e-01*s58+0.000000e+00*s59 \
v53_part7=v53_part6+0.000000e+00*s60+0.000000e+00*s61+1.226788e+02*s62+0.000000e+00*s63+0.000000e+00*s64+8.673788e+00*s65+0.000000e+00*s66+0.000000e+00*s67+0.000000e+00*s68+0.000000e+00*s69 \
v53_part8=v53_part7+0.000000e+00*s70+0.000000e+00*s71+2.253944e+02*s72+1.732397e+01*s73+0.000000e+00*s74+0.000000e+00*s75+0.000000e+00*s76+0.000000e+00*s77+0.000000e+00*s78+1.157221e+01*s79 \
v53_part9=v53_part8+1.000000e+04*s80+0.000000e+00*s81+0.000000e+00*s82+1.217560e+01*s83+2.461976e+01*s84+0.000000e+00*s85+0.000000e+00*s86+5.793081e+00*s87+4.413643e+01*s88+0.000000e+00*s89 \
v53_part10=v53_part9+(-6.484351e+01)*s90+0.000000e+00*s91+4.732948e+01*s92+3.662060e+01*s93+8.971469e+02*s94+1.785685e+02*s95+0.000000e+00*s96+0.000000e+00*s97+0.000000e+00*s98+4.268972e+01*s99 \
v53=v53_part10+0.000000e+00*s100+(-1.204831e+01)*s101+8.197345e+00*s102+4.940276e+00*s103+(-7.726264e+00)*s104 \
v54_part1=1.054780e+00*s0+1.853593e+00*s1+0.000000e+00*s2+0.000000e+00*s3+0.000000e+00*s4+1.518259e+00*s5+0.000000e+00*s6+0.000000e+00*s7+4.814898e+01*s8+9.677976e-01*s9 \
v54_part2=v54_part1+0.000000e+00*s10+0.000000e+00*s11+0.000000e+00*s12+0.000000e+00*s13+(-1.773456e+01)*s14+6.113882e-01*s15+0.000000e+00*s16+0.000000e+00*s17+0.000000e+00*s18+1.000000e+04*s19 \
v54_part3=v54_part2+(-6.250000e+02)*s20+1.000000e+04*s21+3.041771e+01*s22+0.000000e+00*s23+1.156653e+00*s24+4.510619e+00*s25+(-4.142405e-01)*s26+0.000000e+00*s27+(-1.704701e+01)*s28+2.821911e+01*s29 \
v54_part4=v54_part3+2.300793e+02*s30+1.000000e+04*s31+1.000000e+04*s32+4.337334e+03*s33+1.000000e+04*s34+1.000000e+04*s35+0.000000e+00*s36+1.000000e+04*s37+0.000000e+00*s38+0.000000e+00*s39 \
v54_part5=v54_part4+0.000000e+00*s40+1.608386e+01*s41+4.421636e-01*s42+0.000000e+00*s43+1.502255e+02*s44+0.000000e+00*s45+0.000000e+00*s46+0.000000e+00*s47+1.000000e+04*s48+1.000000e+04*s49 \
v54_part6=v54_part5+3.825412e-01*s50+9.722169e+00*s51+1.683512e+02*s52+0.000000e+00*s53+9.099781e+00*s54+7.162001e+01*s55+(-3.533851e+00)*s56+(-1.451491e-01)*s57+1.965595e+01*s58+0.000000e+00*s59 \
v54_part7=v54_part6+2.860661e+02*s60+0.000000e+00*s61+7.147588e+00*s62+1.176616e+02*s63+0.000000e+00*s64+(-8.840493e+01)*s65+0.000000e+00*s66+0.000000e+00*s67+0.000000e+00*s68+4.472419e+03*s69 \
v54_part8=v54_part7+0.000000e+00*s70+0.000000e+00*s71+4.710043e-01*s72+1.140795e+00*s73+0.000000e+00*s74+2.168265e+00*s75+0.000000e+00*s76+0.000000e+00*s77+1.924374e+03*s78+1.000000e+04*s79 \
v54_part9=v54_part8+3.101970e+01*s80+7.179969e-01*s81+0.000000e+00*s82+3.156439e+01*s83+4.180336e+01*s84+9.548446e+01*s85+4.314938e+02*s86+3.903142e+00*s87+8.876293e+00*s88+2.172625e+02*s89 \
v54_part10=v54_part9+1.416039e+00*s90+1.240155e+03*s91+1.050514e+02*s92+2.704398e+01*s93+4.834794e+01*s94+(-1.800534e+01)*s95+0.000000e+00*s96+0.000000e+00*s97+7.119947e-02*s98+(-4.038064e-01)*s99 \
v54=v54_part10+1.385555e+02*s100+(-3.873166e+01)*s101+1.747118e-01*s102+7.200965e+01*s103+2.112316e+01*s104 \
v55_part1=2.947415e-01*s0+1.949152e-01*s1+0.000000e+00*s2+0.000000e+00*s3+0.000000e+00*s4+1.859878e-01*s5+0.000000e+00*s6+0.000000e+00*s7+8.332585e-02*s8+7.012527e-01*s9 \
v55_part2=v55_part1+0.000000e+00*s10+0.000000e+00*s11+0.000000e+00*s12+0.000000e+00*s13+3.825559e+02*s14+6.368882e+01*s15+0.000000e+00*s16+0.000000e+00*s17+0.000000e+00*s18+2.253333e+03*s19 \
v55_part3=v55_part2+1.000000e+04*s20+1.000000e+04*s21+4.316128e+01*s22+0.000000e+00*s23+1.309134e+02*s24+1.071795e+01*s25+1.910760e+01*s26+0.000000e+00*s27+(-1.135430e+00)*s28+3.201032e+02*s29 \
v55_part4=v55_part3+1.048917e+02*s30+8.366201e+03*s31+1.000000e+04*s32+1.000000e+04*s33+1.000000e+04*s34+1.000000e+04*s35+0.000000e+00*s36+1.000000e+04*s37+0.000000e+00*s38+0.000000e+00*s39 \
v55_part5=v55_part4+0.000000e+00*s40+4.406016e+01*s41+1.710433e+00*s42+0.000000e+00*s43+2.466674e+02*s44+0.000000e+00*s45+0.000000e+00*s46+0.000000e+00*s47+1.000000e+04*s48+1.000000e+04*s49 \
v55_part6=v55_part5+1.067285e+01*s50+3.465158e+00*s51+2.514011e+03*s52+0.000000e+00*s53+1.338371e+02*s54+5.579457e+01*s55+1.422024e+02*s56+7.948900e+01*s57+4.833588e+00*s58+0.000000e+00*s59 \
v55_part7=v55_part6+1.316341e+02*s60+0.000000e+00*s61+3.046056e+01*s62+6.871858e+03*s63+0.000000e+00*s64+(-6.694239e+00)*s65+0.000000e+00*s66+0.000000e+00*s67+0.000000e+00*s68+4.472419e+03*s69 \
v55_part8=v55_part7+0.000000e+00*s70+0.000000e+00*s71+(-5.417385e+00)*s72+(-1.652656e+01)*s73+0.000000e+00*s74+2.563564e+00*s75+0.000000e+00*s76+0.000000e+00*s77+4.404520e+02*s78+1.000000e+04*s79 \
v55_part9=v55_part8+1.766056e+00*s80+8.709920e-03*s81+0.000000e+00*s82+(-2.144478e+01)*s83+1.010764e+01*s84+1.218088e+02*s85+2.113021e+02*s86+(-1.276323e+01)*s87+5.063118e+01*s88+7.921222e+01*s89 \
v55_part10=v55_part9+(-2.049058e+00)*s90+4.551107e+02*s91+(-9.600157e+01)*s92+(-6.573491e+01)*s93+(-7.792981e+01)*s94+(-1.443336e+00)*s95+0.000000e+00*s96+0.000000e+00*s97+1.133349e+00*s98+(-5.682767e+01)*s99 \
v55=v55_part10+1.971483e+01*s100+(-4.762880e+01)*s101+(-1.222634e+01)*s102+(-6.036244e+01)*s103+3.255485e+00*s104 \
v56_part1=3.203167e-01*s0+(-1.024198e+00)*s1+0.000000e+00*s2+0.000000e+00*s3+0.000000e+00*s4+(-1.838048e-01)*s5+0.000000e+00*s6+0.000000e+00*s7+(-3.073013e+01)*s8+(-1.115398e+00)*s9 \
v56_part2=v56_part1+0.000000e+00*s10+0.000000e+00*s11+0.000000e+00*s12+0.000000e+00*s13+(-1.716378e+02)*s14+8.073440e+00*s15+0.000000e+00*s16+0.000000e+00*s17+0.000000e+00*s18+4.195467e+03*s19 \
v56_part3=v56_part2+1.000000e+04*s20+1.000000e+04*s21+7.592576e+01*s22+0.000000e+00*s23+1.157452e+00*s24+1.606564e+00*s25+(-1.117957e+01)*s26+0.000000e+00*s27+4.173361e+01*s28+4.601840e+03*s29 \
v56_part4=v56_part3+4.474415e+01*s30+8.396865e+03*s31+1.000000e+04*s32+1.230469e+03*s33+1.000000e+04*s34+1.000000e+04*s35+0.000000e+00*s36+1.000000e+04*s37+0.000000e+00*s38+0.000000e+00*s39 \
v56_part5=v56_part4+0.000000e+00*s40+3.091215e+01*s41+(-1.859234e+00)*s42+0.000000e+00*s43+7.990805e+02*s44+0.000000e+00*s45+0.000000e+00*s46+0.000000e+00*s47+1.000000e+04*s48+1.000000e+04*s49 \
v56_part6=v56_part5+(-1.112686e+00)*s50+6.960297e+00*s51+1.180828e+03*s52+0.000000e+00*s53+(-7.680035e+01)*s54+(-4.757107e+01)*s55+(-5.490990e+01)*s56+8.430711e+00*s57+4.779796e-01*s58+0.000000e+00*s59 \
v56_part7=v56_part6+2.883393e+02*s60+0.000000e+00*s61+(-2.362063e+01)*s62+1.000000e+04*s63+0.000000e+00*s64+2.266266e+02*s65+0.000000e+00*s66+0.000000e+00*s67+0.000000e+00*s68+4.472419e+03*s69 \
v56_part8=v56_part7+0.000000e+00*s70+0.000000e+00*s71+3.839499e+01*s72+6.536818e+01*s73+0.000000e+00*s74+2.577586e+00*s75+0.000000e+00*s76+0.000000e+00*s77+1.539980e+03*s78+1.000000e+04*s79 \
v56_part9=v56_part8+(-3.169911e+01)*s80+2.329359e+00*s81+0.000000e+00*s82+3.231537e+00*s83+(-5.020544e+01)*s84+2.896203e+01*s85+6.895114e+01*s86+3.595449e+01*s87+(-4.023999e+01)*s88+1.472529e+00*s89 \
v56_part10=v56_part9+1.789629e+00*s90+7.283655e+03*s91+7.459204e-01*s92+9.544447e+01*s93+8.248872e+01*s94+6.595086e+01*s95+0.000000e+00*s96+0.000000e+00*s97+8.318375e+01*s98+1.499973e+02*s99 \
v56=v56_part10+4.242863e+02*s100+2.222356e+02*s101+6.183832e+01*s102+2.218382e-01*s103+(-2.225626e+01)*s104 \
v57_part1=2.197980e+01*s0+9.231216e+00*s1+2.554053e+01*s2+2.712268e+02*s3+2.263034e+03*s4+3.873749e-03*s5+3.723139e+01*s6+4.316167e-01*s7+4.380585e+03*s8+0.000000e+00*s9 \
v57_part2=v57_part1+5.635460e+02*s10+1.000000e+04*s11+1.000000e+04*s12+1.000000e+04*s13+1.000000e+04*s14+1.000000e+04*s15+1.000000e+04*s16+1.000000e+04*s17+1.000000e+04*s18+1.000000e+04*s19 \
v57_part3=v57_part2+1.000000e+04*s20+1.000000e+04*s21+(-2.868776e+00)*s22+(-8.624668e-01)*s23+(-2.735129e+00)*s24+1.291352e+01*s25+6.829510e+02*s26+4.573962e+02*s27+6.826230e+02*s28+(-1.191404e+01)*s29 \
v57_part4=v57_part3+1.954650e+00*s30+1.000000e+04*s31+1.000000e+04*s32+(-1.729316e+03)*s33+1.000000e+04*s34+1.000000e+04*s35+1.000000e+04*s36+1.000000e+04*s37+(-6.300202e+02)*s38+1.130037e+02*s39 \
v57_part5=v57_part4+1.020325e+01*s40+(-3.406423e+01)*s41+2.065075e+03*s42+1.270269e+03*s43+(-8.982254e+02)*s44+1.000000e+04*s45+1.000000e+04*s46+1.000000e+04*s47+2.712261e+03*s48+2.220446e+03*s49 \
v57_part6=v57_part5+7.476158e+03*s50+1.077672e+03*s51+1.000000e+04*s52+2.616594e+01*s53+(-1.586301e+01)*s54+1.000000e+04*s55+7.349043e+02*s56+(-9.869119e+00)*s57+7.229825e-01*s58+0.000000e+00*s59 \
v57_part7=v57_part6+2.488368e+03*s60+1.000000e+04*s61+3.683352e+02*s62+1.914506e+03*s63+0.000000e+00*s64+1.000000e+04*s65+4.939354e+01*s66+4.075289e+03*s67+0.000000e+00*s68+6.156664e+03*s69 \
v57_part8=v57_part7+(-5.714170e+01)*s70+1.571194e+01*s71+(-2.870302e+01)*s72+1.311211e+01*s73+(-4.886294e+02)*s74+6.785867e+00*s75+(-6.399096e+01)*s76+(-4.653272e+01)*s77+(-5.612591e+00)*s78+9.771304e+01*s79 \
v57_part9=v57_part8+1.183919e+03*s80+1.675313e+03*s81+4.733739e+01*s82+(-4.201900e+01)*s83+(-1.521088e+00)*s84+(-3.342717e+00)*s85+(-1.007247e+02)*s86+3.133133e+01*s87+2.482367e+01*s88+(-3.572673e+01)*s89 \
v57_part10=v57_part9+1.000000e+04*s90+(-3.810464e+01)*s91+(-3.352960e+01)*s92+1.428961e+00*s93+(-5.517663e+01)*s94+(-8.997251e+00)*s95+(-4.557011e+01)*s96+(-1.722960e+01)*s97+(-1.879388e+01)*s98+(-1.000563e+02)*s99 \
v57=v57_part10+(-6.821365e+01)*s100+(-4.256674e+01)*s101+(-9.945786e+01)*s102+(-9.122054e+01)*s103+(-5.747521e+01)*s104 \
v58_part1=(-2.830595e+01)*s0+1.889236e+01*s1+1.427587e+03*s2+1.840507e+02*s3+4.649375e+03*s4+(-2.087617e+01)*s5+2.466153e+02*s6+1.249384e+00*s7+1.598762e+03*s8+0.000000e+00*s9 \
v58_part2=v58_part1+4.931716e+01*s10+1.000000e+04*s11+1.000000e+04*s12+1.000000e+04*s13+1.000000e+04*s14+1.000000e+04*s15+1.000000e+04*s16+1.000000e+04*s17+1.000000e+04*s18+1.000000e+04*s19 \
v58_part3=v58_part2+1.000000e+04*s20+1.000000e+04*s21+1.969690e+01*s22+5.553542e+01*s23+8.493447e+01*s24+2.531588e+01*s25+1.155452e+03*s26+1.217035e+02*s27+5.531464e+02*s28+6.568750e+01*s29 \
v58_part4=v58_part3+5.355154e+01*s30+1.000000e+04*s31+1.000000e+04*s32+(-1.137588e+03)*s33+1.000000e+04*s34+1.000000e+04*s35+1.000000e+04*s36+1.000000e+04*s37+1.782823e+03*s38+2.517852e+03*s39 \
v58_part5=v58_part4+7.274879e+03*s40+1.640004e+02*s41+2.896070e+03*s42+1.327440e+03*s43+5.687592e+03*s44+1.000000e+04*s45+1.000000e+04*s46+3.854752e+03*s47+6.312095e+03*s48+1.000000e+04*s49 \
v58_part6=v58_part5+7.780132e+03*s50+5.366159e+03*s51+1.000000e+04*s52+(-1.156035e+02)*s53+(-7.627031e+01)*s54+5.457960e+01*s55+3.392615e+03*s56+(-6.971082e+01)*s57+6.634158e+00*s58+0.000000e+00*s59 \
v58_part7=v58_part6+5.122818e+02*s60+1.000000e+04*s61+4.504270e+03*s62+(-2.036831e+03)*s63+0.000000e+00*s64+1.000000e+04*s65+3.747138e+02*s66+1.000000e+04*s67+0.000000e+00*s68+(-1.000000e+04)*s69 \
v58_part8=v58_part7+2.214052e+02*s70+7.158028e+01*s71+8.796021e+01*s72+7.539997e+01*s73+1.799687e+03*s74+(-1.053855e+02)*s75+1.459641e+02*s76+1.202634e+02*s77+8.305235e+01*s78+6.938251e+00*s79 \
v58_part9=v58_part8+5.039886e+03*s80+1.338855e+03*s81+7.481543e+01*s82+1.333202e+02*s83+5.543944e+01*s84+1.420212e+01*s85+1.931322e+02*s86+1.978805e+01*s87+2.965199e+01*s88+9.922892e+01*s89 \
v58_part10=v58_part9+1.000000e+04*s90+1.042314e+02*s91+8.581130e+01*s92+4.197353e+01*s93+1.513251e+02*s94+1.499055e+02*s95+1.326007e+02*s96+6.154746e+01*s97+7.827991e+01*s98+1.452727e+02*s99 \
v58=v58_part10+1.286724e+02*s100+7.718042e+01*s101+1.464202e+02*s102+1.770620e+02*s103+1.449721e+02*s104 \
v59_part1=(-5.762246e-02)*s0+1.996451e+01*s1+2.593153e+02*s2+1.594132e+02*s3+5.997876e+03*s4+3.382707e+01*s5+3.459521e+02*s6+2.369681e+02*s7+1.172203e+03*s8+0.000000e+00*s9 \
v59_part2=v59_part1+1.179329e+02*s10+1.000000e+04*s11+1.000000e+04*s12+1.000000e+04*s13+1.000000e+04*s14+1.000000e+04*s15+1.000000e+04*s16+1.000000e+04*s17+1.000000e+04*s18+1.000000e+04*s19 \
v59_part3=v59_part2+1.000000e+04*s20+1.000000e+04*s21+1.419178e+01*s22+9.350297e-01*s23+(-2.009133e+01)*s24+(-5.694768e+00)*s25+1.518075e+03*s26+7.477078e+02*s27+4.594722e+02*s28+(-5.734667e+00)*s29 \
v59_part4=v59_part3+(-7.929362e-01)*s30+1.000000e+04*s31+1.000000e+04*s32+6.783526e+03*s33+1.000000e+04*s34+1.000000e+04*s35+1.000000e+04*s36+1.000000e+04*s37+5.281031e+02*s38+1.414627e+02*s39 \
v59_part5=v59_part4+1.277284e+01*s40+(-4.367153e+01)*s41+1.000000e+04*s42+3.114720e+01*s43+(-6.379919e+01)*s44+1.000000e+04*s45+1.000000e+04*s46+7.065915e+02*s47+(-7.144393e+03)*s48+(-1.000000e+04)*s49 \
v59_part6=v59_part5+1.158214e+02*s50+1.438634e+03*s51+1.000000e+04*s52+1.082392e+02*s53+1.458836e+03*s54+1.000000e+04*s55+1.000000e+04*s56+2.318572e+02*s57+2.910046e+01*s58+0.000000e+00*s59 \
v59_part7=v59_part6+5.256404e+02*s60+1.000000e+04*s61+1.629563e+03*s62+1.000000e+04*s63+0.000000e+00*s64+1.000000e+04*s65+1.315629e+02*s66+1.000000e+04*s67+0.000000e+00*s68+1.000000e+04*s69 \
v59_part8=v59_part7+1.939471e+00*s70+2.787124e+01*s71+(-1.185176e+01)*s72+4.634240e+01*s73+1.000000e+04*s74+1.846651e+02*s75+(-2.436713e+01)*s76+(-1.887337e+01)*s77+(-4.253726e+01)*s78+1.653783e+03*s79 \
v59_part9=v59_part8+(-4.885789e+02)*s80+8.802887e+02*s81+3.481788e+03*s82+(-1.993318e+01)*s83+(-7.816446e+00)*s84+9.190183e+01*s85+(-1.626628e+01)*s86+(-3.430555e+00)*s87+2.578377e+01*s88+1.063901e+00*s89 \
v59_part10=v59_part9+1.000000e+04*s90+6.830087e-02*s91+(-2.494613e-01)*s92+(-6.137922e+00)*s93+(-5.869758e+01)*s94+(-1.217607e+02)*s95+(-3.930806e+01)*s96+4.084674e+00*s97+(-1.064036e+01)*s98+1.039571e+01*s99 \
v59=v59_part10+(-2.613959e-01)*s100+4.093612e+01*s101+1.300508e+01*s102+(-5.901904e+01)*s103+(-4.549917e+01)*s104 \
v60_part1=(-8.551576e-01)*s0+(-4.318425e-02)*s1+(-3.835969e-01)*s2+1.196651e+00*s3+4.946606e-01*s4+1.288817e-01*s5+4.636639e-01*s6+8.404570e-01*s7+7.641100e-01*s8+0.000000e+00*s9 \
v60_part2=v60_part1+4.211578e-01*s10+2.257859e-01*s11+4.279024e-01*s12+1.170773e+00*s13+7.597957e-01*s14+(-3.188034e-01)*s15+4.645554e-01*s16+2.685608e-02*s17+(-9.956766e-02)*s18+7.310729e-01*s19 \
v60_part3=v60_part2+1.467880e-01*s20+(-8.826013e-02)*s21+0.000000e+00*s22+0.000000e+00*s23+0.000000e+00*s24+0.000000e+00*s25+7.411872e-02*s26+1.228403e+00*s27+1.594580e+00*s28+0.000000e+00*s29 \
v60_part4=v60_part3+0.000000e+00*s30+2.314493e-01*s31+1.129780e-01*s32+1.729848e-01*s33+3.376893e-01*s34+0.000000e+00*s35+3.825176e-01*s36+2.514954e-01*s37+0.000000e+00*s38+0.000000e+00*s39 \
v60_part5=v60_part4+2.277117e-03*s40+0.000000e+00*s41+0.000000e+00*s42+0.000000e+00*s43+1.064670e-01*s44+(-2.288448e-02)*s45+(-1.090437e-01)*s46+1.941955e-02*s47+0.000000e+00*s48+0.000000e+00*s49 \
v60_part6=v60_part5+2.921425e-03*s50+0.000000e+00*s51+4.369533e+00*s52+2.105436e+00*s53+1.997556e+00*s54+1.959151e+00*s55+1.903374e+00*s56+2.078372e+00*s57+2.322508e+00*s58+3.923825e+02*s59 \
v60_part7=v60_part6+8.405171e+00*s60+8.260298e+00*s61+3.422470e+00*s62+2.437023e-02*s63+1.335640e+02*s64+2.322109e+00*s65+(-3.010616e+01)*s66+(-3.626917e+01)*s67+1.000000e+04*s68+(-2.528977e+01)*s69 \
v60_part8=v60_part7+1.829714e+00*s70+1.904077e+00*s71+2.238447e+00*s72+3.070375e+00*s73+2.563573e+00*s74+3.215440e+00*s75+3.005990e+00*s76+2.504883e+00*s77+1.740154e+00*s78+(-2.442259e-06)*s79 \
v60_part9=v60_part8+(-1.966900e-02)*s80+8.513588e+00*s81+(-1.361735e-03)*s82+1.568859e+00*s83+2.484240e+00*s84+2.000339e+00*s85+1.631725e+00*s86+1.557711e+00*s87+2.147581e+00*s88+2.033920e+00*s89 \
v60_part10=v60_part9+6.542156e-02*s90+2.344645e+00*s91+1.998300e+00*s92+1.441999e+00*s93+1.833117e+00*s94+2.077486e+00*s95+1.573802e+00*s96+2.233086e+00*s97+1.555099e+00*s98+7.265657e-01*s99 \
v60=v60_part10+1.184848e+00*s100+1.680874e+00*s101+1.095914e+00*s102+1.292616e+00*s103+1.457801e+00*s104 \
v61_part1=2.972249e+01*s0+1.619697e+01*s1+5.405799e+00*s2+(-7.419097e-01)*s3+1.410074e-01*s4+1.312584e+01*s5+5.664307e-01*s6+6.947372e-01*s7+(-4.029094e-01)*s8+0.000000e+00*s9 \
v61_part2=v61_part1+4.353840e-01*s10+6.770031e-02*s11+2.776846e-01*s12+1.129288e+00*s13+(-1.048782e-01)*s14+2.276264e+00*s15+6.488971e-01*s16+1.321323e+00*s17+1.466000e+00*s18+(-1.519259e-01)*s19 \
v61_part3=v61_part2+3.604167e-01*s20+7.731684e-01*s21+0.000000e+00*s22+0.000000e+00*s23+0.000000e+00*s24+0.000000e+00*s25+(-1.271092e+00)*s26+(-1.266895e+00)*s27+(-1.308777e+00)*s28+0.000000e+00*s29 \
v61_part4=v61_part3+0.000000e+00*s30+(-6.124490e-03)*s31+(-2.640484e-02)*s32+2.399485e-01*s33+1.739744e-01*s34+0.000000e+00*s35+(-1.337514e-03)*s36+2.938762e-04*s37+0.000000e+00*s38+0.000000e+00*s39 \
v61_part5=v61_part4+2.265006e-04*s40+0.000000e+00*s41+0.000000e+00*s42+0.000000e+00*s43+(-1.809994e-01)*s44+2.486260e-01*s45+1.575541e-01*s46+6.498220e-02*s47+0.000000e+00*s48+0.000000e+00*s49 \
v61_part6=v61_part5+5.357098e-02*s50+0.000000e+00*s51+2.468217e+00*s52+3.590864e-01*s53+(-1.062449e-01)*s54+1.525093e-03*s55+(-6.341925e-01)*s56+(-3.019904e-01)*s57+2.053972e-01*s58+7.632841e+02*s59 \
v61_part7=v61_part6+(-6.253979e-01)*s60+(-8.956303e-01)*s61+1.086124e+01*s62+3.546434e-03*s63+9.943753e+02*s64+7.844628e+00*s65+6.803903e+01*s66+9.028503e+01*s67+3.021306e+03*s68+5.493161e+01*s69 \
v61_part8=v61_part7+(-4.963055e-01)*s70+(-8.502288e-01)*s71+(-1.644551e+00)*s72+(-2.456877e+00)*s73+(-2.313533e+00)*s74+(-3.672537e+00)*s75+(-2.337100e+00)*s76+(-1.463299e+00)*s77+(-4.652390e-01)*s78+2.318753e-01*s79 \
v61_part9=v61_part8+2.340562e-01*s80+5.205635e+00*s81+1.866523e-01*s82+(-1.188879e+00)*s83+(-2.064526e+00)*s84+(-1.318779e+00)*s85+(-7.549136e-01)*s86+(-6.433192e-01)*s87+(-1.501426e+00)*s88+(-1.135045e+00)*s89 \
v61_part10=v61_part9+4.514080e-01*s90+(-2.699840e+00)*s91+(-1.223360e+00)*s92+(-3.809176e-01)*s93+(-8.166156e-01)*s94+(-5.967535e-01)*s95+(-8.413501e-01)*s96+(-3.557989e-01)*s97+(-3.935954e-01)*s98+8.153406e-01*s99 \
v61=v61_part10+1.554093e-01*s100+7.552505e-01*s101+5.403671e-01*s102+(-7.591358e-02)*s103+1.595923e-01*s104 \
v62_part1=(-8.011505e+00)*s0+(-2.555033e+00)*s1+(-7.052572e-01)*s2+3.355050e-02*s3+1.431054e-01*s4+2.159761e-02*s5+1.328055e-02*s6+(-5.708506e-01)*s7+2.279754e-01*s8+0.000000e+00*s9 \
v62_part2=v62_part1+(-1.518715e-01)*s10+1.238935e+00*s11+1.048845e+00*s12+(-1.979204e+00)*s13+1.469655e-01*s14+(-1.565309e-01)*s15+(-1.651902e-01)*s16+(-2.410989e-01)*s17+(-2.111615e-01)*s18+2.150304e-01*s19 \
v62_part3=v62_part2+2.408798e-01*s20+(-6.830610e-03)*s21+0.000000e+00*s22+0.000000e+00*s23+0.000000e+00*s24+0.000000e+00*s25+1.568629e+00*s26+1.194082e-02*s27+2.045251e-03*s28+0.000000e+00*s29 \
v62_part4=v62_part3+0.000000e+00*s30+(-9.865216e-03)*s31+2.325616e-01*s32+1.538090e-02*s33+(-3.154905e-01)*s34+0.000000e+00*s35+(-9.760298e-02)*s36+(-5.241133e-02)*s37+0.000000e+00*s38+0.000000e+00*s39 \
v62_part5=v62_part4+(-1.314839e-03)*s40+0.000000e+00*s41+0.000000e+00*s42+0.000000e+00*s43+1.970649e-01*s44+(-1.381683e-01)*s45+5.271944e-03*s46+(-8.622184e-02)*s47+0.000000e+00*s48+0.000000e+00*s49 \
v62_part6=v62_part5+(-8.705832e-02)*s50+0.000000e+00*s51+(-6.923844e+00)*s52+(-9.684328e-01)*s53+(-2.283485e-01)*s54+(-4.108766e-01)*s55+1.815686e-01*s56+(-3.030860e-01)*s57+(-6.595298e-01)*s58+1.147393e+02*s59 \
v62_part7=v62_part6+(-3.434738e+00)*s60+(-4.026534e+00)*s61+(-9.408865e+00)*s62+5.566429e-02*s63+1.098619e+02*s64+(-1.011238e+01)*s65+(-2.226745e+01)*s66+(-3.692476e+01)*s67+1.000000e+04*s68+(-1.634939e+01)*s69 \
v62_part8=v62_part7+(-5.892295e-01)*s70+6.943108e-03*s71+7.612381e-01*s72+(-3.252030e-02)*s73+8.334669e-01*s74+1.222080e+00*s75+2.975092e-01*s76+1.088326e-01*s77+(-2.498426e-01)*s78+(-1.399020e-05)*s79 \
v62_part9=v62_part8+(-2.323090e-01)*s80+6.907050e+01*s81+(-7.800541e-03)*s82+9.658915e-01*s83+2.760920e-01*s84+1.516871e-01*s85+1.241453e-01*s86+1.626749e-01*s87+3.962199e-01*s88+(-2.116775e-02)*s89 \
v62_part10=v62_part9+(-7.005920e-01)*s90+1.095336e+00*s91+(-6.770682e-02)*s92+(-2.489218e-01)*s93+(-1.958644e-01)*s94+(-9.954449e-01)*s95+1.865218e-01*s96+(-2.077523e+00)*s97+(-5.360300e-01)*s98+(-9.010165e-01)*s99 \
v62=v62_part10+(-7.450151e-01)*s100+(-2.800468e+00)*s101+(-1.257182e+00)*s102+(-5.485284e-01)*s103+(-1.307929e+00)*s104 \
v63_part1=7.653680e-02*s0+3.940832e-01*s1+9.050901e+00*s2+3.977589e+01*s3+2.409102e+00*s4+7.501574e-03*s5+1.373954e+02*s6+2.058787e+03*s7+5.229317e+00*s8+0.000000e+00*s9 \
v63_part2=v63_part1+(-2.875145e+01)*s10+1.000000e+04*s11+1.000000e+04*s12+1.000000e+04*s13+1.000000e+04*s14+1.000000e+04*s15+1.000000e+04*s16+1.000000e+04*s17+1.000000e+04*s18+1.000000e+04*s19 \
v63_part3=v63_part2+1.000000e+04*s20+1.000000e+04*s21+0.000000e+00*s22+0.000000e+00*s23+0.000000e+00*s24+0.000000e+00*s25+5.149261e+02*s26+1.014573e+03*s27+1.000000e+04*s28+0.000000e+00*s29 \
v63_part4=v63_part3+0.000000e+00*s30+1.000000e+04*s31+1.000000e+04*s32+1.000000e+04*s33+1.000000e+04*s34+1.000000e+04*s35+1.000000e+04*s36+1.000000e+04*s37+9.441776e+01*s38+5.104941e+02*s39 \
v63_part5=v63_part4+5.585378e+02*s40+5.601370e+01*s41+0.000000e+00*s42+2.364507e+01*s43+1.000000e+04*s44+1.000000e+04*s45+7.184696e+03*s46+7.289646e+03*s47+1.000000e+04*s48+1.000000e+04*s49 \
v63_part6=v63_part5+5.492351e+03*s50+1.398464e+03*s51+(-4.777974e+00)*s52+1.005648e+01*s53+7.295411e+00*s54+1.551278e+01*s55+3.416964e+00*s56+1.448751e+01*s57+6.686774e+00*s58+8.962839e+02*s59 \
v63_part7=v63_part6+1.233045e+03*s60+1.000000e+04*s61+3.610293e+02*s62+3.437071e+03*s63+1.000000e+04*s64+3.060201e+03*s65+1.000000e+04*s66+1.000000e+04*s67+6.280810e+02*s68+1.000000e+04*s69 \
v63_part8=v63_part7+(-2.455630e+00)*s70+(-4.150571e+00)*s71+(-3.164645e+00)*s72+(-1.240566e+00)*s73+(-1.069878e+01)*s74+(-6.923141e+00)*s75+1.549630e+00*s76+(-3.814296e+00)*s77+(-3.914397e+00)*s78+1.000000e+04*s79 \
v63_part9=v63_part8+0.000000e+00*s80+1.000000e+04*s81+1.000000e+04*s82+2.777081e+00*s83+(-5.213422e+00)*s84+3.152466e+00*s85+1.227168e-01*s86+(-1.873801e+00)*s87+(-4.103061e+00)*s88+1.707756e+00*s89 \
v63_part10=v63_part9+3.263976e+02*s90+(-5.086506e-01)*s91+(-3.939022e+00)*s92+2.706488e-01*s93+(-1.187388e+00)*s94+2.437568e+00*s95+(-3.700785e+00)*s96+(-4.126908e-03)*s97+(-3.319634e+00)*s98+(-4.130335e+00)*s99 \
v63=v63_part10+(-1.572542e+00)*s100+5.911112e-01*s101+(-6.627199e+00)*s102+(-5.823661e+00)*s103+(-9.586641e+00)*s104 \
v64_part1=3.211212e+00*s0+5.403590e-01*s1+(-2.691845e+00)*s2+4.590963e+01*s3+5.074894e+01*s4+3.901104e+00*s5+1.430972e+02*s6+3.052420e+02*s7+1.033539e+01*s8+0.000000e+00*s9 \
v64_part2=v64_part1+(-1.026139e+01)*s10+1.000000e+04*s11+1.000000e+04*s12+1.000000e+04*s13+1.000000e+04*s14+1.000000e+04*s15+1.000000e+04*s16+1.000000e+04*s17+1.000000e+04*s18+1.000000e+04*s19 \
v64_part3=v64_part2+1.000000e+04*s20+1.000000e+04*s21+0.000000e+00*s22+0.000000e+00*s23+0.000000e+00*s24+0.000000e+00*s25+(-9.214737e+00)*s26+1.957820e+03*s27+1.000000e+04*s28+0.000000e+00*s29 \
v64_part4=v64_part3+0.000000e+00*s30+1.000000e+04*s31+1.000000e+04*s32+1.000000e+04*s33+1.000000e+04*s34+1.000000e+04*s35+1.000000e+04*s36+1.000000e+04*s37+1.274832e+02*s38+(-1.050108e+02)*s39 \
v64_part5=v64_part4+(-5.977116e+00)*s40+1.042694e+01*s41+0.000000e+00*s42+3.586058e+01*s43+1.000000e+04*s44+1.000000e+04*s45+(-3.725472e+03)*s46+2.747633e+03*s47+1.000000e+04*s48+1.000000e+04*s49 \
v64_part6=v64_part5+5.492351e+03*s50+1.181208e+03*s51+3.225321e+00*s52+(-4.549312e+00)*s53+1.710895e-01*s54+(-1.082090e+01)*s55+(-1.796391e+00)*s56+(-1.543965e+01)*s57+(-8.727721e-02)*s58+1.743020e+02*s59 \
v64_part7=v64_part6+4.235859e+02*s60+1.000000e+04*s61+2.298868e+03*s62+1.000000e+04*s63+1.000000e+04*s64+4.749488e+03*s65+1.000000e+04*s66+1.000000e+04*s67+1.000000e+04*s68+1.000000e+04*s69 \
v64_part8=v64_part7+1.371790e+01*s70+7.174955e+00*s71+1.386881e+01*s72+1.128891e+01*s73+2.032242e+01*s74+2.152173e+01*s75+8.661649e+00*s76+1.271460e+01*s77+1.270326e+01*s78+1.000000e+04*s79 \
v64_part9=v64_part8+0.000000e+00*s80+1.000000e+04*s81+1.000000e+04*s82+8.650199e+00*s83+1.680818e+01*s84+8.715183e+00*s85+1.217654e+01*s86+1.434068e+01*s87+1.236353e+01*s88+1.030655e+01*s89 \
v64_part10=v64_part9+(-3.347561e+03)*s90+1.555622e+01*s91+1.743752e+01*s92+1.467778e+01*s93+1.425424e+01*s94+1.184617e+01*s95+1.117762e+01*s96+1.505124e+01*s97+1.865573e+01*s98+1.685263e+01*s99 \
v64=v64_part10+1.454648e+01*s100+1.372271e+01*s101+2.147756e+01*s102+2.499012e+01*s103+2.560776e+01*s104 \
v65_part1=7.136215e+00*s0+1.075825e+01*s1+7.091324e+01*s2+1.391628e+01*s3+8.053663e+01*s4+2.233966e+00*s5+2.436831e+00*s6+3.600427e+02*s7+1.100044e+00*s8+0.000000e+00*s9 \
v65_part2=v65_part1+1.061442e+02*s10+1.000000e+04*s11+1.000000e+04*s12+1.000000e+04*s13+1.000000e+04*s14+1.000000e+04*s15+1.000000e+04*s16+1.000000e+04*s17+1.000000e+04*s18+1.000000e+04*s19 \
v65_part3=v65_part2+1.000000e+04*s20+1.000000e+04*s21+0.000000e+00*s22+0.000000e+00*s23+0.000000e+00*s24+0.000000e+00*s25+(-2.885348e+02)*s26+3.331018e+02*s27+4.075406e+03*s28+0.000000e+00*s29 \
v65_part4=v65_part3+0.000000e+00*s30+1.000000e+04*s31+1.000000e+04*s32+1.000000e+04*s33+1.000000e+04*s34+1.000000e+04*s35+1.000000e+04*s36+1.000000e+04*s37+3.092108e+02*s38+1.136339e+01*s39 \
v65_part5=v65_part4+8.313870e-01*s40+9.305885e+01*s41+0.000000e+00*s42+1.204192e+03*s43+1.000000e+04*s44+1.000000e+04*s45+7.021014e+03*s46+(-5.547475e+03)*s47+1.000000e+04*s48+1.000000e+04*s49 \
v65_part6=v65_part5+5.492351e+03*s50+1.280979e+01*s51+1.681800e+01*s52+(-9.210946e-02)*s53+(-1.022839e-01)*s54+(-3.837467e-02)*s55+9.414106e+00*s56+5.037678e+00*s57+1.682492e+00*s58+2.989450e+02*s59 \
v65_part7=v65_part6+7.978316e+01*s60+1.000000e+04*s61+1.712130e+03*s62+1.000000e+04*s63+1.000000e+04*s64+1.000000e+04*s65+1.000000e+04*s66+1.000000e+04*s67+3.514601e+02*s68+1.000000e+04*s69 \
v65_part8=v65_part7+6.120436e+00*s70+1.494170e+01*s71+1.888084e+00*s72+2.808648e+00*s73+8.188909e+00*s74+1.293347e+00*s75+1.816031e+00*s76+3.228303e+00*s77+2.775753e+00*s78+1.000000e+04*s79 \
v65_part9=v65_part8+0.000000e+00*s80+1.000000e+04*s81+1.000000e+04*s82+(-2.898248e+00)*s83+2.888555e+00*s84+(-1.287871e+00)*s85+(-7.185556e-01)*s86+(-1.167110e+00)*s87+7.515971e+00*s88+8.836275e-01*s89 \
v65_part10=v65_part9+9.856913e+03*s90+(-2.276689e+00)*s91+(-8.634761e-02)*s92+(-4.863112e+00)*s93+(-1.212858e+00)*s94+(-3.996024e+00)*s95+7.567619e+00*s96+(-3.847382e+00)*s97+(-3.225098e+00)*s98+6.982366e-02*s99 \
v65=v65_part10+5.236115e-03*s100+(-2.543610e+00)*s101+(-3.432475e+00)*s102+(-9.471838e+00)*s103+(-2.241600e+00)*s104 \
v66_part1=0.000000e+00*s0+0.000000e+00*s1+0.000000e+00*s2+0.000000e+00*s3+0.000000e+00*s4+0.000000e+00*s5+0.000000e+00*s6+0.000000e+00*s7+2.002802e+00*s8+0.000000e+00*s9 \
v66_part2=v66_part1+2.111924e+00*s10+0.000000e+00*s11+0.000000e+00*s12+0.000000e+00*s13+0.000000e+00*s14+0.000000e+00*s15+0.000000e+00*s16+0.000000e+00*s17+0.000000e+00*s18+0.000000e+00*s19 \
v66_part3=v66_part2+0.000000e+00*s20+0.000000e+00*s21+0.000000e+00*s22+0.000000e+00*s23+0.000000e+00*s24+1.225274e+02*s25+0.000000e+00*s26+0.000000e+00*s27+0.000000e+00*s28+0.000000e+00*s29 \
v66_part4=v66_part3+2.690478e+00*s30+0.000000e+00*s31+0.000000e+00*s32+0.000000e+00*s33+0.000000e+00*s34+0.000000e+00*s35+0.000000e+00*s36+0.000000e+00*s37+1.224820e+00*s38+2.791517e-01*s39 \
v66_part5=v66_part4+4.614329e-01*s40+9.635231e+02*s41+4.528210e+01*s42+6.700781e-02*s43+0.000000e+00*s44+0.000000e+00*s45+0.000000e+00*s46+0.000000e+00*s47+0.000000e+00*s48+0.000000e+00*s49 \
v66_part6=v66_part5+0.000000e+00*s50+1.577623e-01*s51+0.000000e+00*s52+0.000000e+00*s53+0.000000e+00*s54+0.000000e+00*s55+0.000000e+00*s56+0.000000e+00*s57+9.177334e-02*s58+0.000000e+00*s59 \
v66_part7=v66_part6+0.000000e+00*s60+0.000000e+00*s61+0.000000e+00*s62+0.000000e+00*s63+0.000000e+00*s64+0.000000e+00*s65+0.000000e+00*s66+0.000000e+00*s67+0.000000e+00*s68+0.000000e+00*s69 \
v66_part8=v66_part7+0.000000e+00*s70+0.000000e+00*s71+0.000000e+00*s72+0.000000e+00*s73+0.000000e+00*s74+0.000000e+00*s75+0.000000e+00*s76+0.000000e+00*s77+0.000000e+00*s78+4.922220e-05*s79 \
v66_part9=v66_part8+0.000000e+00*s80+0.000000e+00*s81+1.529386e-02*s82+0.000000e+00*s83+0.000000e+00*s84+0.000000e+00*s85+(-1.434963e-01)*s86+0.000000e+00*s87+(-2.622723e-02)*s88+2.008894e-01*s89 \
v66_part10=v66_part9+0.000000e+00*s90+0.000000e+00*s91+0.000000e+00*s92+0.000000e+00*s93+0.000000e+00*s94+0.000000e+00*s95+0.000000e+00*s96+0.000000e+00*s97+0.000000e+00*s98+0.000000e+00*s99 \
v66=v66_part10+0.000000e+00*s100+0.000000e+00*s101+0.000000e+00*s102+0.000000e+00*s103+0.000000e+00*s104 \
v67_part1=0.000000e+00*s0+0.000000e+00*s1+0.000000e+00*s2+0.000000e+00*s3+0.000000e+00*s4+0.000000e+00*s5+0.000000e+00*s6+0.000000e+00*s7+(-9.575166e-01)*s8+0.000000e+00*s9 \
v67_part2=v67_part1+(-1.197277e+00)*s10+0.000000e+00*s11+0.000000e+00*s12+0.000000e+00*s13+0.000000e+00*s14+0.000000e+00*s15+0.000000e+00*s16+0.000000e+00*s17+0.000000e+00*s18+0.000000e+00*s19 \
v67_part3=v67_part2+0.000000e+00*s20+0.000000e+00*s21+0.000000e+00*s22+0.000000e+00*s23+0.000000e+00*s24+2.360128e+02*s25+0.000000e+00*s26+0.000000e+00*s27+0.000000e+00*s28+0.000000e+00*s29 \
v67_part4=v67_part3+2.582315e+01*s30+0.000000e+00*s31+0.000000e+00*s32+0.000000e+00*s33+0.000000e+00*s34+0.000000e+00*s35+0.000000e+00*s36+0.000000e+00*s37+(-2.326960e+00)*s38+(-6.419804e-01)*s39 \
v67_part5=v67_part4+(-5.858037e-01)*s40+3.962611e+02*s41+4.850191e+03*s42+(-6.286275e-01)*s43+0.000000e+00*s44+0.000000e+00*s45+0.000000e+00*s46+0.000000e+00*s47+0.000000e+00*s48+0.000000e+00*s49 \
v67_part6=v67_part5+0.000000e+00*s50+(-1.487582e-01)*s51+0.000000e+00*s52+0.000000e+00*s53+0.000000e+00*s54+0.000000e+00*s55+0.000000e+00*s56+0.000000e+00*s57+(-1.676464e-01)*s58+0.000000e+00*s59 \
v67_part7=v67_part6+0.000000e+00*s60+0.000000e+00*s61+0.000000e+00*s62+0.000000e+00*s63+0.000000e+00*s64+0.000000e+00*s65+0.000000e+00*s66+0.000000e+00*s67+0.000000e+00*s68+0.000000e+00*s69 \
v67_part8=v67_part7+0.000000e+00*s70+0.000000e+00*s71+0.000000e+00*s72+0.000000e+00*s73+0.000000e+00*s74+0.000000e+00*s75+0.000000e+00*s76+0.000000e+00*s77+0.000000e+00*s78+1.410400e-01*s79 \
v67_part9=v67_part8+0.000000e+00*s80+0.000000e+00*s81+6.673239e-02*s82+0.000000e+00*s83+0.000000e+00*s84+0.000000e+00*s85+(-2.059015e-02)*s86+0.000000e+00*s87+(-6.748903e-02)*s88+(-1.765926e-01)*s89 \
v67_part10=v67_part9+0.000000e+00*s90+0.000000e+00*s91+0.000000e+00*s92+0.000000e+00*s93+0.000000e+00*s94+0.000000e+00*s95+0.000000e+00*s96+0.000000e+00*s97+0.000000e+00*s98+0.000000e+00*s99 \
v67=v67_part10+0.000000e+00*s100+0.000000e+00*s101+0.000000e+00*s102+0.000000e+00*s103+0.000000e+00*s104 \
v68_part1=0.000000e+00*s0+0.000000e+00*s1+0.000000e+00*s2+0.000000e+00*s3+0.000000e+00*s4+0.000000e+00*s5+0.000000e+00*s6+0.000000e+00*s7+8.635965e-01*s8+0.000000e+00*s9 \
v68_part2=v68_part1+(-2.235208e-01)*s10+0.000000e+00*s11+0.000000e+00*s12+0.000000e+00*s13+0.000000e+00*s14+0.000000e+00*s15+0.000000e+00*s16+0.000000e+00*s17+0.000000e+00*s18+0.000000e+00*s19 \
v68_part3=v68_part2+0.000000e+00*s20+0.000000e+00*s21+0.000000e+00*s22+0.000000e+00*s23+0.000000e+00*s24+4.171864e+01*s25+0.000000e+00*s26+0.000000e+00*s27+0.000000e+00*s28+0.000000e+00*s29 \
v68_part4=v68_part3+2.158512e+03*s30+0.000000e+00*s31+0.000000e+00*s32+0.000000e+00*s33+0.000000e+00*s34+0.000000e+00*s35+0.000000e+00*s36+0.000000e+00*s37+1.354029e+00*s38+8.251247e-01*s39 \
v68_part5=v68_part4+3.798283e-01*s40+8.112531e+02*s41+1.164046e+02*s42+1.080394e+00*s43+0.000000e+00*s44+0.000000e+00*s45+0.000000e+00*s46+0.000000e+00*s47+0.000000e+00*s48+0.000000e+00*s49 \
v68_part6=v68_part5+0.000000e+00*s50+8.845306e-02*s51+0.000000e+00*s52+0.000000e+00*s53+0.000000e+00*s54+0.000000e+00*s55+0.000000e+00*s56+0.000000e+00*s57+6.066860e-02*s58+0.000000e+00*s59 \
v68_part7=v68_part6+0.000000e+00*s60+0.000000e+00*s61+0.000000e+00*s62+0.000000e+00*s63+0.000000e+00*s64+0.000000e+00*s65+0.000000e+00*s66+0.000000e+00*s67+0.000000e+00*s68+0.000000e+00*s69 \
v68_part8=v68_part7+0.000000e+00*s70+0.000000e+00*s71+0.000000e+00*s72+0.000000e+00*s73+0.000000e+00*s74+0.000000e+00*s75+0.000000e+00*s76+0.000000e+00*s77+0.000000e+00*s78+(-1.988252e-01)*s79 \
v68_part9=v68_part8+0.000000e+00*s80+0.000000e+00*s81+(-1.235773e-01)*s82+0.000000e+00*s83+0.000000e+00*s84+0.000000e+00*s85+2.726893e-01*s86+0.000000e+00*s87+1.242880e-01*s88+3.953688e-02*s89 \
v68_part10=v68_part9+0.000000e+00*s90+0.000000e+00*s91+0.000000e+00*s92+0.000000e+00*s93+0.000000e+00*s94+0.000000e+00*s95+0.000000e+00*s96+0.000000e+00*s97+0.000000e+00*s98+0.000000e+00*s99 \
v68=v68_part10+0.000000e+00*s100+0.000000e+00*s101+0.000000e+00*s102+0.000000e+00*s103+0.000000e+00*s104 \
v69_part1=0.000000e+00*s0+0.000000e+00*s1+(-1.946305e+00)*s2+(-2.153162e-01)*s3+(-6.236773e+00)*s4+0.000000e+00*s5+0.000000e+00*s6+0.000000e+00*s7+1.032255e+01*s8+(-8.108659e-01)*s9 \
v69_part2=v69_part1+3.510925e+00*s10+6.113653e+00*s11+2.507620e+01*s12+1.000000e+04*s13+4.186939e+00*s14+0.000000e+00*s15+1.000000e+04*s16+0.000000e+00*s17+0.000000e+00*s18+0.000000e+00*s19 \
v69_part3=v69_part2+0.000000e+00*s20+0.000000e+00*s21+(-3.935126e+00)*s22+0.000000e+00*s23+0.000000e+00*s24+7.372028e+00*s25+(-1.598055e+00)*s26+(-8.182268e+00)*s27+(-3.207474e+00)*s28+(-1.512985e+02)*s29 \
v69_part4=v69_part3+(-1.986897e+00)*s30+8.784660e+00*s31+1.081719e-02*s32+2.650500e+00*s33+(-1.485183e-02)*s34+1.383554e+01*s35+1.117128e+00*s36+(-2.699719e-01)*s37+1.393776e+00*s38+0.000000e+00*s39 \
v69_part5=v69_part4+1.769022e+00*s40+0.000000e+00*s41+4.438365e+00*s42+(-4.198859e+00)*s43+4.983674e+00*s44+(-4.099429e+00)*s45+(-5.867627e+00)*s46+4.213316e+00*s47+1.000000e+04*s48+1.000000e+04*s49 \
v69_part6=v69_part5+(-1.996301e+00)*s50+1.796347e+00*s51+(-1.561798e+01)*s52+(-3.689930e+01)*s53+5.481421e+00*s54+(-2.142752e+01)*s55+9.004445e+00*s56+(-1.961229e+01)*s57+8.218248e+00*s58+5.951375e-01*s59 \
v69_part7=v69_part6+1.789801e+00*s60+1.861638e-01*s61+(-9.282243e+00)*s62+0.000000e+00*s63+(-6.173616e+00)*s64+5.076846e+00*s65+(-2.040001e+00)*s66+9.219395e-01*s67+(-4.665651e+00)*s68+1.793966e+00*s69 \
v69_part8=v69_part7+(-2.304631e+01)*s70+(-4.334256e-01)*s71+5.102482e+00*s72+8.750213e-02*s73+5.570389e+01*s74+(-1.787595e+02)*s75+2.251607e+00*s76+(-2.867557e+01)*s77+(-1.049450e+02)*s78+1.000000e+04*s79 \
v69_part9=v69_part8+9.057965e+00*s80+3.008545e+01*s81+1.000000e+04*s82+3.612256e+01*s83+5.645139e+01*s84+1.743885e+00*s85+(-1.697067e-01)*s86+2.055503e+01*s87+(-8.966206e-01)*s88+(-7.363853e+01)*s89 \
v69_part10=v69_part9+(-3.775055e+01)*s90+(-8.537843e-01)*s91+(-5.988924e+00)*s92+(-4.026620e+02)*s93+(-5.412469e+01)*s94+(-5.774193e+02)*s95+3.947176e+02*s96+1.794949e+03*s97+3.426692e+02*s98+(-3.992150e+02)*s99 \
v69=v69_part10+(-1.125236e+00)*s100+7.415390e+02*s101+(-1.477939e+01)*s102+3.425954e+02*s103+5.834874e+02*s104 \
v70_part1=0.000000e+00*s0+0.000000e+00*s1+1.772427e+01*s2+(-2.587468e+00)*s3+2.373736e+01*s4+0.000000e+00*s5+0.000000e+00*s6+0.000000e+00*s7+6.372132e+00*s8+4.937714e-01*s9 \
v70_part2=v70_part1+1.175237e+01*s10+9.868669e+02*s11+4.047805e+03*s12+1.000000e+04*s13+4.331923e+00*s14+0.000000e+00*s15+1.000000e+04*s16+0.000000e+00*s17+0.000000e+00*s18+0.000000e+00*s19 \
v70_part3=v70_part2+0.000000e+00*s20+0.000000e+00*s21+(-2.973551e+01)*s22+0.000000e+00*s23+0.000000e+00*s24+(-4.544836e+01)*s25+1.622425e+01*s26+3.413888e+01*s27+2.662357e+01*s28+(-1.546461e+01)*s29 \
v70_part4=v70_part3+(-3.774533e+00)*s30+(-7.270547e+00)*s31+1.353908e-01*s32+(-1.579816e+01)*s33+1.062852e+01*s34+(-6.891308e+00)*s35+(-1.894677e+00)*s36+(-3.802693e+00)*s37+9.466911e+00*s38+0.000000e+00*s39 \
v70_part5=v70_part4+5.047758e+00*s40+0.000000e+00*s41+1.930708e-01*s42+9.792641e-01*s43+1.459254e+01*s44+2.464319e+01*s45+3.168296e+01*s46+(-3.341278e+01)*s47+1.000000e+04*s48+1.000000e+04*s49 \
v70_part6=v70_part5+6.146904e+01*s50+7.407714e-01*s51+2.484128e+01*s52+1.343207e+02*s53+2.663393e+01*s54+8.475400e+01*s55+3.023232e+01*s56+8.697201e+01*s57+4.211221e+01*s58+1.104532e+01*s59 \
v70_part7=v70_part6+1.047395e+01*s60+1.440633e+01*s61+2.104854e+01*s62+0.000000e+00*s63+3.509527e+01*s64+2.618273e+01*s65+2.498503e+01*s66+2.980224e+01*s67+2.860213e+01*s68+2.543086e+01*s69 \
v70_part8=v70_part7+1.782613e+02*s70+1.236116e+02*s71+4.511164e+00*s72+7.894717e+01*s73+8.505396e+01*s74+3.716432e+02*s75+1.609535e+02*s76+1.361336e+02*s77+2.150902e+02*s78+1.000000e+04*s79 \
v70_part9=v70_part8+(-2.059562e+01)*s80+1.049744e+01*s81+1.000000e+04*s82+2.898896e+02*s83+1.035974e+02*s84+2.447098e+02*s85+1.173188e+02*s86+6.732102e+01*s87+1.123616e+02*s88+2.083913e+02*s89 \
v70_part10=v70_part9+1.576294e+02*s90+2.946824e+02*s91+3.184781e+01*s92+4.971577e+02*s93+9.810098e+01*s94+4.373193e+02*s95+(-3.632927e+02)*s96+(-2.058283e+03)*s97+6.595557e+00*s98+(-1.339898e+03)*s99 \
v70=v70_part10+1.701049e+02*s100+(-4.753019e+03)*s101+1.184361e+03*s102+9.535546e+00*s103+(-3.971408e+01)*s104 \
v71_part1=0.000000e+00*s0+0.000000e+00*s1+(-3.171717e+00)*s2+3.639783e+00*s3+(-6.741752e-01)*s4+0.000000e+00*s5+0.000000e+00*s6+0.000000e+00*s7+1.329864e+01*s8+1.941670e+00*s9 \
v71_part2=v71_part1+1.118827e+01*s10+1.331937e+03*s11+5.463170e+03*s12+1.000000e+04*s13+(-2.897437e-02)*s14+0.000000e+00*s15+1.000000e+04*s16+0.000000e+00*s17+0.000000e+00*s18+0.000000e+00*s19 \
v71_part3=v71_part2+0.000000e+00*s20+0.000000e+00*s21+1.086677e+02*s22+0.000000e+00*s23+0.000000e+00*s24+7.223525e+01*s25+(-2.196648e+00)*s26+(-9.611902e+00)*s27+(-3.391350e+00)*s28+3.883125e+02*s29 \
v71_part4=v71_part3+2.764809e+01*s30+7.592564e+00*s31+1.169089e+01*s32+2.314158e+01*s33+(-5.945896e+00)*s34+1.640982e+00*s35+8.839198e+00*s36+8.846564e+00*s37+3.187149e+00*s38+0.000000e+00*s39 \
v71_part5=v71_part4+8.327500e+00*s40+0.000000e+00*s41+1.664631e+01*s42+2.009924e+01*s43+1.587668e+00*s44+5.400106e+00*s45+(-4.973902e+00)*s46+6.545936e+01*s47+1.000000e+04*s48+1.000000e+04*s49 \
v71_part6=v71_part5+(-8.026303e+01)*s50+1.866078e+01*s51+3.169441e+01*s52+2.677905e+00*s53+9.132316e-01*s54+(-1.584755e+00)*s55+(-5.633602e+00)*s56+(-6.305176e+00)*s57+5.341346e+00*s58+7.071730e-01*s59 \
v71_part7=v71_part6+1.966098e+00*s60+6.479823e-01*s61+4.520541e+00*s62+0.000000e+00*s63+(-1.238311e+00)*s64+(-1.147517e+01)*s65+5.978746e-01*s66+(-7.256208e+00)*s67+(-1.152964e-01)*s68+(-3.543653e+00)*s69 \
v71_part8=v71_part7+(-6.957537e+01)*s70+(-4.638197e+01)*s71+4.829084e+02*s72+(-4.600804e-01)*s73+(-8.646563e+01)*s74+(-4.086164e+01)*s75+3.611463e-01*s76+8.834717e+01*s77+3.240550e+01*s78+1.000000e+04*s79 \
v71_part9=v71_part8+2.212442e+01*s80+(-1.681639e+01)*s81+1.000000e+04*s82+6.820521e+01*s83+3.150370e+01*s84+(-1.745240e+02)*s85+8.439202e+00*s86+9.565739e+01*s87+(-1.927880e+01)*s88+(-3.513498e+01)*s89 \
v71_part10=v71_part9+(-1.367084e+02)*s90+1.582502e+02*s91+1.202498e+03*s92+5.930517e+02*s93+3.210697e+02*s94+7.110431e+02*s95+4.239204e+02*s96+1.002727e+03*s97+(-2.552238e+00)*s98+6.206886e+03*s99 \
v71=v71_part10+2.604811e+02*s100+9.158980e+03*s101+(-4.054935e+00)*s102+1.084321e+03*s103+1.944513e+02*s104 \
v72_part1=6.078357e+02*s0+0.000000e+00*s1+0.000000e+00*s2+3.698129e+00*s3+2.003366e+00*s4+0.000000e+00*s5+3.689927e+00*s6+0.000000e+00*s7+9.048655e-01*s8+0.000000e+00*s9 \
v72_part2=v72_part1+9.952067e-01*s10+(-1.632876e+02)*s11+(-1.109458e+02)*s12+(-1.509317e+00)*s13+0.000000e+00*s14+0.000000e+00*s15+(-5.828530e+00)*s16+0.000000e+00*s17+0.000000e+00*s18+1.000000e+04*s19 \
v72_part3=v72_part2+0.000000e+00*s20+5.455837e+03*s21+(-4.388240e+00)*s22+1.447018e+02*s23+0.000000e+00*s24+3.094092e-01*s25+0.000000e+00*s26+1.413712e-02*s27+0.000000e+00*s28+8.040018e+00*s29 \
v72_part4=v72_part3+6.852111e+00*s30+0.000000e+00*s31+8.907903e-02*s32+0.000000e+00*s33+0.000000e+00*s34+0.000000e+00*s35+0.000000e+00*s36+8.563241e-01*s37+0.000000e+00*s38+0.000000e+00*s39 \
v72_part5=v72_part4+4.189280e+01*s40+0.000000e+00*s41+0.000000e+00*s42+(-1.259754e+00)*s43+0.000000e+00*s44+0.000000e+00*s45+0.000000e+00*s46+0.000000e+00*s47+(-1.994842e+03)*s48+(-7.044262e+03)*s49 \
v72_part6=v72_part5+0.000000e+00*s50+(-1.027763e+00)*s51+0.000000e+00*s52+0.000000e+00*s53+0.000000e+00*s54+0.000000e+00*s55+0.000000e+00*s56+0.000000e+00*s57+0.000000e+00*s58+0.000000e+00*s59 \
v72_part7=v72_part6+0.000000e+00*s60+0.000000e+00*s61+0.000000e+00*s62+1.132963e+02*s63+1.196312e-01*s64+(-4.637972e-02)*s65+(-2.136164e-03)*s66+(-1.204660e-01)*s67+1.397655e-01*s68+(-9.938506e-03)*s69 \
v72_part8=v72_part7+0.000000e+00*s70+0.000000e+00*s71+0.000000e+00*s72+0.000000e+00*s73+0.000000e+00*s74+0.000000e+00*s75+0.000000e+00*s76+0.000000e+00*s77+0.000000e+00*s78+1.873367e+02*s79 \
v72_part9=v72_part8+0.000000e+00*s80+(-2.452112e-01)*s81+1.000000e+04*s82+0.000000e+00*s83+0.000000e+00*s84+0.000000e+00*s85+0.000000e+00*s86+0.000000e+00*s87+0.000000e+00*s88+0.000000e+00*s89 \
v72_part10=v72_part9+0.000000e+00*s90+0.000000e+00*s91+0.000000e+00*s92+0.000000e+00*s93+0.000000e+00*s94+0.000000e+00*s95+0.000000e+00*s96+0.000000e+00*s97+0.000000e+00*s98+0.000000e+00*s99 \
v72=v72_part10+0.000000e+00*s100+0.000000e+00*s101+0.000000e+00*s102+0.000000e+00*s103+0.000000e+00*s104 \
v73_part1=3.408713e+01*s0+0.000000e+00*s1+0.000000e+00*s2+1.803706e+00*s3+2.623511e-01*s4+0.000000e+00*s5+(-1.368768e-02)*s6+0.000000e+00*s7+1.845371e+00*s8+0.000000e+00*s9 \
v73_part2=v73_part1+7.599227e-01*s10+5.143522e+02*s11+9.398086e+02*s12+1.786726e+01*s13+0.000000e+00*s14+0.000000e+00*s15+1.132190e+02*s16+0.000000e+00*s17+0.000000e+00*s18+3.250988e+02*s19 \
v73_part3=v73_part2+0.000000e+00*s20+1.560063e+03*s21+4.679527e+01*s22+4.190145e+01*s23+0.000000e+00*s24+3.376384e+01*s25+0.000000e+00*s26+(-2.319976e-01)*s27+0.000000e+00*s28+8.673561e+00*s29 \
v73_part4=v73_part3+1.415043e+00*s30+0.000000e+00*s31+(-1.354625e-02)*s32+0.000000e+00*s33+0.000000e+00*s34+0.000000e+00*s35+0.000000e+00*s36+4.999842e-02*s37+0.000000e+00*s38+0.000000e+00*s39 \
v73_part5=v73_part4+3.587232e+01*s40+0.000000e+00*s41+0.000000e+00*s42+3.667153e+01*s43+0.000000e+00*s44+0.000000e+00*s45+0.000000e+00*s46+0.000000e+00*s47+1.140996e+03*s48+8.724924e+03*s49 \
v73_part6=v73_part5+0.000000e+00*s50+5.477338e+00*s51+0.000000e+00*s52+0.000000e+00*s53+0.000000e+00*s54+0.000000e+00*s55+0.000000e+00*s56+0.000000e+00*s57+0.000000e+00*s58+0.000000e+00*s59 \
v73_part7=v73_part6+0.000000e+00*s60+0.000000e+00*s61+0.000000e+00*s62+1.027990e+02*s63+(-8.063600e-02)*s64+(-1.577789e-02)*s65+1.278189e-01*s66+1.347929e-01*s67+(-1.677863e-01)*s68+6.815264e-02*s69 \
v73_part8=v73_part7+0.000000e+00*s70+0.000000e+00*s71+0.000000e+00*s72+0.000000e+00*s73+0.000000e+00*s74+0.000000e+00*s75+0.000000e+00*s76+0.000000e+00*s77+0.000000e+00*s78+2.720377e+02*s79 \
v73_part9=v73_part8+0.000000e+00*s80+2.838935e-01*s81+1.000000e+04*s82+0.000000e+00*s83+0.000000e+00*s84+0.000000e+00*s85+0.000000e+00*s86+0.000000e+00*s87+0.000000e+00*s88+0.000000e+00*s89 \
v73_part10=v73_part9+0.000000e+00*s90+0.000000e+00*s91+0.000000e+00*s92+0.000000e+00*s93+0.000000e+00*s94+0.000000e+00*s95+0.000000e+00*s96+0.000000e+00*s97+0.000000e+00*s98+0.000000e+00*s99 \
v73=v73_part10+0.000000e+00*s100+0.000000e+00*s101+0.000000e+00*s102+0.000000e+00*s103+0.000000e+00*s104 \
v74_part1=2.060950e+00*s0+0.000000e+00*s1+0.000000e+00*s2+(-2.253116e+00)*s3+3.932414e-01*s4+0.000000e+00*s5+2.091108e+00*s6+0.000000e+00*s7+(-1.201072e+00)*s8+0.000000e+00*s9 \
v74_part2=v74_part1+(-1.429192e-01)*s10+8.088886e+01*s11+8.408928e+01*s12+(-5.399556e+00)*s13+0.000000e+00*s14+0.000000e+00*s15+(-5.673021e+01)*s16+0.000000e+00*s17+0.000000e+00*s18+7.762661e+02*s19 \
v74_part3=v74_part2+0.000000e+00*s20+6.747481e+03*s21+(-2.373183e+01)*s22+2.458046e-01*s23+0.000000e+00*s24+(-2.018202e+01)*s25+0.000000e+00*s26+2.585068e-01*s27+0.000000e+00*s28+(-7.383373e+00)*s29 \
v74_part4=v74_part3+1.479518e+00*s30+0.000000e+00*s31+1.090441e-03*s32+0.000000e+00*s33+0.000000e+00*s34+0.000000e+00*s35+0.000000e+00*s36+(-3.491341e-01)*s37+0.000000e+00*s38+0.000000e+00*s39 \
v74_part5=v74_part4+1.710105e+01*s40+0.000000e+00*s41+0.000000e+00*s42+(-3.496333e+01)*s43+0.000000e+00*s44+0.000000e+00*s45+0.000000e+00*s46+0.000000e+00*s47+3.402630e+03*s48+(-1.376036e+03)*s49 \
v74_part6=v74_part5+0.000000e+00*s50+2.413381e+00*s51+0.000000e+00*s52+0.000000e+00*s53+0.000000e+00*s54+0.000000e+00*s55+0.000000e+00*s56+0.000000e+00*s57+0.000000e+00*s58+0.000000e+00*s59 \
v74_part7=v74_part6+0.000000e+00*s60+0.000000e+00*s61+0.000000e+00*s62+1.513576e+02*s63+(-6.187719e-04)*s64+1.921119e-01*s65+(-1.691892e-03)*s66+1.424856e-01*s67+1.521526e-01*s68+5.579585e-02*s69 \
v74_part8=v74_part7+0.000000e+00*s70+0.000000e+00*s71+0.000000e+00*s72+0.000000e+00*s73+0.000000e+00*s74+0.000000e+00*s75+0.000000e+00*s76+0.000000e+00*s77+0.000000e+00*s78+2.720377e+02*s79 \
v74_part9=v74_part8+0.000000e+00*s80+2.519692e-02*s81+1.000000e+04*s82+0.000000e+00*s83+0.000000e+00*s84+0.000000e+00*s85+0.000000e+00*s86+0.000000e+00*s87+0.000000e+00*s88+0.000000e+00*s89 \
v74_part10=v74_part9+0.000000e+00*s90+0.000000e+00*s91+0.000000e+00*s92+0.000000e+00*s93+0.000000e+00*s94+0.000000e+00*s95+0.000000e+00*s96+0.000000e+00*s97+0.000000e+00*s98+0.000000e+00*s99 \
v74=v74_part10+0.000000e+00*s100+0.000000e+00*s101+0.000000e+00*s102+0.000000e+00*s103+0.000000e+00*s104 \
v75_part1=(-1.208769e+01)*s0+1.306770e+01*s1+9.797471e+01*s2+2.554109e+03*s3+2.126242e+03*s4+1.362747e-01*s5+6.556501e+02*s6+2.416157e+01*s7+4.569155e+01*s8+1.000000e+04*s9 \
v75_part2=v75_part1+0.000000e+00*s10+(-6.444567e+00)*s11+(-5.009758e+00)*s12+0.000000e+00*s13+1.000000e+04*s14+(-1.332918e+00)*s15+(-6.490398e+00)*s16+(-3.717216e+00)*s17+(-4.024512e+00)*s18+(-3.858695e+00)*s19 \
v75_part3=v75_part2+(-3.008601e+00)*s20+(-2.340447e+00)*s21+0.000000e+00*s22+(-1.144758e+02)*s23+(-1.910975e+00)*s24+0.000000e+00*s25+(-3.602589e+00)*s26+(-6.696706e-01)*s27+1.414061e+00*s28+0.000000e+00*s29 \
v75_part4=v75_part3+0.000000e+00*s30+(-9.939942e+00)*s31+(-5.182912e+00)*s32+(-2.496211e+00)*s33+(-1.212843e+00)*s34+(-6.690252e+00)*s35+(-5.529918e+00)*s36+(-2.026175e+00)*s37+6.129546e+01*s38+4.549410e+01*s39 \
v75_part5=v75_part4+3.334074e+00*s40+(-9.505385e-01)*s41+0.000000e+00*s42+0.000000e+00*s43+(-1.665267e+01)*s44+(-8.217194e+00)*s45+(-2.473769e+00)*s46+(-9.531166e+00)*s47+(-1.358126e+00)*s48+3.444216e+00*s49 \
v75_part6=v75_part5+0.000000e+00*s50+7.194669e+00*s51+0.000000e+00*s52+0.000000e+00*s53+0.000000e+00*s54+0.000000e+00*s55+0.000000e+00*s56+0.000000e+00*s57+(-4.604137e-01)*s58+(-1.220046e+00)*s59 \
v75_part7=v75_part6+(-1.745949e+00)*s60+(-2.003572e+00)*s61+(-1.409449e+00)*s62+4.264293e-01*s63+(-6.259257e+00)*s64+4.683734e+00*s65+7.607196e-01*s66+2.393571e+00*s67+(-5.305706e+00)*s68+(-2.161322e-01)*s69 \
v75_part8=v75_part7+0.000000e+00*s70+0.000000e+00*s71+0.000000e+00*s72+(-1.588574e+00)*s73+(-3.450199e+00)*s74+2.719515e+00*s75+(-2.619299e+00)*s76+(-1.204472e+00)*s77+(-1.395661e+00)*s78+(-2.952787e+00)*s79 \
v75_part9=v75_part8+(-1.223657e-01)*s80+(-8.217636e+00)*s81+(-6.247154e+00)*s82+(-1.305210e+00)*s83+(-9.734572e-01)*s84+8.274241e+00*s85+(-2.198924e+00)*s86+7.670502e-01*s87+8.915403e-01*s88+(-2.048201e+00)*s89 \
v75_part10=v75_part9+0.000000e+00*s90+2.784159e-03*s91+(-2.258218e+00)*s92+(-6.441060e-01)*s93+(-8.288109e-02)*s94+(-5.750090e+00)*s95+(-1.802357e+00)*s96+(-2.471386e+00)*s97+(-1.758873e-01)*s98+7.136687e+00*s99 \
v75=v75_part10+(-3.978570e+00)*s100+(-3.384390e+00)*s101+1.900748e-01*s102+0.000000e+00*s103+0.000000e+00*s104 \
v76_part1=4.624791e+01*s0+3.960502e+00*s1+1.702225e+01*s2+1.000000e+04*s3+1.459448e+02*s4+1.483241e+01*s5+1.932247e+03*s6+2.603722e+01*s7+1.515219e+02*s8+1.000000e+04*s9 \
v76_part2=v76_part1+0.000000e+00*s10+3.951212e+01*s11+3.117297e+01*s12+0.000000e+00*s13+1.000000e+04*s14+1.221963e+01*s15+2.107497e+01*s16+1.621552e+01*s17+1.622886e+01*s18+1.517384e+01*s19 \
v76_part3=v76_part2+1.397974e+01*s20+1.218836e+01*s21+0.000000e+00*s22+(-5.792745e+01)*s23+(-6.406444e+01)*s24+0.000000e+00*s25+1.852659e+01*s26+1.076520e+01*s27+6.958095e+00*s28+0.000000e+00*s29 \
v76_part4=v76_part3+0.000000e+00*s30+3.934690e+01*s31+2.758649e+01*s32+2.187530e+01*s33+2.291802e+01*s34+2.390064e+01*s35+3.302118e+01*s36+2.364502e+01*s37+(-1.032331e+02)*s38+(-1.137240e+02)*s39 \
v76_part5=v76_part4+(-4.030323e+01)*s40+(-8.440494e+00)*s41+0.000000e+00*s42+0.000000e+00*s43+5.530289e+01*s44+4.920281e+01*s45+3.633534e+01*s46+3.116077e+01*s47+(-4.019033e+01)*s48+(-3.623702e+01)*s49 \
v76_part6=v76_part5+0.000000e+00*s50+7.660925e+00*s51+0.000000e+00*s52+0.000000e+00*s53+0.000000e+00*s54+0.000000e+00*s55+0.000000e+00*s56+0.000000e+00*s57+2.758936e+00*s58+6.634324e+00*s59 \
v76_part7=v76_part6+6.458829e+00*s60+6.829340e+00*s61+5.847084e+00*s62+(-5.777608e+00)*s63+2.205973e+01*s64+7.917382e+00*s65+1.068103e+01*s66+1.552363e+01*s67+1.671032e+01*s68+1.443604e+01*s69 \
v76_part8=v76_part7+0.000000e+00*s70+0.000000e+00*s71+0.000000e+00*s72+4.713624e+00*s73+6.384413e+00*s74+2.811582e-02*s75+4.554592e+00*s76+3.443805e+00*s77+3.387470e+00*s78+2.184536e+01*s79 \
v76_part9=v76_part8+2.127506e+01*s80+1.587741e+01*s81+2.436180e+01*s82+2.456114e+00*s83+4.166264e+00*s84+(-3.226891e+00)*s85+4.625126e+00*s86+3.138174e+00*s87+4.964536e+00*s88+6.696527e+00*s89 \
v76_part10=v76_part9+0.000000e+00*s90+3.435662e+00*s91+5.287220e+00*s92+3.175232e+00*s93+4.563695e+00*s94+7.247148e+00*s95+1.022805e+01*s96+6.119792e+00*s97+1.789287e+00*s98+(-6.188462e+00)*s99 \
v76=v76_part10+8.133144e+00*s100+3.248353e+00*s101+(-1.101804e+00)*s102+0.000000e+00*s103+0.000000e+00*s104 \
v77_part1=1.255447e+01*s0+8.575693e-01*s1+4.177481e+01*s2+8.470480e+02*s3+8.292974e+03*s4+5.714383e+00*s5+5.992314e+03*s6+(-4.140215e+01)*s7+2.478026e+01*s8+1.000000e+04*s9 \
v77_part2=v77_part1+0.000000e+00*s10+(-7.816874e+00)*s11+(-9.532906e+00)*s12+0.000000e+00*s13+1.000000e+04*s14+(-9.041478e-01)*s15+(-1.618961e+00)*s16+(-1.327203e+00)*s17+(-7.853938e-01)*s18+3.142858e-04*s19 \
v77_part3=v77_part2+1.794824e-01*s20+1.266188e+00*s21+0.000000e+00*s22+3.518359e+02*s23+1.259395e+02*s24+0.000000e+00*s25+(-3.848105e+00)*s26+(-7.609498e-01)*s27+(-7.871049e-01)*s28+0.000000e+00*s29 \
v77_part4=v77_part3+0.000000e+00*s30+(-1.069025e+01)*s31+(-6.918133e+00)*s32+(-4.775039e+00)*s33+(-6.939681e+00)*s34+(-1.563960e+00)*s35+(-1.191801e+01)*s36+(-6.638354e+00)*s37+3.841348e+01*s38+9.901911e+01*s39 \
v77_part5=v77_part4+7.532860e+01*s40+9.115026e+01*s41+0.000000e+00*s42+0.000000e+00*s43+(-3.613548e+01)*s44+(-3.179311e+01)*s45+(-4.001672e+01)*s46+(-2.867496e+01)*s47+9.987251e+01*s48+8.278469e+01*s49 \
v77_part6=v77_part5+0.000000e+00*s50+1.951563e+01*s51+0.000000e+00*s52+0.000000e+00*s53+0.000000e+00*s54+0.000000e+00*s55+0.000000e+00*s56+0.000000e+00*s57+(-1.251880e+00)*s58+(-1.906100e+00)*s59 \
v77_part7=v77_part6+(-4.198232e-01)*s60+(-9.588527e-02)*s61+(-2.337053e-02)*s62+8.556712e+00*s63+(-1.694292e+00)*s64+(-5.911221e+00)*s65+(-1.758394e+00)*s66+(-8.451249e+00)*s67+(-1.591528e-01)*s68+(-3.558140e+00)*s69 \
v77_part8=v77_part7+0.000000e+00*s70+0.000000e+00*s71+0.000000e+00*s72+(-1.449397e+00)*s73+(-3.755125e-01)*s74+(-2.564420e+00)*s75+(-7.123113e-03)*s76+(-3.968938e-01)*s77+5.223513e-01*s78+7.137986e+00*s79 \
v77_part9=v77_part8+(-1.623084e+00)*s80+(-9.508010e-02)*s81+8.593920e+00*s82+9.022889e-01*s83+(-9.352741e-01)*s84+(-8.362394e+00)*s85+8.001118e-01*s86+(-1.679921e+00)*s87+(-2.659476e+00)*s88+(-1.671142e+00)*s89 \
v77_part10=v77_part9+0.000000e+00*s90+(-3.662982e+00)*s91+(-5.153774e-01)*s92+(-1.067916e-01)*s93+(-3.021564e+00)*s94+3.626843e+00*s95+(-7.779893e+00)*s96+(-2.755003e+00)*s97+8.307328e-02*s98+4.532543e-01*s99 \
v77=v77_part10+(-2.879919e+00)*s100+3.980633e+00*s101+5.552878e+00*s102+0.000000e+00*s103+0.000000e+00*s104 \
v78_part1=0.000000e+00*s0+1.602066e-02*s1+4.099297e+00*s2+2.187424e-01*s3+(-8.731421e+00)*s4+0.000000e+00*s5+3.067210e+00*s6+1.531350e+01*s7+3.162373e+01*s8+8.692566e-01*s9 \
v78_part2=v78_part1+0.000000e+00*s10+0.000000e+00*s11+0.000000e+00*s12+0.000000e+00*s13+8.710816e+03*s14+0.000000e+00*s15+0.000000e+00*s16+0.000000e+00*s17+0.000000e+00*s18+0.000000e+00*s19 \
v78_part3=v78_part2+0.000000e+00*s20+0.000000e+00*s21+0.000000e+00*s22+(-8.713738e+00)*s23+1.349840e+00*s24+0.000000e+00*s25+0.000000e+00*s26+4.513334e-02*s27+0.000000e+00*s28+0.000000e+00*s29 \
v78_part4=v78_part3+0.000000e+00*s30+0.000000e+00*s31+0.000000e+00*s32+0.000000e+00*s33+0.000000e+00*s34+0.000000e+00*s35+0.000000e+00*s36+0.000000e+00*s37+(-7.082010e+00)*s38+6.969410e+00*s39 \
v78_part5=v78_part4+3.414524e-01*s40+2.570231e-01*s41+0.000000e+00*s42+0.000000e+00*s43+0.000000e+00*s44+0.000000e+00*s45+0.000000e+00*s46+0.000000e+00*s47+(-2.341802e+00)*s48+(-1.123107e+01)*s49 \
v78_part6=v78_part5+0.000000e+00*s50+(-6.351235e+00)*s51+0.000000e+00*s52+0.000000e+00*s53+0.000000e+00*s54+2.201699e+03*s55+0.000000e+00*s56+0.000000e+00*s57+0.000000e+00*s58+0.000000e+00*s59 \
v78_part7=v78_part6+0.000000e+00*s60+0.000000e+00*s61+0.000000e+00*s62+2.865103e+00*s63+0.000000e+00*s64+0.000000e+00*s65+0.000000e+00*s66+0.000000e+00*s67+0.000000e+00*s68+0.000000e+00*s69 \
v78_part8=v78_part7+0.000000e+00*s70+0.000000e+00*s71+0.000000e+00*s72+0.000000e+00*s73+0.000000e+00*s74+0.000000e+00*s75+0.000000e+00*s76+0.000000e+00*s77+0.000000e+00*s78+0.000000e+00*s79 \
v78_part9=v78_part8+0.000000e+00*s80+0.000000e+00*s81+0.000000e+00*s82+0.000000e+00*s83+0.000000e+00*s84+0.000000e+00*s85+0.000000e+00*s86+0.000000e+00*s87+0.000000e+00*s88+0.000000e+00*s89 \
v78_part10=v78_part9+0.000000e+00*s90+0.000000e+00*s91+0.000000e+00*s92+0.000000e+00*s93+0.000000e+00*s94+0.000000e+00*s95+0.000000e+00*s96+0.000000e+00*s97+0.000000e+00*s98+0.000000e+00*s99 \
v78=v78_part10+0.000000e+00*s100+0.000000e+00*s101+0.000000e+00*s102+0.000000e+00*s103+0.000000e+00*s104 \
v79_part1=0.000000e+00*s0+1.113025e-03*s1+1.894097e+00*s2+1.125774e+01*s3+5.561767e+01*s4+0.000000e+00*s5+2.180057e+01*s6+4.941753e+00*s7+4.148237e+00*s8+4.735577e-01*s9 \
v79_part2=v79_part1+0.000000e+00*s10+0.000000e+00*s11+0.000000e+00*s12+0.000000e+00*s13+1.000000e+04*s14+0.000000e+00*s15+0.000000e+00*s16+0.000000e+00*s17+0.000000e+00*s18+0.000000e+00*s19 \
v79_part3=v79_part2+0.000000e+00*s20+0.000000e+00*s21+0.000000e+00*s22+7.547313e+01*s23+5.368684e+01*s24+0.000000e+00*s25+0.000000e+00*s26+(-1.168151e-02)*s27+0.000000e+00*s28+0.000000e+00*s29 \
v79_part4=v79_part3+0.000000e+00*s30+0.000000e+00*s31+0.000000e+00*s32+0.000000e+00*s33+0.000000e+00*s34+0.000000e+00*s35+0.000000e+00*s36+0.000000e+00*s37+8.146527e+01*s38+6.573347e+01*s39 \
v79_part5=v79_part4+6.970980e+01*s40+3.585342e+01*s41+0.000000e+00*s42+0.000000e+00*s43+0.000000e+00*s44+0.000000e+00*s45+0.000000e+00*s46+0.000000e+00*s47+3.739894e+01*s48+4.859834e+01*s49 \
v79_part6=v79_part5+0.000000e+00*s50+4.085106e+01*s51+0.000000e+00*s52+0.000000e+00*s53+0.000000e+00*s54+2.007884e+03*s55+0.000000e+00*s56+0.000000e+00*s57+0.000000e+00*s58+0.000000e+00*s59 \
v79_part7=v79_part6+0.000000e+00*s60+0.000000e+00*s61+0.000000e+00*s62+2.494730e+01*s63+0.000000e+00*s64+0.000000e+00*s65+0.000000e+00*s66+0.000000e+00*s67+0.000000e+00*s68+0.000000e+00*s69 \
v79_part8=v79_part7+0.000000e+00*s70+0.000000e+00*s71+0.000000e+00*s72+0.000000e+00*s73+0.000000e+00*s74+0.000000e+00*s75+0.000000e+00*s76+0.000000e+00*s77+0.000000e+00*s78+0.000000e+00*s79 \
v79_part9=v79_part8+0.000000e+00*s80+0.000000e+00*s81+0.000000e+00*s82+0.000000e+00*s83+0.000000e+00*s84+0.000000e+00*s85+0.000000e+00*s86+0.000000e+00*s87+0.000000e+00*s88+0.000000e+00*s89 \
v79_part10=v79_part9+0.000000e+00*s90+0.000000e+00*s91+0.000000e+00*s92+0.000000e+00*s93+0.000000e+00*s94+0.000000e+00*s95+0.000000e+00*s96+0.000000e+00*s97+0.000000e+00*s98+0.000000e+00*s99 \
v79=v79_part10+0.000000e+00*s100+0.000000e+00*s101+0.000000e+00*s102+0.000000e+00*s103+0.000000e+00*s104 \
v80_part1=0.000000e+00*s0+(-3.480381e-03)*s1+(-8.578843e-01)*s2+(-1.796253e-01)*s3+(-1.375651e+01)*s4+0.000000e+00*s5+(-1.086730e+01)*s6+(-1.026044e+01)*s7+5.025882e-01*s8+4.404322e-01*s9 \
v80_part2=v80_part1+0.000000e+00*s10+0.000000e+00*s11+0.000000e+00*s12+0.000000e+00*s13+1.935569e+03*s14+0.000000e+00*s15+0.000000e+00*s16+0.000000e+00*s17+0.000000e+00*s18+0.000000e+00*s19 \
v80_part3=v80_part2+0.000000e+00*s20+0.000000e+00*s21+0.000000e+00*s22+(-3.603338e+01)*s23+(-3.519793e+01)*s24+0.000000e+00*s25+0.000000e+00*s26+(-1.605330e-02)*s27+0.000000e+00*s28+0.000000e+00*s29 \
v80_part4=v80_part3+0.000000e+00*s30+0.000000e+00*s31+0.000000e+00*s32+0.000000e+00*s33+0.000000e+00*s34+0.000000e+00*s35+0.000000e+00*s36+0.000000e+00*s37+(-7.453212e+01)*s38+(-8.253417e+01)*s39 \
v80_part5=v80_part4+(-7.416590e+01)*s40+(-3.606771e+01)*s41+0.000000e+00*s42+0.000000e+00*s43+0.000000e+00*s44+0.000000e+00*s45+0.000000e+00*s46+0.000000e+00*s47+(-5.015063e+01)*s48+(-5.294882e+01)*s49 \
v80_part6=v80_part5+0.000000e+00*s50+(-6.567580e+01)*s51+0.000000e+00*s52+0.000000e+00*s53+0.000000e+00*s54+8.161453e+02*s55+0.000000e+00*s56+0.000000e+00*s57+0.000000e+00*s58+0.000000e+00*s59 \
v80_part7=v80_part6+0.000000e+00*s60+0.000000e+00*s61+0.000000e+00*s62+(-1.357635e+00)*s63+0.000000e+00*s64+0.000000e+00*s65+0.000000e+00*s66+0.000000e+00*s67+0.000000e+00*s68+0.000000e+00*s69 \
v80_part8=v80_part7+0.000000e+00*s70+0.000000e+00*s71+0.000000e+00*s72+0.000000e+00*s73+0.000000e+00*s74+0.000000e+00*s75+0.000000e+00*s76+0.000000e+00*s77+0.000000e+00*s78+0.000000e+00*s79 \
v80_part9=v80_part8+0.000000e+00*s80+0.000000e+00*s81+0.000000e+00*s82+0.000000e+00*s83+0.000000e+00*s84+0.000000e+00*s85+0.000000e+00*s86+0.000000e+00*s87+0.000000e+00*s88+0.000000e+00*s89 \
v80_part10=v80_part9+0.000000e+00*s90+0.000000e+00*s91+0.000000e+00*s92+0.000000e+00*s93+0.000000e+00*s94+0.000000e+00*s95+0.000000e+00*s96+0.000000e+00*s97+0.000000e+00*s98+0.000000e+00*s99 \
v80=v80_part10+0.000000e+00*s100+0.000000e+00*s101+0.000000e+00*s102+0.000000e+00*s103+0.000000e+00*s104 \
v81_part1=0.000000e+00*s0+0.000000e+00*s1+0.000000e+00*s2+0.000000e+00*s3+(-1.355570e+00)*s4+0.000000e+00*s5+0.000000e+00*s6+0.000000e+00*s7+0.000000e+00*s8+0.000000e+00*s9 \
v81_part2=v81_part1+0.000000e+00*s10+1.000000e+04*s11+1.000000e+04*s12+1.000000e+04*s13+1.000000e+04*s14+1.000000e+04*s15+1.000000e+04*s16+1.000000e+04*s17+1.000000e+04*s18+1.000000e+04*s19 \
v81_part3=v81_part2+1.000000e+04*s20+1.000000e+04*s21+2.055398e+01*s22+(-9.590544e+00)*s23+(-8.688855e-02)*s24+7.482167e+00*s25+0.000000e+00*s26+0.000000e+00*s27+0.000000e+00*s28+2.641593e+01*s29 \
v81_part4=v81_part3+(-4.295144e-01)*s30+1.000000e+04*s31+1.000000e+04*s32+1.000000e+04*s33+1.000000e+04*s34+1.000000e+04*s35+1.000000e+04*s36+1.000000e+04*s37+1.903980e+00*s38+(-3.022758e+00)*s39 \
v81_part5=v81_part4+(-2.110552e-01)*s40+9.462434e-01*s41+(-1.244537e+01)*s42+(-6.925614e+00)*s43+1.000000e+04*s44+1.000000e+04*s45+1.000000e+04*s46+1.000000e+04*s47+(-7.338790e+00)*s48+(-6.148950e+00)*s49 \
v81_part6=v81_part5+2.073457e+03*s50+7.884445e-03*s51+0.000000e+00*s52+0.000000e+00*s53+0.000000e+00*s54+0.000000e+00*s55+0.000000e+00*s56+0.000000e+00*s57+0.000000e+00*s58+0.000000e+00*s59 \
v81_part7=v81_part6+0.000000e+00*s60+0.000000e+00*s61+0.000000e+00*s62+2.886797e+00*s63+0.000000e+00*s64+0.000000e+00*s65+0.000000e+00*s66+0.000000e+00*s67+0.000000e+00*s68+0.000000e+00*s69 \
v81_part8=v81_part7+0.000000e+00*s70+0.000000e+00*s71+0.000000e+00*s72+0.000000e+00*s73+0.000000e+00*s74+0.000000e+00*s75+0.000000e+00*s76+0.000000e+00*s77+0.000000e+00*s78+1.000000e+04*s79 \
v81_part9=v81_part8+1.000000e+04*s80+1.039480e+03*s81+1.000000e+04*s82+0.000000e+00*s83+0.000000e+00*s84+0.000000e+00*s85+0.000000e+00*s86+0.000000e+00*s87+0.000000e+00*s88+0.000000e+00*s89 \
v81_part10=v81_part9+4.149468e+01*s90+0.000000e+00*s91+0.000000e+00*s92+0.000000e+00*s93+0.000000e+00*s94+0.000000e+00*s95+0.000000e+00*s96+0.000000e+00*s97+0.000000e+00*s98+0.000000e+00*s99 \
v81=v81_part10+0.000000e+00*s100+0.000000e+00*s101+0.000000e+00*s102+0.000000e+00*s103+0.000000e+00*s104 \
v82_part1=0.000000e+00*s0+0.000000e+00*s1+0.000000e+00*s2+0.000000e+00*s3+4.755692e+00*s4+0.000000e+00*s5+0.000000e+00*s6+0.000000e+00*s7+0.000000e+00*s8+0.000000e+00*s9 \
v82_part2=v82_part1+0.000000e+00*s10+1.000000e+04*s11+1.000000e+04*s12+1.000000e+04*s13+1.000000e+04*s14+1.000000e+04*s15+1.000000e+04*s16+1.000000e+04*s17+1.000000e+04*s18+1.000000e+04*s19 \
v82_part3=v82_part2+1.000000e+04*s20+1.000000e+04*s21+2.951602e+01*s22+4.670238e+01*s23+3.138474e+01*s24+3.729103e+01*s25+0.000000e+00*s26+0.000000e+00*s27+0.000000e+00*s28+6.135059e+01*s29 \
v82_part4=v82_part3+3.572699e+01*s30+1.000000e+04*s31+1.000000e+04*s32+1.000000e+04*s33+1.000000e+04*s34+1.000000e+04*s35+1.000000e+04*s36+1.000000e+04*s37+4.505038e+01*s38+4.664069e+01*s39 \
v82_part5=v82_part4+4.545586e+01*s40+6.301923e+01*s41+5.384662e+01*s42+5.396422e+01*s43+1.000000e+04*s44+1.000000e+04*s45+1.000000e+04*s46+1.000000e+04*s47+6.629073e+01*s48+6.004454e+01*s49 \
v82_part6=v82_part5+1.000000e+04*s50+9.123338e+01*s51+0.000000e+00*s52+0.000000e+00*s53+0.000000e+00*s54+0.000000e+00*s55+0.000000e+00*s56+0.000000e+00*s57+0.000000e+00*s58+0.000000e+00*s59 \
v82_part7=v82_part6+0.000000e+00*s60+0.000000e+00*s61+0.000000e+00*s62+1.016259e+00*s63+0.000000e+00*s64+0.000000e+00*s65+0.000000e+00*s66+0.000000e+00*s67+0.000000e+00*s68+0.000000e+00*s69 \
v82_part8=v82_part7+0.000000e+00*s70+0.000000e+00*s71+0.000000e+00*s72+0.000000e+00*s73+0.000000e+00*s74+0.000000e+00*s75+0.000000e+00*s76+0.000000e+00*s77+0.000000e+00*s78+9.290078e+03*s79 \
v82_part9=v82_part8+1.000000e+04*s80+1.774358e+02*s81+1.000000e+04*s82+0.000000e+00*s83+0.000000e+00*s84+0.000000e+00*s85+0.000000e+00*s86+0.000000e+00*s87+0.000000e+00*s88+0.000000e+00*s89 \
v82_part10=v82_part9+(-8.133000e+01)*s90+0.000000e+00*s91+0.000000e+00*s92+0.000000e+00*s93+0.000000e+00*s94+0.000000e+00*s95+0.000000e+00*s96+0.000000e+00*s97+0.000000e+00*s98+0.000000e+00*s99 \
v82=v82_part10+0.000000e+00*s100+0.000000e+00*s101+0.000000e+00*s102+0.000000e+00*s103+0.000000e+00*s104 \
v83_part1=0.000000e+00*s0+0.000000e+00*s1+0.000000e+00*s2+0.000000e+00*s3+1.970693e-01*s4+0.000000e+00*s5+0.000000e+00*s6+0.000000e+00*s7+0.000000e+00*s8+0.000000e+00*s9 \
v83_part2=v83_part1+0.000000e+00*s10+1.000000e+04*s11+1.000000e+04*s12+1.000000e+04*s13+1.000000e+04*s14+1.000000e+04*s15+1.000000e+04*s16+1.000000e+04*s17+1.000000e+04*s18+1.000000e+04*s19 \
v83_part3=v83_part2+1.000000e+04*s20+1.000000e+04*s21+1.403009e+01*s22+1.307956e+01*s23+1.645362e+01*s24+1.640942e+01*s25+0.000000e+00*s26+0.000000e+00*s27+0.000000e+00*s28+9.206848e-01*s29 \
v83_part4=v83_part3+8.838727e+00*s30+1.000000e+04*s31+1.000000e+04*s32+1.000000e+04*s33+1.000000e+04*s34+1.000000e+04*s35+1.000000e+04*s36+1.000000e+04*s37+(-1.461134e+01)*s38+(-8.996597e+00)*s39 \
v83_part5=v83_part4+(-1.341335e+01)*s40+2.563162e+01*s41+(-4.368101e+00)*s42+(-1.366045e+01)*s43+1.000000e+04*s44+1.000000e+04*s45+1.000000e+04*s46+1.000000e+04*s47+(-2.390489e+01)*s48+(-1.592530e+01)*s49 \
v83_part6=v83_part5+1.000000e+04*s50+(-9.758369e+01)*s51+0.000000e+00*s52+0.000000e+00*s53+0.000000e+00*s54+0.000000e+00*s55+0.000000e+00*s56+0.000000e+00*s57+0.000000e+00*s58+0.000000e+00*s59 \
v83_part7=v83_part6+0.000000e+00*s60+0.000000e+00*s61+0.000000e+00*s62+1.044018e-01*s63+0.000000e+00*s64+0.000000e+00*s65+0.000000e+00*s66+0.000000e+00*s67+0.000000e+00*s68+0.000000e+00*s69 \
v83_part8=v83_part7+0.000000e+00*s70+0.000000e+00*s71+0.000000e+00*s72+0.000000e+00*s73+0.000000e+00*s74+0.000000e+00*s75+0.000000e+00*s76+0.000000e+00*s77+0.000000e+00*s78+1.000000e+04*s79 \
v83_part9=v83_part8+1.000000e+04*s80+2.771538e+03*s81+1.000000e+04*s82+0.000000e+00*s83+0.000000e+00*s84+0.000000e+00*s85+0.000000e+00*s86+0.000000e+00*s87+0.000000e+00*s88+0.000000e+00*s89 \
v83_part10=v83_part9+1.206817e+02*s90+0.000000e+00*s91+0.000000e+00*s92+0.000000e+00*s93+0.000000e+00*s94+0.000000e+00*s95+0.000000e+00*s96+0.000000e+00*s97+0.000000e+00*s98+0.000000e+00*s99 \
v83=v83_part10+0.000000e+00*s100+0.000000e+00*s101+0.000000e+00*s102+0.000000e+00*s103+0.000000e+00*s104 \
v84_part1=0.000000e+00*s0+0.000000e+00*s1+0.000000e+00*s2+0.000000e+00*s3+0.000000e+00*s4+0.000000e+00*s5+6.208731e+02*s6+0.000000e+00*s7+0.000000e+00*s8+1.000000e+04*s9 \
v84_part2=v84_part1+1.725703e+01*s10+0.000000e+00*s11+0.000000e+00*s12+0.000000e+00*s13+0.000000e+00*s14+0.000000e+00*s15+0.000000e+00*s16+0.000000e+00*s17+0.000000e+00*s18+0.000000e+00*s19 \
v84_part3=v84_part2+0.000000e+00*s20+0.000000e+00*s21+0.000000e+00*s22+0.000000e+00*s23+0.000000e+00*s24+(-5.234680e-02)*s25+0.000000e+00*s26+0.000000e+00*s27+0.000000e+00*s28+0.000000e+00*s29 \
v84_part4=v84_part3+0.000000e+00*s30+0.000000e+00*s31+0.000000e+00*s32+0.000000e+00*s33+0.000000e+00*s34+0.000000e+00*s35+0.000000e+00*s36+0.000000e+00*s37+0.000000e+00*s38+0.000000e+00*s39 \
v84_part5=v84_part4+0.000000e+00*s40+0.000000e+00*s41+0.000000e+00*s42+0.000000e+00*s43+1.203701e-03*s44+0.000000e+00*s45+8.499599e-02*s46+(-2.297933e-04)*s47+0.000000e+00*s48+0.000000e+00*s49 \
v84_part6=v84_part5+(-9.863093e-03)*s50+0.000000e+00*s51+0.000000e+00*s52+0.000000e+00*s53+0.000000e+00*s54+2.425313e+03*s55+0.000000e+00*s56+0.000000e+00*s57+0.000000e+00*s58+0.000000e+00*s59 \
v84_part7=v84_part6+0.000000e+00*s60+0.000000e+00*s61+0.000000e+00*s62+0.000000e+00*s63+0.000000e+00*s64+0.000000e+00*s65+0.000000e+00*s66+0.000000e+00*s67+0.000000e+00*s68+0.000000e+00*s69 \
v84_part8=v84_part7+0.000000e+00*s70+0.000000e+00*s71+0.000000e+00*s72+0.000000e+00*s73+0.000000e+00*s74+0.000000e+00*s75+0.000000e+00*s76+0.000000e+00*s77+1.000000e+04*s78+0.000000e+00*s79 \
v84_part9=v84_part8+0.000000e+00*s80+3.166811e-01*s81+0.000000e+00*s82+3.477664e+01*s83+7.914796e+00*s84+1.052381e+03*s85+0.000000e+00*s86+0.000000e+00*s87+0.000000e+00*s88+2.169291e+03*s89 \
v84_part10=v84_part9+0.000000e+00*s90+0.000000e+00*s91+0.000000e+00*s92+0.000000e+00*s93+1.000000e+04*s94+0.000000e+00*s95+0.000000e+00*s96+3.298608e+02*s97+7.560486e+00*s98+0.000000e+00*s99 \
v84=v84_part10+0.000000e+00*s100+0.000000e+00*s101+1.000000e+04*s102+4.863897e+02*s103+2.116011e+03*s104 \
v85_part1=0.000000e+00*s0+0.000000e+00*s1+0.000000e+00*s2+0.000000e+00*s3+0.000000e+00*s4+0.000000e+00*s5+2.668633e+01*s6+0.000000e+00*s7+0.000000e+00*s8+1.000000e+04*s9 \
v85_part2=v85_part1+(-2.536586e+00)*s10+0.000000e+00*s11+0.000000e+00*s12+0.000000e+00*s13+0.000000e+00*s14+0.000000e+00*s15+0.000000e+00*s16+0.000000e+00*s17+0.000000e+00*s18+0.000000e+00*s19 \
v85_part3=v85_part2+0.000000e+00*s20+0.000000e+00*s21+0.000000e+00*s22+0.000000e+00*s23+0.000000e+00*s24+(-3.587881e-02)*s25+0.000000e+00*s26+0.000000e+00*s27+0.000000e+00*s28+0.000000e+00*s29 \
v85_part4=v85_part3+0.000000e+00*s30+0.000000e+00*s31+0.000000e+00*s32+0.000000e+00*s33+0.000000e+00*s34+0.000000e+00*s35+0.000000e+00*s36+0.000000e+00*s37+0.000000e+00*s38+0.000000e+00*s39 \
v85_part5=v85_part4+0.000000e+00*s40+0.000000e+00*s41+0.000000e+00*s42+0.000000e+00*s43+3.331684e-01*s44+0.000000e+00*s45+1.573623e-01*s46+1.778697e-01*s47+0.000000e+00*s48+0.000000e+00*s49 \
v85_part6=v85_part5+1.639956e-01*s50+0.000000e+00*s51+0.000000e+00*s52+0.000000e+00*s53+0.000000e+00*s54+3.432570e+03*s55+0.000000e+00*s56+0.000000e+00*s57+0.000000e+00*s58+0.000000e+00*s59 \
v85_part7=v85_part6+0.000000e+00*s60+0.000000e+00*s61+0.000000e+00*s62+0.000000e+00*s63+0.000000e+00*s64+0.000000e+00*s65+0.000000e+00*s66+0.000000e+00*s67+0.000000e+00*s68+0.000000e+00*s69 \
v85_part8=v85_part7+0.000000e+00*s70+0.000000e+00*s71+0.000000e+00*s72+0.000000e+00*s73+0.000000e+00*s74+0.000000e+00*s75+0.000000e+00*s76+0.000000e+00*s77+2.246353e+03*s78+0.000000e+00*s79 \
v85_part9=v85_part8+0.000000e+00*s80+4.861076e-01*s81+0.000000e+00*s82+7.355457e+02*s83+3.409164e+03*s84+4.275110e+03*s85+0.000000e+00*s86+0.000000e+00*s87+0.000000e+00*s88+7.342699e+02*s89 \
v85_part10=v85_part9+0.000000e+00*s90+0.000000e+00*s91+0.000000e+00*s92+0.000000e+00*s93+1.000000e+04*s94+0.000000e+00*s95+0.000000e+00*s96+4.326258e+02*s97+2.706682e+00*s98+0.000000e+00*s99 \
v85=v85_part10+0.000000e+00*s100+0.000000e+00*s101+1.000000e+04*s102+8.830010e+02*s103+3.310136e+03*s104 \
v86_part1=0.000000e+00*s0+0.000000e+00*s1+0.000000e+00*s2+0.000000e+00*s3+0.000000e+00*s4+0.000000e+00*s5+1.638369e+02*s6+0.000000e+00*s7+0.000000e+00*s8+1.000000e+04*s9 \
v86_part2=v86_part1+2.841636e-02*s10+0.000000e+00*s11+0.000000e+00*s12+0.000000e+00*s13+0.000000e+00*s14+0.000000e+00*s15+0.000000e+00*s16+0.000000e+00*s17+0.000000e+00*s18+0.000000e+00*s19 \
v86_part3=v86_part2+0.000000e+00*s20+0.000000e+00*s21+0.000000e+00*s22+0.000000e+00*s23+0.000000e+00*s24+1.322087e-01*s25+0.000000e+00*s26+0.000000e+00*s27+0.000000e+00*s28+0.000000e+00*s29 \
v86_part4=v86_part3+0.000000e+00*s30+0.000000e+00*s31+0.000000e+00*s32+0.000000e+00*s33+0.000000e+00*s34+0.000000e+00*s35+0.000000e+00*s36+0.000000e+00*s37+0.000000e+00*s38+0.000000e+00*s39 \
v86_part5=v86_part4+0.000000e+00*s40+0.000000e+00*s41+0.000000e+00*s42+0.000000e+00*s43+(-4.678374e-01)*s44+0.000000e+00*s45+(-2.955818e-01)*s46+(-1.726530e-01)*s47+0.000000e+00*s48+0.000000e+00*s49 \
v86_part6=v86_part5+(-2.317637e-01)*s50+0.000000e+00*s51+0.000000e+00*s52+0.000000e+00*s53+0.000000e+00*s54+3.547169e+03*s55+0.000000e+00*s56+0.000000e+00*s57+0.000000e+00*s58+0.000000e+00*s59 \
v86_part7=v86_part6+0.000000e+00*s60+0.000000e+00*s61+0.000000e+00*s62+0.000000e+00*s63+0.000000e+00*s64+0.000000e+00*s65+0.000000e+00*s66+0.000000e+00*s67+0.000000e+00*s68+0.000000e+00*s69 \
v86_part8=v86_part7+0.000000e+00*s70+0.000000e+00*s71+0.000000e+00*s72+0.000000e+00*s73+0.000000e+00*s74+0.000000e+00*s75+0.000000e+00*s76+0.000000e+00*s77+9.050440e+02*s78+0.000000e+00*s79 \
v86_part9=v86_part8+0.000000e+00*s80+(-1.024932e+00)*s81+0.000000e+00*s82+4.401623e+02*s83+3.852613e+01*s84+1.774808e+02*s85+0.000000e+00*s86+0.000000e+00*s87+0.000000e+00*s88+1.616917e+03*s89 \
v86_part10=v86_part9+0.000000e+00*s90+0.000000e+00*s91+0.000000e+00*s92+0.000000e+00*s93+1.000000e+04*s94+0.000000e+00*s95+0.000000e+00*s96+4.518069e+01*s97+5.709879e+00*s98+0.000000e+00*s99 \
v86=v86_part10+0.000000e+00*s100+0.000000e+00*s101+6.613318e+03*s102+5.500593e+01*s103+5.703041e+02*s104 \
v87_part1=2.247440e+01*s0+4.778451e+01*s1+7.564441e+02*s2+2.091341e+02*s3+1.616098e+00*s4+8.116041e+00*s5+6.589841e+02*s6+4.880369e+01*s7+6.297345e+02*s8+1.116093e-03*s9 \
v87_part2=v87_part1+(-1.542125e+01)*s10+(-9.590705e-01)*s11+(-6.867538e-01)*s12+4.380520e+00*s13+1.000431e+00*s14+2.181101e+00*s15+8.430640e+00*s16+1.125535e+01*s17+4.176565e-01*s18+4.511913e+00*s19 \
v87_part3=v87_part2+3.256321e+00*s20+2.373104e+00*s21+5.773074e+02*s22+7.188899e+02*s23+1.664345e+01*s24+1.150287e+01*s25+(-5.634440e+01)*s26+4.149054e+01*s27+1.874459e-03*s28+7.378754e-02*s29 \
v87_part4=v87_part3+2.415836e+00*s30+1.084815e+00*s31+1.272183e+00*s32+6.194087e-01*s33+6.908543e-01*s34+2.847897e+01*s35+1.436601e+00*s36+1.356496e+00*s37+1.000000e+04*s38+1.000000e+04*s39 \
v87_part5=v87_part4+1.000000e+04*s40+1.704505e+00*s41+9.195567e+01*s42+1.000000e+04*s43+1.383138e+00*s44+1.017677e+00*s45+5.737307e-01*s46+1.006370e+00*s47+1.000000e+04*s48+1.000000e+04*s49 \
v87_part6=v87_part5+1.527315e+00*s50+1.000000e+04*s51+(-3.009876e+00)*s52+1.741657e-01*s53+7.054300e+00*s54+3.782077e-02*s55+1.758268e+00*s56+4.212387e-01*s57+3.471123e+01*s58+1.929763e+01*s59 \
v87_part7=v87_part6+9.671249e+01*s60+1.000000e+04*s61+2.357005e+02*s62+9.958194e+00*s63+(-5.518770e+00)*s64+3.889751e+01*s65+4.571120e+01*s66+1.574638e+02*s67+6.122716e+01*s68+3.646945e+01*s69 \
v87_part8=v87_part7+(-1.486969e+00)*s70+4.979522e+00*s71+1.162689e+03*s72+(-1.045209e+00)*s73+2.578409e+00*s74+9.350128e+00*s75+3.723983e+01*s76+3.528072e+01*s77+1.041314e+01*s78+1.396668e+00*s79 \
v87_part9=v87_part8+2.662658e+02*s80+(-2.634286e-01)*s81+1.337535e+00*s82+7.403234e+01*s83+5.936316e+00*s84+2.138464e+01*s85+1.162443e+00*s86+4.968812e+00*s87+1.016305e+01*s88+6.120558e+00*s89 \
v87_part10=v87_part9+1.000000e+04*s90+1.334697e+02*s91+1.733177e+02*s92+1.000000e+04*s93+7.787541e+01*s94+1.000000e+04*s95+9.009780e+00*s96+3.093436e+01*s97+(-3.043762e-01)*s98+1.000000e+04*s99 \
v87=v87_part10+2.221318e+00*s100+6.846643e+03*s101+6.966670e+02*s102+3.479901e+02*s103+1.000000e+04*s104 \
v88_part1=(-3.003025e-01)*s0+1.096307e+02*s1+1.604438e+02*s2+7.830587e+01*s3+2.087284e+02*s4+9.231368e-01*s5+1.943968e+01*s6+2.036942e+01*s7+4.042092e+02*s8+3.894491e+00*s9 \
v88_part2=v88_part1+8.886982e+01*s10+4.259503e+00*s11+4.262717e+00*s12+(-2.679443e+01)*s13+(-5.298853e-01)*s14+(-7.343982e-01)*s15+(-9.792191e+00)*s16+(-1.463915e+01)*s17+(-6.134394e-01)*s18+(-1.201605e+00)*s19 \
v88_part3=v88_part2+(-3.696555e+00)*s20+(-3.128073e+00)*s21+3.884638e+01*s22+4.001160e+02*s23+(-2.567722e+00)*s24+(-1.898115e+01)*s25+5.797235e+01*s26+5.176346e-01*s27+3.218325e+01*s28+(-1.060457e+01)*s29 \
v88_part4=v88_part3+4.984967e+00*s30+(-6.826046e-01)*s31+(-1.488526e+00)*s32+(-5.770631e-01)*s33+(-4.706297e-01)*s34+1.062743e+01*s35+(-1.171777e+00)*s36+(-9.865728e-01)*s37+1.000000e+04*s38+1.000000e+04*s39 \
v88_part5=v88_part4+1.000000e+04*s40+4.767398e-02*s41+(-4.565240e+01)*s42+1.000000e+04*s43+(-1.527287e+00)*s44+(-5.526478e-01)*s45+(-6.353277e-01)*s46+(-1.124080e+00)*s47+1.000000e+04*s48+1.000000e+04*s49 \
v88_part6=v88_part5+(-6.744305e-01)*s50+1.000000e+04*s51+2.373216e+01*s52+1.614331e+01*s53+2.271204e+00*s54+1.743387e+01*s55+1.565189e+01*s56+1.561874e+01*s57+(-4.374977e-01)*s58+6.508342e+00*s59 \
v88_part7=v88_part6+8.172045e+01*s60+1.241114e+02*s61+7.794696e+01*s62+(-1.143267e+01)*s63+7.737832e+01*s64+6.777089e+02*s65+1.814298e+00*s66+(-9.070565e+01)*s67+(-4.117237e+01)*s68+2.384445e+01*s69 \
v88_part8=v88_part7+3.385580e+01*s70+1.666128e+01*s71+1.856916e+03*s72+1.577020e+01*s73+4.802574e+00*s74+4.223192e+00*s75+(-9.890131e+00)*s76+3.639575e-01*s77+2.077742e+01*s78+(-4.118619e+01)*s79 \
v88_part9=v88_part8+(-1.131961e+02)*s80+2.404411e+00*s81+(-1.593090e+01)*s82+3.695881e+02*s83+2.223404e+02*s84+3.233924e+00*s85+6.209960e+00*s86+3.817753e+01*s87+1.468482e+01*s88+5.463638e+00*s89 \
v88_part10=v88_part9+1.000000e+04*s90+(-1.331869e+02)*s91+9.192832e+01*s92+1.000000e+04*s93+1.660726e+03*s94+1.000000e+04*s95+2.310403e+01*s96+3.373571e+01*s97+3.801437e+01*s98+1.000000e+04*s99 \
v88=v88_part10+3.678326e+01*s100+(-1.456922e+03)*s101+1.353352e+03*s102+7.161771e+02*s103+1.000000e+04*s104 \
v89_part1=(-2.312796e+01)*s0+1.061923e-01*s1+3.566408e+02*s2+4.386064e+02*s3+1.460558e+01*s4+9.081736e-02*s5+5.682576e+01*s6+3.255290e+01*s7+2.382068e+01*s8+(-1.918326e-03)*s9 \
v89_part2=v89_part1+5.777335e+02*s10+1.414051e+00*s11+1.553299e+00*s12+3.285306e+01*s13+9.802818e-01*s14+3.831019e-01*s15+4.939918e+00*s16+5.154299e+00*s17+7.540946e+00*s18+1.475455e+00*s19 \
v89_part3=v89_part2+6.236525e+00*s20+9.658365e+00*s21+1.128658e+02*s22+8.942638e+03*s23+6.029865e+00*s24+2.102592e+01*s25+6.614908e+01*s26+(-1.751303e+00)*s27+2.380559e+01*s28+5.078069e+01*s29 \
v89_part4=v89_part3+1.647846e+01*s30+9.351130e-01*s31+1.638470e+00*s32+9.212854e-01*s33+8.999823e-01*s34+2.199578e+02*s35+3.693206e-01*s36+4.610174e-01*s37+1.000000e+04*s38+1.000000e+04*s39 \
v89_part5=v89_part4+1.000000e+04*s40+6.105488e+02*s41+7.018904e+00*s42+1.000000e+04*s43+1.306161e+00*s44+2.830570e-01*s45+1.577455e+00*s46+1.764699e+00*s47+1.000000e+04*s48+1.000000e+04*s49 \
v89_part6=v89_part5+1.066878e-01*s50+1.000000e+04*s51+(-5.249815e+00)*s52+(-7.432788e+00)*s53+3.774573e-01*s54+(-7.054255e+00)*s55+(-6.305420e+00)*s56+(-7.034615e+00)*s57+(-1.056823e-01)*s58+(-1.372212e+00)*s59 \
v89_part7=v89_part6+1.492846e+02*s60+1.527328e+02*s61+9.280586e+01*s62+6.933260e+01*s63+(-3.429266e+01)*s64+1.409153e+02*s65+2.906681e-01*s66+(-1.848153e+01)*s67+(-2.868189e-01)*s68+(-3.777773e+01)*s69 \
v89_part8=v89_part7+(-1.925765e+01)*s70+(-1.664709e+01)*s71+2.651151e+02*s72+(-4.684884e+00)*s73+(-3.120635e+00)*s74+(-8.929580e+00)*s75+(-2.350809e+01)*s76+(-2.983806e+01)*s77+(-2.460275e+01)*s78+7.868983e+01*s79 \
v89_part9=v89_part8+(-1.556259e+02)*s80+(-2.157654e+00)*s81+3.724262e+01*s82+6.233504e+00*s83+2.606051e+00*s84+(-2.907960e+01)*s85+(-6.874441e-01)*s86+(-5.219384e+00)*s87+(-1.152157e+01)*s88+(-8.360254e+00)*s89 \
v89_part10=v89_part9+1.000000e+04*s90+(-4.836960e+01)*s91+(-7.249460e+00)*s92+1.627877e+02*s93+(-1.999557e+03)*s94+1.000000e+04*s95+(-3.046737e+01)*s96+(-9.464557e+01)*s97+(-4.171041e+01)*s98+1.000000e+04*s99 \
v89=v89_part10+(-4.549729e+01)*s100+(-1.000000e+04)*s101+1.119627e+03*s102+1.000000e+04*s103+1.000000e+04*s104 \
v90_part1=0.000000e+00*s0+0.000000e+00*s1+1.799622e+01*s2+(-8.831485e+00)*s3+2.154581e+00*s4+0.000000e+00*s5+3.923629e+01*s6+1.742397e+01*s7+2.045542e+01*s8+0.000000e+00*s9 \
v90_part2=v90_part1+3.112130e+00*s10+0.000000e+00*s11+3.813707e+01*s12+(-1.341315e+02)*s13+0.000000e+00*s14+2.271171e+01*s15+(-3.845819e+01)*s16+8.529884e+00*s17+6.234713e-01*s18+1.493001e+01*s19 \
v90_part3=v90_part2+1.322860e+01*s20+(-2.986139e+01)*s21+(-3.462439e+00)*s22+8.358334e+00*s23+2.335483e+01*s24+(-4.973819e+00)*s25+(-3.479113e+01)*s26+3.732365e+00*s27+(-1.165546e+01)*s28+(-3.622137e+01)*s29 \
v90_part4=v90_part3+(-2.296150e+01)*s30+0.000000e+00*s31+0.000000e+00*s32+0.000000e+00*s33+0.000000e+00*s34+0.000000e+00*s35+0.000000e+00*s36+0.000000e+00*s37+(-1.053184e+01)*s38+(-2.401972e+01)*s39 \
v90_part5=v90_part4+(-3.409548e+01)*s40+(-1.885716e+02)*s41+1.172526e-01*s42+(-9.431818e+01)*s43+0.000000e+00*s44+0.000000e+00*s45+0.000000e+00*s46+0.000000e+00*s47+(-1.043225e+02)*s48+(-7.298606e+01)*s49 \
v90_part6=v90_part5+0.000000e+00*s50+(-2.987505e+02)*s51+0.000000e+00*s52+0.000000e+00*s53+0.000000e+00*s54+0.000000e+00*s55+0.000000e+00*s56+0.000000e+00*s57+0.000000e+00*s58+0.000000e+00*s59 \
v90_part7=v90_part6+0.000000e+00*s60+0.000000e+00*s61+0.000000e+00*s62+(-2.534991e+01)*s63+(-3.477730e+01)*s64+(-8.124746e+00)*s65+4.147384e+00*s66+3.240263e+01*s67+(-7.640487e+01)*s68+3.014553e+01*s69 \
v90_part8=v90_part7+0.000000e+00*s70+0.000000e+00*s71+0.000000e+00*s72+0.000000e+00*s73+0.000000e+00*s74+0.000000e+00*s75+0.000000e+00*s76+0.000000e+00*s77+0.000000e+00*s78+1.194945e+01*s79 \
v90_part9=v90_part8+0.000000e+00*s80+(-9.536164e-01)*s81+3.004027e+01*s82+0.000000e+00*s83+0.000000e+00*s84+0.000000e+00*s85+0.000000e+00*s86+0.000000e+00*s87+0.000000e+00*s88+0.000000e+00*s89 \
v90_part10=v90_part9+(-1.868974e+02)*s90+0.000000e+00*s91+0.000000e+00*s92+0.000000e+00*s93+0.000000e+00*s94+0.000000e+00*s95+0.000000e+00*s96+0.000000e+00*s97+0.000000e+00*s98+0.000000e+00*s99 \
v90=v90_part10+0.000000e+00*s100+0.000000e+00*s101+0.000000e+00*s102+0.000000e+00*s103+(-4.085800e+01)*s104 \
v91_part1=0.000000e+00*s0+0.000000e+00*s1+2.767358e+00*s2+9.343672e+01*s3+6.541908e+01*s4+0.000000e+00*s5+(-2.890540e+01)*s6+(-8.827223e+00)*s7+(-8.457781e-01)*s8+0.000000e+00*s9 \
v91_part2=v91_part1+3.147448e+01*s10+0.000000e+00*s11+(-7.156844e+00)*s12+4.322157e+02*s13+0.000000e+00*s14+1.869807e+02*s15+2.365842e+02*s16+1.392378e+02*s17+1.242513e+02*s18+1.165757e+02*s19 \
v91_part3=v91_part2+1.199974e+02*s20+1.609444e+02*s21+4.807087e+01*s22+(-6.982273e+00)*s23+5.822459e+01*s24+4.851835e+01*s25+1.249125e+02*s26+7.725887e+01*s27+8.133460e+01*s28+1.799789e+02*s29 \
v91_part4=v91_part3+9.395954e+01*s30+0.000000e+00*s31+0.000000e+00*s32+0.000000e+00*s33+0.000000e+00*s34+0.000000e+00*s35+0.000000e+00*s36+0.000000e+00*s37+7.452014e+01*s38+9.146700e+01*s39 \
v91_part5=v91_part4+1.088036e+02*s40+4.735909e+02*s41+1.661071e+02*s42+1.659624e+02*s43+0.000000e+00*s44+0.000000e+00*s45+0.000000e+00*s46+0.000000e+00*s47+2.341155e+02*s48+2.076807e+02*s49 \
v91_part6=v91_part5+0.000000e+00*s50+5.484615e+02*s51+0.000000e+00*s52+0.000000e+00*s53+0.000000e+00*s54+0.000000e+00*s55+0.000000e+00*s56+0.000000e+00*s57+0.000000e+00*s58+0.000000e+00*s59 \
v91_part7=v91_part6+0.000000e+00*s60+0.000000e+00*s61+0.000000e+00*s62+5.844062e+01*s63+1.651753e+01*s64+(-1.383920e+01)*s65+(-7.504803e-01)*s66+(-1.493794e+01)*s67+6.099278e+01*s68+(-3.622427e+01)*s69 \
v91_part8=v91_part7+0.000000e+00*s70+0.000000e+00*s71+0.000000e+00*s72+0.000000e+00*s73+0.000000e+00*s74+0.000000e+00*s75+0.000000e+00*s76+0.000000e+00*s77+0.000000e+00*s78+(-2.191526e-01)*s79 \
v91_part9=v91_part8+0.000000e+00*s80+2.074666e+02*s81+(-2.816556e+00)*s82+0.000000e+00*s83+0.000000e+00*s84+0.000000e+00*s85+0.000000e+00*s86+0.000000e+00*s87+0.000000e+00*s88+0.000000e+00*s89 \
v91_part10=v91_part9+1.640053e+02*s90+0.000000e+00*s91+0.000000e+00*s92+0.000000e+00*s93+0.000000e+00*s94+0.000000e+00*s95+0.000000e+00*s96+0.000000e+00*s97+0.000000e+00*s98+0.000000e+00*s99 \
v91=v91_part10+0.000000e+00*s100+0.000000e+00*s101+0.000000e+00*s102+0.000000e+00*s103+4.884367e+01*s104 \
v92_part1=0.000000e+00*s0+0.000000e+00*s1+1.107713e+01*s2+(-5.639759e-01)*s3+2.894508e+00*s4+0.000000e+00*s5+2.087842e+01*s6+2.257991e+01*s7+4.879682e+00*s8+0.000000e+00*s9 \
v92_part2=v92_part1+2.292189e+00*s10+0.000000e+00*s11+(-1.816899e+01)*s12+(-2.352643e+01)*s13+0.000000e+00*s14+(-1.054706e+02)*s15+(-5.571389e+01)*s16+(-4.241297e+01)*s17+(-2.649795e+01)*s18+(-3.186546e+01)*s19 \
v92_part3=v92_part2+(-1.993655e+01)*s20+(-1.807363e+01)*s21+(-1.049200e+01)*s22+4.635024e+01*s23+(-4.033291e+01)*s24+(-7.553108e-01)*s25+4.727619e+00*s26+(-1.458587e+00)*s27+1.543105e+01*s28+(-7.129471e+01)*s29 \
v92_part4=v92_part3+2.834639e-01*s30+0.000000e+00*s31+0.000000e+00*s32+0.000000e+00*s33+0.000000e+00*s34+0.000000e+00*s35+0.000000e+00*s36+0.000000e+00*s37+6.908138e+00*s38+3.399532e+00*s39 \
v92_part5=v92_part4+1.647330e-01*s40+(-1.408167e+02)*s41+(-1.242013e+02)*s42+1.358170e-01*s43+0.000000e+00*s44+0.000000e+00*s45+0.000000e+00*s46+0.000000e+00*s47+(-4.789193e+01)*s48+(-5.702460e+01)*s49 \
v92_part6=v92_part5+0.000000e+00*s50+(-2.420843e+02)*s51+0.000000e+00*s52+0.000000e+00*s53+0.000000e+00*s54+0.000000e+00*s55+0.000000e+00*s56+0.000000e+00*s57+0.000000e+00*s58+0.000000e+00*s59 \
v92_part7=v92_part6+0.000000e+00*s60+0.000000e+00*s61+0.000000e+00*s62+3.180575e-01*s63+1.169027e+02*s64+1.091790e+02*s65+6.049025e+01*s66+3.990210e+01*s67+1.051460e+02*s68+8.533466e+01*s69 \
v92_part8=v92_part7+0.000000e+00*s70+0.000000e+00*s71+0.000000e+00*s72+0.000000e+00*s73+0.000000e+00*s74+0.000000e+00*s75+0.000000e+00*s76+0.000000e+00*s77+0.000000e+00*s78+5.509607e+02*s79 \
v92_part9=v92_part8+0.000000e+00*s80+(-1.464348e+01)*s81+5.208147e+02*s82+0.000000e+00*s83+0.000000e+00*s84+0.000000e+00*s85+0.000000e+00*s86+0.000000e+00*s87+0.000000e+00*s88+0.000000e+00*s89 \
v92_part10=v92_part9+1.985846e+02*s90+0.000000e+00*s91+0.000000e+00*s92+0.000000e+00*s93+0.000000e+00*s94+0.000000e+00*s95+0.000000e+00*s96+0.000000e+00*s97+0.000000e+00*s98+0.000000e+00*s99 \
v92=v92_part10+0.000000e+00*s100+0.000000e+00*s101+0.000000e+00*s102+0.000000e+00*s103+1.744801e+01*s104 \
_p0=v0+v1*od_+v2*w_ \
_p1=0.5*(_p0+sqrt(_p0*_p0+0.001)) \
_p2=v3+v4*od_+v5/w_ \
_p3=1.15*0.975*0.5*(_p2+sqrt(_p2*_p2+0.001)) \
_p4=v6+v7*od_+v8*w_ \
_p5=0.5*(_p4+sqrt(_p4*_p4+0.001)) \
_p6=v9+v10*od_+v11/w_ \
_p7=1.15*0.975*0.5*(_p6+sqrt(_p6*_p6+0.001)) \
_p8=v12+v13*od_+v14*w_ \
_p9=0.5*(_p8+sqrt(_p8*_p8+0.001)) \
_p10=v15+v16*od_+v17*w_ \
_p11=0.5*(_p10+sqrt(_p10*_p10+0.001)) \
_p12=1.05*1e-09*_p1 \
_p13=v18+v19*od_+v20*w_ \
_p14=0.5*(_p13+sqrt(_p13*_p13+0.001)) \
_p15=1.05*1e-09*_p14 \
_p16=v21+v22*od_+v23/w_ \
_p17=1.15*0.975*0.5*(_p16+sqrt(_p16*_p16+0.001)) \
_p18=1.05*1e-09*_p5 \
_p19=v24+v25*od_+v26*w_ \
_p20=0.5*(_p19+sqrt(_p19*_p19+0.001)) \
_p21=1.05*1e-09*_p20 \
_p22=v27+v28*od_+v29/w_ \
_p23=1.15*0.975*0.5*(_p22+sqrt(_p22*_p22+0.001)) \
_p24=1e-15*_p9 \
_p25=v30+v31*od_+v32*w_ \
_p26=0.5*(_p25+sqrt(_p25*_p25+0.001)) \
_p27=1e-15*_p26 \
_p28=v33+v34*od_+v35*w_ \
_p29=0.5*(_p28+sqrt(_p28*_p28+0.001)) \
_p30=1e-15*_p29 \
_p31=1e-15*_p11 \
_p32=v36+v37*od_+v38*w_ \
_p33=0.5*(_p32+sqrt(_p32*_p32+0.001)) \
_p34=1e-15*_p33 \
_p35=v39+v40*od_+v41*w_ \
_p36=0.5*(_p35+sqrt(_p35*_p35+0.001)) \
_p37=1.05*1e-10*_p36 \
_p39=v42+v43*od_+v44*w_ \
_p40=atan(_p39-0.5)/1.5708 \
_p41=v45+v46*od_+v47*w_ \
_p42=atan(_p41-0.5)/1.5708 \
_p43=v48+v49*od_+v50*w_ \
_p44=atan(_p43-0.5)/1.5708 \
_p38_xsc1=1.0 \
_p38_sc1=1.0 \
_p38_xsc2=_p38_xsc1+_p40*_p40 \
_p38_sc2=1.0/sqrt(_p38_xsc2) \
_p38_xsc3=_p38_xsc2+_p42*_p42 \
_p38_sc3=1.0/sqrt(_p38_xsc3) \
_p38_xsc4=_p38_xsc3+_p44*_p44 \
_p38_sc4=1.0/sqrt(_p38_xsc4) \
_p45=(1.0*_p40)*1.0*_p38_sc2 \
_p46=(1.0*_p42)*1.0*_p38_sc3 \
_p47=(1.0*_p44)*1.0*_p38_sc4 \
_p48=(_p40*_p42+1.0*_p40)*_p38_sc2*_p38_sc3 \
_p49=(_p40*_p44+1.0*_p42)*_p38_sc2*_p38_sc4 \
_p50=(_p42*_p44+_p40*_p42+1.0*_p40)*_p38_sc3*_p38_sc4 \
_p51=v51+v52*od_+v53*w_ \
_p52=0.5*(_p51+sqrt(_p51*_p51+0.001)) \
_p53=v54+v55*od_+v56*w_ \
_p54=0.5*(_p53+sqrt(_p53*_p53+0.001)) \
_p55=v57+v58*od_+v59*w_ \
_p56=0.5*(_p55+sqrt(_p55*_p55+0.001)) \
_p57=v60+v61*od_+v62*w_ \
_p58=0.5*(_p57+sqrt(_p57*_p57+0.001)) \
_p59=v63+v64*od_+v65*w_ \
_p60=0.5*(_p59+sqrt(_p59*_p59+0.001)) \
_p61=v66+v67*od_+v68*w_ \
_p62=0.5*(_p61+sqrt(_p61*_p61+0.001)) \
_p63=v69+v70*od_+v71*w_ \
_p64=0.5*(_p63+sqrt(_p63*_p63+0.001)) \
_p65=v72+v73*od_+v74*w_ \
_p66=0.5*(_p65+sqrt(_p65*_p65+0.001)) \
_p67=v75+v76*od_+v77*w_ \
_p68=0.5*(_p67+sqrt(_p67*_p67+0.001)) \
_p69=v78+v79*od_+v80*w_ \
_p70=0.5*(_p69+sqrt(_p69*_p69+0.001)) \
_p71=v81+v82*od_+v83*w_ \
_p72=0.5*(_p71+sqrt(_p71*_p71+0.001)) \
_p73=v84+v85*od_+v86*w_ \
_p74=0.5*(_p73+sqrt(_p73*_p73+0.001)) \
_p75=1e-14*_p52 \
_p76=0.9*100*_p54 \
_p77=1e-14*_p56 \
_p78=0.9*100*_p58 \
_p79=1e-14*_p60 \
_p80=0.9*100*_p62 \
_p81=1e-14*_p64 \
_p82=0.9*100*_p66 \
_p83=1e-14*_p68 \
_p84=0.9*100*_p70 \
_p85=1e-14*_p72 \
_p86=0.9*100*_p74 \
_p87=v87+v88*od_+v89*w_ \
_p88=0.5*(_p87+sqrt(_p87*_p87+0.001)) \
_p89=v90+v91*od_+v92*w_ \
_p90=0.5*(_p89+sqrt(_p89*_p89+0.001)) \
_p91=0.9*100*_p88 \
_p92=1e-15*_p90
lp1 (p1 _np1) inductor l=_p12
rp1 (_np1 _np2) resistor r=_p3
lp2 (_np3 p2) inductor l=_p15
rp2 (_np3 _np2) resistor r=_p17
ls1 (s1 _ns1) inductor l=_p18
rs1 (_ns1 _ns2) resistor r=_p7
ls2 (_ns3 s2) inductor l=_p21
rs2 (_ns3 _ns2) resistor r=_p23
c1 (p1 s1) capacitor c=_p24
c2 (p2 s2) capacitor c=_p27
c3 (_np2 _ns2) capacitor c=_p30
c4 (p1 s2) capacitor c=_p31
c5 (p2 s1) capacitor c=_p34
lcts (_ns2 cts) inductor l=_p37
k12_ks mutual_inductor coupling=_p45 ind1=lp1 ind2=lp2
k13_ks mutual_inductor coupling=_p46 ind1=lp1 ind2=ls1
k14_ks mutual_inductor coupling=_p47 ind1=lp1 ind2=ls2
k23_ks mutual_inductor coupling=_p48 ind1=lp2 ind2=ls1
k24_ks mutual_inductor coupling=_p49 ind1=lp2 ind2=ls2
k34_ks mutual_inductor coupling=_p50 ind1=ls1 ind2=ls2
c_1_sub (p1 _n1_1_sub) capacitor c=_p75
rs_1_sub (_n1_1_sub _nbulk) resistor r=_p76
c_2_sub (p2 _n1_2_sub) capacitor c=_p77
rs_2_sub (_n1_2_sub _nbulk) resistor r=_p78
c_3_sub (_np2 _n1_3_sub) capacitor c=_p79
rs_3_sub (_n1_3_sub _nbulk) resistor r=_p80
c_4_sub (s1 _n1_4_sub) capacitor c=_p81
rs_4_sub (_n1_4_sub _nbulk) resistor r=_p82
c_5_sub (s2 _n1_5_sub) capacitor c=_p83
rs_5_sub (_n1_5_sub _nbulk) resistor r=_p84
c_6_sub (_ns2 _n1_6_sub) capacitor c=_p85
rs_6_sub (_n1_6_sub _nbulk) resistor r=_p86
rs_1_sub1 (_nbulk gnd) resistor r=_p91
cs_1_sub1 (_nbulk gnd) capacitor c=_p92
ends l_sqctout_trans_rfvil
