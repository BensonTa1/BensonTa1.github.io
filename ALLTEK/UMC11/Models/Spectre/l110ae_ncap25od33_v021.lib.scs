simulator lang=spectre insensitive=yes
library mylib
section tt
parameters dtoxe_ncap_25od33=0.0000e+00
parameters dxw_ncap_25od33=0.0000e+00
parameters dxl_ncap_25od33=0.0000e+00
parameters dcwwl_ncap_25od33=0.0000e+00
parameters dclwl_ncap_25od33=0.0000e+00
parameters dcmina_ncap_25od33=0.0000e+00
include "l110ae_ncap25od33_v021.mdl.scs"
endsection tt
section ss
parameters dtoxe_ncap_25od33=+5.65000e-10
parameters dxw_ncap_25od33=-1.2000e-08
parameters dxl_ncap_25od33=-4.300e-09
parameters dcwwl_ncap_25od33=-3.00e-09
parameters dclwl_ncap_25od33=+3.0000e-9
parameters dcmina_ncap_25od33=+7.45e-02
include "l110ae_ncap25od33_v021.mdl.scs"
endsection ss
section ff
parameters dtoxe_ncap_25od33=-4.5800e-10
parameters dxw_ncap_25od33=+7.800e-09
parameters dxl_ncap_25od33=+4.00e-09
parameters dcwwl_ncap_25od33=+3.100e-09
parameters dclwl_ncap_25od33=-4.000e-9
parameters dcmina_ncap_25od33=-6.2500e-02
include "l110ae_ncap25od33_v021.mdl.scs"
endsection ff
endlibrary mylib
