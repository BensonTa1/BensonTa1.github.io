simulator lang=spectre insensitive=yes

// DEVICE 1
//  ******************************************************
//   Emitter Area=4.5X4.5 um^2  ,Base Area=11.7X11.7 um^2*
//  ******************************************************

inline subckt pnp_sv45x45_l110e ( c b e )
parameters mis_flag=1 mismatch=0
//
parameters abf_v45x45  = 9.2000e-3
parameters ais_v45x45  = 1.1500e-3
parameters p_bf_v45x45 = abf_v45x45 * mc_bf_pnp_v45x45 * mis_flag
parameters p_is_v45x45 = ais_v45x45 * mc_is_pnp_v45x45 * mis_flag

//
pnp_sv45x45_l110e ( c b e ) pnp_sv45x45_l110e_main

model pnp_sv45x45_l110e_main bjt type=pnp
+  struct=vertical           tnom=25
+  mjc=0.474                 mje=0.308                 vjc=0.588
+  vje=0.698                 af=1                      kf=0
+  irb=5.7916e-005           rb=122.79                 rbm=10.037
+  vaf=587.25                ikf=0.0013666             ise=2.2253e-017
+  ne=1.4882                 ns=20.349                 br=0.0016691
+  iss=2.4297e-011           nr=0.993                  var=30.116
+  ikr=0.001725              nkf=0.36895               isc=5.4477e-015
+  nc=1.0787
+  xtb=0.00010152            xti=3.959                 eg=1.16
+  ctc=0.00332               cte=0.0010049             tlev=1
+  tlevc=1                   tvjc=0.0028               tvje=0.0017088
+  tnf1=7.0045e-007          tnr1=0.00016717           tbf1=0.0045427
+  tbr1=0.0034106            tikf1=-0.0048824          trb1=0.0072152
+  trc1=0.00064594           tre1=-0.0069851           tbf2=9.2654e-006
+  tbr2=2.4859e-006
//
+  is  = 9.5298e-019*(1+dis_pnp_sv45x45_l110e)*(1+p_is_v45x45)
+  bf  = 1.1497*(1+dbf_pnp_sv45x45_l110e)*(1+p_bf_v45x45)
+  re  = 8.7616*(1+dre_pnp_sv45x45_l110e)
+  rc  = 23.321*(1+drc_pnp_sv45x45_l110e)
+  nf  = 0.99574*(1+dnf_pnp_sv45x45_l110e)
+  cjc = 1.1334e-014*(1+dcjc_pnp_sv45x45_l110e)
+  cje = 1.9622e-014*(1+dcje_pnp_sv45x45_l110e)
//
//  ************************************************************
//
//

ends pnp_sv90x90_l110e

// DEVICE 2
//  **************************************************
//   Emitter Area=9X9 um^2  ,Base Area=16.2X16.2 um^2*
//  **************************************************

inline subckt pnp_sv90x90_l110e ( c b e )
parameters mis_flag=1 mismatch=0
//
parameters abf_v90x90  = 5.4500e-4
parameters ais_v90x90  = 7.1000e-4
parameters p_bf_v90x90 = abf_v90x90 * mc_bf_pnp_v90x90 * mis_flag
parameters p_is_v90x90 = ais_v90x90 * mc_is_pnp_v90x90 * mis_flag
//
pnp_sv90x90_l110e ( c b e ) pnp_sv90x90_l110e_main

model pnp_sv90x90_l110e_main bjt type=pnp
+  struct=vertical           tnom=25
+  mjc=0.474                 mje=0.308                 vjc=0.588
+  vje=0.698                 af=1                      kf=0
+  rb=91.758                 irb=4.899e-005            rbm=8.622
+  vaf=587.25                ikf=0.0022987             ise=2.2253e-017
+  ne=1.4882                 ns=20.349                 br=0.0025237
+  iss=2.4297e-011           nr=0.993                  var=30.116
+  ikr=0.001725              nkf=0.3425                isc=5.4477e-015
+  nc=1.0787
+  xtb=0.00010152            xti=3.9604                eg=1.16
+  ctc=0.00332               cte=0.0010049             tlev=1
+  tlevc=1                   tvjc=0.0028               tvje=0.0017088
+  tnf1=7.0045e-007          tnr1=1.1755e-005          tbf1=0.0046282
+  tbr1=0.00024859           tikf1=-0.0059778          trb1=0.0069521
+  trc1=0.00064594           tre1=-0.0059086           tbf2=1.1268e-006
+  tbr2=7.9643e-007
//
+ is  = 3.3706e-018*(1+dis_pnp_sv90x90_l110e)*(1+p_is_v90x90)
+ bf  = 1.0405*(1+dbf_pnp_sv90x90_l110e)*(1+p_bf_v90x90)
+ re  = 4.8251*(1+dre_pnp_sv90x90_l110e)
+ rc  = 22.231*(1+drc_pnp_sv90x90_l110e)
+ nf  = 0.99574*(1+dnf_pnp_sv90x90_l110e)
+ cjc = 2.173e-014*(1+dcjc_pnp_sv90x90_l110e)
+ cje = 7.8489e-014*(1+dcje_pnp_sv90x90_l110e)

//  ************************************************************
//
//

ends pnp_sv135x135_l110e

// DEVICE 3
//  ********************************************************
//   Emitter Area=13.5X13.5 um^2  ,Base Area=20.7X20.7 um^2*
//  ********************************************************

inline subckt pnp_sv135x135_l110e ( c b e )
parameters mis_flag=1 mismatch=0
//
parameters abf_v135x135  = 1.5825e-4
parameters ais_v135x135  = 4.3340e-4
parameters p_bf_v135x135 = abf_v135x135 * mc_bf_pnp_v135x135 * mis_flag
parameters p_is_v135x135 = ais_v135x135 * mc_is_pnp_v135x135 * mis_flag
//
pnp_sv135x135_l110e ( c b e ) pnp_sv135x135_l110e_main

model pnp_sv135x135_l110e_main bjt type=pnp
+  struct=vertical           tnom=25
+  mjc=0.474                 mje=0.308                 vjc=0.588
+  vje=0.698                 af=1                      kf=0
+  rb=79.163                 irb=4.0518e-005           rbm=8.5326
+  vaf=587.25                ikf=0.0038215             ise=2.2253e-017
+  ne=1.4882                 ns=20.349                 br=0.0033413
+  iss=2.4297e-011           nr=0.993                  var=30.116
+  ikr=0.001725              nkf=0.3653                isc=5.4477e-015
+  nc=1.0787
+  xtb=0.00010152            xti=3.8337                eg=1.16
+  ctc=0.00332               cte=0.0010049             tlev=1
+  tlevc=1                   tvjc=0.0028               tvje=0.0017088
+  tnf1=7.0045e-007          tnr1=0.00025031           tbf1=0.0042554
+  tbr1=0.00014441           tikf1=-0.0057157          trb1=0.0111
+  trc1=0.00064594           tre1=-0.0076666           tbf2=1.1268e-006
+  tbr2=2.125e-006
//
+  is  = 7.3999e-018*(1+dis_pnp_sv135x135_l110e)*(1+p_is_v135x135)
+  bf  = 1.0053*(1+dbf_pnp_sv135x135_l110e)*(1+p_bf_v135x135)
+  re  = 2.9303*(1+dre_pnp_sv135x135_l110e)
+  rc  = 22.114*(1+drc_pnp_sv135x135_l110e)
+  nf  = 0.99574*(1+dnf_pnp_sv135x135_l110e)
+  cjc = 3.5479e-014*(1+dcjc_pnp_sv135x135_l110e)
+  cje = 1.766e-013*(1+dcje_pnp_sv135x135_l110e)

//  ************************************************************
//
//

ends pnp_v45x45_l110e

// DEVICE 4
//  *********************************************************
//   Emitter Area=4.5*4.5 um^2  ,Base Area= 10.98*10.98 um^2*
//  *********************************************************
inline subckt pnp_v45x45_l110e ( c b e )
parameters mis_flag=1 mismatch=0
//
parameters abf_45x45  = 9.6800e-3
parameters ais_45x45  = 7.6250e-4
parameters p_bf_45x45 = abf_45x45 * mc_bf_pnp_45x45 * mis_flag
parameters p_is_45x45 = ais_45x45 * mc_is_pnp_45x45 * mis_flag

//
pnp_v45x45_l110e ( c b e ) pnp_v45x45_l110e_main
//
model  pnp_v45x45_l110e_main  bjt  type=pnp

//  ************************************************************
+  struct=vertical           tnom=25
+  is=9.6021e-019*(1+dis_pnp_v45x45_l110e)*(1+p_is_45x45)
+  rb=71.256                 re=8.6181*(1+dre_pnp_v45x45_l110e)
+  irb=0.00014137            rc=25.608*(1+drc_pnp_v45x45_l110e)
+  rbm=34.666
+  bf=1.121*(1+dbf_pnp_v45x45_l110e)*(1+p_bf_45x45)
+  nf=0.999*(1+dnf_pnp_v45x45_l110e)                   vaf=800
+  ikf=0.0023348             ise=7.9315e-017           ne=1.8635
+  br=0.0029084              nr=0.99545                var=57.63
+  ikr=7.63e-005             nkf=0.5                   isc=3.3745e-015
+  nc=1.053                  cjc=9.9824e-015*(1+dcjc_pnp_v45x45_l110e)
+  cje=1.9622e-014*(1+dcje_pnp_v45x45_l110e)           cjs=0
+  fc=0.75                   mjc=0.474                 mje=0.30337
+  mjs=0                     vjc=0.588                 vje=0.6895
+  xcjc=0.5                  cbcp=0                    cbep=0
+  ccsp=0                    itf=0.1                   ptf=0
+  tf=1e-010                 tr=0                      vtf=10
+  xtf=1                     xtb=0                     xti=3.312
+  eg=1.16                   gap1=0.000702             gap2=1108
+  ctc=0.00332               cte=0.00095448            cts=0
+  tlev=1                    tlevc=1                   tvjc=0.0028
+  tvje=0.0016721            tvjs=0                    tis1=0
+  tise1=0                   tisc1=0                   tnf1=0
+  tnr1=0                    tne1=0                    tnc1=0
+  tbf1=0.003709             tbr1=0                    tiss1=0
+  tvaf1=0                   tvar1=0                   tikf1=0
+  tikr1=0                   tns1=0                    trb1=0.00073382
+  trc1=0.002501             tre1=0                    tirb1=0
+  trm1=0                    tmjc1=0                   tmje1=0
+  tmjs1=0                   ttf1=0                    titf1=0
+  ttr1=0                    tis2=0                    tise2=0
+  tisc2=0                   tnf2=0                    tnr2=0
+  tne2=0                    tnc2=0                    tbf2=0
+  tbr2=5e-005               tiss2=0                   tvaf2=0
+  tvar2=0                   tikf2=0                   tikr2=0
+  tns2=0                    trb2=7.434e-005           trc2=0
+  tre2=0                    tirb2=0                   trm2=0
+  tmjc2=0                   tmje2=0                   tmjs2=0
+  ttf2=0                    titf2=0                   ttr2=0
+  af=1                      kf=0
//  ************************************************************
ends pnp_v90x90_l110e

// DEVICE 5
//  *********************************************************
//   Emitter Area=9.0*9.0 um^2  ,Base Area= 15.48*15.48 um^2*
//  *********************************************************

inline subckt pnp_v90x90_l110e ( c b e )
parameters mis_flag=1 mismatch=0
//

parameters abf_90x90  = 4.3178e-3
parameters ais_90x90  = 2.6475e-4
parameters p_bf_90x90 = abf_90x90 * mc_bf_pnp_90x90 * mis_flag
parameters p_is_90x90 = ais_90x90 * mc_is_pnp_90x90 * mis_flag

//
pnp_v90x90_l110e ( c b e ) pnp_v90x90_l110e_main
//
model  pnp_v90x90_l110e_main  bjt  type=pnp

//  ************************************************************
+  struct=vertical           tnom=25
+  is=3.0496e-018*(1+dis_pnp_v90x90_l110e)*(1+p_is_90x90)
+  rb=37                     re=6.3241*(1+dre_pnp_v90x90_l110e)
+  irb=0.0017422             rc=22.356*(1+drc_pnp_v90x90_l110e)
+  rbm=15.972
+  bf=1.0675*(1+dbf_pnp_v90x90_l110e)*(1+p_bf_90x90)
+  nf=0.997*(1+dnf_pnp_v90x90_l110e)                   vaf=800
+  ikf=0.004625              ise=1.23e-016             ne=1.6899
+  br=0.0019295              nr=0.998                  var=58.2063
+  ikr=7.63e-005             nkf=0.5                   isc=1.479e-015
+  nc=1.0704                 cjc=1.9841e-014*(1+dcjc_pnp_v90x90_l110e)
+  cje=7.8489e-014*(1+dcje_pnp_v90x90_l110e)           cjs=0
+  fc=0.75                   mjc=0.474                 mje=0.30337
+  mjs=0                     vjc=0.588                 vje=0.6895
+  xcjc=0.5                  cbcp=0                    cbep=0
+  ccsp=0                    itf=0.1                   ptf=0
+  tf=1e-010                 tr=0                      vtf=10
+  xtf=1                     xtb=0                     xti=3.2973
+  eg=1.16                   gap1=0.000702             gap2=1108
+  ctc=0.00332               cte=0.00095448            cts=0
+  tlev=1                    tlevc=1                   tvjc=0.0028
+  tvje=0.0016721            tvjs=0                    tis1=0
+  tise1=0                   tisc1=0                   tnf1=0
+  tnr1=0.00015473           tne1=0                    tnc1=0
+  tbf1=0.0034716            tbr1=0                    tiss1=0
+  tvaf1=0                   tvar1=0                   tikf1=0
+  tikr1=0                   tns1=0                    trb1=0.0031494
+  trc1=0.003003             tre1=0                    tirb1=0.0005668
+  trm1=0.0015               tmjc1=0                   tmje1=0
+  tmjs1=0                   ttf1=0                    titf1=0
+  ttr1=0                    tis2=0                    tise2=0
+  tisc2=0                   tnf2=0                    tnr2=0
+  tne2=1.1719e-005          tnc2=2e-006               tbf2=0
+  tbr2=2e-006               tiss2=0                   tvaf2=0
+  tvar2=0                   tikf2=0                   tikr2=0
+  tns2=0                    trb2=0                    trc2=0
+  tre2=0                    tirb2=0                   trm2=0
+  tmjc2=0                   tmje2=0                   tmjs2=0
+  ttf2=0                    titf2=0                   ttr2=0
+  af=1                      kf=0
//  ************************************************************
ends pnp_v135x135_l110e

// DEVICE 6
//  ***********************************************************
//   Emitter Area=13.5*13.5 um^2  ,Base Area= 19.98*19.98 um^2*
//  ***********************************************************

inline subckt pnp_v135x135_l110e ( c b e )
parameters mis_flag=1 mismatch=0

parameters abf_135x135  = 3.0000e-3
parameters ais_135x135  = 4.9000e-4
parameters p_bf_135x135 = abf_135x135 * mc_bf_pnp_135x135 * mis_flag
parameters p_is_135x135 = ais_135x135 * mc_is_pnp_135x135 * mis_flag

//
pnp_v135x135_l110e ( c b e ) pnp_v135x135_l110e_main
//
model  pnp_v135x135_l110e_main  bjt  type=pnp

//  ************************************************************
+  struct=vertical           tnom=25
+  is=6.824e-018*(1+dis_pnp_v135x135_l110e)*(1+p_is_135x135)
+  rb=54.476                 re=2.5476*(1+dre_pnp_v135x135_l110e)
+  irb=1.5495e-005           rc=22.815*(1+drc_pnp_v135x135_l110e)
+  rbm=24.035
+  bf=1.045*(1+dbf_pnp_v135x135_l110e)*(1+p_bf_135x135)
+  nf=0.999*(1+dnf_pnp_v135x135_l110e)                 vaf=800
+  ikf=0.0065693             ise=1.0296e-016           ne=1.6864
+  br=0.026291               nr=0.99495                var=90.78
+  ikr=0.0106                nkf=0.5                   isc=5.2191e-015
+  nc=1.0305                 cjc=3.3054e-014*(1+dcjc_pnp_v135x135_l110e)
+  cje=1.766e-013*(1+dcje_pnp_v135x135_l110e)          cjs=0
+  fc=0.75                   mjc=0.474                 mje=0.30337
+  mjs=0                     vjc=0.588                 vje=0.6895
+  xcjc=0.5                  cbcp=0                    cbep=0
+  ccsp=0                    itf=0.1                   ptf=0
+  tf=1e-010                 tr=0                      vtf=10
+  xtf=1                     xtb=0                     xti=3.2643
+  eg=1.16                   gap1=0.000702             gap2=1108
+  ctc=0.00332               cte=0.00095448            cts=0
+  tlev=1                    tlevc=1                   tvjc=0.0028
+  tvje=0.0016721            tvjs=0                    tis1=0
+  tise1=0                   tisc1=0                   tnf1=0
+  tnr1=1e-005               tne1=0                    tnc1=2e-005
+  tbf1=0.0033047            tbr1=0                    tiss1=0
+  tvaf1=0                   tvar1=0                   tikf1=0
+  tikr1=0                   tns1=0                    trb1=0.0097
+  trc1=0.002907             tre1=0                    tirb1=0.011776
+  trm1=0.00085              tmjc1=0                   tmje1=0
+  tmjs1=0                   ttf1=0                    titf1=0
+  ttr1=0                    tis2=0                    tise2=0
+  tisc2=0                   tnf2=0                    tnr2=0
+  tne2=0                    tnc2=0                    tbf2=0
+  tbr2=0.00037              tiss2=0                   tvaf2=0
+  tvar2=0                   tikf2=0                   tikr2=0
+  tns2=0                    trb2=0                    trc2=0
+  tre2=0                    tirb2=0                   trm2=0
+  tmjc2=0                   tmje2=0                   tmjs2=0
+  ttf2=0                    titf2=0                   ttr2=0
+  af=1                      kf=0
//  ************************************************************

ends pnp_v135x135_l110e
