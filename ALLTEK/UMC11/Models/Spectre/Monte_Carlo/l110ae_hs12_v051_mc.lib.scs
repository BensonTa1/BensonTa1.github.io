//
simulator lang=spectre insensitive=yes
library mylib

section tt
parameters dtox_n_12_hsl110e_t=0.0000000e+000
parameters dxl_n_12_hsl110e_t=0.0000000e+000
parameters du0_n_12_hsl110e_t=0.0000000e+000
parameters dvth0_n_12_hsl110e_t=0.0000000e+000
parameters drdsw_n_12_hsl110e_t=0.0000000e+000
parameters dxw_n_12_hsl110e_t=0.0000000e+000
parameters dnlx_n_12_hsl110e_t=0.0000000e+000
parameters dk3_n_12_hsl110e_t=0.0000000e+000
parameters dpvth0_n_12_hsl110e_t=0.0000000e+000
parameters dwwl_n_12_hsl110e_t=0.0000000e+000
parameters dags_n_12_hsl110e_t=0.0000000e+000
parameters dcgdo_n_12_hsl110e_t=0.0000000e+000
parameters dcgso_n_12_hsl110e_t=0.0000000e+000
parameters dcj_n_12_hsl110e_t=0.0000000e+000
parameters dcjsw_n_12_hsl110e_t=0.0000000e+000
parameters dcjswg_n_12_hsl110e_t=0.0000000e+000
parameters dvsat_n_12_hsl110e_t=0.0000000e+000
parameters dwags_n_12_hsl110e_t=0.0000000e+000
parameters dpvsat_n_12_hsl110e_t=0.0000000e+000
parameters dtox_p_12_hsl110e_t=0.0000000e+000
parameters dxl_p_12_hsl110e_t=0.0000000e+000
parameters du0_p_12_hsl110e_t=0.0000000e+000
parameters dvth0_p_12_hsl110e_t=0.0000000e+000
parameters drdsw_p_12_hsl110e_t=0.0000000e+000
parameters dxw_p_12_hsl110e_t=0.0000000e+000
parameters dnlx_p_12_hsl110e_t=0.0000000e+000
parameters dk3_p_12_hsl110e_t=0.0000000e+000
parameters dpvth0_p_12_hsl110e_t=0.0000000e+000
parameters dwwl_p_12_hsl110e_t=0.0000000e+000
parameters dags_p_12_hsl110e_t=0.0000000e+000
parameters dcgdo_p_12_hsl110e_t=0.0000000e+000
parameters dcgso_p_12_hsl110e_t=0.0000000e+000
parameters dcj_p_12_hsl110e_t=0.0000000e+000
parameters dcjsw_p_12_hsl110e_t=0.0000000e+000
parameters dcjswg_p_12_hsl110e_t=0.0000000e+000
parameters dvsat_p_12_hsl110e_t=0.0000000e+000
parameters dwags_p_12_hsl110e_t=0.0000000e+000
parameters dpvsat_p_12_hsl110e_t=0.0000000e+000
parameters dpags_p_12_hsl110e_t=0.0000000e+000
//

endsection tt
//
section ff
parameters dtox_n_12_hsl110e_t=-5.2800000e-011
parameters dxl_n_12_hsl110e_t=-0.5600000e-009
parameters du0_n_12_hsl110e_t=1.2000000e-003
parameters dvth0_n_12_hsl110e_t=-3.1600000e-002
parameters drdsw_n_12_hsl110e_t=-8.8000000e+000
parameters dxw_n_12_hsl110e_t=1.2180000e-008
parameters dnlx_n_12_hsl110e_t=-2.4200000e-008
parameters dk3_n_12_hsl110e_t=-2.8300000e+000
parameters dpvth0_n_12_hsl110e_t=-7.4500000e-016
parameters dwwl_n_12_hsl110e_t=5.4800000e-023
parameters dags_n_12_hsl110e_t=-1.0550000e-001
parameters dcgdo_n_12_hsl110e_t=1.9000000e-011
parameters dcgso_n_12_hsl110e_t=1.9000000e-011
parameters dcj_n_12_hsl110e_t=-7.2000000e-005
parameters dcjsw_n_12_hsl110e_t=-9.9400000e-012
parameters dcjswg_n_12_hsl110e_t=-3.0300000e-011
parameters dvsat_n_12_hsl110e_t=-0.1520000e+003
parameters dwags_n_12_hsl110e_t=-6.8800000e-009
parameters dpvsat_n_12_hsl110e_t=1.7000000e-011
parameters dtox_p_12_hsl110e_t=-5.2800000e-011
parameters dxl_p_12_hsl110e_t=-0.7430000e-009
parameters du0_p_12_hsl110e_t=6.3300000e-004
parameters dvth0_p_12_hsl110e_t=3.0150000e-002
parameters drdsw_p_12_hsl110e_t=-4.2800000e+001
parameters dxw_p_12_hsl110e_t=5.1000000e-009
parameters dnlx_p_12_hsl110e_t=-1.2640000e-008
parameters dk3_p_12_hsl110e_t=-2.1400000e+001
parameters dpvth0_p_12_hsl110e_t=4.6800000e-016
parameters dwwl_p_12_hsl110e_t=-2.1600000e-023
parameters dags_p_12_hsl110e_t=-1.4100000e-001
parameters dcgdo_p_12_hsl110e_t=2.0000000e-011
parameters dcgso_p_12_hsl110e_t=2.0000000e-011
parameters dcj_p_12_hsl110e_t=-9.6900000e-005
parameters dcjsw_p_12_hsl110e_t=-1.1800000e-011
parameters dcjswg_p_12_hsl110e_t=-4.8200000e-011
parameters dvsat_p_12_hsl110e_t=-7.8400000e+003
parameters dwags_p_12_hsl110e_t=-1.0790000e-008
parameters dpvsat_p_12_hsl110e_t=-4.2750000e-010
parameters dpags_p_12_hsl110e_t=0.0000000e+000
//

endsection ff
//
section ss
parameters dtox_n_12_hsl110e_t=5.2800000e-011
parameters dxl_n_12_hsl110e_t=2.3200000e-009
parameters du0_n_12_hsl110e_t=-1.4880000e-003
parameters dvth0_n_12_hsl110e_t=3.1150000e-002
parameters drdsw_n_12_hsl110e_t=9.4700000e+000
parameters dxw_n_12_hsl110e_t=-1.8400000e-008
parameters dnlx_n_12_hsl110e_t=2.5000000e-008
parameters dk3_n_12_hsl110e_t=2.3500000e+000
parameters dpvth0_n_12_hsl110e_t=8.5400000e-016
parameters dwwl_n_12_hsl110e_t=-2.4100000e-023
parameters dags_n_12_hsl110e_t=1.0920000e-001
parameters dcgdo_n_12_hsl110e_t=-1.9000000e-011
parameters dcgso_n_12_hsl110e_t=-1.9000000e-011
parameters dcj_n_12_hsl110e_t=7.2000000e-005
parameters dcjsw_n_12_hsl110e_t=9.9400000e-012
parameters dcjswg_n_12_hsl110e_t=3.0300000e-011
parameters dvsat_n_12_hsl110e_t=0.6500000e+003
parameters dwags_n_12_hsl110e_t=6.3200000e-009
parameters dpvsat_n_12_hsl110e_t=4.8400000e-011
parameters dtox_p_12_hsl110e_t=5.2800000e-011
parameters dxl_p_12_hsl110e_t=3.6800000e-009
parameters du0_p_12_hsl110e_t=-7.6400000e-004
parameters dvth0_p_12_hsl110e_t=-2.9300000e-002
parameters drdsw_p_12_hsl110e_t=4.2800000e+001
parameters dxw_p_12_hsl110e_t=-2.2000000e-008
parameters dnlx_p_12_hsl110e_t=1.2960000e-008
parameters dk3_p_12_hsl110e_t=2.0200000e+001
parameters dpvth0_p_12_hsl110e_t=-5.3900000e-016
parameters dwwl_p_12_hsl110e_t=3.3400000e-023
parameters dags_p_12_hsl110e_t=1.4680000e-001
parameters dcgdo_p_12_hsl110e_t=-2.0000000e-011
parameters dcgso_p_12_hsl110e_t=-2.0000000e-011
parameters dcj_p_12_hsl110e_t=9.6900000e-005
parameters dcjsw_p_12_hsl110e_t=1.1800000e-011
parameters dcjswg_p_12_hsl110e_t=4.8200000e-011
parameters dvsat_p_12_hsl110e_t=2.9100000e+004
parameters dwags_p_12_hsl110e_t=0.3750000e-008
parameters dpvsat_p_12_hsl110e_t=0.0000000e+000
parameters dpags_p_12_hsl110e_t=5.4100000e-014
//

endsection ss
//
section fnsp
parameters dtox_n_12_hsl110e_t=0.0000000e+000
parameters dxl_n_12_hsl110e_t=-1.1500000e-009
parameters du0_n_12_hsl110e_t=0.7980000e-003
parameters dvth0_n_12_hsl110e_t=-1.8800000e-002
parameters drdsw_n_12_hsl110e_t=-2.6000000e+000
parameters dxw_n_12_hsl110e_t=0.6680000e-008
parameters dnlx_n_12_hsl110e_t=-1.5050000e-008
parameters dk3_n_12_hsl110e_t=-1.3320000e+000
parameters dpvth0_n_12_hsl110e_t=-3.6800000e-016
parameters dwwl_n_12_hsl110e_t=1.6700000e-023
parameters dags_n_12_hsl110e_t=-0.5070000e-001
parameters dcgdo_n_12_hsl110e_t=0.0000000e+000
parameters dcgso_n_12_hsl110e_t=0.0000000e+000
parameters dcj_n_12_hsl110e_t=-7.2000000e-005
parameters dcjsw_n_12_hsl110e_t=-9.9400000e-012
parameters dcjswg_n_12_hsl110e_t=-3.0300000e-011
parameters dvsat_n_12_hsl110e_t=0.4200000e+003
parameters dwags_n_12_hsl110e_t=-3.5200000e-009
parameters dpvsat_n_12_hsl110e_t=-0.3200000e-011
parameters dtox_p_12_hsl110e_t=0.0000000e+000
parameters dxl_p_12_hsl110e_t=1.3300000e-009
parameters du0_p_12_hsl110e_t=-4.2000000e-004
parameters dvth0_p_12_hsl110e_t=-1.8450000e-002
parameters drdsw_p_12_hsl110e_t=2.1400000e+001
parameters dxw_p_12_hsl110e_t=-0.7200000e-008
parameters dnlx_p_12_hsl110e_t=0.6750000e-008
parameters dk3_p_12_hsl110e_t=1.0400000e+001
parameters dpvth0_p_12_hsl110e_t=-2.5600000e-016
parameters dwwl_p_12_hsl110e_t=0.9900000e-023
parameters dags_p_12_hsl110e_t=0.6960000e-001
parameters dcgdo_p_12_hsl110e_t=0.0000000e+000
parameters dcgso_p_12_hsl110e_t=0.0000000e+000
parameters dcj_p_12_hsl110e_t=9.6900000e-005
parameters dcjsw_p_12_hsl110e_t=1.1800000e-011
parameters dcjswg_p_12_hsl110e_t=4.8200000e-011
parameters dvsat_p_12_hsl110e_t=0.8600000e+004
parameters dwags_p_12_hsl110e_t=0.3380000e-008
parameters dpvsat_p_12_hsl110e_t=0.0000000e+000
parameters dpags_p_12_hsl110e_t=2.4500000e-014
//

endsection fnsp
//
section snfp
parameters dtox_n_12_hsl110e_t=0.0000000e+000
parameters dxl_n_12_hsl110e_t=1.1500000e-009
parameters du0_n_12_hsl110e_t=-0.8820000e-003
parameters dvth0_n_12_hsl110e_t=1.8200000e-002
parameters drdsw_n_12_hsl110e_t=3.5400000e+000
parameters dxw_n_12_hsl110e_t=-0.8050000e-008
parameters dnlx_n_12_hsl110e_t=1.5800000e-008
parameters dk3_n_12_hsl110e_t=1.2900000e+000
parameters dpvth0_n_12_hsl110e_t=3.9700000e-016
parameters dwwl_n_12_hsl110e_t=-1.3400000e-023
parameters dags_n_12_hsl110e_t=0.5110000e-001
parameters dcgdo_n_12_hsl110e_t=0.0000000e+000
parameters dcgso_n_12_hsl110e_t=0.0000000e+000
parameters dcj_n_12_hsl110e_t=7.2000000e-005
parameters dcjsw_n_12_hsl110e_t=9.9400000e-012
parameters dcjswg_n_12_hsl110e_t=3.0300000e-011
parameters dvsat_n_12_hsl110e_t=-0.7500000e+003
parameters dwags_n_12_hsl110e_t=3.6200000e-009
parameters dpvsat_n_12_hsl110e_t=1.8500000e-011
parameters dtox_p_12_hsl110e_t=0.0000000e+000
parameters dxl_p_12_hsl110e_t=-0.6350000e-009
parameters du0_p_12_hsl110e_t=3.8850000e-004
parameters dvth0_p_12_hsl110e_t=1.8900000e-002
parameters drdsw_p_12_hsl110e_t=-2.1400000e+001
parameters dxw_p_12_hsl110e_t=3.3400000e-009
parameters dnlx_p_12_hsl110e_t=-0.6480000e-008
parameters dk3_p_12_hsl110e_t=-1.0350000e+001
parameters dpvth0_p_12_hsl110e_t=2.4000000e-016
parameters dwwl_p_12_hsl110e_t=-1.1800000e-023
parameters dags_p_12_hsl110e_t=-0.6790000e-001
parameters dcgdo_p_12_hsl110e_t=0.0000000e+000
parameters dcgso_p_12_hsl110e_t=0.0000000e+000
parameters dcj_p_12_hsl110e_t=-9.6900000e-005
parameters dcjsw_p_12_hsl110e_t=-1.1800000e-011
parameters dcjswg_p_12_hsl110e_t=-4.8200000e-011
parameters dvsat_p_12_hsl110e_t=-4.1600000e+003
parameters dwags_p_12_hsl110e_t=-0.5210000e-008
parameters dpvsat_p_12_hsl110e_t=-3.2000000e-010
parameters dpags_p_12_hsl110e_t=0.0000000e+000
//

endsection snfp
//
section tt_g
parameters dtox_n_12_hsl110e_g=0.0000000e+000
parameters dxl_n_12_hsl110e_g=0.0000000e+000
parameters du0_n_12_hsl110e_g=0.0000000e+000
parameters dvth0_n_12_hsl110e_g=0.0000000e+000
parameters drdsw_n_12_hsl110e_g=0.0000000e+000
parameters dxw_n_12_hsl110e_g=0.0000000e+000
parameters dnlx_n_12_hsl110e_g=0.0000000e+000
parameters dk3_n_12_hsl110e_g=0.0000000e+000
parameters dpvth0_n_12_hsl110e_g=0.0000000e+000
parameters dwwl_n_12_hsl110e_g=0.0000000e+000
parameters dags_n_12_hsl110e_g=0.0000000e+000
parameters dcgdo_n_12_hsl110e_g=0.0000000e+000
parameters dcgso_n_12_hsl110e_g=0.0000000e+000
parameters dcj_n_12_hsl110e_g=0.0000000e+000
parameters dcjsw_n_12_hsl110e_g=0.0000000e+000
parameters dcjswg_n_12_hsl110e_g=0.0000000e+000
parameters dvsat_n_12_hsl110e_g=0.0000000e+000
parameters dwags_n_12_hsl110e_g=0.0000000e+000
parameters dpvsat_n_12_hsl110e_g=0.0000000e+000
parameters dtox_p_12_hsl110e_g=0.0000000e+000
parameters dxl_p_12_hsl110e_g=0.0000000e+000
parameters du0_p_12_hsl110e_g=0.0000000e+000
parameters dvth0_p_12_hsl110e_g=0.0000000e+000
parameters drdsw_p_12_hsl110e_g=0.0000000e+000
parameters dxw_p_12_hsl110e_g=0.0000000e+000
parameters dnlx_p_12_hsl110e_g=0.0000000e+000
parameters dk3_p_12_hsl110e_g=0.0000000e+000
parameters dpvth0_p_12_hsl110e_g=0.0000000e+000
parameters dwwl_p_12_hsl110e_g=0.0000000e+000
parameters dags_p_12_hsl110e_g=0.0000000e+000
parameters dcgdo_p_12_hsl110e_g=0.0000000e+000
parameters dcgso_p_12_hsl110e_g=0.0000000e+000
parameters dcj_p_12_hsl110e_g=0.0000000e+000
parameters dcjsw_p_12_hsl110e_g=0.0000000e+000
parameters dcjswg_p_12_hsl110e_g=0.0000000e+000
parameters dvsat_p_12_hsl110e_g=0.0000000e+000
parameters dwags_p_12_hsl110e_g=0.0000000e+000
parameters dpvsat_p_12_hsl110e_g=0.0000000e+000
parameters dpags_p_12_hsl110e_g=0.0000000e+000
//

endsection tt_g
//
section ff_g
parameters dtox_n_12_hsl110e_g=-5.2800000e-011
parameters dxl_n_12_hsl110e_g=-0.5600000e-009
parameters du0_n_12_hsl110e_g=1.2000000e-003
parameters dvth0_n_12_hsl110e_g=-3.1600000e-002
parameters drdsw_n_12_hsl110e_g=-8.8000000e+000
parameters dxw_n_12_hsl110e_g=1.2230000e-008
parameters dnlx_n_12_hsl110e_g=-2.4200000e-008
parameters dk3_n_12_hsl110e_g=-2.8200000e+000
parameters dpvth0_n_12_hsl110e_g=-7.0000000e-016
parameters dwwl_n_12_hsl110e_g=5.4800000e-023
parameters dags_n_12_hsl110e_g=-1.0550000e-001
parameters dcgdo_n_12_hsl110e_g=1.9000000e-011
parameters dcgso_n_12_hsl110e_g=1.9000000e-011
parameters dcj_n_12_hsl110e_g=-7.2000000e-005
parameters dcjsw_n_12_hsl110e_g=-9.9400000e-012
parameters dcjswg_n_12_hsl110e_g=-3.0300000e-011
parameters dvsat_n_12_hsl110e_g=-0.1520000e+003
parameters dwags_n_12_hsl110e_g=-6.8800000e-009
parameters dpvsat_n_12_hsl110e_g=2.3000000e-011
parameters dtox_p_12_hsl110e_g=-5.2800000e-011
parameters dxl_p_12_hsl110e_g=-0.7430000e-009
parameters du0_p_12_hsl110e_g=6.3300000e-004
parameters dvth0_p_12_hsl110e_g=3.0150000e-002
parameters drdsw_p_12_hsl110e_g=-4.2800000e+001
parameters dxw_p_12_hsl110e_g=5.1000000e-009
parameters dnlx_p_12_hsl110e_g=-1.2640000e-008
parameters dk3_p_12_hsl110e_g=-2.1400000e+001
parameters dpvth0_p_12_hsl110e_g=4.4600000e-016
parameters dwwl_p_12_hsl110e_g=-2.1600000e-023
parameters dags_p_12_hsl110e_g=-1.4100000e-001
parameters dcgdo_p_12_hsl110e_g=2.0000000e-011
parameters dcgso_p_12_hsl110e_g=2.0000000e-011
parameters dcj_p_12_hsl110e_g=-9.6900000e-005
parameters dcjsw_p_12_hsl110e_g=-1.1800000e-011
parameters dcjswg_p_12_hsl110e_g=-4.8200000e-011
parameters dvsat_p_12_hsl110e_g=-7.8400000e+003
parameters dwags_p_12_hsl110e_g=-1.0790000e-008
parameters dpvsat_p_12_hsl110e_g=-4.2200000e-010
parameters dpags_p_12_hsl110e_g=0.0000000e+000
//

endsection ff_g
//
section ss_g
parameters dtox_n_12_hsl110e_g=5.2800000e-011
parameters dxl_n_12_hsl110e_g=2.3200000e-009
parameters du0_n_12_hsl110e_g=-1.4880000e-003
parameters dvth0_n_12_hsl110e_g=3.1150000e-002
parameters drdsw_n_12_hsl110e_g=9.4700000e+000
parameters dxw_n_12_hsl110e_g=-1.8400000e-008
parameters dnlx_n_12_hsl110e_g=2.5000000e-008
parameters dk3_n_12_hsl110e_g=2.3500000e+000
parameters dpvth0_n_12_hsl110e_g=8.0100000e-016
parameters dwwl_n_12_hsl110e_g=-2.4100000e-023
parameters dags_n_12_hsl110e_g=1.0920000e-001
parameters dcgdo_n_12_hsl110e_g=-1.9000000e-011
parameters dcgso_n_12_hsl110e_g=-1.9000000e-011
parameters dcj_n_12_hsl110e_g=7.2000000e-005
parameters dcjsw_n_12_hsl110e_g=9.9400000e-012
parameters dcjswg_n_12_hsl110e_g=3.0300000e-011
parameters dvsat_n_12_hsl110e_g=0.6500000e+003
parameters dwags_n_12_hsl110e_g=6.3200000e-009
parameters dpvsat_n_12_hsl110e_g=3.6400000e-011
parameters dtox_p_12_hsl110e_g=5.2800000e-011
parameters dxl_p_12_hsl110e_g=3.6800000e-009
parameters du0_p_12_hsl110e_g=-7.6400000e-004
parameters dvth0_p_12_hsl110e_g=-2.9300000e-002
parameters drdsw_p_12_hsl110e_g=4.2800000e+001
parameters dxw_p_12_hsl110e_g=-2.2000000e-008
parameters dnlx_p_12_hsl110e_g=1.2960000e-008
parameters dk3_p_12_hsl110e_g=2.0200000e+001
parameters dpvth0_p_12_hsl110e_g=-5.1900000e-016
parameters dwwl_p_12_hsl110e_g=3.3400000e-023
parameters dags_p_12_hsl110e_g=1.4680000e-001
parameters dcgdo_p_12_hsl110e_g=-2.0000000e-011
parameters dcgso_p_12_hsl110e_g=-2.0000000e-011
parameters dcj_p_12_hsl110e_g=9.6900000e-005
parameters dcjsw_p_12_hsl110e_g=1.1800000e-011
parameters dcjswg_p_12_hsl110e_g=4.8200000e-011
parameters dvsat_p_12_hsl110e_g=2.9100000e+004
parameters dwags_p_12_hsl110e_g=0.3750000e-008
parameters dpvsat_p_12_hsl110e_g=-1.2100000e-011
parameters dpags_p_12_hsl110e_g=5.4100000e-014
//

endsection ss_g
//
section fnsp_g
parameters dtox_n_12_hsl110e_g=0.0000000e+000
parameters dxl_n_12_hsl110e_g=-1.1500000e-009
parameters du0_n_12_hsl110e_g=0.7980000e-003
parameters dvth0_n_12_hsl110e_g=-1.8800000e-002
parameters drdsw_n_12_hsl110e_g=-2.6000000e+000
parameters dxw_n_12_hsl110e_g=0.6680000e-008
parameters dnlx_n_12_hsl110e_g=-1.5050000e-008
parameters dk3_n_12_hsl110e_g=-1.3320000e+000
parameters dpvth0_n_12_hsl110e_g=-2.6300000e-016
parameters dwwl_n_12_hsl110e_g=1.6700000e-023
parameters dags_n_12_hsl110e_g=-0.5070000e-001
parameters dcgdo_n_12_hsl110e_g=0.0000000e+000
parameters dcgso_n_12_hsl110e_g=0.0000000e+000
parameters dcj_n_12_hsl110e_g=-7.2000000e-005
parameters dcjsw_n_12_hsl110e_g=-9.9400000e-012
parameters dcjswg_n_12_hsl110e_g=-3.0300000e-011
parameters dvsat_n_12_hsl110e_g=0.4200000e+003
parameters dwags_n_12_hsl110e_g=-3.5200000e-009
parameters dpvsat_n_12_hsl110e_g=1.7200000e-011
parameters dtox_p_12_hsl110e_g=0.0000000e+000
parameters dxl_p_12_hsl110e_g=1.3300000e-009
parameters du0_p_12_hsl110e_g=-4.2000000e-004
parameters dvth0_p_12_hsl110e_g=-1.8450000e-002
parameters drdsw_p_12_hsl110e_g=2.1400000e+001
parameters dxw_p_12_hsl110e_g=-0.7200000e-008
parameters dnlx_p_12_hsl110e_g=0.6750000e-008
parameters dk3_p_12_hsl110e_g=1.0400000e+001
parameters dpvth0_p_12_hsl110e_g=-2.2100000e-016
parameters dwwl_p_12_hsl110e_g=0.9900000e-023
parameters dags_p_12_hsl110e_g=0.6960000e-001
parameters dcgdo_p_12_hsl110e_g=0.0000000e+000
parameters dcgso_p_12_hsl110e_g=0.0000000e+000
parameters dcj_p_12_hsl110e_g=9.6900000e-005
parameters dcjsw_p_12_hsl110e_g=1.1800000e-011
parameters dcjswg_p_12_hsl110e_g=4.8200000e-011
parameters dvsat_p_12_hsl110e_g=0.8600000e+004
parameters dwags_p_12_hsl110e_g=0.3380000e-008
parameters dpvsat_p_12_hsl110e_g=-1.0000000e-011
parameters dpags_p_12_hsl110e_g=2.4500000e-014
//

endsection fnsp_g
//
section snfp_g
parameters dtox_n_12_hsl110e_g=0.0000000e+000
parameters dxl_n_12_hsl110e_g=1.1500000e-009
parameters du0_n_12_hsl110e_g=-0.8820000e-003
parameters dvth0_n_12_hsl110e_g=1.8200000e-002
parameters drdsw_n_12_hsl110e_g=3.5400000e+000
parameters dxw_n_12_hsl110e_g=-0.8050000e-008
parameters dnlx_n_12_hsl110e_g=1.5800000e-008
parameters dk3_n_12_hsl110e_g=1.2900000e+000
parameters dpvth0_n_12_hsl110e_g=2.9700000e-016
parameters dwwl_n_12_hsl110e_g=-1.3400000e-023
parameters dags_n_12_hsl110e_g=0.5110000e-001
parameters dcgdo_n_12_hsl110e_g=0.0000000e+000
parameters dcgso_n_12_hsl110e_g=0.0000000e+000
parameters dcj_n_12_hsl110e_g=7.2000000e-005
parameters dcjsw_n_12_hsl110e_g=9.9400000e-012
parameters dcjswg_n_12_hsl110e_g=3.0300000e-011
parameters dvsat_n_12_hsl110e_g=-0.7500000e+003
parameters dwags_n_12_hsl110e_g=3.6200000e-009
parameters dpvsat_n_12_hsl110e_g=-0.200000e-011
parameters dtox_p_12_hsl110e_g=0.0000000e+000
parameters dxl_p_12_hsl110e_g=-0.6350000e-009
parameters du0_p_12_hsl110e_g=3.8850000e-004
parameters dvth0_p_12_hsl110e_g=1.8900000e-002
parameters drdsw_p_12_hsl110e_g=-2.1400000e+001
parameters dxw_p_12_hsl110e_g=3.3400000e-009
parameters dnlx_p_12_hsl110e_g=-0.6480000e-008
parameters dk3_p_12_hsl110e_g=-1.0350000e+001
parameters dpvth0_p_12_hsl110e_g=2.0600000e-016
parameters dwwl_p_12_hsl110e_g=-1.1800000e-023
parameters dags_p_12_hsl110e_g=-0.6790000e-001
parameters dcgdo_p_12_hsl110e_g=0.0000000e+000
parameters dcgso_p_12_hsl110e_g=0.0000000e+000
parameters dcj_p_12_hsl110e_g=-9.6900000e-005
parameters dcjsw_p_12_hsl110e_g=-1.1800000e-011
parameters dcjswg_p_12_hsl110e_g=-4.8200000e-011
parameters dvsat_p_12_hsl110e_g=-4.1600000e+003
parameters dwags_p_12_hsl110e_g=-0.5210000e-008
parameters dpvsat_p_12_hsl110e_g=-3.1350000e-010
parameters dpags_p_12_hsl110e_g=0.0000000e+000
//

endsection snfp_g

//
section tt_tn
parameters dtox_n_12_hsl110e=0.0000000e+000
parameters dxl_n_12_hsl110e=0.0000000e+000
parameters du0_n_12_hsl110e=0.0000000e+000
parameters dvth0_n_12_hsl110e=0.0000000e+000
parameters drdsw_n_12_hsl110e=0.0000000e+000
parameters dxw_n_12_hsl110e=0.0000000e+000
parameters dnlx_n_12_hsl110e=0.0000000e+000
parameters dk3_n_12_hsl110e=0.0000000e+000
parameters dpvth0_n_12_hsl110e=0.0000000e+000
parameters dwwl_n_12_hsl110e=0.0000000e+000
parameters dags_n_12_hsl110e=0.0000000e+000
parameters dcgdo_n_12_hsl110e=0.0000000e+000
parameters dcgso_n_12_hsl110e=0.0000000e+000
parameters dcj_n_12_hsl110e=0.0000000e+000
parameters dcjsw_n_12_hsl110e=0.0000000e+000
parameters dcjswg_n_12_hsl110e=0.0000000e+000
parameters dvsat_n_12_hsl110e=0.0000000e+000
parameters dwags_n_12_hsl110e=0.0000000e+000
parameters dpvsat_n_12_hsl110e=0.0000000e+000
parameters dtox_p_12_hsl110e=0.0000000e+000
parameters dxl_p_12_hsl110e=0.0000000e+000
parameters du0_p_12_hsl110e=0.0000000e+000
parameters dvth0_p_12_hsl110e=0.0000000e+000
parameters drdsw_p_12_hsl110e=0.0000000e+000
parameters dxw_p_12_hsl110e=0.0000000e+000
parameters dnlx_p_12_hsl110e=0.0000000e+000
parameters dk3_p_12_hsl110e=0.0000000e+000
parameters dpvth0_p_12_hsl110e=0.0000000e+000
parameters dwwl_p_12_hsl110e=0.0000000e+000
parameters dags_p_12_hsl110e=0.0000000e+000
parameters dcgdo_p_12_hsl110e=0.0000000e+000
parameters dcgso_p_12_hsl110e=0.0000000e+000
parameters dcj_p_12_hsl110e=0.0000000e+000
parameters dcjsw_p_12_hsl110e=0.0000000e+000
parameters dcjswg_p_12_hsl110e=0.0000000e+000
parameters dvsat_p_12_hsl110e=0.0000000e+000
parameters dwags_p_12_hsl110e=0.0000000e+000
parameters dpvsat_p_12_hsl110e=0.0000000e+000
parameters dpags_p_12_hsl110e=0.0000000e+000
//
endsection tt_tn
//
section ff_tn
parameters dtox_n_12_hsl110e=-5.2800000e-011
parameters dxl_n_12_hsl110e=-0.5600000e-009
parameters du0_n_12_hsl110e=1.2000000e-003
parameters dvth0_n_12_hsl110e=-3.1600000e-002
parameters drdsw_n_12_hsl110e=-8.8000000e+000
parameters dxw_n_12_hsl110e=1.2180000e-008
parameters dnlx_n_12_hsl110e=-2.4200000e-008
parameters dk3_n_12_hsl110e=-2.8300000e+000
parameters dpvth0_n_12_hsl110e=-7.4500000e-016
parameters dwwl_n_12_hsl110e=5.4800000e-023
parameters dags_n_12_hsl110e=-1.0550000e-001
parameters dcgdo_n_12_hsl110e=1.9000000e-011
parameters dcgso_n_12_hsl110e=1.9000000e-011
parameters dcj_n_12_hsl110e=-7.2000000e-005
parameters dcjsw_n_12_hsl110e=-9.9400000e-012
parameters dcjswg_n_12_hsl110e=-3.0300000e-011
parameters dvsat_n_12_hsl110e=-0.1520000e+003
parameters dwags_n_12_hsl110e=-6.8800000e-009
parameters dpvsat_n_12_hsl110e=1.7000000e-011
parameters dtox_p_12_hsl110e=-5.2800000e-011
parameters dxl_p_12_hsl110e=-0.7430000e-009
parameters du0_p_12_hsl110e=6.3300000e-004
parameters dvth0_p_12_hsl110e=3.0150000e-002
parameters drdsw_p_12_hsl110e=-4.2800000e+001
parameters dxw_p_12_hsl110e=5.1000000e-009
parameters dnlx_p_12_hsl110e=-1.2640000e-008
parameters dk3_p_12_hsl110e=-2.1400000e+001
parameters dpvth0_p_12_hsl110e=4.6800000e-016
parameters dwwl_p_12_hsl110e=-2.1600000e-023
parameters dags_p_12_hsl110e=-1.4100000e-001
parameters dcgdo_p_12_hsl110e=2.0000000e-011
parameters dcgso_p_12_hsl110e=2.0000000e-011
parameters dcj_p_12_hsl110e=-9.6900000e-005
parameters dcjsw_p_12_hsl110e=-1.1800000e-011
parameters dcjswg_p_12_hsl110e=-4.8200000e-011
parameters dvsat_p_12_hsl110e=-7.8400000e+003
parameters dwags_p_12_hsl110e=-1.0790000e-008
parameters dpvsat_p_12_hsl110e=-4.2750000e-010
parameters dpags_p_12_hsl110e=0.0000000e+000
endsection ff_tn
//
section ss_tn
parameters dtox_n_12_hsl110e=5.2800000e-011
parameters dxl_n_12_hsl110e=2.3200000e-009
parameters du0_n_12_hsl110e=-1.4880000e-003
parameters dvth0_n_12_hsl110e=3.1150000e-002
parameters drdsw_n_12_hsl110e=9.4700000e+000
parameters dxw_n_12_hsl110e=-1.8400000e-008
parameters dnlx_n_12_hsl110e=2.5000000e-008
parameters dk3_n_12_hsl110e=2.3500000e+000
parameters dpvth0_n_12_hsl110e=8.5400000e-016
parameters dwwl_n_12_hsl110e=-2.4100000e-023
parameters dags_n_12_hsl110e=1.0920000e-001
parameters dcgdo_n_12_hsl110e=-1.9000000e-011
parameters dcgso_n_12_hsl110e=-1.9000000e-011
parameters dcj_n_12_hsl110e=7.2000000e-005
parameters dcjsw_n_12_hsl110e=9.9400000e-012
parameters dcjswg_n_12_hsl110e=3.0300000e-011
parameters dvsat_n_12_hsl110e=0.6500000e+003
parameters dwags_n_12_hsl110e=6.3200000e-009
parameters dpvsat_n_12_hsl110e=4.8400000e-011
parameters dtox_p_12_hsl110e=5.2800000e-011
parameters dxl_p_12_hsl110e=3.6800000e-009
parameters du0_p_12_hsl110e=-7.6400000e-004
parameters dvth0_p_12_hsl110e=-2.9300000e-002
parameters drdsw_p_12_hsl110e=4.2800000e+001
parameters dxw_p_12_hsl110e=-2.2000000e-008
parameters dnlx_p_12_hsl110e=1.2960000e-008
parameters dk3_p_12_hsl110e=2.0200000e+001
parameters dpvth0_p_12_hsl110e=-5.3900000e-016
parameters dwwl_p_12_hsl110e=3.3400000e-023
parameters dags_p_12_hsl110e=1.4680000e-001
parameters dcgdo_p_12_hsl110e=-2.0000000e-011
parameters dcgso_p_12_hsl110e=-2.0000000e-011
parameters dcj_p_12_hsl110e=9.6900000e-005
parameters dcjsw_p_12_hsl110e=1.1800000e-011
parameters dcjswg_p_12_hsl110e=4.8200000e-011
parameters dvsat_p_12_hsl110e=2.9100000e+004
parameters dwags_p_12_hsl110e=0.3750000e-008
parameters dpvsat_p_12_hsl110e=0.0000000e+000
parameters dpags_p_12_hsl110e=5.4100000e-014
endsection ss_tn
//
section fnsp_tn
parameters dtox_n_12_hsl110e=0.0000000e+000
parameters dxl_n_12_hsl110e=-1.1500000e-009
parameters du0_n_12_hsl110e=0.7980000e-003
parameters dvth0_n_12_hsl110e=-1.8800000e-002
parameters drdsw_n_12_hsl110e=-2.6000000e+000
parameters dxw_n_12_hsl110e=0.6680000e-008
parameters dnlx_n_12_hsl110e=-1.5050000e-008
parameters dk3_n_12_hsl110e=-1.3320000e+000
parameters dpvth0_n_12_hsl110e=-3.6800000e-016
parameters dwwl_n_12_hsl110e=1.6700000e-023
parameters dags_n_12_hsl110e=-0.5070000e-001
parameters dcgdo_n_12_hsl110e=0.0000000e+000
parameters dcgso_n_12_hsl110e=0.0000000e+000
parameters dcj_n_12_hsl110e=-7.2000000e-005
parameters dcjsw_n_12_hsl110e=-9.9400000e-012
parameters dcjswg_n_12_hsl110e=-3.0300000e-011
parameters dvsat_n_12_hsl110e=0.4200000e+003
parameters dwags_n_12_hsl110e=-3.5200000e-009
parameters dpvsat_n_12_hsl110e=-0.3200000e-011
parameters dtox_p_12_hsl110e=0.0000000e+000
parameters dxl_p_12_hsl110e=1.3300000e-009
parameters du0_p_12_hsl110e=-4.2000000e-004
parameters dvth0_p_12_hsl110e=-1.8450000e-002
parameters drdsw_p_12_hsl110e=2.1400000e+001
parameters dxw_p_12_hsl110e=-0.7200000e-008
parameters dnlx_p_12_hsl110e=0.6750000e-008
parameters dk3_p_12_hsl110e=1.0400000e+001
parameters dpvth0_p_12_hsl110e=-2.5600000e-016
parameters dwwl_p_12_hsl110e=0.9900000e-023
parameters dags_p_12_hsl110e=0.6960000e-001
parameters dcgdo_p_12_hsl110e=0.0000000e+000
parameters dcgso_p_12_hsl110e=0.0000000e+000
parameters dcj_p_12_hsl110e=9.6900000e-005
parameters dcjsw_p_12_hsl110e=1.1800000e-011
parameters dcjswg_p_12_hsl110e=4.8200000e-011
parameters dvsat_p_12_hsl110e=0.8600000e+004
parameters dwags_p_12_hsl110e=0.3380000e-008
parameters dpvsat_p_12_hsl110e=0.0000000e+000
parameters dpags_p_12_hsl110e=2.4500000e-014
endsection fnsp_tn
//
section snfp_tn
parameters dtox_n_12_hsl110e=0.0000000e+000
parameters dxl_n_12_hsl110e=1.1500000e-009
parameters du0_n_12_hsl110e=-0.8820000e-003
parameters dvth0_n_12_hsl110e=1.8200000e-002
parameters drdsw_n_12_hsl110e=3.5400000e+000
parameters dxw_n_12_hsl110e=-0.8050000e-008
parameters dnlx_n_12_hsl110e=1.5800000e-008
parameters dk3_n_12_hsl110e=1.2900000e+000
parameters dpvth0_n_12_hsl110e=3.9700000e-016
parameters dwwl_n_12_hsl110e=-1.3400000e-023
parameters dags_n_12_hsl110e=0.5110000e-001
parameters dcgdo_n_12_hsl110e=0.0000000e+000
parameters dcgso_n_12_hsl110e=0.0000000e+000
parameters dcj_n_12_hsl110e=7.2000000e-005
parameters dcjsw_n_12_hsl110e=9.9400000e-012
parameters dcjswg_n_12_hsl110e=3.0300000e-011
parameters dvsat_n_12_hsl110e=-0.7500000e+003
parameters dwags_n_12_hsl110e=3.6200000e-009
parameters dpvsat_n_12_hsl110e=1.8500000e-011
parameters dtox_p_12_hsl110e=0.0000000e+000
parameters dxl_p_12_hsl110e=-0.6350000e-009
parameters du0_p_12_hsl110e=3.8850000e-004
parameters dvth0_p_12_hsl110e=1.8900000e-002
parameters drdsw_p_12_hsl110e=-2.1400000e+001
parameters dxw_p_12_hsl110e=3.3400000e-009
parameters dnlx_p_12_hsl110e=-0.6480000e-008
parameters dk3_p_12_hsl110e=-1.0350000e+001
parameters dpvth0_p_12_hsl110e=2.4000000e-016
parameters dwwl_p_12_hsl110e=-1.1800000e-023
parameters dags_p_12_hsl110e=-0.6790000e-001
parameters dcgdo_p_12_hsl110e=0.0000000e+000
parameters dcgso_p_12_hsl110e=0.0000000e+000
parameters dcj_p_12_hsl110e=-9.6900000e-005
parameters dcjsw_p_12_hsl110e=-1.1800000e-011
parameters dcjswg_p_12_hsl110e=-4.8200000e-011
parameters dvsat_p_12_hsl110e=-4.1600000e+003
parameters dwags_p_12_hsl110e=-0.5210000e-008
parameters dpvsat_p_12_hsl110e=-3.2000000e-010
parameters dpags_p_12_hsl110e=0.0000000e+000
endsection snfp_tn

endlibrary mylib
