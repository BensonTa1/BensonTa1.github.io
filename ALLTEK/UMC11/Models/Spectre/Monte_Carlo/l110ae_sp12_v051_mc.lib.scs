//  ******************************************************************************
simulator lang=spectre insensitive=yes
//  tt:   typical n-ch mosfet and typical p-ch mosfet
//  ff:   fast n-ch mosfet and fast p-ch mosfet
//  ss:   slow n-ch mosfet and slow p-ch mosfet
//  fnsp: fast n-ch mosfet and slow p-ch mosfet
//  snfp: slow n-ch mosfet and fast p-ch mosfet
//  ******************************************************************************
//
library mylib

section tt
parameters dtox_n_12_spl110e_t=0.0000000e+000
parameters dxl_n_12_spl110e_t=0.0000000e+000
parameters du0_n_12_spl110e_t=0.0000000e+000
parameters dvth0_n_12_spl110e_t=0.0000000e+000
parameters drdsw_n_12_spl110e_t=0.0000000e+000
parameters dxw_n_12_spl110e_t=0.0000000e+000
parameters dnlx_n_12_spl110e_t=0.0000000e+000
parameters dk3_n_12_spl110e_t=0.0000000e+000
parameters dpvth0_n_12_spl110e_t=0.0000000e+000
parameters dwwl_n_12_spl110e_t=0.0000000e+000
parameters dvsat_n_12_spl110e_t=0.0000000e+000
parameters dpvsat_n_12_spl110e_t=0.0000000e+000
parameters dags_n_12_spl110e_t=0.0000000e+000
parameters dwags_n_12_spl110e_t=0.0000000e+000
parameters dpags_n_12_spl110e_t=0.0000000e+000
parameters dcj_n_12_spl110e_t=0.0000000e+000
parameters dcjsw_n_12_spl110e_t=0.0000000e+000
parameters dcjswg_n_12_spl110e_t=0.0000000e+000
parameters dcgdo_n_12_spl110e_t=0.0000000e+000
parameters dcgso_n_12_spl110e_t=0.0000000e+000
parameters dcgdl_n_12_spl110e_t=0.0000000e+000
parameters dcgsl_n_12_spl110e_t=0.0000000e+000
parameters dwu0_n_12_spl110e_t=0.0000000e+000
parameters dtox_p_12_spl110e_t=0.0000000e+000
parameters dxl_p_12_spl110e_t=0.0000000e+000
parameters du0_p_12_spl110e_t=0.0000000e+000
parameters dvth0_p_12_spl110e_t=0.0000000e+000
parameters drdsw_p_12_spl110e_t=0.0000000e+000
parameters dxw_p_12_spl110e_t=0.0000000e+000
parameters dnlx_p_12_spl110e_t=0.0000000e+000
parameters dk3_p_12_spl110e_t=0.0000000e+000
parameters dpvth0_p_12_spl110e_t=0.0000000e+000
parameters dwwl_p_12_spl110e_t=0.0000000e+000
parameters dvsat_p_12_spl110e_t=0.0000000e+000
parameters dpvsat_p_12_spl110e_t=0.0000000e+000
parameters dags_p_12_spl110e_t=0.0000000e+000
parameters dwags_p_12_spl110e_t=0.0000000e+000
parameters dpags_p_12_spl110e_t=0.0000000e+000
parameters dcj_p_12_spl110e_t=0.0000000e+000
parameters dcjsw_p_12_spl110e_t=0.0000000e+000
parameters dcjswg_p_12_spl110e_t=0.0000000e+000
parameters dcgdo_p_12_spl110e_t=0.0000000e+000
parameters dcgso_p_12_spl110e_t=0.0000000e+000
parameters dcgdl_p_12_spl110e_t=0.0000000e+000
parameters dcgsl_p_12_spl110e_t=0.0000000e+000
parameters dwu0_p_12_spl110e_t=0.0000000e+000
parameters dlags_p_12_spl110e_t=0.0000000e+000
//
endsection tt
//
section ff
parameters dtox_n_12_spl110e_t=-5.2800000e-011
parameters dxl_n_12_spl110e_t=-0.7400000e-009
parameters du0_n_12_spl110e_t=1.7660000e-003
parameters dvth0_n_12_spl110e_t=-3.0000000e-002
parameters drdsw_n_12_spl110e_t=-2.9600000e+000
parameters dxw_n_12_spl110e_t=1.2730000e-008
parameters dnlx_n_12_spl110e_t=-1.4160000e-008
parameters dk3_n_12_spl110e_t=-2.0950000e+000
parameters dpvth0_n_12_spl110e_t=-1.6650000e-015
parameters dwwl_n_12_spl110e_t=0.9830000e-022
parameters dvsat_n_12_spl110e_t=1.4700000e+003
parameters dpvsat_n_12_spl110e_t=-3.1350000e-010
parameters dags_n_12_spl110e_t=-1.0520000e-001
parameters dwags_n_12_spl110e_t=-5.0500000e-009
parameters dpags_n_12_spl110e_t=0.0000000e+000
parameters dcj_n_12_spl110e_t=-7.2000000e-005
parameters dcjsw_n_12_spl110e_t=-9.9400000e-012
parameters dcjswg_n_12_spl110e_t=-3.7600000e-011
parameters dcgdo_n_12_spl110e_t=2.6459000e-011
parameters dcgso_n_12_spl110e_t=2.6459000e-011
parameters dcgdl_n_12_spl110e_t=5.8000000e-012
parameters dcgsl_n_12_spl110e_t=5.8000000e-012
parameters dwu0_n_12_spl110e_t=0.0000000e+000
parameters dtox_p_12_spl110e_t=-5.6800000e-011
parameters dxl_p_12_spl110e_t=-1.8200000e-009
parameters du0_p_12_spl110e_t=3.7100000e-004
parameters dvth0_p_12_spl110e_t=2.6500000e-002
parameters drdsw_p_12_spl110e_t=-5.1200000e+001
parameters dxw_p_12_spl110e_t=1.6650000e-008
parameters dnlx_p_12_spl110e_t=-6.0000000e-009
parameters dk3_p_12_spl110e_t=-4.1500000e+000
parameters dpvth0_p_12_spl110e_t=2.7500000e-015
parameters dwwl_p_12_spl110e_t=3.2300000e-023
parameters dvsat_p_12_spl110e_t=-0.8000000e+004
parameters dpvsat_p_12_spl110e_t=1.1300000e-009
parameters dags_p_12_spl110e_t=-1.4420000e-001
parameters dwags_p_12_spl110e_t=-0.9920000e-008
parameters dpags_p_12_spl110e_t=-2.6550000e-014
parameters dcj_p_12_spl110e_t=-9.6900000e-005
parameters dcjsw_p_12_spl110e_t=-1.1800000e-011
parameters dcjswg_p_12_spl110e_t=-5.4300000e-011
parameters dcgdo_p_12_spl110e_t=1.7500000e-011
parameters dcgso_p_12_spl110e_t=1.7500000e-011
parameters dcgdl_p_12_spl110e_t=6.0980000e-012
parameters dcgsl_p_12_spl110e_t=6.0980000e-012
parameters dwu0_p_12_spl110e_t=0.0000000e+000
parameters dlags_p_12_spl110e_t=-1.5780000e-007
//
endsection ff
//
section ss
parameters dtox_n_12_spl110e_t=5.2800000e-011
parameters dxl_n_12_spl110e_t=3.4500000e-009
parameters du0_n_12_spl110e_t=-2.1300000e-003
parameters dvth0_n_12_spl110e_t=2.9600000e-002
parameters drdsw_n_12_spl110e_t=2.9600000e+000
parameters dxw_n_12_spl110e_t=-3.0000000e-008
parameters dnlx_n_12_spl110e_t=1.2080000e-008
parameters dk3_n_12_spl110e_t=1.7400000e+000
parameters dpvth0_n_12_spl110e_t=2.1100000e-015
parameters dwwl_n_12_spl110e_t=-1.2730000e-022
parameters dvsat_n_12_spl110e_t=-1.8100000e+003
parameters dpvsat_n_12_spl110e_t=5.8000000e-010
parameters dags_n_12_spl110e_t=1.1030000e-001
parameters dwags_n_12_spl110e_t=2.0300000e-009
parameters dpags_n_12_spl110e_t=3.0000000e-014
parameters dcj_n_12_spl110e_t=7.2000000e-005
parameters dcjsw_n_12_spl110e_t=9.9400000e-012
parameters dcjswg_n_12_spl110e_t=3.7600000e-011
parameters dcgdo_n_12_spl110e_t=-2.6459000e-011
parameters dcgso_n_12_spl110e_t=-2.6459000e-011
parameters dcgdl_n_12_spl110e_t=-5.8000000e-012
parameters dcgsl_n_12_spl110e_t=-5.8000000e-012
parameters dwu0_n_12_spl110e_t=-4.8300000e-011
parameters dtox_p_12_spl110e_t=5.6800000e-011
parameters dxl_p_12_spl110e_t=4.5050000e-009
parameters du0_p_12_spl110e_t=-4.5700000e-004
parameters dvth0_p_12_spl110e_t=-2.5950000e-002
parameters drdsw_p_12_spl110e_t=5.1200000e+001
parameters dxw_p_12_spl110e_t=-2.7150000e-008
parameters dnlx_p_12_spl110e_t=4.8100000e-009
parameters dk3_p_12_spl110e_t=3.5400000e+000
parameters dpvth0_p_12_spl110e_t=-3.1800000e-015
parameters dwwl_p_12_spl110e_t=2.9900000e-023
parameters dvsat_p_12_spl110e_t=1.0000000e+004
parameters dpvsat_p_12_spl110e_t=1.1500000e-010
parameters dags_p_12_spl110e_t=1.4560000e-001
parameters dwags_p_12_spl110e_t=1.1640000e-008
parameters dpags_p_12_spl110e_t=1.3000000e-014
parameters dcj_p_12_spl110e_t=9.6900000e-005
parameters dcjsw_p_12_spl110e_t=1.1800000e-011
parameters dcjswg_p_12_spl110e_t=5.4300000e-011
parameters dcgdo_p_12_spl110e_t=-1.7500000e-011
parameters dcgso_p_12_spl110e_t=-1.7500000e-011
parameters dcgdl_p_12_spl110e_t=-6.0980000e-012
parameters dcgsl_p_12_spl110e_t=-6.0980000e-012
parameters dwu0_p_12_spl110e_t=-3.0500000e-011
parameters dlags_p_12_spl110e_t=2.1930000e-007
//
endsection ss
//
section fnsp
parameters dtox_n_12_spl110e_t=0.0000000e+000
parameters dxl_n_12_spl110e_t=-0.6200000e-009
parameters du0_n_12_spl110e_t=1.0100000e-003
parameters dvth0_n_12_spl110e_t=-1.8900000e-002
parameters drdsw_n_12_spl110e_t=-1.4800000e+000
parameters dxw_n_12_spl110e_t=0.7470000e-008
parameters dnlx_n_12_spl110e_t=-0.7480000e-008
parameters dk3_n_12_spl110e_t=-0.9700000e+000
parameters dpvth0_n_12_spl110e_t=-0.8700000e-015
parameters dwwl_n_12_spl110e_t=0.4970000e-022
parameters dvsat_n_12_spl110e_t=1.7000000e+003
parameters dpvsat_n_12_spl110e_t=-2.0900000e-010
parameters dags_n_12_spl110e_t=-0.5040000e-001
parameters dwags_n_12_spl110e_t=-2.5800000e-009
parameters dpags_n_12_spl110e_t=0.0000000e+000
parameters dcj_n_12_spl110e_t=-7.2000000e-005
parameters dcjsw_n_12_spl110e_t=-9.9400000e-012
parameters dcjswg_n_12_spl110e_t=-3.7600000e-011
parameters dcgdo_n_12_spl110e_t=0.0000000e+000
parameters dcgso_n_12_spl110e_t=0.0000000e+000
parameters dcgdl_n_12_spl110e_t=0.0000000e+000
parameters dcgsl_n_12_spl110e_t=0.0000000e+000
parameters dwu0_n_12_spl110e_t=0.0000000e+000
parameters dtox_p_12_spl110e_t=0.0000000e+000
parameters dxl_p_12_spl110e_t=1.8550000e-009
parameters du0_p_12_spl110e_t=-2.6000000e-004
parameters dvth0_p_12_spl110e_t=-1.8400000e-002
parameters drdsw_p_12_spl110e_t=2.5600000e+001
parameters dxw_p_12_spl110e_t=-0.4400000e-008
parameters dnlx_p_12_spl110e_t=2.5500000e-009
parameters dk3_p_12_spl110e_t=1.8800000e+000
parameters dpvth0_p_12_spl110e_t=-1.3500000e-015
parameters dwwl_p_12_spl110e_t=6.1200000e-023
parameters dvsat_p_12_spl110e_t=0.5000000e+004
parameters dpvsat_p_12_spl110e_t=1.0500000e-011
parameters dags_p_12_spl110e_t=0.6740000e-001
parameters dwags_p_12_spl110e_t=0.6480000e-008
parameters dpags_p_12_spl110e_t=0.2500000e-014
parameters dcj_p_12_spl110e_t=9.6900000e-005
parameters dcjsw_p_12_spl110e_t=1.1800000e-011
parameters dcjswg_p_12_spl110e_t=5.4300000e-011
parameters dcgdo_p_12_spl110e_t=0.0000000e+000
parameters dcgso_p_12_spl110e_t=0.0000000e+000
parameters dcgdl_p_12_spl110e_t=0.0000000e+000
parameters dcgsl_p_12_spl110e_t=0.0000000e+000
parameters dwu0_p_12_spl110e_t=-3.0500000e-011
parameters dlags_p_12_spl110e_t=1.0260000e-007
//
endsection fnsp
//
section snfp
parameters dtox_n_12_spl110e_t=0.0000000e+000
parameters dxl_n_12_spl110e_t=1.3000000e-009
parameters du0_n_12_spl110e_t=-1.0880000e-003
parameters dvth0_n_12_spl110e_t=1.8900000e-002
parameters drdsw_n_12_spl110e_t=1.4800000e+000
parameters dxw_n_12_spl110e_t=-1.0000000e-008
parameters dnlx_n_12_spl110e_t=0.7050000e-008
parameters dk3_n_12_spl110e_t=0.9100000e+000
parameters dpvth0_n_12_spl110e_t=0.9400000e-015
parameters dwwl_n_12_spl110e_t=-0.4870000e-022
parameters dvsat_n_12_spl110e_t=-1.7300000e+003
parameters dpvsat_n_12_spl110e_t=2.2700000e-010
parameters dags_n_12_spl110e_t=0.5260000e-001
parameters dwags_n_12_spl110e_t=1.6500000e-009
parameters dpags_n_12_spl110e_t=1.0000000e-014
parameters dcj_n_12_spl110e_t=7.2000000e-005
parameters dcjsw_n_12_spl110e_t=9.9400000e-012
parameters dcjswg_n_12_spl110e_t=3.7600000e-011
parameters dcgdo_n_12_spl110e_t=0.0000000e+000
parameters dcgso_n_12_spl110e_t=0.0000000e+000
parameters dcgdl_n_12_spl110e_t=0.0000000e+000
parameters dcgsl_n_12_spl110e_t=0.0000000e+000
parameters dwu0_n_12_spl110e_t=-1.5000000e-011
parameters dtox_p_12_spl110e_t=0.0000000e+000
parameters dxl_p_12_spl110e_t=-1.2080000e-009
parameters du0_p_12_spl110e_t=2.3600000e-004
parameters dvth0_p_12_spl110e_t=1.8600000e-002
parameters drdsw_p_12_spl110e_t=-2.5600000e+001
parameters dxw_p_12_spl110e_t=0.9920000e-008
parameters dnlx_p_12_spl110e_t=-2.6800000e-009
parameters dk3_p_12_spl110e_t=-1.9100000e+000
parameters dpvth0_p_12_spl110e_t=1.3850000e-015
parameters dwwl_p_12_spl110e_t=1.8500000e-023
parameters dvsat_p_12_spl110e_t=-0.8000000e+004
parameters dpvsat_p_12_spl110e_t=1.1300000e-009
parameters dags_p_12_spl110e_t=-0.6680000e-001
parameters dwags_p_12_spl110e_t=-0.4250000e-008
parameters dpags_p_12_spl110e_t=-1.8700000e-014
parameters dcj_p_12_spl110e_t=-9.6900000e-005
parameters dcjsw_p_12_spl110e_t=-1.1800000e-011
parameters dcjswg_p_12_spl110e_t=-5.4300000e-011
parameters dcgdo_p_12_spl110e_t=0.0000000e+000
parameters dcgso_p_12_spl110e_t=0.0000000e+000
parameters dcgdl_p_12_spl110e_t=0.0000000e+000
parameters dcgsl_p_12_spl110e_t=0.0000000e+000
parameters dwu0_p_12_spl110e_t=0.0000000e+000
parameters dlags_p_12_spl110e_t=-0.8220000e-007
//
endsection snfp
//
section tt_g
parameters dtox_n_12_spl110e_g=0.0000000e+000
parameters dxl_n_12_spl110e_g=0.0000000e+000
parameters du0_n_12_spl110e_g=0.0000000e+000
parameters dvth0_n_12_spl110e_g=0.0000000e+000
parameters drdsw_n_12_spl110e_g=0.0000000e+000
parameters dxw_n_12_spl110e_g=0.0000000e+000
parameters dnlx_n_12_spl110e_g=0.0000000e+000
parameters dk3_n_12_spl110e_g=0.0000000e+000
parameters dpvth0_n_12_spl110e_g=0.0000000e+000
parameters dwwl_n_12_spl110e_g=0.0000000e+000
parameters dvsat_n_12_spl110e_g=0.0000000e+000
parameters dpvsat_n_12_spl110e_g=0.0000000e+000
parameters dags_n_12_spl110e_g=0.0000000e+000
parameters dwags_n_12_spl110e_g=0.0000000e+000
parameters dpags_n_12_spl110e_g=0.0000000e+000
parameters dcj_n_12_spl110e_g=0.0000000e+000
parameters dcjsw_n_12_spl110e_g=0.0000000e+000
parameters dcjswg_n_12_spl110e_g=0.0000000e+000
parameters dcgdo_n_12_spl110e_g=0.0000000e+000
parameters dcgso_n_12_spl110e_g=0.0000000e+000
parameters dcgdl_n_12_spl110e_g=0.0000000e+000
parameters dcgsl_n_12_spl110e_g=0.0000000e+000
parameters dwu0_n_12_spl110e_g=0.0000000e+000
parameters dtox_p_12_spl110e_g=0.0000000e+000
parameters dxl_p_12_spl110e_g=0.0000000e+000
parameters du0_p_12_spl110e_g=0.0000000e+000
parameters dvth0_p_12_spl110e_g=0.0000000e+000
parameters drdsw_p_12_spl110e_g=0.0000000e+000
parameters dxw_p_12_spl110e_g=0.0000000e+000
parameters dnlx_p_12_spl110e_g=0.0000000e+000
parameters dk3_p_12_spl110e_g=0.0000000e+000
parameters dpvth0_p_12_spl110e_g=0.0000000e+000
parameters dwwl_p_12_spl110e_g=0.0000000e+000
parameters dvsat_p_12_spl110e_g=0.0000000e+000
parameters dpvsat_p_12_spl110e_g=0.0000000e+000
parameters dags_p_12_spl110e_g=0.0000000e+000
parameters dwags_p_12_spl110e_g=0.0000000e+000
parameters dpags_p_12_spl110e_g=0.0000000e+000
parameters dcj_p_12_spl110e_g=0.0000000e+000
parameters dcjsw_p_12_spl110e_g=0.0000000e+000
parameters dcjswg_p_12_spl110e_g=0.0000000e+000
parameters dcgdo_p_12_spl110e_g=0.0000000e+000
parameters dcgso_p_12_spl110e_g=0.0000000e+000
parameters dcgdl_p_12_spl110e_g=0.0000000e+000
parameters dcgsl_p_12_spl110e_g=0.0000000e+000
parameters dwu0_p_12_spl110e_g=0.0000000e+000
parameters dlags_p_12_spl110e_g=0.0000000e+000

//
//
endsection tt_g
//
section ff_g
parameters dtox_n_12_spl110e_g=-5.2800000e-011
parameters dxl_n_12_spl110e_g=-7.4000000e-010
parameters du0_n_12_spl110e_g=1.7633723e-003
parameters dvth0_n_12_spl110e_g=-2.9994337e-002
parameters drdsw_n_12_spl110e_g=-2.9816016e+000
parameters dxw_n_12_spl110e_g=1.2696290e-008
parameters dnlx_n_12_spl110e_g=-1.4422150e-008
parameters dk3_n_12_spl110e_g=-2.1198042e+000
parameters dpvth0_n_12_spl110e_g=-1.0007682e-015
parameters dwwl_n_12_spl110e_g=9.7531905e-023
parameters dvsat_n_12_spl110e_g=1.5144894e+003
parameters dpvsat_n_12_spl110e_g=-2.6279387e-010
parameters dags_n_12_spl110e_g=-1.0509358e-001
parameters dwags_n_12_spl110e_g=-4.9199512e-009
parameters dpags_n_12_spl110e_g=0.0000000e+000
parameters dcj_n_12_spl110e_g=-7.2000000e-005
parameters dcjsw_n_12_spl110e_g=-9.9400000e-012
parameters dcjswg_n_12_spl110e_g=-3.7600000e-011
parameters dcgdo_n_12_spl110e_g=2.6459000e-011
parameters dcgso_n_12_spl110e_g=2.6459000e-011
parameters dcgdl_n_12_spl110e_g=5.8000000e-012
parameters dcgsl_n_12_spl110e_g=5.8000000e-012
parameters dwu0_n_12_spl110e_g=0.0000000e+000
parameters dtox_p_12_spl110e_g=-5.6800000e-011
parameters dxl_p_12_spl110e_g=-1.8200000e-009
parameters du0_p_12_spl110e_g=3.7182871e-004
parameters dvth0_p_12_spl110e_g=2.6651243e-002
parameters drdsw_p_12_spl110e_g=-5.2587278e+001
parameters dxw_p_12_spl110e_g=1.6528005e-008
parameters dnlx_p_12_spl110e_g=-6.1846463e-009
parameters dk3_p_12_spl110e_g=-4.1881423e+000
parameters dpvth0_p_12_spl110e_g=2.3246289e-015
parameters dwwl_p_12_spl110e_g=4.7661934e-023
parameters dvsat_p_12_spl110e_g=-8.1597272e+003
parameters dpvsat_p_12_spl110e_g=1.3214249e-009
parameters dags_p_12_spl110e_g=-1.4484006e-001
parameters dwags_p_12_spl110e_g=-1.0050649e-008
parameters dpags_p_12_spl110e_g=-2.6550000e-014
parameters dcj_p_12_spl110e_g=-9.6900000e-005
parameters dcjsw_p_12_spl110e_g=-1.1800000e-011
parameters dcjswg_p_12_spl110e_g=-5.4300000e-011
parameters dcgdo_p_12_spl110e_g=1.7500000e-011
parameters dcgso_p_12_spl110e_g=1.7500000e-011
parameters dcgdl_p_12_spl110e_g=6.0980000e-012
parameters dcgsl_p_12_spl110e_g=6.0980000e-012
parameters dwu0_p_12_spl110e_g=0.0000000e+000
parameters dlags_p_12_spl110e_g=-1.5780000e-007

//
//
endsection ff_g
//
section ss_g
parameters dtox_n_12_spl110e_g=5.2800000e-011
parameters dxl_n_12_spl110e_g=3.4500000e-009
parameters du0_n_12_spl110e_g=-2.1716064e-003
parameters dvth0_n_12_spl110e_g=2.9476631e-002
parameters drdsw_n_12_spl110e_g=2.8747048e+000
parameters dxw_n_12_spl110e_g=-4.4792120e-008
parameters dnlx_n_12_spl110e_g=1.1770263e-008
parameters dk3_n_12_spl110e_g=1.7401277e+000
parameters dpvth0_n_12_spl110e_g=1.9047371e-015
parameters dwwl_n_12_spl110e_g=-3.4464723e-022
parameters dvsat_n_12_spl110e_g=-2.3149282e+003
parameters dpvsat_n_12_spl110e_g=-5.4614942e-010
parameters dags_n_12_spl110e_g=1.1347163e-001
parameters dwags_n_12_spl110e_g=-2.5566022e-010
parameters dpags_n_12_spl110e_g=3.0000000e-014
parameters dcj_n_12_spl110e_g=7.2000000e-005
parameters dcjsw_n_12_spl110e_g=9.9400000e-012
parameters dcjswg_n_12_spl110e_g=3.7600000e-011
parameters dcgdo_n_12_spl110e_g=-2.6459000e-011
parameters dcgso_n_12_spl110e_g=-2.6459000e-011
parameters dcgdl_n_12_spl110e_g=-5.8000000e-012
parameters dcgsl_n_12_spl110e_g=-5.8000000e-012
parameters dwu0_n_12_spl110e_g=-4.8300000e-011
parameters dtox_p_12_spl110e_g=5.6800000e-011
parameters dxl_p_12_spl110e_g=4.5050000e-009
parameters du0_p_12_spl110e_g=-4.5731024e-004
parameters dvth0_p_12_spl110e_g=-2.6102330e-002
parameters drdsw_p_12_spl110e_g=5.3407918e+001
parameters dxw_p_12_spl110e_g=-2.7233920e-008
parameters dnlx_p_12_spl110e_g=5.0538364e-009
parameters dk3_p_12_spl110e_g=3.5907126e+000
parameters dpvth0_p_12_spl110e_g=-2.7718921e-015
parameters dwwl_p_12_spl110e_g=-7.0252896e-024
parameters dvsat_p_12_spl110e_g=1.2016773e+004
parameters dpvsat_p_12_spl110e_g=-9.9024276e-010
parameters dags_p_12_spl110e_g=1.4640044e-001
parameters dwags_p_12_spl110e_g=1.1786354e-008
parameters dpags_p_12_spl110e_g=1.3000000e-014
parameters dcj_p_12_spl110e_g=9.6900000e-005
parameters dcjsw_p_12_spl110e_g=1.1800000e-011
parameters dcjswg_p_12_spl110e_g=5.4300000e-011
parameters dcgdo_p_12_spl110e_g=-1.7500000e-011
parameters dcgso_p_12_spl110e_g=-1.7500000e-011
parameters dcgdl_p_12_spl110e_g=-6.0980000e-012
parameters dcgsl_p_12_spl110e_g=-6.0980000e-012
parameters dwu0_p_12_spl110e_g=-3.0500000e-011
parameters dlags_p_12_spl110e_g=2.1930000e-007

//
//
endsection ss_g
//
section fnsp_g
parameters dtox_n_12_spl110e_g=0.0000000e+000
parameters dxl_n_12_spl110e_g=-6.2000000e-010
parameters du0_n_12_spl110e_g=1.0056500e-003
parameters dvth0_n_12_spl110e_g=-1.8906885e-002
parameters drdsw_n_12_spl110e_g=-1.4855853e+000
parameters dxw_n_12_spl110e_g=7.4480153e-009
parameters dnlx_n_12_spl110e_g=-7.6421662e-009
parameters dk3_n_12_spl110e_g=-9.9185630e-001
parameters dpvth0_n_12_spl110e_g=-5.2184082e-016
parameters dwwl_n_12_spl110e_g=5.1055151e-023
parameters dvsat_n_12_spl110e_g=1.7131727e+003
parameters dpvsat_n_12_spl110e_g=-1.7077250e-010
parameters dags_n_12_spl110e_g=-5.0129047e-002
parameters dwags_n_12_spl110e_g=-2.5764684e-009
parameters dpags_n_12_spl110e_g=0.0000000e+000
parameters dcj_n_12_spl110e_g=-7.2000000e-005
parameters dcjsw_n_12_spl110e_g=-9.9400000e-012
parameters dcjswg_n_12_spl110e_g=-3.7600000e-011
parameters dcgdo_n_12_spl110e_g=0.0000000e+000
parameters dcgso_n_12_spl110e_g=0.0000000e+000
parameters dcgdl_n_12_spl110e_g=0.0000000e+000
parameters dcgsl_n_12_spl110e_g=0.0000000e+000
parameters dwu0_n_12_spl110e_g=0.0000000e+000
parameters dtox_p_12_spl110e_g=0.0000000e+000
parameters dxl_p_12_spl110e_g=1.8550000e-009
parameters du0_p_12_spl110e_g=-2.5997052e-004
parameters dvth0_p_12_spl110e_g=-1.8510339e-002
parameters drdsw_p_12_spl110e_g=2.6265358e+001
parameters dxw_p_12_spl110e_g=-4.3897181e-009
parameters dnlx_p_12_spl110e_g=2.6850358e-009
parameters dk3_p_12_spl110e_g=1.9019713e+000
parameters dpvth0_p_12_spl110e_g=-1.1188462e-015
parameters dwwl_p_12_spl110e_g=4.9289646e-023
parameters dvsat_p_12_spl110e_g=5.8398465e+003
parameters dpvsat_p_12_spl110e_g=-2.3037070e-010
parameters dags_p_12_spl110e_g=6.7935267e-002
parameters dwags_p_12_spl110e_g=6.5172958e-009
parameters dpags_p_12_spl110e_g=2.5000000e-015
parameters dcj_p_12_spl110e_g=9.6900000e-005
parameters dcjsw_p_12_spl110e_g=1.1800000e-011
parameters dcjswg_p_12_spl110e_g=5.4300000e-011
parameters dcgdo_p_12_spl110e_g=0.0000000e+000
parameters dcgso_p_12_spl110e_g=0.0000000e+000
parameters dcgdl_p_12_spl110e_g=0.0000000e+000
parameters dcgsl_p_12_spl110e_g=0.0000000e+000
parameters dwu0_p_12_spl110e_g=-3.0500000e-011
parameters dlags_p_12_spl110e_g=1.0260000e-007

//
//
endsection fnsp_g
//
section snfp_g
parameters dtox_n_12_spl110e_g=0.0000000e+000
parameters dxl_n_12_spl110e_g=1.3000000e-009
parameters du0_n_12_spl110e_g=-1.0861017e-003
parameters dvth0_n_12_spl110e_g=1.8887364e-002
parameters drdsw_n_12_spl110e_g=1.3861330e+000
parameters dxw_n_12_spl110e_g=-1.2406965e-008
parameters dnlx_n_12_spl110e_g=6.8339801e-009
parameters dk3_n_12_spl110e_g=8.7244180e-001
parameters dpvth0_n_12_spl110e_g=6.4039804e-016
parameters dwwl_n_12_spl110e_g=-1.1585026e-022
parameters dvsat_n_12_spl110e_g=-1.9112526e+003
parameters dpvsat_n_12_spl110e_g=-6.4195745e-011
parameters dags_n_12_spl110e_g=5.2797653e-002
parameters dwags_n_12_spl110e_g=2.1959511e-009
parameters dpags_n_12_spl110e_g=1.0000000e-014
parameters dcj_n_12_spl110e_g=7.2000000e-005
parameters dcjsw_n_12_spl110e_g=9.9400000e-012
parameters dcjswg_n_12_spl110e_g=3.7600000e-011
parameters dcgdo_n_12_spl110e_g=0.0000000e+000
parameters dcgso_n_12_spl110e_g=0.0000000e+000
parameters dcgdl_n_12_spl110e_g=0.0000000e+000
parameters dcgsl_n_12_spl110e_g=0.0000000e+000
parameters dwu0_n_12_spl110e_g=-1.5000000e-011
parameters dtox_p_12_spl110e_g=0.0000000e+000
parameters dxl_p_12_spl110e_g=-1.2080000e-009
parameters du0_p_12_spl110e_g=2.3693831e-004
parameters dvth0_p_12_spl110e_g=1.8647113e-002
parameters drdsw_p_12_spl110e_g=-2.5921561e+001
parameters dxw_p_12_spl110e_g=9.8287823e-009
parameters dnlx_p_12_spl110e_g=-2.8085360e-009
parameters dk3_p_12_spl110e_g=-1.9364730e+000
parameters dpvth0_p_12_spl110e_g=1.1702615e-015
parameters dwwl_p_12_spl110e_g=2.6767696e-023
parameters dvsat_p_12_spl110e_g=-8.3200372e+003
parameters dpvsat_p_12_spl110e_g=1.2594543e-009
parameters dags_p_12_spl110e_g=-6.7000936e-002
parameters dwags_p_12_spl110e_g=-4.3238801e-009
parameters dpags_p_12_spl110e_g=-1.8700000e-014
parameters dcj_p_12_spl110e_g=-9.6900000e-005
parameters dcjsw_p_12_spl110e_g=-1.1800000e-011
parameters dcjswg_p_12_spl110e_g=-5.4300000e-011
parameters dcgdo_p_12_spl110e_g=0.0000000e+000
parameters dcgso_p_12_spl110e_g=0.0000000e+000
parameters dcgdl_p_12_spl110e_g=0.0000000e+000
parameters dcgsl_p_12_spl110e_g=0.0000000e+000
parameters dwu0_p_12_spl110e_g=0.0000000e+000
parameters dlags_p_12_spl110e_g=-8.2200000e-008

//
//
endsection snfp_g
//
//
//
//
//
//

endlibrary mylib
