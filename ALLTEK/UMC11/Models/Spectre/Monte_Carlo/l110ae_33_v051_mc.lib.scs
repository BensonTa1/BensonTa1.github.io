//  *************************** start of model card ******************************
simulator lang=spectre insensitive=yes
library mylib

section tt
parameters dtox_n_33_l110e_t=0
parameters dxl_n_33_l110e_t=0
parameters du0_n_33_l110e_t=0
parameters dvth0_n_33_l110e_t=0
parameters drdsw_n_33_l110e_t=0
parameters dxw_n_33_l110e_t=0
parameters dnlx_n_33_l110e_t=0
parameters dk3_n_33_l110e_t=0
parameters dpvth0_n_33_l110e_t=0
parameters dwwl_n_33_l110e_t=0
parameters dcgdo_n_33_l110e_t=0
parameters dcgso_n_33_l110e_t=0
parameters dcj_n_33_l110e_t=0
parameters dcjsw_n_33_l110e_t=0
parameters dcjswg_n_33_l110e_t=0
parameters dcgdl_n_33_l110e_t=0
parameters dcgsl_n_33_l110e_t=0
parameters dtox_p_33_l110e_t=0
parameters dxl_p_33_l110e_t=0
parameters du0_p_33_l110e_t=0
parameters dvth0_p_33_l110e_t=0
parameters drdsw_p_33_l110e_t=0
parameters dxw_p_33_l110e_t=0
parameters dnlx_p_33_l110e_t=0
parameters dk3_p_33_l110e_t=0
parameters dpvth0_p_33_l110e_t=0
parameters dwwl_p_33_l110e_t=0
parameters dcgdl_p_33_l110e_t=0
parameters dcgsl_p_33_l110e_t=0
parameters dcgdo_p_33_l110e_t=0
parameters dcgso_p_33_l110e_t=0
parameters dcj_p_33_l110e_t=0
parameters dcjsw_p_33_l110e_t=0
parameters dcjswg_p_33_l110e_t=0
//
endsection tt
//
section ff
parameters dtox_n_33_l110e_t=-1.50000e-10
parameters dxl_n_33_l110e_t=-1.00000e-08
parameters du0_n_33_l110e_t=1.85860e-03
parameters dvth0_n_33_l110e_t=-2.02970e-02
parameters drdsw_n_33_l110e_t=-1.35060e+02
parameters dxw_n_33_l110e_t=3.00040e-10
parameters dnlx_n_33_l110e_t=-5.94860e-08
parameters dk3_n_33_l110e_t=-7.54700e-01
parameters dpvth0_n_33_l110e_t=-4.20450e-16
parameters dwwl_n_33_l110e_t=-1.35e-22
parameters dcgdo_n_33_l110e_t=0.5e-011
parameters dcgso_n_33_l110e_t=0.5e-011
parameters dcj_n_33_l110e_t=-0.000078
parameters dcjsw_n_33_l110e_t=-1.08e-11
parameters dcjswg_n_33_l110e_t=-2.3e-11
parameters dcgdl_n_33_l110e_t=1.8e-011
parameters dcgsl_n_33_l110e_t=1.8e-011
parameters dtox_p_33_l110e_t=-1.50000e-10
parameters dxl_p_33_l110e_t=-5.00000e-09
parameters du0_p_33_l110e_t=4.05900e-04
parameters dvth0_p_33_l110e_t=2.85520e-02
parameters drdsw_p_33_l110e_t=-2.35830e+02
parameters dxw_p_33_l110e_t=1.26200e-08
parameters dnlx_p_33_l110e_t=-1.70800e-08
parameters dk3_p_33_l110e_t=-1.19510e-01
parameters dpvth0_p_33_l110e_t=1.65390e-15
parameters dwwl_p_33_l110e_t=-2.77500e-22
parameters dcgdl_p_33_l110e_t=2.0171e-011
parameters dcgsl_p_33_l110e_t=2.0171e-011
parameters dcgdo_p_33_l110e_t=0.9112e-011
parameters dcgso_p_33_l110e_t=0.9112e-011
parameters dcj_p_33_l110e_t=-0.0000993
parameters dcjsw_p_33_l110e_t=-1.2e-11
parameters dcjswg_p_33_l110e_t=-3.59e-11
//
endsection ff
//
section ss
parameters dtox_n_33_l110e_t=1.50000e-10
parameters dxl_n_33_l110e_t=1.00000e-08
parameters du0_n_33_l110e_t=-2.10900e-03
parameters dvth0_n_33_l110e_t=1.92990e-02
parameters drdsw_n_33_l110e_t=2.09570e+02
parameters dxw_n_33_l110e_t=-3.04050e-09
parameters dnlx_n_33_l110e_t=6.36560e-08
parameters dk3_n_33_l110e_t=6.93660e-01
parameters dpvth0_n_33_l110e_t=6.31730e-16
parameters dwwl_n_33_l110e_t=1.95450e-22
parameters dcgdo_n_33_l110e_t=-0.5e-011
parameters dcgso_n_33_l110e_t=-0.5e-011
parameters dcj_n_33_l110e_t=0.000078
parameters dcjsw_n_33_l110e_t=1.08e-11
parameters dcjswg_n_33_l110e_t=2.3e-11
parameters dcgdl_n_33_l110e_t=-1.8e-011
parameters dcgsl_n_33_l110e_t=-1.8e-011
parameters dtox_p_33_l110e_t=1.50000e-10
parameters dxl_p_33_l110e_t=5.00000e-09
parameters du0_p_33_l110e_t=-4.89180e-04
parameters dvth0_p_33_l110e_t=-2.73880e-02
parameters drdsw_p_33_l110e_t=4.20460e+02
parameters dxw_p_33_l110e_t=-2.200e-08
parameters dnlx_p_33_l110e_t=1.82340e-08
parameters dk3_p_33_l110e_t=9.57600e-02
parameters dpvth0_p_33_l110e_t=-1.28e-15
parameters dwwl_p_33_l110e_t=4.20600e-22
parameters dcgdl_p_33_l110e_t=-2.0171e-011
parameters dcgsl_p_33_l110e_t=-2.0171e-011
parameters dcgdo_p_33_l110e_t=-0.9112e-011
parameters dcgso_p_33_l110e_t=-0.9112e-011
parameters dcj_p_33_l110e_t=0.0000993
parameters dcjsw_p_33_l110e_t=1.2e-11
parameters dcjswg_p_33_l110e_t=3.59e-11
//
endsection ss
//
section fnsp
parameters dtox_n_33_l110e_t=0.00000e+00
parameters dxl_n_33_l110e_t=-1.00000e-08
parameters du0_n_33_l110e_t=1.19810e-03
parameters dvth0_n_33_l110e_t=-1.71030e-02
parameters drdsw_n_33_l110e_t=-0.75600e+02
parameters dxw_n_33_l110e_t=5.58200e-10
parameters dnlx_n_33_l110e_t=-2.21220e-08
parameters dk3_n_33_l110e_t=-3.54e-01
parameters dpvth0_n_33_l110e_t=-1.54780e-16
parameters dwwl_n_33_l110e_t=-5.04600e-23
parameters dcgdo_n_33_l110e_t=0
parameters dcgso_n_33_l110e_t=0
parameters dcj_n_33_l110e_t=-0.000078
parameters dcjsw_n_33_l110e_t=-1.08e-11
parameters dcjswg_n_33_l110e_t=-2.3e-11
parameters dcgdl_n_33_l110e_t=0
parameters dcgsl_n_33_l110e_t=0
parameters dtox_p_33_l110e_t=0.00000e+00
parameters dxl_p_33_l110e_t=5.00000e-09
parameters du0_p_33_l110e_t=-2.92940e-04
parameters dvth0_p_33_l110e_t=-2.23680e-02
parameters drdsw_p_33_l110e_t=1.26e+02
parameters dxw_p_33_l110e_t=-1.00e-08
parameters dnlx_p_33_l110e_t=7.85330e-09
parameters dk3_p_33_l110e_t=3.16660e-02
parameters dpvth0_p_33_l110e_t=-7.60e-16
parameters dwwl_p_33_l110e_t=1.52e-22
parameters dcgdl_p_33_l110e_t=0
parameters dcgsl_p_33_l110e_t=0
parameters dcgdo_p_33_l110e_t=0
parameters dcgso_p_33_l110e_t=0
parameters dcj_p_33_l110e_t=0.0000993
parameters dcjsw_p_33_l110e_t=1.2e-11
parameters dcjswg_p_33_l110e_t=3.59e-11
//
endsection fnsp
//
section snfp
parameters dtox_n_33_l110e_t=0.00000e+00
parameters dxl_n_33_l110e_t=1.00000e-08
parameters du0_n_33_l110e_t=-1.20e-03
parameters dvth0_n_33_l110e_t=1.68060e-02
parameters drdsw_n_33_l110e_t=0.90790e+02
parameters dxw_n_33_l110e_t=-9.85070e-10
parameters dnlx_n_33_l110e_t=2.40050e-08
parameters dk3_n_33_l110e_t=3.58810e-01
parameters dpvth0_n_33_l110e_t=1.67180e-16
parameters dwwl_n_33_l110e_t=7.04700e-23
parameters dcgdo_n_33_l110e_t=0
parameters dcgso_n_33_l110e_t=0
parameters dcj_n_33_l110e_t=0.000078
parameters dcjsw_n_33_l110e_t=1.08e-11
parameters dcjswg_n_33_l110e_t=2.3e-11
parameters dcgdl_n_33_l110e_t=0
parameters dcgsl_n_33_l110e_t=0
parameters dtox_p_33_l110e_t=0.00000e+00
parameters dxl_p_33_l110e_t=-5.00000e-09
parameters du0_p_33_l110e_t=2.71930e-04
parameters dvth0_p_33_l110e_t=2.29320e-02
parameters drdsw_p_33_l110e_t=-9.00e+01
parameters dxw_p_33_l110e_t=7.650e-09
parameters dnlx_p_33_l110e_t=-6.89070e-09
parameters dk3_p_33_l110e_t=-3.44730e-02
parameters dpvth0_p_33_l110e_t=8.230e-16
parameters dwwl_p_33_l110e_t=-1.1450e-22
parameters dcgdl_p_33_l110e_t=0
parameters dcgsl_p_33_l110e_t=0
parameters dcgdo_p_33_l110e_t=0
parameters dcgso_p_33_l110e_t=0
parameters dcj_p_33_l110e_t=-0.0000993
parameters dcjsw_p_33_l110e_t=-1.2e-11
parameters dcjswg_p_33_l110e_t=-3.59e-11
//
endsection snfp
//
//  **************************** local*******************************
//
//
//
//
//
//
//  **************************** global*******************************
//
section tt_g
parameters dtox_n_33_l110e_g=0.0000000e+000
parameters dxl_n_33_l110e_g=0.0000000e+000
parameters du0_n_33_l110e_g=0.0000000e+000
parameters dvth0_n_33_l110e_g=0.0000000e+000
parameters drdsw_n_33_l110e_g=0.0000000e+000
parameters dxw_n_33_l110e_g=0.0000000e+000
parameters dnlx_n_33_l110e_g=0.0000000e+000
parameters dk3_n_33_l110e_g=0.0000000e+000
parameters dpvth0_n_33_l110e_g=0.0000000e+000
parameters dwwl_n_33_l110e_g=0.0000000e+000
parameters dcgdo_n_33_l110e_g=0.0000000e+000
parameters dcgso_n_33_l110e_g=0.0000000e+000
parameters dcj_n_33_l110e_g=0.0000000e+000
parameters dcjsw_n_33_l110e_g=0.0000000e+000
parameters dcjswg_n_33_l110e_g=0.0000000e+000
parameters dcgdl_n_33_l110e_g=0.0000000e+000
parameters dcgsl_n_33_l110e_g=0.0000000e+000
parameters dtox_p_33_l110e_g=0.0000000e+000
parameters dxl_p_33_l110e_g=0.0000000e+000
parameters du0_p_33_l110e_g=0.0000000e+000
parameters dvth0_p_33_l110e_g=0.0000000e+000
parameters drdsw_p_33_l110e_g=0.0000000e+000
parameters dxw_p_33_l110e_g=0.0000000e+000
parameters dnlx_p_33_l110e_g=0.0000000e+000
parameters dk3_p_33_l110e_g=0.0000000e+000
parameters dpvth0_p_33_l110e_g=0.0000000e+000
parameters dwwl_p_33_l110e_g=0.0000000e+000
parameters dcgdl_p_33_l110e_g=0.0000000e+000
parameters dcgsl_p_33_l110e_g=0.0000000e+000
parameters dcgdo_p_33_l110e_g=0.0000000e+000
parameters dcgso_p_33_l110e_g=0.0000000e+000
parameters dcj_p_33_l110e_g=0.0000000e+000
parameters dcjsw_p_33_l110e_g=0.0000000e+000
parameters dcjswg_p_33_l110e_g=0.0000000e+000
//
//
endsection tt_g
//
section ff_g
parameters dtox_n_33_l110e_g=-1.5000000e-010
parameters dxl_n_33_l110e_g=-1.0000000e-008
parameters du0_n_33_l110e_g=1.8510452e-003
parameters dvth0_n_33_l110e_g=-2.0273470e-002
parameters drdsw_n_33_l110e_g=-1.3583810e+002
parameters dxw_n_33_l110e_g=4.5290291e-010
parameters dnlx_n_33_l110e_g=-5.9391111e-008
parameters dk3_n_33_l110e_g=-7.6310646e-001
parameters dpvth0_n_33_l110e_g=1.4097708e-015
parameters dwwl_n_33_l110e_g=-1.6352151e-022
parameters dcgdo_n_33_l110e_g=0.5e-011
parameters dcgso_n_33_l110e_g=0.5e-011
parameters dcj_n_33_l110e_g=-7.8000000e-005
parameters dcjsw_n_33_l110e_g=-1.0800000e-011
parameters dcjswg_n_33_l110e_g=-2.3000000e-011
parameters dcgdl_n_33_l110e_g=1.8e-011
parameters dcgsl_n_33_l110e_g=1.8e-011
parameters dtox_p_33_l110e_g=-1.5000000e-010
parameters dxl_p_33_l110e_g=-5.0000000e-009
parameters du0_p_33_l110e_g=4.0490227e-004
parameters dvth0_p_33_l110e_g=2.8569239e-002
parameters drdsw_p_33_l110e_g=-2.3901011e+002
parameters dxw_p_33_l110e_g=1.2711644e-008
parameters dnlx_p_33_l110e_g=-1.7084634e-008
parameters dk3_p_33_l110e_g=-1.1389541e-001
parameters dpvth0_p_33_l110e_g=1.2905272e-015
parameters dwwl_p_33_l110e_g=-2.8395171e-022
parameters dcgdl_p_33_l110e_g=2.0171000e-011
parameters dcgsl_p_33_l110e_g=2.0171000e-011
parameters dcgdo_p_33_l110e_g=0.9112e-011
parameters dcgso_p_33_l110e_g=0.9112e-011
parameters dcj_p_33_l110e_g=-9.9300000e-005
parameters dcjsw_p_33_l110e_g=-1.2000000e-011
parameters dcjswg_p_33_l110e_g=-3.5900000e-011
//
//
endsection ff_g
//
section ss_g
parameters dtox_n_33_l110e_g=1.5000000e-010
parameters dxl_n_33_l110e_g=1.0000000e-008
parameters du0_n_33_l110e_g=-2.0988307e-003
parameters dvth0_n_33_l110e_g=1.9289125e-002
parameters drdsw_n_33_l110e_g=2.0878048e+002
parameters dxw_n_33_l110e_g=-2.9330896e-009
parameters dnlx_n_33_l110e_g=6.3555652e-008
parameters dk3_n_33_l110e_g=6.9857449e-001
parameters dpvth0_n_33_l110e_g=-9.7346033e-016
parameters dwwl_n_33_l110e_g=2.1983660e-022
parameters dcgdo_n_33_l110e_g=-0.5e-011
parameters dcgso_n_33_l110e_g=-0.5e-011
parameters dcj_n_33_l110e_g=7.8000000e-005
parameters dcjsw_n_33_l110e_g=1.0800000e-011
parameters dcjswg_n_33_l110e_g=2.3000000e-011
parameters dcgdl_n_33_l110e_g=-1.8e-011
parameters dcgsl_n_33_l110e_g=-1.8e-011
parameters dtox_p_33_l110e_g=1.5000000e-010
parameters dxl_p_33_l110e_g=5.0000000e-009
parameters du0_p_33_l110e_g=-4.8451821e-004
parameters dvth0_p_33_l110e_g=-2.7412130e-002
parameters drdsw_p_33_l110e_g=4.2287525e+002
parameters dxw_p_33_l110e_g=-2.0835740e-008
parameters dnlx_p_33_l110e_g=1.8241372e-008
parameters dk3_p_33_l110e_g=9.7342127e-002
parameters dpvth0_p_33_l110e_g=-9.5696773e-016
parameters dwwl_p_33_l110e_g=4.2769012e-022
parameters dcgdl_p_33_l110e_g=-2.0171000e-011
parameters dcgsl_p_33_l110e_g=-2.0171000e-011
parameters dcgdo_p_33_l110e_g=-0.9112e-011
parameters dcgso_p_33_l110e_g=-0.9112e-011
parameters dcj_p_33_l110e_g=9.9300000e-005
parameters dcjsw_p_33_l110e_g=1.2000000e-011
parameters dcjswg_p_33_l110e_g=3.5900000e-011
//
//
endsection ss_g
//
section fnsp_g
parameters dtox_n_33_l110e_g=0.0000000e+000
parameters dxl_n_33_l110e_g=-1.0000000e-008
parameters du0_n_33_l110e_g=1.1562993e-003
parameters dvth0_n_33_l110e_g=-1.6936822e-002
parameters drdsw_n_33_l110e_g=-7.4548433e+001
parameters dxw_n_33_l110e_g=4.8558638e-010
parameters dnlx_n_33_l110e_g=-2.2687040e-008
parameters dk3_n_33_l110e_g=-3.7517173e-001
parameters dpvth0_n_33_l110e_g=8.0066227e-016
parameters dwwl_n_33_l110e_g=-6.9501595e-023
parameters dcgdo_n_33_l110e_g=0.0000000e+000
parameters dcgso_n_33_l110e_g=0.0000000e+000
parameters dcj_n_33_l110e_g=-7.8000000e-005
parameters dcjsw_n_33_l110e_g=-1.0800000e-011
parameters dcjswg_n_33_l110e_g=-2.3000000e-011
parameters dcgdl_n_33_l110e_g=0.0000000e+000
parameters dcgsl_n_33_l110e_g=0.0000000e+000
parameters dtox_p_33_l110e_g=0.0000000e+000
parameters dxl_p_33_l110e_g=5.0000000e-009
parameters du0_p_33_l110e_g=-2.9430034e-004
parameters dvth0_p_33_l110e_g=-2.2291692e-002
parameters drdsw_p_33_l110e_g=1.1547839e+002
parameters dxw_p_33_l110e_g=-9.0863696e-009
parameters dnlx_p_33_l110e_g=8.5396911e-009
parameters dk3_p_33_l110e_g=5.8406750e-002
parameters dpvth0_p_33_l110e_g=-5.3145360e-016
parameters dwwl_p_33_l110e_g=1.6887215e-022
parameters dcgdl_p_33_l110e_g=0.0000000e+000
parameters dcgsl_p_33_l110e_g=0.0000000e+000
parameters dcgdo_p_33_l110e_g=0.0000000e+000
parameters dcgso_p_33_l110e_g=0.0000000e+000
parameters dcj_p_33_l110e_g=9.9300000e-005
parameters dcjsw_p_33_l110e_g=1.2000000e-011
parameters dcjswg_p_33_l110e_g=3.5900000e-011
//
//
endsection fnsp_g
//
section snfp_g
parameters dtox_n_33_l110e_g=0.0000000e+000
parameters dxl_n_33_l110e_g=1.0000000e-008
parameters du0_n_33_l110e_g=-1.2108799e-003
parameters dvth0_n_33_l110e_g=1.6646062e-002
parameters drdsw_n_33_l110e_g=9.0449392e+001
parameters dxw_n_33_l110e_g=-1.1255766e-009
parameters dnlx_n_33_l110e_g=2.4462972e-008
parameters dk3_n_33_l110e_g=3.6247902e-001
parameters dpvth0_n_33_l110e_g=-6.8566048e-016
parameters dwwl_n_33_l110e_g=8.5322493e-023
parameters dcgdo_n_33_l110e_g=0.0000000e+000
parameters dcgso_n_33_l110e_g=0.0000000e+000
parameters dcj_n_33_l110e_g=7.8000000e-005
parameters dcjsw_n_33_l110e_g=1.0800000e-011
parameters dcjswg_n_33_l110e_g=2.3000000e-011
parameters dcgdl_n_33_l110e_g=0.0000000e+000
parameters dcgsl_n_33_l110e_g=0.0000000e+000
parameters dtox_p_33_l110e_g=0.0000000e+000
parameters dxl_p_33_l110e_g=-5.0000000e-009
parameters du0_p_33_l110e_g=2.7452260e-004
parameters dvth0_p_33_l110e_g=2.2898525e-002
parameters drdsw_p_33_l110e_g=-8.0999764e+001
parameters dxw_p_33_l110e_g=7.3018037e-009
parameters dnlx_p_33_l110e_g=-7.7096410e-009
parameters dk3_p_33_l110e_g=-5.3120567e-002
parameters dpvth0_p_33_l110e_g=5.9485037e-016
parameters dwwl_p_33_l110e_g=-1.2542707e-022
parameters dcgdl_p_33_l110e_g=0.0000000e+000
parameters dcgsl_p_33_l110e_g=0.0000000e+000
parameters dcgdo_p_33_l110e_g=0.0000000e+000
parameters dcgso_p_33_l110e_g=0.0000000e+000
parameters dcj_p_33_l110e_g=-9.9300000e-005
parameters dcjsw_p_33_l110e_g=-1.2000000e-011
parameters dcjswg_p_33_l110e_g=-3.5900000e-011
//
//
endsection snfp_g
//
// *********thermal noise**************
section tt_tn
//
parameters dtox_n_33_l110e=0
parameters dxl_n_33_l110e=0
parameters du0_n_33_l110e=0
parameters dvth0_n_33_l110e=0
parameters drdsw_n_33_l110e=0
parameters dxw_n_33_l110e=0
parameters dnlx_n_33_l110e=0
parameters dk3_n_33_l110e=0
parameters dpvth0_n_33_l110e=0
parameters dwwl_n_33_l110e=0
parameters dcgdo_n_33_l110e=0
parameters dcgso_n_33_l110e=0
parameters dcj_n_33_l110e=0
parameters dcjsw_n_33_l110e=0
parameters dcjswg_n_33_l110e=0
parameters dcgdl_n_33_l110e=0
parameters dcgsl_n_33_l110e=0
parameters dtox_p_33_l110e=0
parameters dxl_p_33_l110e=0
parameters du0_p_33_l110e=0
parameters dvth0_p_33_l110e=0
parameters drdsw_p_33_l110e=0
parameters dxw_p_33_l110e=0
parameters dnlx_p_33_l110e=0
parameters dk3_p_33_l110e=0
parameters dpvth0_p_33_l110e=0
parameters dwwl_p_33_l110e=0
parameters dcgdl_p_33_l110e=0
parameters dcgsl_p_33_l110e=0
parameters dcgdo_p_33_l110e=0
parameters dcgso_p_33_l110e=0
parameters dcj_p_33_l110e=0
parameters dcjsw_p_33_l110e=0
parameters dcjswg_p_33_l110e=0
//
endsection tt_tn
//
section ff_tn
//
parameters dtox_n_33_l110e=-1.50000e-10
parameters dxl_n_33_l110e=-1.00000e-08
parameters du0_n_33_l110e=1.85860e-03
parameters dvth0_n_33_l110e=-2.02970e-02
parameters drdsw_n_33_l110e=-1.35060e+02
parameters dxw_n_33_l110e=3.00040e-10
parameters dnlx_n_33_l110e=-5.94860e-08
parameters dk3_n_33_l110e=-7.54700e-01
parameters dpvth0_n_33_l110e=-4.20450e-16
parameters dwwl_n_33_l110e=-1.35e-22
parameters dcgdo_n_33_l110e=0.5e-011
parameters dcgso_n_33_l110e=0.5e-011
parameters dcj_n_33_l110e=-0.000078
parameters dcjsw_n_33_l110e=-1.08e-11
parameters dcjswg_n_33_l110e=-2.3e-11
parameters dcgdl_n_33_l110e=1.8e-011
parameters dcgsl_n_33_l110e=1.8e-011
parameters dtox_p_33_l110e=-1.50000e-10
parameters dxl_p_33_l110e=-5.00000e-09
parameters du0_p_33_l110e=4.05900e-04
parameters dvth0_p_33_l110e=2.85520e-02
parameters drdsw_p_33_l110e=-2.35830e+02
parameters dxw_p_33_l110e=1.26200e-08
parameters dnlx_p_33_l110e=-1.70800e-08
parameters dk3_p_33_l110e=-1.19510e-01
parameters dpvth0_p_33_l110e=1.65390e-15
parameters dwwl_p_33_l110e=-2.77500e-22
parameters dcgdl_p_33_l110e=2.0171e-011
parameters dcgsl_p_33_l110e=2.0171e-011
parameters dcgdo_p_33_l110e=0.9112e-011
parameters dcgso_p_33_l110e=0.9112e-011
parameters dcj_p_33_l110e=-0.0000993
parameters dcjsw_p_33_l110e=-1.2e-11
parameters dcjswg_p_33_l110e=-3.59e-11
//
endsection ff_tn
//
section ss_tn
//
parameters dtox_n_33_l110e=1.50000e-10
parameters dxl_n_33_l110e=1.00000e-08
parameters du0_n_33_l110e=-2.10900e-03
parameters dvth0_n_33_l110e=1.92990e-02
parameters drdsw_n_33_l110e=2.09570e+02
parameters dxw_n_33_l110e=-3.04050e-09
parameters dnlx_n_33_l110e=6.36560e-08
parameters dk3_n_33_l110e=6.93660e-01
parameters dpvth0_n_33_l110e=6.31730e-16
parameters dwwl_n_33_l110e=1.95450e-22
parameters dcgdo_n_33_l110e=-0.5e-011
parameters dcgso_n_33_l110e=-0.5e-011
parameters dcj_n_33_l110e=0.000078
parameters dcjsw_n_33_l110e=1.08e-11
parameters dcjswg_n_33_l110e=2.3e-11
parameters dcgdl_n_33_l110e=-1.8e-011
parameters dcgsl_n_33_l110e=-1.8e-011
parameters dtox_p_33_l110e=1.50000e-10
parameters dxl_p_33_l110e=5.00000e-09
parameters du0_p_33_l110e=-4.89180e-04
parameters dvth0_p_33_l110e=-2.73880e-02
parameters drdsw_p_33_l110e=4.20460e+02
parameters dxw_p_33_l110e=-2.200e-08
parameters dnlx_p_33_l110e=1.82340e-08
parameters dk3_p_33_l110e=9.57600e-02
parameters dpvth0_p_33_l110e=-1.28e-15
parameters dwwl_p_33_l110e=4.20600e-22
parameters dcgdl_p_33_l110e=-2.0171e-011
parameters dcgsl_p_33_l110e=-2.0171e-011
parameters dcgdo_p_33_l110e=-0.9112e-011
parameters dcgso_p_33_l110e=-0.9112e-011
parameters dcj_p_33_l110e=0.0000993
parameters dcjsw_p_33_l110e=1.2e-11
parameters dcjswg_p_33_l110e=3.59e-11
//
endsection ss_tn
//
section fnsp_tn
//
parameters dtox_n_33_l110e=0.00000e+00
parameters dxl_n_33_l110e=-1.00000e-08
parameters du0_n_33_l110e=1.19810e-03
parameters dvth0_n_33_l110e=-1.71030e-02
parameters drdsw_n_33_l110e=-0.75600e+02
parameters dxw_n_33_l110e=5.58200e-10
parameters dnlx_n_33_l110e=-2.21220e-08
parameters dk3_n_33_l110e=-3.54e-01
parameters dpvth0_n_33_l110e=-1.54780e-16
parameters dwwl_n_33_l110e=-5.04600e-23
parameters dcgdo_n_33_l110e=0
parameters dcgso_n_33_l110e=0
parameters dcj_n_33_l110e=-0.000078
parameters dcjsw_n_33_l110e=-1.08e-11
parameters dcjswg_n_33_l110e=-2.3e-11
parameters dcgdl_n_33_l110e=0
parameters dcgsl_n_33_l110e=0
parameters dtox_p_33_l110e=0.00000e+00
parameters dxl_p_33_l110e=5.00000e-09
parameters du0_p_33_l110e=-2.92940e-04
parameters dvth0_p_33_l110e=-2.23680e-02
parameters drdsw_p_33_l110e=1.26e+02
parameters dxw_p_33_l110e=-1.00e-08
parameters dnlx_p_33_l110e=7.85330e-09
parameters dk3_p_33_l110e=3.16660e-02
parameters dpvth0_p_33_l110e=-7.60e-16
parameters dwwl_p_33_l110e=1.52e-22
parameters dcgdl_p_33_l110e=0
parameters dcgsl_p_33_l110e=0
parameters dcgdo_p_33_l110e=0
parameters dcgso_p_33_l110e=0
parameters dcj_p_33_l110e=0.0000993
parameters dcjsw_p_33_l110e=1.2e-11
parameters dcjswg_p_33_l110e=3.59e-11
//
endsection fnsp_tn
//
section snfp_tn
//
parameters dtox_n_33_l110e=0.00000e+00
parameters dxl_n_33_l110e=1.00000e-08
parameters du0_n_33_l110e=-1.20e-03
parameters dvth0_n_33_l110e=1.68060e-02
parameters drdsw_n_33_l110e=0.90790e+02
parameters dxw_n_33_l110e=-9.85070e-10
parameters dnlx_n_33_l110e=2.40050e-08
parameters dk3_n_33_l110e=3.58810e-01
parameters dpvth0_n_33_l110e=1.67180e-16
parameters dwwl_n_33_l110e=7.04700e-23
parameters dcgdo_n_33_l110e=0
parameters dcgso_n_33_l110e=0
parameters dcj_n_33_l110e=0.000078
parameters dcjsw_n_33_l110e=1.08e-11
parameters dcjswg_n_33_l110e=2.3e-11
parameters dcgdl_n_33_l110e=0
parameters dcgsl_n_33_l110e=0
parameters dtox_p_33_l110e=0.00000e+00
parameters dxl_p_33_l110e=-5.00000e-09
parameters du0_p_33_l110e=2.71930e-04
parameters dvth0_p_33_l110e=2.29320e-02
parameters drdsw_p_33_l110e=-9.00e+01
parameters dxw_p_33_l110e=7.650e-09
parameters dnlx_p_33_l110e=-6.89070e-09
parameters dk3_p_33_l110e=-3.44730e-02
parameters dpvth0_p_33_l110e=8.230e-16
parameters dwwl_p_33_l110e=-1.1450e-22
parameters dcgdl_p_33_l110e=0
parameters dcgsl_p_33_l110e=0
parameters dcgdo_p_33_l110e=0
parameters dcgso_p_33_l110e=0
parameters dcj_p_33_l110e=-0.0000993
parameters dcjsw_p_33_l110e=-1.2e-11
parameters dcjswg_p_33_l110e=-3.59e-11
//
endsection snfp_tn
//****************************************
endlibrary mylib
