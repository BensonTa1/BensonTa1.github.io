simulator lang=spectre insensitive=yes
library mylib

section tt
parameters dis_pnp_sv45x45_l110e=0
parameters dbf_pnp_sv45x45_l110e=0
parameters dnf_pnp_sv45x45_l110e=0
parameters dre_pnp_sv45x45_l110e=0
parameters drc_pnp_sv45x45_l110e=0
parameters dcje_pnp_sv45x45_l110e=0
parameters dcjc_pnp_sv45x45_l110e=0
parameters dis_pnp_sv90x90_l110e=0
parameters dbf_pnp_sv90x90_l110e=0
parameters dnf_pnp_sv90x90_l110e=0
parameters dre_pnp_sv90x90_l110e=0
parameters drc_pnp_sv90x90_l110e=0
parameters dcje_pnp_sv90x90_l110e=0
parameters dcjc_pnp_sv90x90_l110e=0
parameters dis_pnp_sv135x135_l110e=0
parameters dbf_pnp_sv135x135_l110e=0
parameters dnf_pnp_sv135x135_l110e=0
parameters dre_pnp_sv135x135_l110e=0
parameters drc_pnp_sv135x135_l110e=0
parameters dcje_pnp_sv135x135_l110e=0
parameters dcjc_pnp_sv135x135_l110e=0
parameters dis_pnp_v45x45_l110e=0
parameters dbf_pnp_v45x45_l110e=0
parameters dnf_pnp_v45x45_l110e=0
parameters dre_pnp_v45x45_l110e=0
parameters drc_pnp_v45x45_l110e=0
parameters dcje_pnp_v45x45_l110e=0
parameters dcjc_pnp_v45x45_l110e=0
parameters dis_pnp_v90x90_l110e=0
parameters dbf_pnp_v90x90_l110e=0
parameters dnf_pnp_v90x90_l110e=0
parameters dre_pnp_v90x90_l110e=0
parameters drc_pnp_v90x90_l110e=0
parameters dcje_pnp_v90x90_l110e=0
parameters dcjc_pnp_v90x90_l110e=0
parameters dis_pnp_v135x135_l110e=0
parameters dbf_pnp_v135x135_l110e=0
parameters dnf_pnp_v135x135_l110e=0
parameters dre_pnp_v135x135_l110e=0
parameters drc_pnp_v135x135_l110e=0
parameters dcje_pnp_v135x135_l110e=0
parameters dcjc_pnp_v135x135_l110e=0
include "l110ae_bjt_pnp_v031_mc.mdl.scs"
endsection tt

section ff
parameters dis_pnp_sv45x45_l110e=-0.2
parameters dbf_pnp_sv45x45_l110e=0.15
parameters dnf_pnp_sv45x45_l110e=-0.005
parameters dre_pnp_sv45x45_l110e=-0.2
parameters drc_pnp_sv45x45_l110e=-0.2
parameters dcje_pnp_sv45x45_l110e=-0.1
parameters dcjc_pnp_sv45x45_l110e=-0.1
parameters dis_pnp_sv90x90_l110e=-0.2
parameters dbf_pnp_sv90x90_l110e=0.15
parameters dnf_pnp_sv90x90_l110e=-0.005
parameters dre_pnp_sv90x90_l110e=-0.2
parameters drc_pnp_sv90x90_l110e=-0.2
parameters dcje_pnp_sv90x90_l110e=-0.1
parameters dcjc_pnp_sv90x90_l110e=-0.1
parameters dis_pnp_sv135x135_l110e=-0.2
parameters dbf_pnp_sv135x135_l110e=0.15
parameters dnf_pnp_sv135x135_l110e=-0.005
parameters dre_pnp_sv135x135_l110e=-0.2
parameters drc_pnp_sv135x135_l110e=-0.2
parameters dcje_pnp_sv135x135_l110e=-0.1
parameters dcjc_pnp_sv135x135_l110e=-0.1
parameters dis_pnp_v45x45_l110e=-0.2
parameters dbf_pnp_v45x45_l110e=0.15
parameters dnf_pnp_v45x45_l110e=-0.005
parameters dre_pnp_v45x45_l110e=-0.2
parameters drc_pnp_v45x45_l110e=-0.2
parameters dcje_pnp_v45x45_l110e=-0.1
parameters dcjc_pnp_v45x45_l110e=-0.1
parameters dis_pnp_v90x90_l110e=-0.2
parameters dbf_pnp_v90x90_l110e=0.15
parameters dnf_pnp_v90x90_l110e=-0.005
parameters dre_pnp_v90x90_l110e=-0.2
parameters drc_pnp_v90x90_l110e=-0.2
parameters dcje_pnp_v90x90_l110e=-0.1
parameters dcjc_pnp_v90x90_l110e=-0.1
parameters dis_pnp_v135x135_l110e=-0.2
parameters dbf_pnp_v135x135_l110e=0.15
parameters dnf_pnp_v135x135_l110e=-0.005
parameters dre_pnp_v135x135_l110e=-0.2
parameters drc_pnp_v135x135_l110e=-0.2
parameters dcje_pnp_v135x135_l110e=-0.1
parameters dcjc_pnp_v135x135_l110e=-0.1
include "l110ae_bjt_pnp_v031_mc.mdl.scs"
endsection ff

section ss
parameters dis_pnp_sv45x45_l110e=0.2
parameters dbf_pnp_sv45x45_l110e=-0.15
parameters dnf_pnp_sv45x45_l110e=0.005
parameters dre_pnp_sv45x45_l110e=0.2
parameters drc_pnp_sv45x45_l110e=0.2
parameters dcje_pnp_sv45x45_l110e=0.1
parameters dcjc_pnp_sv45x45_l110e=0.1
parameters dis_pnp_sv90x90_l110e=0.2
parameters dbf_pnp_sv90x90_l110e=-0.15
parameters dnf_pnp_sv90x90_l110e=0.005
parameters dre_pnp_sv90x90_l110e=0.2
parameters drc_pnp_sv90x90_l110e=0.2
parameters dcje_pnp_sv90x90_l110e=0.1
parameters dcjc_pnp_sv90x90_l110e=0.1
parameters dis_pnp_sv135x135_l110e=0.2
parameters dbf_pnp_sv135x135_l110e=-0.15
parameters dnf_pnp_sv135x135_l110e=0.005
parameters dre_pnp_sv135x135_l110e=0.2
parameters drc_pnp_sv135x135_l110e=0.2
parameters dcje_pnp_sv135x135_l110e=0.1
parameters dcjc_pnp_sv135x135_l110e=0.1
parameters dis_pnp_v45x45_l110e=0.2
parameters dbf_pnp_v45x45_l110e=-0.15
parameters dnf_pnp_v45x45_l110e=0.005
parameters dre_pnp_v45x45_l110e=0.2
parameters drc_pnp_v45x45_l110e=0.2
parameters dcje_pnp_v45x45_l110e=0.1
parameters dcjc_pnp_v45x45_l110e=0.1
parameters dis_pnp_v90x90_l110e=0.2
parameters dbf_pnp_v90x90_l110e=-0.15
parameters dnf_pnp_v90x90_l110e=0.005
parameters dre_pnp_v90x90_l110e=0.2
parameters drc_pnp_v90x90_l110e=0.2
parameters dcje_pnp_v90x90_l110e=0.1
parameters dcjc_pnp_v90x90_l110e=0.1
parameters dis_pnp_v135x135_l110e=0.2
parameters dbf_pnp_v135x135_l110e=-0.15
parameters dnf_pnp_v135x135_l110e=0.005
parameters dre_pnp_v135x135_l110e=0.2
parameters drc_pnp_v135x135_l110e=0.2
parameters dcje_pnp_v135x135_l110e=0.1
parameters dcjc_pnp_v135x135_l110e=0.1
include "l110ae_bjt_pnp_v031_mc.mdl.scs"
endsection ss

endlibrary mylib
