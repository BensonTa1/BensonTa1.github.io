simulator lang=spectre insensitive=yes
//
parameters alpha_n_12_hsl110e = 0.2
parameters alpha_p_12_hsl110e = 0.2

parameters a1_np_12_hsl110e_xx = 0
parameters a2_np_12_hsl110e_xx = 0
parameters a3_np_12_hsl110e_xx = 0
parameters a4_np_12_hsl110e_xx = 0
parameters a5_np_12_hsl110e_xx = 0
statistics {
process {
vary a1_np_12_hsl110e_xx dist=gauss std=sigma/3
vary a2_np_12_hsl110e_xx dist=gauss std=sigma/3
vary a3_np_12_hsl110e_xx dist=gauss std=sigma/3
vary a4_np_12_hsl110e_xx dist=gauss std=sigma/3
vary a5_np_12_hsl110e_xx dist=gauss std=sigma/3
 }
}
parameters a1_np_12_hsl110e = a1_np_12_hsl110e_xx
parameters a2_np_12_hsl110e = a2_np_12_hsl110e_xx
parameters a3_np_12_hsl110e = a3_np_12_hsl110e_xx
parameters a4_np_12_hsl110e = a4_np_12_hsl110e_xx
parameters a5_np_12_hsl110e = a5_np_12_hsl110e_xx
parameters comp1_np_12_hsl110e	= 10.676814892908
parameters comp2_np_12_hsl110e	= 5.88537352991715
parameters comp3_np_12_hsl110e	= 2.62712646335746
parameters comp4_np_12_hsl110e	= 0.682794772578717
parameters comp5_np_12_hsl110e	= 2.12454108671727e-14
parameters 	dtox_n_12_hsl110e_g	  =	alpha_n_12_hsl110e*(6.96149660260723e-12*a1_np_12_hsl110e*comp1_np_12_hsl110e+9.78947849812059e-13*a2_np_12_hsl110e*comp2_np_12_hsl110e+-1.59362066538782e-12*a3_np_12_hsl110e*comp3_np_12_hsl110e+-1.04836586744647e-12*a4_np_12_hsl110e*comp4_np_12_hsl110e+-1.28364527310677e-12*a5_np_12_hsl110e*comp5_np_12_hsl110e)
parameters 	dxl_n_12_hsl110e_g	  =	alpha_n_12_hsl110e*(1.84760883564472e-10*a1_np_12_hsl110e*comp1_np_12_hsl110e+2.85452895394978e-10*a2_np_12_hsl110e*comp2_np_12_hsl110e+3.66907626636048e-10*a3_np_12_hsl110e*comp3_np_12_hsl110e+4.1056021348115e-10*a4_np_12_hsl110e*comp4_np_12_hsl110e+2.80445398048823e-10*a5_np_12_hsl110e*comp5_np_12_hsl110e)
parameters 	du0_n_12_hsl110e_g	  =	alpha_n_12_hsl110e*(-1.70040852972592e-04*a1_np_12_hsl110e*comp1_np_12_hsl110e+-2.23247079647696e-04*a2_np_12_hsl110e*comp2_np_12_hsl110e+-5.17353154418386e-05*a3_np_12_hsl110e*comp3_np_12_hsl110e+-2.88422757769331e-05*a4_np_12_hsl110e*comp4_np_12_hsl110e+-2.18713275387395e-04*a5_np_12_hsl110e*comp5_np_12_hsl110e)
parameters 	dvth0_n_12_hsl110e_g	  =	alpha_n_12_hsl110e*(3.96163021663574e-03*a1_np_12_hsl110e*comp1_np_12_hsl110e+4.99386752610875e-03*a2_np_12_hsl110e*comp2_np_12_hsl110e+-4.50251933564597e-05*a3_np_12_hsl110e*comp3_np_12_hsl110e+9.53633406770634e-04*a4_np_12_hsl110e*comp4_np_12_hsl110e+-1.77493337837409e-03*a5_np_12_hsl110e*comp5_np_12_hsl110e)
parameters 	drdsw_n_12_hsl110e_g	  =	alpha_n_12_hsl110e*(1.17572392184633*a1_np_12_hsl110e*comp1_np_12_hsl110e+0.901624038254296*a2_np_12_hsl110e*comp2_np_12_hsl110e+-7.39490150004574e-02*a3_np_12_hsl110e*comp3_np_12_hsl110e+-0.509542368482659*a4_np_12_hsl110e*comp4_np_12_hsl110e+-0.9120477990915*a5_np_12_hsl110e*comp5_np_12_hsl110e)
parameters 	dxw_n_12_hsl110e_g	  =	alpha_n_12_hsl110e*(-1.96711640249292e-09*a1_np_12_hsl110e*comp1_np_12_hsl110e+-1.99479728081643e-09*a2_np_12_hsl110e*comp2_np_12_hsl110e+-1.01732288005758e-09*a3_np_12_hsl110e*comp3_np_12_hsl110e+-4.79795486798014e-10*a4_np_12_hsl110e*comp4_np_12_hsl110e+4.54899878790899e-10*a5_np_12_hsl110e*comp5_np_12_hsl110e)
parameters 	dnlx_n_12_hsl110e_g	  =	alpha_n_12_hsl110e*(3.09881056560289e-09*a1_np_12_hsl110e*comp1_np_12_hsl110e+4.13251088487231e-09*a2_np_12_hsl110e*comp2_np_12_hsl110e+1.28139886831456e-10*a3_np_12_hsl110e*comp3_np_12_hsl110e+1.74278996463455e-10*a4_np_12_hsl110e*comp4_np_12_hsl110e+-2.86120510852085e-09*a5_np_12_hsl110e*comp5_np_12_hsl110e)
parameters 	dk3_n_12_hsl110e_g	  =	alpha_n_12_hsl110e*(0.326981506884051*a1_np_12_hsl110e*comp1_np_12_hsl110e+0.364457590258055*a2_np_12_hsl110e*comp2_np_12_hsl110e+-0.101821173577339*a3_np_12_hsl110e*comp3_np_12_hsl110e+-3.00955164816601e-02*a4_np_12_hsl110e*comp4_np_12_hsl110e+-0.137644811970062*a5_np_12_hsl110e*comp5_np_12_hsl110e)
parameters 	dpvth0_n_12_hsl110e_g	  =	alpha_n_12_hsl110e*(9.65682105818995e-17*a1_np_12_hsl110e*comp1_np_12_hsl110e+8.00185017601585e-17*a2_np_12_hsl110e*comp2_np_12_hsl110e+8.55611649510013e-18*a3_np_12_hsl110e*comp3_np_12_hsl110e+3.48171357249934e-19*a4_np_12_hsl110e*comp4_np_12_hsl110e+-2.03936724374754e-17*a5_np_12_hsl110e*comp5_np_12_hsl110e)
parameters 	dwwl_n_12_hsl110e_g	  =	alpha_n_12_hsl110e*(-4.96518290957395e-24*a1_np_12_hsl110e*comp1_np_12_hsl110e+-4.57007961736864e-24*a2_np_12_hsl110e*comp2_np_12_hsl110e+6.26472929230058e-24*a3_np_12_hsl110e*comp3_np_12_hsl110e+3.73103817251295e-24*a4_np_12_hsl110e*comp4_np_12_hsl110e+7.20435318179206e-25*a5_np_12_hsl110e*comp5_np_12_hsl110e)
parameters 	dags_n_12_hsl110e_g	  =	alpha_n_12_hsl110e*(1.36841559651581e-02*a1_np_12_hsl110e*comp1_np_12_hsl110e+1.40993129615262e-02*a2_np_12_hsl110e*comp2_np_12_hsl110e+3.84329260905899e-05*a3_np_12_hsl110e*comp3_np_12_hsl110e+1.75639441853242e-03*a4_np_12_hsl110e*comp4_np_12_hsl110e+-4.70214314230523e-03*a5_np_12_hsl110e*comp5_np_12_hsl110e)
parameters 	dcgdo_n_12_hsl110e_g	  =	alpha_n_12_hsl110e*(-2.50508400472608e-12*a1_np_12_hsl110e*comp1_np_12_hsl110e+-3.52272900500552e-13*a2_np_12_hsl110e*comp2_np_12_hsl110e+5.73461981863047e-13*a3_np_12_hsl110e*comp3_np_12_hsl110e+3.77252868967483e-13*a4_np_12_hsl110e*comp4_np_12_hsl110e+-1.71251899931766e-12*a5_np_12_hsl110e*comp5_np_12_hsl110e)
parameters 	dcgso_n_12_hsl110e_g	  =	alpha_n_12_hsl110e*(-2.50508400472608e-12*a1_np_12_hsl110e*comp1_np_12_hsl110e+-3.52272900500552e-13*a2_np_12_hsl110e*comp2_np_12_hsl110e+5.73461981863047e-13*a3_np_12_hsl110e*comp3_np_12_hsl110e+3.77252868967483e-13*a4_np_12_hsl110e*comp4_np_12_hsl110e+-1.71251899931766e-12*a5_np_12_hsl110e*comp5_np_12_hsl110e)
parameters 	dcj_n_12_hsl110e_g	  =	alpha_n_12_hsl110e*(8.8127126471113e-06*a1_np_12_hsl110e*comp1_np_12_hsl110e+1.85060320397273e-05*a2_np_12_hsl110e*comp2_np_12_hsl110e+1.46988399299766e-06*a3_np_12_hsl110e*comp3_np_12_hsl110e+3.39770175596014e-06*a4_np_12_hsl110e*comp4_np_12_hsl110e+1.23629716416673e-06*a5_np_12_hsl110e*comp5_np_12_hsl110e)
parameters 	dcjsw_n_12_hsl110e_g	  =	alpha_n_12_hsl110e*(1.21664394044842e-12*a1_np_12_hsl110e*comp1_np_12_hsl110e+2.55486053437347e-12*a2_np_12_hsl110e*comp2_np_12_hsl110e+2.02925651255511e-13*a3_np_12_hsl110e*comp3_np_12_hsl110e+4.69071603531165e-13*a4_np_12_hsl110e*comp4_np_12_hsl110e+8.59937219184809e-14*a5_np_12_hsl110e*comp5_np_12_hsl110e)
parameters 	dcjswg_n_12_hsl110e_g	  =	alpha_n_12_hsl110e*(3.70868323899267e-12*a1_np_12_hsl110e*comp1_np_12_hsl110e+7.78795515005191e-12*a2_np_12_hsl110e*comp2_np_12_hsl110e+6.18576180386521e-13*a3_np_12_hsl110e*comp3_np_12_hsl110e+1.4298661556332e-12*a4_np_12_hsl110e*comp4_np_12_hsl110e+-2.48061728264753e-12*a5_np_12_hsl110e*comp5_np_12_hsl110e)
parameters 	dvsat_n_12_hsl110e_g	  =	alpha_n_12_hsl110e*(60.6908251378388*a1_np_12_hsl110e*comp1_np_12_hsl110e+-138.57478714801*a2_np_12_hsl110e*comp2_np_12_hsl110e+88.7158399481457*a3_np_12_hsl110e*comp3_np_12_hsl110e+291.111171125323*a4_np_12_hsl110e*comp4_np_12_hsl110e+-376.800305493933*a5_np_12_hsl110e*comp5_np_12_hsl110e)
parameters 	dwags_n_12_hsl110e_g	  =	alpha_n_12_hsl110e*(8.34423242045136e-10*a1_np_12_hsl110e*comp1_np_12_hsl110e+9.79341275466746e-10*a2_np_12_hsl110e*comp2_np_12_hsl110e+-1.39951799498673e-10*a3_np_12_hsl110e*comp3_np_12_hsl110e+-7.83601960172535e-11*a4_np_12_hsl110e*comp4_np_12_hsl110e+-5.06204799940858e-10*a5_np_12_hsl110e*comp5_np_12_hsl110e)
parameters 	dpvsat_n_12_hsl110e_g	  =	alpha_n_12_hsl110e*(1.13822067116028e-12*a1_np_12_hsl110e*comp1_np_12_hsl110e+-2.59155733192102e-12*a2_np_12_hsl110e*comp2_np_12_hsl110e+9.78110408521743e-12*a3_np_12_hsl110e*comp3_np_12_hsl110e+5.79039771388097e-13*a4_np_12_hsl110e*comp4_np_12_hsl110e+4.66081551328454e-12*a5_np_12_hsl110e*comp5_np_12_hsl110e)
parameters 	dtox_p_12_hsl110e_g	  =	alpha_p_12_hsl110e*(6.96149660260723e-12*a1_np_12_hsl110e*comp1_np_12_hsl110e+9.7894784981206e-13*a2_np_12_hsl110e*comp2_np_12_hsl110e+-1.59362066538782e-12*a3_np_12_hsl110e*comp3_np_12_hsl110e+-1.04836586744647e-12*a4_np_12_hsl110e*comp4_np_12_hsl110e+-1.21490388724249e-12*a5_np_12_hsl110e*comp5_np_12_hsl110e)
parameters 	dxl_p_12_hsl110e_g	  =	alpha_p_12_hsl110e*(3.09090737882983e-10*a1_np_12_hsl110e*comp1_np_12_hsl110e+-2.14750503216684e-10*a2_np_12_hsl110e*comp2_np_12_hsl110e+4.06449792803096e-10*a3_np_12_hsl110e*comp3_np_12_hsl110e+-2.33001616789102e-12*a4_np_12_hsl110e*comp4_np_12_hsl110e+1.15619040099272e-10*a5_np_12_hsl110e*comp5_np_12_hsl110e)
parameters 	du0_p_12_hsl110e_g	  =	alpha_p_12_hsl110e*(-9.62801175410298e-05*a1_np_12_hsl110e*comp1_np_12_hsl110e+8.44109888518047e-05*a2_np_12_hsl110e*comp2_np_12_hsl110e+1.82593858588695e-05*a3_np_12_hsl110e*comp3_np_12_hsl110e+3.65373282437749e-05*a4_np_12_hsl110e*comp4_np_12_hsl110e+1.01147907338509e-04*a5_np_12_hsl110e*comp5_np_12_hsl110e)
parameters 	dvth0_p_12_hsl110e_g	  =	alpha_p_12_hsl110e*(-4.09369176805879e-03*a1_np_12_hsl110e*comp1_np_12_hsl110e+3.89801723008769e-03*a2_np_12_hsl110e*comp2_np_12_hsl110e+1.9702042653698e-03*a3_np_12_hsl110e*comp3_np_12_hsl110e+1.69551880991473e-03*a4_np_12_hsl110e*comp4_np_12_hsl110e+6.23059804436212e-04*a5_np_12_hsl110e*comp5_np_12_hsl110e)
parameters 	drdsw_p_12_hsl110e_g	  =	alpha_p_12_hsl110e*(5.84521296866256*a1_np_12_hsl110e*comp1_np_12_hsl110e+-4.31009237725101*a2_np_12_hsl110e*comp2_np_12_hsl110e+-2.37458004131329*a3_np_12_hsl110e*comp3_np_12_hsl110e+-2.28459005518174*a4_np_12_hsl110e*comp4_np_12_hsl110e+-0.976227222844893*a5_np_12_hsl110e*comp5_np_12_hsl110e)
parameters 	dxw_p_12_hsl110e_g	  =	alpha_p_12_hsl110e*(-1.88394436968717e-09*a1_np_12_hsl110e*comp1_np_12_hsl110e+1.12985635034697e-09*a2_np_12_hsl110e*comp2_np_12_hsl110e+-2.34626755856692e-09*a3_np_12_hsl110e*comp3_np_12_hsl110e+-9.53789297806714e-11*a4_np_12_hsl110e*comp4_np_12_hsl110e+-6.93315960956396e-10*a5_np_12_hsl110e*comp5_np_12_hsl110e)
parameters 	dnlx_p_12_hsl110e_g	  =	alpha_p_12_hsl110e*(1.75063945291896e-09*a1_np_12_hsl110e*comp1_np_12_hsl110e+-1.34137001031174e-09*a2_np_12_hsl110e*comp2_np_12_hsl110e+-6.82172466111056e-10*a3_np_12_hsl110e*comp3_np_12_hsl110e+-8.2479887389491e-10*a4_np_12_hsl110e*comp4_np_12_hsl110e+-5.72661284572385e-10*a5_np_12_hsl110e*comp5_np_12_hsl110e)
parameters 	dk3_p_12_hsl110e_g	  =	alpha_p_12_hsl110e*(2.83639589549859*a1_np_12_hsl110e*comp1_np_12_hsl110e+-2.07777041676888*a2_np_12_hsl110e*comp2_np_12_hsl110e+-1.39752304942007*a3_np_12_hsl110e*comp3_np_12_hsl110e+-1.39117887054354*a4_np_12_hsl110e*comp4_np_12_hsl110e+3.79199434757276e-02*a5_np_12_hsl110e*comp5_np_12_hsl110e)
parameters 	dpvth0_p_12_hsl110e_g	  =	alpha_p_12_hsl110e*(-6.58421547158392e-17*a1_np_12_hsl110e*comp1_np_12_hsl110e+4.25186111556154e-17*a2_np_12_hsl110e*comp2_np_12_hsl110e+1.21563119379023e-17*a3_np_12_hsl110e*comp3_np_12_hsl110e+1.95981928647583e-17*a4_np_12_hsl110e*comp4_np_12_hsl110e+-6.05844448644058e-18*a5_np_12_hsl110e*comp5_np_12_hsl110e)
parameters 	dwwl_p_12_hsl110e_g	  =	alpha_p_12_hsl110e*(3.77076093538701e-24*a1_np_12_hsl110e*comp1_np_12_hsl110e+-2.19381427243915e-24*a2_np_12_hsl110e*comp2_np_12_hsl110e+1.15937722326325e-24*a3_np_12_hsl110e*comp3_np_12_hsl110e+2.51183930786377e-24*a4_np_12_hsl110e*comp4_np_12_hsl110e+2.26442189895921e-24*a5_np_12_hsl110e*comp5_np_12_hsl110e)
parameters 	dags_p_12_hsl110e_g	  =	alpha_p_12_hsl110e*(1.96378426980223e-02*a1_np_12_hsl110e*comp1_np_12_hsl110e+-1.37682622585188e-02*a2_np_12_hsl110e*comp2_np_12_hsl110e+-6.81967235125063e-03*a3_np_12_hsl110e*comp3_np_12_hsl110e+-7.48846170851709e-03*a4_np_12_hsl110e*comp4_np_12_hsl110e+3.66767912753549e-03*a5_np_12_hsl110e*comp5_np_12_hsl110e)
parameters 	dcgdo_p_12_hsl110e_g	  =	alpha_p_12_hsl110e*(-2.63693053129061e-12*a1_np_12_hsl110e*comp1_np_12_hsl110e+-3.70813579474264e-13*a2_np_12_hsl110e*comp2_np_12_hsl110e+6.03644191434775e-13*a3_np_12_hsl110e*comp3_np_12_hsl110e+3.97108283123656e-13*a4_np_12_hsl110e*comp4_np_12_hsl110e+-5.18666585233881e-14*a5_np_12_hsl110e*comp5_np_12_hsl110e)
parameters 	dcgso_p_12_hsl110e_g	  =	alpha_p_12_hsl110e*(-2.63693053129061e-12*a1_np_12_hsl110e*comp1_np_12_hsl110e+-3.70813579474264e-13*a2_np_12_hsl110e*comp2_np_12_hsl110e+6.03644191434775e-13*a3_np_12_hsl110e*comp3_np_12_hsl110e+3.97108283123656e-13*a4_np_12_hsl110e*comp4_np_12_hsl110e+-5.18666585233881e-14*a5_np_12_hsl110e*comp5_np_12_hsl110e)
parameters 	dcj_p_12_hsl110e_g	  =	alpha_p_12_hsl110e*(1.36914144106354e-05*a1_np_12_hsl110e*comp1_np_12_hsl110e+-2.13128512016941e-05*a2_np_12_hsl110e*comp2_np_12_hsl110e+-7.82753108891239e-06*a3_np_12_hsl110e*comp3_np_12_hsl110e+-8.42071954336455e-06*a4_np_12_hsl110e*comp4_np_12_hsl110e+1.49725644520729e-05*a5_np_12_hsl110e*comp5_np_12_hsl110e)
parameters 	dcjsw_p_12_hsl110e_g	  =	alpha_p_12_hsl110e*(1.66727234309079e-12*a1_np_12_hsl110e*comp1_np_12_hsl110e+-2.59537300495346e-12*a2_np_12_hsl110e*comp2_np_12_hsl110e+-9.53197800300994e-13*a3_np_12_hsl110e*comp3_np_12_hsl110e+-1.02543333964605e-12*a4_np_12_hsl110e*comp4_np_12_hsl110e+3.4046299756715e-13*a5_np_12_hsl110e*comp5_np_12_hsl110e)
parameters 	dcjswg_p_12_hsl110e_g	  =	alpha_p_12_hsl110e*(6.8103836387268e-12*a1_np_12_hsl110e*comp1_np_12_hsl110e+-1.06014388846404e-11*a2_np_12_hsl110e*comp2_np_12_hsl110e+-3.89357067580575e-12*a3_np_12_hsl110e*comp3_np_12_hsl110e+-4.18863448906267e-12*a4_np_12_hsl110e*comp4_np_12_hsl110e+1.80134536512064e-12*a5_np_12_hsl110e*comp5_np_12_hsl110e)
parameters 	dvsat_p_12_hsl110e_g	  =	alpha_p_12_hsl110e*(2556.23918227949*a1_np_12_hsl110e*comp1_np_12_hsl110e+-1338.06801406936*a2_np_12_hsl110e*comp2_np_12_hsl110e+2959.98742210475*a3_np_12_hsl110e*comp3_np_12_hsl110e+405.638033328856*a4_np_12_hsl110e*comp4_np_12_hsl110e+922.372486197564*a5_np_12_hsl110e*comp5_np_12_hsl110e)
parameters 	dwags_p_12_hsl110e_g	  =	alpha_p_12_hsl110e*(9.79704583875557e-10*a1_np_12_hsl110e*comp1_np_12_hsl110e+-8.39170952407964e-10*a2_np_12_hsl110e*comp2_np_12_hsl110e+-1.67485840466564e-09*a3_np_12_hsl110e*comp3_np_12_hsl110e+-5.72604724145853e-10*a4_np_12_hsl110e*comp4_np_12_hsl110e+-1.62017238525482e-10*a5_np_12_hsl110e*comp5_np_12_hsl110e)
parameters 	dpvsat_p_12_hsl110e_g	  =	alpha_p_12_hsl110e*(2.76819438006762e-11*a1_np_12_hsl110e*comp1_np_12_hsl110e+-3.06312592148245e-11*a2_np_12_hsl110e*comp2_np_12_hsl110e+-7.05686778334858e-11*a3_np_12_hsl110e*comp3_np_12_hsl110e+1.27663619540966e-10*a4_np_12_hsl110e*comp4_np_12_hsl110e+7.9189397428952e-11*a5_np_12_hsl110e*comp5_np_12_hsl110e)
parameters 	dpags_p_12_hsl110e_g	  =	alpha_p_12_hsl110e*(3.81032014555613e-15*a1_np_12_hsl110e*comp1_np_12_hsl110e+-2.7401779979194e-15*a2_np_12_hsl110e*comp2_np_12_hsl110e+7.10520642759761e-15*a3_np_12_hsl110e*comp3_np_12_hsl110e+-7.73967290815829e-15*a4_np_12_hsl110e*comp4_np_12_hsl110e+-2.38461781888633e-15*a5_np_12_hsl110e*comp5_np_12_hsl110e)
