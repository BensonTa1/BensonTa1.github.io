simulator lang=spectre insensitive=yes
+ etoption1  = ptions                                                      gmin       = 1e-13
inline subckt n_33_l110e ( d g s b )
parameters w=0u l=0u
+ dtemp=0 nf=1 mf=1 mis_flag=1
+ nf_odd=nf-2*int(nf/2) nf_even=1-nf_odd
+ sa=0 sb=0 sd=0
+ a_unit=sd*w   p_unit=2*(sd+w)  a_sa_edge=sa*w   p_sa_edge=2*(sa+w)
+ a_sb_edge=sb*w   p_sb_edge=2*(sb+w)
+ ad=(nf_odd*(a_unit*((nf+1)/2-1)+a_sb_edge) + nf_even*(a_unit*nf/2))/nf
+ as=(nf_odd*(a_unit*((nf+1)/2-1)+a_sa_edge) + nf_even*(a_unit*(nf/2-1)+a_sa_edge+a_sb_edge))/nf
+ pd=(nf_odd*(p_unit*((nf+1)/2-1)+p_sb_edge) + nf_even*(p_unit*nf/2))/nf
+ ps=(nf_odd*(p_unit*((nf+1)/2-1)+p_sa_edge) + nf_even*(p_unit*(nf/2-1)+p_sa_edge+p_sb_edge))/nf
//
//

parameters beta  = 1
parameters compl1	= 7.42703514570425
parameters compl2	= 4.98071310168044
parameters compl3	= 0.169054373657777
parameters compl4	= 5.53765472414446e-02
parameters compl5	= 1.27268445825736e-13
parameters l_factor_n=1/sqrt(2*w*0.9*(l*0.9+12e-9)*mf*1e+12)
parameters  b1_np_33_l110e = b1_np_33_l110e_xx
parameters  b2_np_33_l110e = b2_np_33_l110e_xx
parameters  b3_np_33_l110e = b3_np_33_l110e_xx
parameters  b4_np_33_l110e = b4_np_33_l110e_xx
parameters  b5_np_33_l110e = b5_np_33_l110e_xx
parameters  dtox_n_33_l110e_l = beta*(0*b1_np_33_l110e*compl1+0*b2_np_33_l110e*compl2+0*b3_np_33_l110e*compl3+0*b4_np_33_l110e*compl4+0*b5_np_33_l110e*compl5)* mis_flag*l_factor_n
parameters  dxl_n_33_l110e_l = beta*(0*b1_np_33_l110e*compl1+0*b2_np_33_l110e*compl2+0*b3_np_33_l110e*compl3+0*b4_np_33_l110e*compl4+0*b5_np_33_l110e*compl5)* mis_flag*l_factor_n
parameters  du0_n_33_l110e_l = beta*(-2.17904879479892e-05*b1_np_33_l110e*compl1+2.78291342807903e-05*b2_np_33_l110e*compl2+-3.00613830374162e-06*b3_np_33_l110e*compl3+2.4159809221672e-05*b4_np_33_l110e*compl4+8.13544086937782e-05*b5_np_33_l110e*compl5)* mis_flag*l_factor_n
parameters  dvth0_n_33_l110e_l = beta*(-1.22942337866237e-03*b1_np_33_l110e*compl1+1.5868620213625e-03*b2_np_33_l110e*compl2+2.25712963186997e-04*b3_np_33_l110e*compl3+1.29899870676079e-04*b4_np_33_l110e*compl4+1.44510078491726e-03*b5_np_33_l110e*compl5)* mis_flag*l_factor_n
parameters  drdsw_n_33_l110e_l = beta*(-0.583550900674499*b1_np_33_l110e*compl1+0.76539524537797*b2_np_33_l110e*compl2+0.497725586513749*b3_np_33_l110e*compl3+-0.819286574493792*b4_np_33_l110e*compl4+-1.27296825348759*b5_np_33_l110e*compl5)* mis_flag*l_factor_n
parameters  dxw_n_33_l110e_l = beta*(0*b1_np_33_l110e*compl1+0*b2_np_33_l110e*compl2+0*b3_np_33_l110e*compl3+0*b4_np_33_l110e*compl4+0*b5_np_33_l110e*compl5)* mis_flag*l_factor_n
parameters  dnlx_n_33_l110e_l = beta*(0*b1_np_33_l110e*compl1+0*b2_np_33_l110e*compl2+0*b3_np_33_l110e*compl3+0*b4_np_33_l110e*compl4+0*b5_np_33_l110e*compl5)* mis_flag*l_factor_n
parameters  dk3_n_33_l110e_l = beta*(0*b1_np_33_l110e*compl1+0*b2_np_33_l110e*compl2+0*b3_np_33_l110e*compl3+0*b4_np_33_l110e*compl4+0*b5_np_33_l110e*compl5)* mis_flag*l_factor_n
parameters  dpvth0_n_33_l110e_l = beta*(0*b1_np_33_l110e*compl1+0*b2_np_33_l110e*compl2+0*b3_np_33_l110e*compl3+0*b4_np_33_l110e*compl4+0*b5_np_33_l110e*compl5)* mis_flag*l_factor_n
parameters  dwwl_n_33_l110e_l = beta*(0*b1_np_33_l110e*compl1+0*b2_np_33_l110e*compl2+0*b3_np_33_l110e*compl3+0*b4_np_33_l110e*compl4+0*b5_np_33_l110e*compl5)* mis_flag*l_factor_n
parameters  dcgdo_n_33_l110e_l = beta*(0*b1_np_33_l110e*compl1+0*b2_np_33_l110e*compl2+0*b3_np_33_l110e*compl3+0*b4_np_33_l110e*compl4+0*b5_np_33_l110e*compl5)* mis_flag*l_factor_n
parameters  dcgso_n_33_l110e_l = beta*(0*b1_np_33_l110e*compl1+0*b2_np_33_l110e*compl2+0*b3_np_33_l110e*compl3+0*b4_np_33_l110e*compl4+0*b5_np_33_l110e*compl5)* mis_flag*l_factor_n
parameters  dcj_n_33_l110e_l = beta*(0*b1_np_33_l110e*compl1+0*b2_np_33_l110e*compl2+0*b3_np_33_l110e*compl3+0*b4_np_33_l110e*compl4+0*b5_np_33_l110e*compl5)* mis_flag*l_factor_n
parameters  dcjsw_n_33_l110e_l = beta*(0*b1_np_33_l110e*compl1+0*b2_np_33_l110e*compl2+0*b3_np_33_l110e*compl3+0*b4_np_33_l110e*compl4+0*b5_np_33_l110e*compl5)* mis_flag*l_factor_n
parameters  dcjswg_n_33_l110e_l = beta*(0*b1_np_33_l110e*compl1+0*b2_np_33_l110e*compl2+0*b3_np_33_l110e*compl3+0*b4_np_33_l110e*compl4+0*b5_np_33_l110e*compl5)* mis_flag*l_factor_n
parameters  dcgdl_n_33_l110e_l = beta*(0*b1_np_33_l110e*compl1+0*b2_np_33_l110e*compl2+0*b3_np_33_l110e*compl3+0*b4_np_33_l110e*compl4+0*b5_np_33_l110e*compl5)* mis_flag*l_factor_n
parameters  dcgsl_n_33_l110e_l = beta*(0*b1_np_33_l110e*compl1+0*b2_np_33_l110e*compl2+0*b3_np_33_l110e*compl3+0*b4_np_33_l110e*compl4+0*b5_np_33_l110e*compl5)* mis_flag*l_factor_n
parameters  dtox_n_33_l110e = (global_flag_n_33_l110e*dtox_n_33_l110e_g  + local_flag_n_33_l110e*dtox_n_33_l110e_l)*(1-total_flag_n_33_l110e)+ total_flag_n_33_l110e*dtox_n_33_l110e_t
parameters  dxl_n_33_l110e = (global_flag_n_33_l110e*dxl_n_33_l110e_g  + local_flag_n_33_l110e*dxl_n_33_l110e_l)*(1-total_flag_n_33_l110e)+ total_flag_n_33_l110e*dxl_n_33_l110e_t
parameters  du0_n_33_l110e = (global_flag_n_33_l110e*du0_n_33_l110e_g  + local_flag_n_33_l110e*du0_n_33_l110e_l)*(1-total_flag_n_33_l110e)+ total_flag_n_33_l110e*du0_n_33_l110e_t
parameters  dvth0_n_33_l110e = (global_flag_n_33_l110e*dvth0_n_33_l110e_g  + local_flag_n_33_l110e*dvth0_n_33_l110e_l)*(1-total_flag_n_33_l110e)+ total_flag_n_33_l110e*dvth0_n_33_l110e_t
parameters  drdsw_n_33_l110e = (global_flag_n_33_l110e*drdsw_n_33_l110e_g  + local_flag_n_33_l110e*drdsw_n_33_l110e_l)*(1-total_flag_n_33_l110e)+ total_flag_n_33_l110e*drdsw_n_33_l110e_t
parameters  dxw_n_33_l110e = (global_flag_n_33_l110e*dxw_n_33_l110e_g  + local_flag_n_33_l110e*dxw_n_33_l110e_l)*(1-total_flag_n_33_l110e)+ total_flag_n_33_l110e*dxw_n_33_l110e_t
parameters  dnlx_n_33_l110e = (global_flag_n_33_l110e*dnlx_n_33_l110e_g  + local_flag_n_33_l110e*dnlx_n_33_l110e_l)*(1-total_flag_n_33_l110e)+ total_flag_n_33_l110e*dnlx_n_33_l110e_t
parameters  dk3_n_33_l110e = (global_flag_n_33_l110e*dk3_n_33_l110e_g  + local_flag_n_33_l110e*dk3_n_33_l110e_l)*(1-total_flag_n_33_l110e)+ total_flag_n_33_l110e*dk3_n_33_l110e_t
parameters  dpvth0_n_33_l110e = (global_flag_n_33_l110e*dpvth0_n_33_l110e_g  + local_flag_n_33_l110e*dpvth0_n_33_l110e_l)*(1-total_flag_n_33_l110e)+ total_flag_n_33_l110e*dpvth0_n_33_l110e_t
parameters  dwwl_n_33_l110e = (global_flag_n_33_l110e*dwwl_n_33_l110e_g  + local_flag_n_33_l110e*dwwl_n_33_l110e_l)*(1-total_flag_n_33_l110e)+ total_flag_n_33_l110e*dwwl_n_33_l110e_t
parameters  dcgdo_n_33_l110e = (global_flag_n_33_l110e*dcgdo_n_33_l110e_g  + local_flag_n_33_l110e*dcgdo_n_33_l110e_l)*(1-total_flag_n_33_l110e)+ total_flag_n_33_l110e*dcgdo_n_33_l110e_t
parameters  dcgso_n_33_l110e = (global_flag_n_33_l110e*dcgso_n_33_l110e_g  + local_flag_n_33_l110e*dcgso_n_33_l110e_l)*(1-total_flag_n_33_l110e)+ total_flag_n_33_l110e*dcgso_n_33_l110e_t
parameters  dcj_n_33_l110e = (global_flag_n_33_l110e*dcj_n_33_l110e_g  + local_flag_n_33_l110e*dcj_n_33_l110e_l)*(1-total_flag_n_33_l110e)+ total_flag_n_33_l110e*dcj_n_33_l110e_t
parameters  dcjsw_n_33_l110e = (global_flag_n_33_l110e*dcjsw_n_33_l110e_g  + local_flag_n_33_l110e*dcjsw_n_33_l110e_l)*(1-total_flag_n_33_l110e)+ total_flag_n_33_l110e*dcjsw_n_33_l110e_t
parameters  dcjswg_n_33_l110e = (global_flag_n_33_l110e*dcjswg_n_33_l110e_g  + local_flag_n_33_l110e*dcjswg_n_33_l110e_l)*(1-total_flag_n_33_l110e)+ total_flag_n_33_l110e*dcjswg_n_33_l110e_t
parameters  dcgdl_n_33_l110e = (global_flag_n_33_l110e*dcgdl_n_33_l110e_g  + local_flag_n_33_l110e*dcgdl_n_33_l110e_l)*(1-total_flag_n_33_l110e)+ total_flag_n_33_l110e*dcgdl_n_33_l110e_t
parameters  dcgsl_n_33_l110e = (global_flag_n_33_l110e*dcgsl_n_33_l110e_g  + local_flag_n_33_l110e*dcgsl_n_33_l110e_l)*(1-total_flag_n_33_l110e)+ total_flag_n_33_l110e*dcgsl_n_33_l110e_t

//
n_33_l110e ( d g s b ) n_33_l110e_main trise=dtemp w=w l=l as=as ad=ad ps=ps pd=pd
+ m=1 dtemp=dtemp
+ sa=sa sb=sb
model n_33_l110e_main bsim3v3 type=n
+ lmin       = 3.06e-007                                                   lmax       = 5e-005
+ wmin       = 1.6e-007                                                    wmax       = 0.0001
+ version    = 3.24                                                        mobmod     = 1
+ capmod     = 3                                                           nqsmod     = 0
+ binunit    = 2
+ tnom       = 25                                                          xl         = 3e-009+dxl_n_33_l110e
+ xw         = 1e-009+dxw_n_33_l110e                                       llc        = 1.205e-014
+ tox        = 7.49e-009+dtox_n_33_l110e                                   toxm       = 7.49e-009
+ wint       = 3.2825e-008                                                 lint       = -8.4375e-010
+ hdif       = 1.34e-007                                                   ldif       = 7.9e-008
+ ll         = -7.4526e-015                                                wl         = -1.7696e-014
+ lln        = 1.0169                                                      wln        = 0.91057
+ lw         = -2.4007e-021                                                ww         = -5.4e-016
+ lwn        = 0.80487                                                     wwn        = 1.1
+ lwl        = 2.6125e-021                                                 wwl        = -2.185e-022+dwwl_n_33_l110e
+ cgbo       = 0                                                           cgso       = 0.5e-010+dcgso_n_33_l110e
+ cgdo       = 0.5e-010+dcgdo_n_33_l110e                                   xpart      = 1
+ dlc        = -2e-08                                                      dwc        = 2.5513e-12
+ wwc        = 8.526e-017                                                  vth0       = 0.58+dvth0_n_33_l110e
+ lvth0      = 5.41e-008                                                   pvth0      = 5.2892e-016+dpvth0_n_33_l110e
+ k1         = 0.66941                                                     lk1        = -2.4077e-008
+ pk1        = 1.444e-015                                                  k2         = -0.022002
+ lk2        = -2.7444e-008                                                pk2        = 2.2634e-015
+ k3         = 1.3864+dk3_n_33_l110e                                       wk3        = -1.7211e-007
+ k3b        = 0.653                                                       wk3b       = 6.7694e-009
+ nlx        = 8.8279e-010+dnlx_n_33_l110e                                 dvt0       = 15.586
+ dvt1       = 0.5183                                                      dvt2       = -0.00050685
+ dvt0w      = 3.7409                                                      dvt1w      = 2525600
+ dvt2w      = -0.0011914                                                  nch        = 6.6276e+017
+ voff       = -0.11991                                                    nfactor    = 0.496
+ lnfactor   = 2.8315e-008                                                 cdsc       = 0
+ cdscb      = 0                                                           cdscd      = 0
+ cit        = 0                                                           u0         = 0.039168+du0_n_33_l110e
+ lu0        = 7.178e-011                                                  ua         = 6.6366e-011
+ lua        = -3.4684e-016                                                wua        = 1.1680002e-017
+ ub         = 1.4084e-018                                                 uc         = 5.214e-011
+ luc        = -3.226e-017                                                 ngate      = 1.8243e+020
+ xj         = 1.07e-007                                                   w0         = 7.9515e-009
+ prwg       = 0.31168                                                     pprwg      = -9.0909e-015
+ prwb       = -0.085385                                                   wr         = 1
+ rdsw       = 324.3+drdsw_n_33_l110e                                      a0         = 1.4269
+ la0        = -5.556e-007                                                 ags        = 0.26485
+ a1         = 0.013218                                                    a2         = 0.55622
+ b0         = 6.3623e-007                                                 wb0        = -6.3648e-014
+ b1         = 1.49e-006                                                   vsat       = 116450
+ keta       = -0.048114                                                   lketa      = 1.71e-008
+ wketa      = 2.324e-009                                                  dwg        = -2.509e-009
+ dwb        = 2.11e-009                                                   alpha0     = 1.7136e-005
+ beta0      = 31.2                                                        pclm       = 2.8362758
+ ppclm      = 1.2032e-013                                                 pdiblc1    = 0.00668673
+ pdiblc2    = 0.00153                                                     pdiblcb    = 0.22473
+ drout      = 0.834991                                                    pvag       = 0.004912788
+ pscbe1     = 2.496e+008                                                  pscbe2     = 9.94e-008
+ delta      = 0.011608656                                                 eta0       = 0.608
+ peta0      = -5.38e-015                                                  etab       = -0.013791
+ petab      = 1.068e-015                                                  dsub       = 0.4571169
+ elm        = 5                                                           alpha1     = 74.298
+ vfb        = -0.7706789                                                  cf         = 6.83e-011
+ ckappa     = 0.5                                                         cgdl       = 1.8e-010+dcgdl_n_33_l110e
+ cgsl       = 1.8e-010+dcgsl_n_33_l110e                                   acde       = 0.46654
+ moin       = 22.546                                                      noff       = 2.9038
+ voffcv     = -0.088241                                                   kt1        = -0.3186688
+ kt1l       = 2.3155e-008                                                 kt2        = -0.03874474
+ lkt2       = 1.1e-008                                                    ute        = -1.05
+ lute       = -3.959829e-010                                              wute       = 4.911742e-008
+ ua1        = 3.25e-009                                                   lua1       = -7.70616e-016
+ wua1       = 4.64e-017                                                   pua1       = 1e-023
+ ub1        = -3.8e-018                                                   lub1       = 1.377533e-024
+ uc1        = -5.6e-011                                                   luc1       = 5.911338e-017
+ prt        = -300                                                        at         = 73200
+ noimod     = 2                                                           noia       = 1.7800000e+21
+ noib       = 1.4500000e+05                                               noic       = -9.55000e-13
+ em         = 2.5000000e+07                                               ef         = 0.9077
+ rsh        = 8.5                                                         js         = 7.49e-008
+ jsw        = 1.08e-013                                                   cj         = 0.00078+dcj_n_33_l110e
+ mj         = 0.278                                                       cjsw       = 1.08e-010+dcjsw_n_33_l110e
+ mjsw       = 0.12                                                        pb         = 0.608
+ rd         = 0                                                           rdc        = 0
+ rs         = 0                                                           rsc        = 0
+ xti        = 3                                                           nj         = 1.0161
+ pbsw       = 0.8                                                         cjswg      = 2.3e-010+dcjswg_n_33_l110e
+ pbswg      = 0.905                                                       mjswg      = 0.624
+ tcj        = 0.0009                                                      tcjsw      = 0.0004
+ tpb        = 0.001494                                                    tpbsw      = 0.0006
+ saref      = 2.2e-006                                                    sbref      = 2.2e-006
+ wlod       = 0                                                           kvth0      = 5.250e-09
+ lkvth0     = -2.710e-8                                                   wkvth0     = 0
+ pkvth0     = 0                                                           llodvth    = 1
+ wlodvth    = 1                                                           stk2       = 5.6e-10
+ lodk2      = 1                                                           lodeta0    = 1
+ ku0        = -1.51e-7                                                    lku0       = 5.557e-7
+ wku0       = 0                                                           pku0       = 0
+ llodku0    = 1.120e+00                                                   wlodku0    = 1
+ kvsat      = 1                                                           steta0     = 0.000e+00
+ tku0       = 0
+ minr=0.01                 imax=0.1
ends n_33_l110e
//
//
//
inline subckt p_33_l110e ( d g s b )
parameters w=0u l=0u
+ dtemp=0 nf=1 mf=1 mis_flag=1
+ nf_odd=nf-2*int(nf/2) nf_even=1-nf_odd
+ sa=0 sb=0 sd=0
+ a_unit=sd*w   p_unit=2*(sd+w)  a_sa_edge=sa*w   p_sa_edge=2*(sa+w)
+ a_sb_edge=sb*w   p_sb_edge=2*(sb+w)
+ ad=(nf_odd*(a_unit*((nf+1)/2-1)+a_sb_edge) + nf_even*(a_unit*nf/2))/nf
+ as=(nf_odd*(a_unit*((nf+1)/2-1)+a_sa_edge) + nf_even*(a_unit*(nf/2-1)+a_sa_edge+a_sb_edge))/nf
+ pd=(nf_odd*(p_unit*((nf+1)/2-1)+p_sb_edge) + nf_even*(p_unit*nf/2))/nf
+ ps=(nf_odd*(p_unit*((nf+1)/2-1)+p_sa_edge) + nf_even*(p_unit*(nf/2-1)+p_sa_edge+p_sb_edge))/nf
//
//

parameters beta  = 1
parameters compl1	= 7.42703514570425
parameters compl2	= 4.98071310168044
parameters compl3	= 0.169054373657777
parameters compl4	= 5.53765472414446e-02
parameters compl5	= 1.27268445825736e-13
parameters l_factor_p=1/sqrt(2*w*0.9*(l*0.9+12e-9)*mf*1e+12)
parameters b1_np_33_l110e = b1_np_33_l110e_xx
parameters b2_np_33_l110e = b2_np_33_l110e_xx
parameters b3_np_33_l110e = b3_np_33_l110e_xx
parameters b4_np_33_l110e = b4_np_33_l110e_xx
parameters b5_np_33_l110e = b5_np_33_l110e_xx
parameters  dtox_p_33_l110e_l = beta*(0*b1_np_33_l110e*compl1+0*b2_np_33_l110e*compl2+0*b3_np_33_l110e*compl3+0*b4_np_33_l110e*compl4+0*b5_np_33_l110e*compl5)* mis_flag*l_factor_p
parameters  dxl_p_33_l110e_l = beta*(0*b1_np_33_l110e*compl1+0*b2_np_33_l110e*compl2+0*b3_np_33_l110e*compl3+0*b4_np_33_l110e*compl4+0*b5_np_33_l110e*compl5)* mis_flag*l_factor_p
parameters  du0_p_33_l110e_l = beta*(-1.91443658282247e-08*b1_np_33_l110e*compl1+1.80927593367808e-06*b2_np_33_l110e*compl2+-3.48308610271757e-06*b3_np_33_l110e*compl3+1.68528737379946e-06*b4_np_33_l110e*compl4+-1.30935324403904e-06*b5_np_33_l110e*compl5)* mis_flag*l_factor_p
parameters  dvth0_p_33_l110e_l = beta*(4.57743851753258e-04*b1_np_33_l110e*compl1+7.74204910158086e-04*b2_np_33_l110e*compl2+3.51213519776528e-04*b3_np_33_l110e*compl3+-7.97535880185586e-04*b4_np_33_l110e*compl4+1.9939876397303e-04*b5_np_33_l110e*compl5)* mis_flag*l_factor_p
parameters  drdsw_p_33_l110e_l = beta*(-2.18834660947854*b1_np_33_l110e*compl1+-2.243877664779*b2_np_33_l110e*compl2+-5.56076785641547*b3_np_33_l110e*compl3+-7.19903991597131*b4_np_33_l110e*compl4+2.12134346908021*b5_np_33_l110e*compl5)* mis_flag*l_factor_p
parameters  dxw_p_33_l110e_l = beta*(0*b1_np_33_l110e*compl1+0*b2_np_33_l110e*compl2+0*b3_np_33_l110e*compl3+0*b4_np_33_l110e*compl4+0*b5_np_33_l110e*compl5)* mis_flag*l_factor_p
parameters  dnlx_p_33_l110e_l = beta*(0*b1_np_33_l110e*compl1+0*b2_np_33_l110e*compl2+0*b3_np_33_l110e*compl3+0*b4_np_33_l110e*compl4+0*b5_np_33_l110e*compl5)* mis_flag*l_factor_p
parameters  dk3_p_33_l110e_l = beta*(0*b1_np_33_l110e*compl1+0*b2_np_33_l110e*compl2+0*b3_np_33_l110e*compl3+0*b4_np_33_l110e*compl4+0*b5_np_33_l110e*compl5)* mis_flag*l_factor_p
parameters  dpvth0_p_33_l110e_l = beta*(0*b1_np_33_l110e*compl1+0*b2_np_33_l110e*compl2+0*b3_np_33_l110e*compl3+0*b4_np_33_l110e*compl4+0*b5_np_33_l110e*compl5)* mis_flag*l_factor_p
parameters  dwwl_p_33_l110e_l = beta*(0*b1_np_33_l110e*compl1+0*b2_np_33_l110e*compl2+0*b3_np_33_l110e*compl3+0*b4_np_33_l110e*compl4+0*b5_np_33_l110e*compl5)* mis_flag*l_factor_p
parameters  dcgdl_p_33_l110e_l = beta*(0*b1_np_33_l110e*compl1+0*b2_np_33_l110e*compl2+0*b3_np_33_l110e*compl3+0*b4_np_33_l110e*compl4+0*b5_np_33_l110e*compl5)* mis_flag*l_factor_p
parameters  dcgsl_p_33_l110e_l = beta*(0*b1_np_33_l110e*compl1+0*b2_np_33_l110e*compl2+0*b3_np_33_l110e*compl3+0*b4_np_33_l110e*compl4+0*b5_np_33_l110e*compl5)* mis_flag*l_factor_p
parameters  dcgdo_p_33_l110e_l = beta*(0*b1_np_33_l110e*compl1+0*b2_np_33_l110e*compl2+0*b3_np_33_l110e*compl3+0*b4_np_33_l110e*compl4+0*b5_np_33_l110e*compl5)* mis_flag*l_factor_p
parameters  dcgso_p_33_l110e_l = beta*(0*b1_np_33_l110e*compl1+0*b2_np_33_l110e*compl2+0*b3_np_33_l110e*compl3+0*b4_np_33_l110e*compl4+0*b5_np_33_l110e*compl5)* mis_flag*l_factor_p
parameters  dcj_p_33_l110e_l = beta*(0*b1_np_33_l110e*compl1+0*b2_np_33_l110e*compl2+0*b3_np_33_l110e*compl3+0*b4_np_33_l110e*compl4+0*b5_np_33_l110e*compl5)* mis_flag*l_factor_p
parameters  dcjsw_p_33_l110e_l = beta*(0*b1_np_33_l110e*compl1+0*b2_np_33_l110e*compl2+0*b3_np_33_l110e*compl3+0*b4_np_33_l110e*compl4+0*b5_np_33_l110e*compl5)* mis_flag*l_factor_p
parameters  dcjswg_p_33_l110e_l = beta*(0*b1_np_33_l110e*compl1+0*b2_np_33_l110e*compl2+0*b3_np_33_l110e*compl3+0*b4_np_33_l110e*compl4+0*b5_np_33_l110e*compl5)* mis_flag*l_factor_p
parameters  dtox_p_33_l110e = (global_flag_p_33_l110e*dtox_p_33_l110e_g  + local_flag_p_33_l110e*dtox_p_33_l110e_l)*(1-total_flag_p_33_l110e)+ total_flag_p_33_l110e*dtox_p_33_l110e_t
parameters  dxl_p_33_l110e = (global_flag_p_33_l110e*dxl_p_33_l110e_g  + local_flag_p_33_l110e*dxl_p_33_l110e_l)*(1-total_flag_p_33_l110e)+ total_flag_p_33_l110e*dxl_p_33_l110e_t
parameters  du0_p_33_l110e = (global_flag_p_33_l110e*du0_p_33_l110e_g  + local_flag_p_33_l110e*du0_p_33_l110e_l)*(1-total_flag_p_33_l110e)+ total_flag_p_33_l110e*du0_p_33_l110e_t
parameters  dvth0_p_33_l110e = (global_flag_p_33_l110e*dvth0_p_33_l110e_g  + local_flag_p_33_l110e*dvth0_p_33_l110e_l)*(1-total_flag_p_33_l110e)+ total_flag_p_33_l110e*dvth0_p_33_l110e_t
parameters  drdsw_p_33_l110e = (global_flag_p_33_l110e*drdsw_p_33_l110e_g  + local_flag_p_33_l110e*drdsw_p_33_l110e_l)*(1-total_flag_p_33_l110e)+ total_flag_p_33_l110e*drdsw_p_33_l110e_t
parameters  dxw_p_33_l110e = (global_flag_p_33_l110e*dxw_p_33_l110e_g  + local_flag_p_33_l110e*dxw_p_33_l110e_l)*(1-total_flag_p_33_l110e)+ total_flag_p_33_l110e*dxw_p_33_l110e_t
parameters  dnlx_p_33_l110e = (global_flag_p_33_l110e*dnlx_p_33_l110e_g  + local_flag_p_33_l110e*dnlx_p_33_l110e_l)*(1-total_flag_p_33_l110e)+ total_flag_p_33_l110e*dnlx_p_33_l110e_t
parameters  dk3_p_33_l110e = (global_flag_p_33_l110e*dk3_p_33_l110e_g  + local_flag_p_33_l110e*dk3_p_33_l110e_l)*(1-total_flag_p_33_l110e)+ total_flag_p_33_l110e*dk3_p_33_l110e_t
parameters  dpvth0_p_33_l110e = (global_flag_p_33_l110e*dpvth0_p_33_l110e_g  + local_flag_p_33_l110e*dpvth0_p_33_l110e_l)*(1-total_flag_p_33_l110e)+ total_flag_p_33_l110e*dpvth0_p_33_l110e_t
parameters  dwwl_p_33_l110e = (global_flag_p_33_l110e*dwwl_p_33_l110e_g  + local_flag_p_33_l110e*dwwl_p_33_l110e_l)*(1-total_flag_p_33_l110e)+ total_flag_p_33_l110e*dwwl_p_33_l110e_t
parameters  dcgdl_p_33_l110e = (global_flag_p_33_l110e*dcgdl_p_33_l110e_g  + local_flag_p_33_l110e*dcgdl_p_33_l110e_l)*(1-total_flag_p_33_l110e)+ total_flag_p_33_l110e*dcgdl_p_33_l110e_t
parameters  dcgsl_p_33_l110e = (global_flag_p_33_l110e*dcgsl_p_33_l110e_g  + local_flag_p_33_l110e*dcgsl_p_33_l110e_l)*(1-total_flag_p_33_l110e)+ total_flag_p_33_l110e*dcgsl_p_33_l110e_t
parameters  dcgdo_p_33_l110e = (global_flag_p_33_l110e*dcgdo_p_33_l110e_g  + local_flag_p_33_l110e*dcgdo_p_33_l110e_l)*(1-total_flag_p_33_l110e)+ total_flag_p_33_l110e*dcgdo_p_33_l110e_t
parameters  dcgso_p_33_l110e = (global_flag_p_33_l110e*dcgso_p_33_l110e_g  + local_flag_p_33_l110e*dcgso_p_33_l110e_l)*(1-total_flag_p_33_l110e)+ total_flag_p_33_l110e*dcgso_p_33_l110e_t
parameters  dcj_p_33_l110e = (global_flag_p_33_l110e*dcj_p_33_l110e_g  + local_flag_p_33_l110e*dcj_p_33_l110e_l)*(1-total_flag_p_33_l110e)+ total_flag_p_33_l110e*dcj_p_33_l110e_t
parameters  dcjsw_p_33_l110e = (global_flag_p_33_l110e*dcjsw_p_33_l110e_g  + local_flag_p_33_l110e*dcjsw_p_33_l110e_l)*(1-total_flag_p_33_l110e)+ total_flag_p_33_l110e*dcjsw_p_33_l110e_t
parameters  dcjswg_p_33_l110e = (global_flag_p_33_l110e*dcjswg_p_33_l110e_g  + local_flag_p_33_l110e*dcjswg_p_33_l110e_l)*(1-total_flag_p_33_l110e)+ total_flag_p_33_l110e*dcjswg_p_33_l110e_t

//
p_33_l110e ( d g s b ) p_33_l110e_main trise=dtemp w=w l=l as=as ad=ad ps=ps pd=pd
+ m=1 dtemp=dtemp
+ sa=sa sb=sb
model p_33_l110e_main bsim3v3 type=p
+ lmin       = 3.06e-007                                                   lmax       = 5e-005
+ wmin       = 1.6e-007                                                    wmax       = 0.0001
+ version    = 3.24                                                        mobmod     = 1
+ capmod     = 3                                                           nqsmod     = 0
+ binunit    = 2
+ tnom       = 25                                                          xl         = 3e-009+dxl_p_33_l110e
+ xw         = 4e-009+dxw_p_33_l110e                                       tox        = 7.68e-009+dtox_p_33_l110e
+ toxm       = 7.68e-009                                                   wint       = 4.4077e-008
+ lint       = 2.4338e-008                                                 dlc        = 1.5e-08
+ dwc        = 2.5629e-009                                                 hdif       = 1.34e-007
+ ldif       = 7.9e-008                                                    ll         = 0
+ wl         = 0                                                           lln        = 1
+ wln        = 1                                                           lw         = -1.8116e-014
+ ww         = -5.6355e-015                                                lwn        = 1
+ wwn        = 1                                                           lwl        = 3.8655e-021
+ wwl        = -7.9761e-022+dwwl_p_33_l110e                                cgbo       = 0
+ cgso       = 0.9112e-010+dcgso_p_33_l110e                                cgdo       = 0.9112e-010+dcgdo_p_33_l110e
+ xpart      = 1                                                           lwc        = -2.9006e-015
+ lwlc       = 2.215e-023                                                  wlc        = 9.1699e-017
+ wwc        = -2.1655e-017                                                wwlc       = -7.3317e-022
+ llc        = 1.1417e-014                                                 vth0       = -0.5964+dvth0_p_33_l110e
+ pvth0      = -4.6e-016+dpvth0_p_33_l110e                                 lvth0      = 1.233e-008
+ k1         = 0.92099                                                     k2         = -0.019624
+ k3         = 1.1262+dk3_p_33_l110e                                       wk3        = -1.09e-007
+ pk3        = -2.4e-014                                                   k3b        = 0.54284
+ pk3b       = 6.6336e-014                                                 nlx        = 6.4205e-009+dnlx_p_33_l110e
+ dvt0       = 2.6286                                                      dvt1       = 1.6845
+ dvt2       = -0.89636                                                    dvt0w      = 0
+ dvt1w      = 5300000                                                     dvt2w      = -0.032
+ nch        = 3.6e+017                                                    voff       = -0.10658
+ nfactor    = 1.046                                                       cdsc       = 0.00359
+ cdscb      = 0.00135                                                     cdscd      = 1e-020
+ cit        = 0                                                           u0         = 0.010601+du0_p_33_l110e
+ ua         = 5.835e-010                                                  ub         = 1.1639e-018
+ uc         = -2.347e-011                                                 wuc        = -1e-017
+ ngate      = 1.5194e+020                                                 xj         = 1.17e-007
+ w0         = 7.7449e-008                                                 prwg       = 0.0041
+ prwb       = -0.118192                                                   pprwb      = -1.3657e-015
+ wr         = 1                                                           rdsw       = 828.42+drdsw_p_33_l110e
+ a0         = 0.999                                                       ags        = 0.14571
+ lags       = 6.018e-008                                                  pags       = -2.8465e-014
+ a1         = 0.030502                                                    a2         = 1
+ b0         = 3.0824e-008                                                 b1         = -2.28e-008
+ vsat       = 111900                                                      keta       = -0.015246
+ lketa      = -8.6455e-009                                                pketa      = -1.2562e-016
+ dwg        = -8.8086e-009                                                dwb        = -3.6464e-009
+ alpha0     = 4.4626e-006                                                 beta0      = 29.6
+ pclm       = 1.6405                                                      pdiblc1    = 0.091304
+ pdiblc2    = 0.0017978                                                   pdiblcb    = 0
+ drout      = 0.7088                                                      pvag       = 5.42e-007
+ pscbe1     = 6.4807e+008                                                 pscbe2     = 8.3017e-006
+ delta      = 0.015631                                                    eta0       = 0.054758
+ etab       = -0.066667                                                   dsub       = 0.51001
+ elm        = 5                                                           alpha1     = 12.87
+ vfb        = -1.1015795                                                  lvfb       = 0
+ ppclm      = 3.99e-013                                                   pdvt2      = -1.8e-014
+ cf         = 6.7752e-011                                                 ckappa     = 1.0548
+ cgdl       = 2.0171e-010+dcgdl_p_33_l110e                                cgsl       = 2.0171e-010+dcgsl_p_33_l110e
+ vfbcv      = -1                                                          acde       = 1.0487
+ moin       = 5.671                                                       noff       = 2.21
+ voffcv     = -0.03762                                                    kt1        = -0.39
+ kt1l       = 3.74e-009                                                   kt2        = -0.0423
+ ute        = -0.7235196                                                  ua1        = 2.42e-009
+ ub1        = -3.308519e-018                                              wub1       = 1.62e-025
+ uc1        = -1.5894291e-013                                             prt        = 200
+ at         = 10000                                                       noimod     = 2
+ noia       = 2.3611128e+20                                               noib       = 5.5303842e+03
+ noic       = 3.6108638e-11                                               em         = 2.1981607e+07
+ ef         = 1.2                                                         rsh        = 7.67
+ js         = 3.06e-007                                                   jsw        = 1.5e-012
+ cj         = 0.000993+dcj_p_33_l110e                                     mj         = 0.33
+ cjsw       = 1.2e-010+dcjsw_p_33_l110e                                   mjsw       = 0.13
+ pb         = 0.79                                                        rd         = 0
+ rdc        = 0                                                           rs         = 0
+ rsc        = 0                                                           xti        = 3
+ nj         = 1.03                                                        pbsw       = 0.78
+ cjswg      = 3.59e-010+dcjswg_p_33_l110e                                 pbswg      = 0.7
+ mjswg      = 0.45                                                        tcj        = 0.00072
+ tcjsw      = 0.0001                                                      tcjswg     = 0.001416
+ tpb        = 0.0015                                                      tpbsw      = 0.0005
+ tpbswg     = 0.00258                                                     saref      = 2.2e-006
+ sbref      = 2.2e-006                                                    wlod       = 0
+ kvth0      = -1.440e-09                                                  lkvth0     = 0
+ wkvth0     = 0                                                           pkvth0     = 0
+ llodvth    = 1                                                           wlodvth    = 1
+ stk2       = 1.129e-09                                                   lodk2      = 1.000e+00
+ lodeta0    = 1                                                           ku0        = 1.02e-007
+ lku0       = 3.1e-08                                                     wku0       = 0
+ pku0       = 0                                                           llodku0    = 1.22
+ wlodku0    = 1                                                           kvsat      = 0
+ steta0     = 0                                                           tku0       = 0
+ minr=0.01                 imax=0.1
ends p_33_l110e
//
//
//
inline subckt n_33bpw_l110e ( d g s b )
parameters w=0u l=0u
+ dtemp=0 nf=1 mf=1 mis_flag=1
+ nf_odd=nf-2*int(nf/2) nf_even=1-nf_odd
+ sa=0 sb=0 sd=0
+ a_unit=sd*w   p_unit=2*(sd+w)  a_sa_edge=sa*w   p_sa_edge=2*(sa+w)
+ a_sb_edge=sb*w   p_sb_edge=2*(sb+w)
+ ad=(nf_odd*(a_unit*((nf+1)/2-1)+a_sb_edge) + nf_even*(a_unit*nf/2))/nf
+ as=(nf_odd*(a_unit*((nf+1)/2-1)+a_sa_edge) + nf_even*(a_unit*(nf/2-1)+a_sa_edge+a_sb_edge))/nf
+ pd=(nf_odd*(p_unit*((nf+1)/2-1)+p_sb_edge) + nf_even*(p_unit*nf/2))/nf
+ ps=(nf_odd*(p_unit*((nf+1)/2-1)+p_sa_edge) + nf_even*(p_unit*(nf/2-1)+p_sa_edge+p_sb_edge))/nf
//
//

parameters beta  = 1
parameters compl1	= 7.42703514570425
parameters compl2	= 4.98071310168044
parameters compl3	= 0.169054373657777
parameters compl4	= 5.53765472414446e-02
parameters compl5	= 1.27268445825736e-13
parameters l_factor_n=1/sqrt(2*w*0.9*(l*0.9+12e-9)*mf*1e+12)
parameters  b1_np_33_l110e = b1_np_33_l110e_xx
parameters  b2_np_33_l110e = b2_np_33_l110e_xx
parameters  b3_np_33_l110e = b3_np_33_l110e_xx
parameters  b4_np_33_l110e = b4_np_33_l110e_xx
parameters  b5_np_33_l110e = b5_np_33_l110e_xx
parameters  dtox_n_33_l110e_l = beta*(0*b1_np_33_l110e*compl1+0*b2_np_33_l110e*compl2+0*b3_np_33_l110e*compl3+0*b4_np_33_l110e*compl4+0*b5_np_33_l110e*compl5)* mis_flag*l_factor_n
parameters  dxl_n_33_l110e_l = beta*(0*b1_np_33_l110e*compl1+0*b2_np_33_l110e*compl2+0*b3_np_33_l110e*compl3+0*b4_np_33_l110e*compl4+0*b5_np_33_l110e*compl5)* mis_flag*l_factor_n
parameters  du0_n_33_l110e_l = beta*(-2.17904879479892e-05*b1_np_33_l110e*compl1+2.78291342807903e-05*b2_np_33_l110e*compl2+-3.00613830374162e-06*b3_np_33_l110e*compl3+2.4159809221672e-05*b4_np_33_l110e*compl4+8.13544086937782e-05*b5_np_33_l110e*compl5)* mis_flag*l_factor_n
parameters  dvth0_n_33_l110e_l = beta*(-1.22942337866237e-03*b1_np_33_l110e*compl1+1.5868620213625e-03*b2_np_33_l110e*compl2+2.25712963186997e-04*b3_np_33_l110e*compl3+1.29899870676079e-04*b4_np_33_l110e*compl4+1.44510078491726e-03*b5_np_33_l110e*compl5)* mis_flag*l_factor_n
parameters  drdsw_n_33_l110e_l = beta*(-0.583550900674499*b1_np_33_l110e*compl1+0.76539524537797*b2_np_33_l110e*compl2+0.497725586513749*b3_np_33_l110e*compl3+-0.819286574493792*b4_np_33_l110e*compl4+-1.27296825348759*b5_np_33_l110e*compl5)* mis_flag*l_factor_n
parameters  dxw_n_33_l110e_l = beta*(0*b1_np_33_l110e*compl1+0*b2_np_33_l110e*compl2+0*b3_np_33_l110e*compl3+0*b4_np_33_l110e*compl4+0*b5_np_33_l110e*compl5)* mis_flag*l_factor_n
parameters  dnlx_n_33_l110e_l = beta*(0*b1_np_33_l110e*compl1+0*b2_np_33_l110e*compl2+0*b3_np_33_l110e*compl3+0*b4_np_33_l110e*compl4+0*b5_np_33_l110e*compl5)* mis_flag*l_factor_n
parameters  dk3_n_33_l110e_l = beta*(0*b1_np_33_l110e*compl1+0*b2_np_33_l110e*compl2+0*b3_np_33_l110e*compl3+0*b4_np_33_l110e*compl4+0*b5_np_33_l110e*compl5)* mis_flag*l_factor_n
parameters  dpvth0_n_33_l110e_l = beta*(0*b1_np_33_l110e*compl1+0*b2_np_33_l110e*compl2+0*b3_np_33_l110e*compl3+0*b4_np_33_l110e*compl4+0*b5_np_33_l110e*compl5)* mis_flag*l_factor_n
parameters  dwwl_n_33_l110e_l = beta*(0*b1_np_33_l110e*compl1+0*b2_np_33_l110e*compl2+0*b3_np_33_l110e*compl3+0*b4_np_33_l110e*compl4+0*b5_np_33_l110e*compl5)* mis_flag*l_factor_n
parameters  dcgdo_n_33_l110e_l = beta*(0*b1_np_33_l110e*compl1+0*b2_np_33_l110e*compl2+0*b3_np_33_l110e*compl3+0*b4_np_33_l110e*compl4+0*b5_np_33_l110e*compl5)* mis_flag*l_factor_n
parameters  dcgso_n_33_l110e_l = beta*(0*b1_np_33_l110e*compl1+0*b2_np_33_l110e*compl2+0*b3_np_33_l110e*compl3+0*b4_np_33_l110e*compl4+0*b5_np_33_l110e*compl5)* mis_flag*l_factor_n
parameters  dcj_n_33_l110e_l = beta*(0*b1_np_33_l110e*compl1+0*b2_np_33_l110e*compl2+0*b3_np_33_l110e*compl3+0*b4_np_33_l110e*compl4+0*b5_np_33_l110e*compl5)* mis_flag*l_factor_n
parameters  dcjsw_n_33_l110e_l = beta*(0*b1_np_33_l110e*compl1+0*b2_np_33_l110e*compl2+0*b3_np_33_l110e*compl3+0*b4_np_33_l110e*compl4+0*b5_np_33_l110e*compl5)* mis_flag*l_factor_n
parameters  dcjswg_n_33_l110e_l = beta*(0*b1_np_33_l110e*compl1+0*b2_np_33_l110e*compl2+0*b3_np_33_l110e*compl3+0*b4_np_33_l110e*compl4+0*b5_np_33_l110e*compl5)* mis_flag*l_factor_n
parameters  dcgdl_n_33_l110e_l = beta*(0*b1_np_33_l110e*compl1+0*b2_np_33_l110e*compl2+0*b3_np_33_l110e*compl3+0*b4_np_33_l110e*compl4+0*b5_np_33_l110e*compl5)* mis_flag*l_factor_n
parameters  dcgsl_n_33_l110e_l = beta*(0*b1_np_33_l110e*compl1+0*b2_np_33_l110e*compl2+0*b3_np_33_l110e*compl3+0*b4_np_33_l110e*compl4+0*b5_np_33_l110e*compl5)* mis_flag*l_factor_n
parameters  dtox_n_33_l110e = (global_flag_n_33_l110e*dtox_n_33_l110e_g  + local_flag_n_33_l110e*dtox_n_33_l110e_l)*(1-total_flag_n_33_l110e)+ total_flag_n_33_l110e*dtox_n_33_l110e_t
parameters  dxl_n_33_l110e = (global_flag_n_33_l110e*dxl_n_33_l110e_g  + local_flag_n_33_l110e*dxl_n_33_l110e_l)*(1-total_flag_n_33_l110e)+ total_flag_n_33_l110e*dxl_n_33_l110e_t
parameters  du0_n_33_l110e = (global_flag_n_33_l110e*du0_n_33_l110e_g  + local_flag_n_33_l110e*du0_n_33_l110e_l)*(1-total_flag_n_33_l110e)+ total_flag_n_33_l110e*du0_n_33_l110e_t
parameters  dvth0_n_33_l110e = (global_flag_n_33_l110e*dvth0_n_33_l110e_g  + local_flag_n_33_l110e*dvth0_n_33_l110e_l)*(1-total_flag_n_33_l110e)+ total_flag_n_33_l110e*dvth0_n_33_l110e_t
parameters  drdsw_n_33_l110e = (global_flag_n_33_l110e*drdsw_n_33_l110e_g  + local_flag_n_33_l110e*drdsw_n_33_l110e_l)*(1-total_flag_n_33_l110e)+ total_flag_n_33_l110e*drdsw_n_33_l110e_t
parameters  dxw_n_33_l110e = (global_flag_n_33_l110e*dxw_n_33_l110e_g  + local_flag_n_33_l110e*dxw_n_33_l110e_l)*(1-total_flag_n_33_l110e)+ total_flag_n_33_l110e*dxw_n_33_l110e_t
parameters  dnlx_n_33_l110e = (global_flag_n_33_l110e*dnlx_n_33_l110e_g  + local_flag_n_33_l110e*dnlx_n_33_l110e_l)*(1-total_flag_n_33_l110e)+ total_flag_n_33_l110e*dnlx_n_33_l110e_t
parameters  dk3_n_33_l110e = (global_flag_n_33_l110e*dk3_n_33_l110e_g  + local_flag_n_33_l110e*dk3_n_33_l110e_l)*(1-total_flag_n_33_l110e)+ total_flag_n_33_l110e*dk3_n_33_l110e_t
parameters  dpvth0_n_33_l110e = (global_flag_n_33_l110e*dpvth0_n_33_l110e_g  + local_flag_n_33_l110e*dpvth0_n_33_l110e_l)*(1-total_flag_n_33_l110e)+ total_flag_n_33_l110e*dpvth0_n_33_l110e_t
parameters  dwwl_n_33_l110e = (global_flag_n_33_l110e*dwwl_n_33_l110e_g  + local_flag_n_33_l110e*dwwl_n_33_l110e_l)*(1-total_flag_n_33_l110e)+ total_flag_n_33_l110e*dwwl_n_33_l110e_t
parameters  dcgdo_n_33_l110e = (global_flag_n_33_l110e*dcgdo_n_33_l110e_g  + local_flag_n_33_l110e*dcgdo_n_33_l110e_l)*(1-total_flag_n_33_l110e)+ total_flag_n_33_l110e*dcgdo_n_33_l110e_t
parameters  dcgso_n_33_l110e = (global_flag_n_33_l110e*dcgso_n_33_l110e_g  + local_flag_n_33_l110e*dcgso_n_33_l110e_l)*(1-total_flag_n_33_l110e)+ total_flag_n_33_l110e*dcgso_n_33_l110e_t
parameters  dcj_n_33_l110e = (global_flag_n_33_l110e*dcj_n_33_l110e_g  + local_flag_n_33_l110e*dcj_n_33_l110e_l)*(1-total_flag_n_33_l110e)+ total_flag_n_33_l110e*dcj_n_33_l110e_t
parameters  dcjsw_n_33_l110e = (global_flag_n_33_l110e*dcjsw_n_33_l110e_g  + local_flag_n_33_l110e*dcjsw_n_33_l110e_l)*(1-total_flag_n_33_l110e)+ total_flag_n_33_l110e*dcjsw_n_33_l110e_t
parameters  dcjswg_n_33_l110e = (global_flag_n_33_l110e*dcjswg_n_33_l110e_g  + local_flag_n_33_l110e*dcjswg_n_33_l110e_l)*(1-total_flag_n_33_l110e)+ total_flag_n_33_l110e*dcjswg_n_33_l110e_t
parameters  dcgdl_n_33_l110e = (global_flag_n_33_l110e*dcgdl_n_33_l110e_g  + local_flag_n_33_l110e*dcgdl_n_33_l110e_l)*(1-total_flag_n_33_l110e)+ total_flag_n_33_l110e*dcgdl_n_33_l110e_t
parameters  dcgsl_n_33_l110e = (global_flag_n_33_l110e*dcgsl_n_33_l110e_g  + local_flag_n_33_l110e*dcgsl_n_33_l110e_l)*(1-total_flag_n_33_l110e)+ total_flag_n_33_l110e*dcgsl_n_33_l110e_t

//
n_33bpw_l110e ( d g s b ) n_33bpw_l110e_main trise=dtemp w=w l=l as=as ad=ad ps=ps pd=pd
+ m=1 dtemp=dtemp
+ sa=sa sb=sb
model n_33bpw_l110e_main bsim3v3 type=n
+ lmin       = 3.06e-007                                                   lmax       = 5e-005
+ wmin       = 1.6e-007                                                    wmax       = 0.0001
+ version    = 3.24                                                        mobmod     = 1
+ capmod     = 3                                                           nqsmod     = 0
+ binunit    = 2
+ tnom       = 25                                                          xl         = 3e-009+dxl_n_33_l110e
+ xw         = 1e-009+dxw_n_33_l110e                                       llc        = 1.205e-014
+ tox        = 7.49e-009+dtox_n_33_l110e                                   toxm       = 7.49e-009
+ wint       = 3.2825e-008                                                 lint       = -8.4375e-010
+ hdif       = 1.34e-007                                                   ldif       = 7.9e-008
+ ll         = -7.4526e-015                                                wl         = -1.7696e-014
+ lln        = 1.0169                                                      wln        = 0.91057
+ lw         = -2.4007e-021                                                ww         = -5.4e-016
+ lwn        = 0.80487                                                     wwn        = 1.1
+ lwl        = 2.6125e-021                                                 wwl        = -2.185e-022+dwwl_n_33_l110e
+ cgbo       = 0                                                           cgso       = 0.5e-010+dcgso_n_33_l110e
+ cgdo       = 0.5e-010+dcgdo_n_33_l110e                                   xpart      = 1
+ dlc        = -2e-08                                                      dwc        = 2.5513e-12
+ wwc        = 8.526e-017                                                  vth0       = 0.58+dvth0_n_33_l110e
+ lvth0      = 5.41e-008                                                   pvth0      = 5.2892e-016+dpvth0_n_33_l110e
+ k1         = 0.66941                                                     lk1        = -2.4077e-008
+ pk1        = 1.444e-015                                                  k2         = -0.022002
+ lk2        = -2.7444e-008                                                pk2        = 2.2634e-015
+ k3         = 1.3864+dk3_n_33_l110e                                       wk3        = -1.7211e-007
+ k3b        = 0.653                                                       wk3b       = 6.7694e-009
+ nlx        = 8.8279e-010+dnlx_n_33_l110e                                 dvt0       = 15.586
+ dvt1       = 0.5183                                                      dvt2       = -0.00050685
+ dvt0w      = 3.7409                                                      dvt1w      = 2525600
+ dvt2w      = -0.0011914                                                  nch        = 6.6276e+017
+ voff       = -0.11991                                                    nfactor    = 0.496
+ lnfactor   = 2.8315e-008                                                 cdsc       = 0
+ cdscb      = 0                                                           cdscd      = 0
+ cit        = 0                                                           u0         = 0.039168+du0_n_33_l110e
+ lu0        = 7.178e-011                                                  ua         = 6.6366e-011
+ lua        = -3.4684e-016                                                wua        = 1.1680002e-017
+ ub         = 1.4084e-018                                                 uc         = 5.214e-011
+ luc        = -3.226e-017                                                 ngate      = 1.8243e+020
+ xj         = 1.07e-007                                                   w0         = 7.9515e-009
+ prwg       = 0.31168                                                     pprwg      = -9.0909e-015
+ prwb       = -0.085385                                                   wr         = 1
+ rdsw       = 324.3+drdsw_n_33_l110e                                      a0         = 1.4269
+ la0        = -5.556e-007                                                 ags        = 0.26485
+ a1         = 0.013218                                                    a2         = 0.55622
+ b0         = 6.3623e-007                                                 wb0        = -6.3648e-014
+ b1         = 1.49e-006                                                   vsat       = 116450
+ keta       = -0.048114                                                   lketa      = 1.71e-008
+ wketa      = 2.324e-009                                                  dwg        = -2.509e-009
+ dwb        = 2.11e-009                                                   alpha0     = 1.7136e-005
+ beta0      = 31.2                                                        pclm       = 2.8362758
+ ppclm      = 1.2032e-013                                                 pdiblc1    = 0.00668673
+ pdiblc2    = 0.00153                                                     pdiblcb    = 0.22473
+ drout      = 0.834991                                                    pvag       = 0.004912788
+ pscbe1     = 2.496e+008                                                  pscbe2     = 9.94e-008
+ delta      = 0.011608656                                                 eta0       = 0.608
+ peta0      = -5.38e-015                                                  etab       = -0.013791
+ petab      = 1.068e-015                                                  dsub       = 0.4571169
+ elm        = 5                                                           alpha1     = 74.298
+ vfb        = -0.7706789                                                  cf         = 6.83e-011
+ ckappa     = 0.5                                                         cgdl       = 1.8e-010+dcgdl_n_33_l110e
+ cgsl       = 1.8e-010+dcgsl_n_33_l110e                                   acde       = 0.46654
+ moin       = 22.546                                                      noff       = 2.9038
+ voffcv     = -0.088241                                                   kt1        = -0.3186688
+ kt1l       = 2.3155e-008                                                 kt2        = -0.03874474
+ lkt2       = 1.1e-008                                                    ute        = -1.05
+ lute       = -3.959829e-010                                              wute       = 4.911742e-008
+ ua1        = 3.25e-009                                                   lua1       = -7.70616e-016
+ wua1       = 4.64e-017                                                   pua1       = 1e-023
+ ub1        = -3.8e-018                                                   lub1       = 1.377533e-024
+ uc1        = -5.6e-011                                                   luc1       = 5.911338e-017
+ prt        = -300                                                        at         = 73200
+ noimod     = 2                                                           noia       = 1.7800000e+21
+ noib       = 1.4500000e+05                                               noic       = -9.55000e-13
+ em         = 2.5000000e+07                                               ef         = 0.9077
+ rsh        = 8.5                                                         js         = 7.49e-008
+ jsw        = 1.08e-013                                                   cj         = 0.00078+dcj_n_33_l110e
+ mj         = 0.278                                                       cjsw       = 1.08e-010+dcjsw_n_33_l110e
+ mjsw       = 0.12                                                        pb         = 0.608
+ rd         = 0                                                           rdc        = 0
+ rs         = 0                                                           rsc        = 0
+ xti        = 3                                                           nj         = 1.0161
+ pbsw       = 0.8                                                         cjswg      = 2.3e-010+dcjswg_n_33_l110e
+ pbswg      = 0.905                                                       mjswg      = 0.624
+ tcj        = 0.0009                                                      tcjsw      = 0.0004
+ tpb        = 0.001494                                                    tpbsw      = 0.0006
+ saref      = 2.2e-006                                                    sbref      = 2.2e-006
+ wlod       = 0                                                           kvth0      = 5.250e-09
+ lkvth0     = -2.710e-8                                                   wkvth0     = 0
+ pkvth0     = 0                                                           llodvth    = 1
+ wlodvth    = 1                                                           stk2       = 5.6e-10
+ lodk2      = 1                                                           lodeta0    = 1
+ ku0        = -1.51e-7                                                    lku0       = 5.557e-7
+ wku0       = 0                                                           pku0       = 0
+ llodku0    = 1.120e+00                                                   wlodku0    = 1
+ kvsat      = 1                                                           steta0     = 0.000e+00
+ tku0       = 0
+ minr=0.01                 imax=0.1
ends n_33bpw_l110e
