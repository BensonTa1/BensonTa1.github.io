simulator lang=spectre insensitive=yes
//
parameters alpha_n_12_lll110e = 0.2
parameters alpha_p_12_lll110e = 0.2

parameters a1_np_12_lll110e_xx = 0
parameters a2_np_12_lll110e_xx = 0
parameters a3_np_12_lll110e_xx = 0
parameters a4_np_12_lll110e_xx = 0
parameters a5_np_12_lll110e_xx = 0
statistics {
process {
vary a1_np_12_lll110e_xx dist=gauss std=sigma/3
vary a2_np_12_lll110e_xx dist=gauss std=sigma/3
vary a3_np_12_lll110e_xx dist=gauss std=sigma/3
vary a4_np_12_lll110e_xx dist=gauss std=sigma/3
vary a5_np_12_lll110e_xx dist=gauss std=sigma/3
 }
}
parameters a1_np_12_lll110e = a1_np_12_lll110e_xx
parameters a2_np_12_lll110e = a2_np_12_lll110e_xx
parameters a3_np_12_lll110e = a3_np_12_lll110e_xx
parameters a4_np_12_lll110e = a4_np_12_lll110e_xx
parameters a5_np_12_lll110e = a5_np_12_lll110e_xx
parameters comp1_np_12_lll110e	= 11.8668857523648
parameters comp2_np_12_lll110e	= 6.11366534401375
parameters comp3_np_12_lll110e	= 2.37834029634892
parameters comp4_np_12_lll110e	= 0.378967065168863
parameters comp5_np_12_lll110e	= 1.26752779035181e-14
parameters 	dtox_n_12_lll110e_g	  =	alpha_n_12_lll110e*(9.52298200781944e-12*a1_np_12_lll110e*comp1_np_12_lll110e+5.37821713333657e-13*a2_np_12_lll110e*comp2_np_12_lll110e+-1.79955505354227e-12*a3_np_12_lll110e*comp3_np_12_lll110e+-4.64933357965219e-13*a4_np_12_lll110e*comp4_np_12_lll110e+7.53293758731393e-14*a5_np_12_lll110e*comp5_np_12_lll110e)
parameters 	du0_n_12_lll110e_g	  =	alpha_n_12_lll110e*(-7.93637118304075e-05*a1_np_12_lll110e*comp1_np_12_lll110e+-1.39320658506909e-04*a2_np_12_lll110e*comp2_np_12_lll110e+-2.80227281440121e-05*a3_np_12_lll110e*comp3_np_12_lll110e+5.17754720508525e-06*a4_np_12_lll110e*comp4_np_12_lll110e+-2.10268740103811e-04*a5_np_12_lll110e*comp5_np_12_lll110e)
parameters 	dvth0_n_12_lll110e_g	  =	alpha_n_12_lll110e*(2.32038601193803e-03*a1_np_12_lll110e*comp1_np_12_lll110e+4.38934369123658e-03*a2_np_12_lll110e*comp2_np_12_lll110e+-5.54281333355426e-04*a3_np_12_lll110e*comp3_np_12_lll110e+-1.15306108717328e-03*a4_np_12_lll110e*comp4_np_12_lll110e+4.9920207546753e-03*a5_np_12_lll110e*comp5_np_12_lll110e)
parameters 	dxl_n_12_lll110e_g	  =	alpha_n_12_lll110e*(9.84066050388168e-11*a1_np_12_lll110e*comp1_np_12_lll110e+4.96288265672668e-11*a2_np_12_lll110e*comp2_np_12_lll110e+6.0191760420013e-11*a3_np_12_lll110e*comp3_np_12_lll110e+-8.41788818132043e-11*a4_np_12_lll110e*comp4_np_12_lll110e+1.53876656923964e-11*a5_np_12_lll110e*comp5_np_12_lll110e)
parameters 	dxw_n_12_lll110e_g	  =	alpha_n_12_lll110e*(-1.67952718889376e-09*a1_np_12_lll110e*comp1_np_12_lll110e+-1.69693675608209e-09*a2_np_12_lll110e*comp2_np_12_lll110e+-6.41841583729979e-10*a3_np_12_lll110e*comp3_np_12_lll110e+-3.22023646174583e-10*a4_np_12_lll110e*comp4_np_12_lll110e+5.23645944538175e-10*a5_np_12_lll110e*comp5_np_12_lll110e)
parameters 	dnlx_n_12_lll110e_g	  =	alpha_n_12_lll110e*(1.03902184582433e-09*a1_np_12_lll110e*comp1_np_12_lll110e+1.56619931670222e-09*a2_np_12_lll110e*comp2_np_12_lll110e+-3.01100498268593e-10*a3_np_12_lll110e*comp3_np_12_lll110e+-7.02033624200617e-10*a4_np_12_lll110e*comp4_np_12_lll110e+2.0366287738916e-10*a5_np_12_lll110e*comp5_np_12_lll110e)
parameters 	dk3_n_12_lll110e_g	  =	alpha_n_12_lll110e*(0.779851592423089*a1_np_12_lll110e*comp1_np_12_lll110e+0.775729147973373*a2_np_12_lll110e*comp2_np_12_lll110e+-0.179535889034698*a3_np_12_lll110e*comp3_np_12_lll110e+-0.484892545823599*a4_np_12_lll110e*comp4_np_12_lll110e+-0.29401667229218*a5_np_12_lll110e*comp5_np_12_lll110e)
parameters 	dpvth0_n_12_lll110e_g	  =	alpha_n_12_lll110e*(2.97298704770763e-17*a1_np_12_lll110e*comp1_np_12_lll110e+2.97970102887086e-17*a2_np_12_lll110e*comp2_np_12_lll110e+-1.897724432685e-17*a3_np_12_lll110e*comp3_np_12_lll110e+1.70264072377701e-17*a4_np_12_lll110e*comp4_np_12_lll110e+-8.8830494296316e-18*a5_np_12_lll110e*comp5_np_12_lll110e)
parameters 	dwwl_n_12_lll110e_g	  =	alpha_n_12_lll110e*(-1.12159407091164e-19*a1_np_12_lll110e*comp1_np_12_lll110e+-1.00740241804903e-19*a2_np_12_lll110e*comp2_np_12_lll110e+7.79971633830233e-20*a3_np_12_lll110e*comp3_np_12_lll110e+-7.40596602729417e-20*a4_np_12_lll110e*comp4_np_12_lll110e+1.45816004775944e-19*a5_np_12_lll110e*comp5_np_12_lll110e)
parameters 	dcj_n_12_lll110e_g	  =	alpha_n_12_lll110e*(8.31815644015945e-06*a1_np_12_lll110e*comp1_np_12_lll110e+1.71296297397625e-05*a2_np_12_lll110e*comp2_np_12_lll110e+-1.99213376818402e-06*a3_np_12_lll110e*comp3_np_12_lll110e+-4.15381171275013e-06*a4_np_12_lll110e*comp4_np_12_lll110e+6.16282051304668e-06*a5_np_12_lll110e*comp5_np_12_lll110e)
parameters 	dcjsw_n_12_lll110e_g	  =	alpha_n_12_lll110e*(1.14836770854424e-12*a1_np_12_lll110e*comp1_np_12_lll110e+2.36484055018387e-12*a2_np_12_lll110e*comp2_np_12_lll110e+-2.75025134107628e-13*a3_np_12_lll110e*comp3_np_12_lll110e+-5.73456783676899e-13*a4_np_12_lll110e*comp4_np_12_lll110e+4.0697065434542e-13*a5_np_12_lll110e*comp5_np_12_lll110e)
parameters 	dcjswg_n_12_lll110e_g	  =	alpha_n_12_lll110e*(4.74828096792436e-12*a1_np_12_lll110e*comp1_np_12_lll110e+9.77816364311441e-12*a2_np_12_lll110e*comp2_np_12_lll110e+-1.13717635933837e-12*a3_np_12_lll110e*comp3_np_12_lll110e+-2.3711341860283e-12*a4_np_12_lll110e*comp4_np_12_lll110e+-9.32843920535611e-12*a5_np_12_lll110e*comp5_np_12_lll110e)
parameters 	dcgdo_n_12_lll110e_g	  =	alpha_n_12_lll110e*(-2.22005708430041e-12*a1_np_12_lll110e*comp1_np_12_lll110e+-1.2538035919805e-13*a2_np_12_lll110e*comp2_np_12_lll110e+4.19523521300855e-13*a3_np_12_lll110e*comp3_np_12_lll110e+1.08388170242343e-13*a4_np_12_lll110e*comp4_np_12_lll110e+3.97942985050735e-12*a5_np_12_lll110e*comp5_np_12_lll110e)
parameters 	dcgso_n_12_lll110e_g	  =	alpha_n_12_lll110e*(-2.22005708430041e-12*a1_np_12_lll110e*comp1_np_12_lll110e+-1.2538035919805e-13*a2_np_12_lll110e*comp2_np_12_lll110e+4.19523521300855e-13*a3_np_12_lll110e*comp3_np_12_lll110e+1.08388170242343e-13*a4_np_12_lll110e*comp4_np_12_lll110e+3.97942985050735e-12*a5_np_12_lll110e*comp5_np_12_lll110e)
parameters 	dcf_n_12_lll110e_g	  =	alpha_n_12_lll110e*(-1.07831106020041e-12*a1_np_12_lll110e*comp1_np_12_lll110e+-6.0898897155053e-14*a2_np_12_lll110e*comp2_np_12_lll110e+2.03768117600225e-13*a3_np_12_lll110e*comp3_np_12_lll110e+5.26455664557974e-14*a4_np_12_lll110e*comp4_np_12_lll110e+-1.23244199562213e-14*a5_np_12_lll110e*comp5_np_12_lll110e)
parameters 	dcgdl_n_12_lll110e_g	  =	alpha_n_12_lll110e*(-3.75586410388398e-13*a1_np_12_lll110e*comp1_np_12_lll110e+-2.12116883738793e-14*a2_np_12_lll110e*comp2_np_12_lll110e+7.09744513117067e-14*a3_np_12_lll110e*comp3_np_12_lll110e+1.8336971638148e-14*a4_np_12_lll110e*comp4_np_12_lll110e+-3.25018542055278e-14*a5_np_12_lll110e*comp5_np_12_lll110e)
parameters 	dcgsl_n_12_lll110e_g	  =	alpha_n_12_lll110e*(-3.75586410388398e-13*a1_np_12_lll110e*comp1_np_12_lll110e+-2.12116883738793e-14*a2_np_12_lll110e*comp2_np_12_lll110e+7.09744513117067e-14*a3_np_12_lll110e*comp3_np_12_lll110e+1.8336971638148e-14*a4_np_12_lll110e*comp4_np_12_lll110e+-3.25018542055278e-14*a5_np_12_lll110e*comp5_np_12_lll110e)
parameters 	dvsat_n_12_lll110e_g	  =	alpha_n_12_lll110e*(1007.40249918645*a1_np_12_lll110e*comp1_np_12_lll110e+538.780144133518*a2_np_12_lll110e*comp2_np_12_lll110e+336.78894371502*a3_np_12_lll110e*comp3_np_12_lll110e+-236.373131998391*a4_np_12_lll110e*comp4_np_12_lll110e+-108.174707641639*a5_np_12_lll110e*comp5_np_12_lll110e)
parameters 	dags_n_12_lll110e_g	  =	alpha_n_12_lll110e*(2.06738397168604e-02*a1_np_12_lll110e*comp1_np_12_lll110e+2.03770764992036e-02*a2_np_12_lll110e*comp2_np_12_lll110e+-2.46655275536269e-03*a3_np_12_lll110e*comp3_np_12_lll110e+-7.79869477978964e-03*a4_np_12_lll110e*comp4_np_12_lll110e+-3.59030316357733e-03*a5_np_12_lll110e*comp5_np_12_lll110e)
parameters 	drdsw_n_12_lll110e_g	  =	alpha_n_12_lll110e*(0.164976725359994*a1_np_12_lll110e*comp1_np_12_lll110e+0.451680590206234*a2_np_12_lll110e*comp2_np_12_lll110e+0.284822114748938*a3_np_12_lll110e*comp3_np_12_lll110e+0.698214409601827*a4_np_12_lll110e*comp4_np_12_lll110e+-2.62957010147871e-03*a5_np_12_lll110e*comp5_np_12_lll110e)
parameters 	dwags_n_12_lll110e_g	  =	alpha_n_12_lll110e*(7.15569984217181e-10*a1_np_12_lll110e*comp1_np_12_lll110e+7.45604610714856e-10*a2_np_12_lll110e*comp2_np_12_lll110e+-1.3546392017932e-10*a3_np_12_lll110e*comp3_np_12_lll110e+-2.15425651233782e-10*a4_np_12_lll110e*comp4_np_12_lll110e+-3.35998552708811e-10*a5_np_12_lll110e*comp5_np_12_lll110e)
parameters 	dpvsat_n_12_lll110e_g	  =	alpha_n_12_lll110e*(3.89481818060382e-11*a1_np_12_lll110e*comp1_np_12_lll110e+3.44414484761654e-11*a2_np_12_lll110e*comp2_np_12_lll110e+1.06256472760089e-10*a3_np_12_lll110e*comp3_np_12_lll110e+3.56846011015281e-11*a4_np_12_lll110e*comp4_np_12_lll110e+4.09808756970989e-11*a5_np_12_lll110e*comp5_np_12_lll110e)
parameters 	dtox_p_12_lll110e_g	  =	alpha_p_12_lll110e*(1.01062646557984e-11*a1_np_12_lll110e*comp1_np_12_lll110e+5.7076329327534e-13*a2_np_12_lll110e*comp2_np_12_lll110e+-1.90977780057174e-12*a3_np_12_lll110e*comp3_np_12_lll110e+-4.93410526140624e-13*a4_np_12_lll110e*comp4_np_12_lll110e+-4.52069927208697e-13*a5_np_12_lll110e*comp5_np_12_lll110e)
parameters 	dxl_p_12_lll110e_g	  =	alpha_p_12_lll110e*(2.20470417238848e-10*a1_np_12_lll110e*comp1_np_12_lll110e+-1.94998943002598e-10*a2_np_12_lll110e*comp2_np_12_lll110e+3.71925345954423e-10*a3_np_12_lll110e*comp3_np_12_lll110e+-6.42534763397968e-10*a4_np_12_lll110e*comp4_np_12_lll110e+2.05717744602202e-11*a5_np_12_lll110e*comp5_np_12_lll110e)
parameters 	du0_p_12_lll110e_g	  =	alpha_p_12_lll110e*(-5.62109638312717e-05*a1_np_12_lll110e*comp1_np_12_lll110e+6.66390857431933e-05*a2_np_12_lll110e*comp2_np_12_lll110e+-1.57803181275242e-05*a3_np_12_lll110e*comp3_np_12_lll110e+-3.3389222237253e-05*a4_np_12_lll110e*comp4_np_12_lll110e+-3.94803088453157e-05*a5_np_12_lll110e*comp5_np_12_lll110e)
parameters 	dvth0_p_12_lll110e_g	  =	alpha_p_12_lll110e*(-2.45559984244416e-03*a1_np_12_lll110e*comp1_np_12_lll110e+4.22204822823842e-03*a2_np_12_lll110e*comp2_np_12_lll110e+3.72795037739528e-04*a3_np_12_lll110e*comp3_np_12_lll110e+-6.1123157427085e-04*a4_np_12_lll110e*comp4_np_12_lll110e+2.34856135683771e-03*a5_np_12_lll110e*comp5_np_12_lll110e)
parameters 	drdsw_p_12_lll110e_g	  =	alpha_p_12_lll110e*(11.4423898476304*a1_np_12_lll110e*comp1_np_12_lll110e+-12.1597388224678*a2_np_12_lll110e*comp2_np_12_lll110e+0.976327156789363*a3_np_12_lll110e*comp3_np_12_lll110e+2.73276270159162*a4_np_12_lll110e*comp4_np_12_lll110e+6.08030692801139*a5_np_12_lll110e*comp5_np_12_lll110e)
parameters 	dxw_p_12_lll110e_g	  =	alpha_p_12_lll110e*(-2.32502944305453e-10*a1_np_12_lll110e*comp1_np_12_lll110e+2.1045295040676e-10*a2_np_12_lll110e*comp2_np_12_lll110e+1.30082129680464e-10*a3_np_12_lll110e*comp3_np_12_lll110e+-1.90853969889251e-10*a4_np_12_lll110e*comp4_np_12_lll110e+-1.00106178240867e-10*a5_np_12_lll110e*comp5_np_12_lll110e)
parameters 	dnlx_p_12_lll110e_g	  =	alpha_p_12_lll110e*(7.08670333285437e-10*a1_np_12_lll110e*comp1_np_12_lll110e+-6.82098116380672e-10*a2_np_12_lll110e*comp2_np_12_lll110e+-4.10349995768984e-11*a3_np_12_lll110e*comp3_np_12_lll110e+-1.04613958682128e-10*a4_np_12_lll110e*comp4_np_12_lll110e+5.43947393279322e-10*a5_np_12_lll110e*comp5_np_12_lll110e)
parameters 	dk3_p_12_lll110e_g	  =	alpha_p_12_lll110e*(0.287628406189131*a1_np_12_lll110e*comp1_np_12_lll110e+-0.246586872445772*a2_np_12_lll110e*comp2_np_12_lll110e+-7.40840827579794e-02*a3_np_12_lll110e*comp3_np_12_lll110e+-1.03691553390902e-02*a4_np_12_lll110e*comp4_np_12_lll110e+0.153226217592609*a5_np_12_lll110e*comp5_np_12_lll110e)
parameters 	dpvth0_p_12_lll110e_g	  =	alpha_p_12_lll110e*(-1.70398469548856e-16*a1_np_12_lll110e*comp1_np_12_lll110e+1.55040743216301e-16*a2_np_12_lll110e*comp2_np_12_lll110e+3.68032573360309e-17*a3_np_12_lll110e*comp3_np_12_lll110e+8.65222803561575e-18*a4_np_12_lll110e*comp4_np_12_lll110e+-4.67206894709713e-17*a5_np_12_lll110e*comp5_np_12_lll110e)
parameters 	dwwl_p_12_lll110e_g	  =	alpha_p_12_lll110e*(1.0539264676214e-25*a1_np_12_lll110e*comp1_np_12_lll110e+-1.33331972628065e-24*a2_np_12_lll110e*comp2_np_12_lll110e+2.70299501420809e-23*a3_np_12_lll110e*comp3_np_12_lll110e+1.67471179661958e-24*a4_np_12_lll110e*comp4_np_12_lll110e+-4.97336769834756e-24*a5_np_12_lll110e*comp5_np_12_lll110e)
parameters 	dcgdo_p_12_lll110e_g	  =	alpha_p_12_lll110e*(-1.93733165221576e-12*a1_np_12_lll110e*comp1_np_12_lll110e+-1.09413104806315e-13*a2_np_12_lll110e*comp2_np_12_lll110e+3.66096981205005e-13*a3_np_12_lll110e*comp3_np_12_lll110e+9.45848800110511e-14*a4_np_12_lll110e*comp4_np_12_lll110e+3.81577129551236e-14*a5_np_12_lll110e*comp5_np_12_lll110e)
parameters 	dcgso_p_12_lll110e_g	  =	alpha_p_12_lll110e*(-1.93733165221576e-12*a1_np_12_lll110e*comp1_np_12_lll110e+-1.09413104806315e-13*a2_np_12_lll110e*comp2_np_12_lll110e+3.66096981205005e-13*a3_np_12_lll110e*comp3_np_12_lll110e+9.45848800110511e-14*a4_np_12_lll110e*comp4_np_12_lll110e+3.81577129551236e-14*a5_np_12_lll110e*comp5_np_12_lll110e)
parameters 	dcj_p_12_lll110e_g	  =	alpha_p_12_lll110e*(1.18745717048946e-05*a1_np_12_lll110e*comp1_np_12_lll110e+-2.17507535908796e-05*a2_np_12_lll110e*comp2_np_12_lll110e+-1.67834208752515e-06*a3_np_12_lll110e*comp3_np_12_lll110e+4.46403720373891e-06*a4_np_12_lll110e*comp4_np_12_lll110e+2.94262720454236e-05*a5_np_12_lll110e*comp5_np_12_lll110e)
parameters 	dcjsw_p_12_lll110e_g	  =	alpha_p_12_lll110e*(1.44602627572504e-12*a1_np_12_lll110e*comp1_np_12_lll110e+-2.64869857969431e-12*a2_np_12_lll110e*comp2_np_12_lll110e+-2.04380151009255e-13*a3_np_12_lll110e*comp3_np_12_lll110e+5.43608245656546e-13*a4_np_12_lll110e*comp4_np_12_lll110e+1.21773990109893e-12*a5_np_12_lll110e*comp5_np_12_lll110e)
parameters 	dcjswg_p_12_lll110e_g	  =	alpha_p_12_lll110e*(6.50711824076268e-12*a1_np_12_lll110e*comp1_np_12_lll110e+-1.19191436086244e-11*a2_np_12_lll110e*comp2_np_12_lll110e+-9.19710679541661e-13*a3_np_12_lll110e*comp3_np_12_lll110e+2.44623710545456e-12*a4_np_12_lll110e*comp4_np_12_lll110e+-2.21389360465267e-12*a5_np_12_lll110e*comp5_np_12_lll110e)
parameters 	dcgdl_p_12_lll110e_g	  =	alpha_p_12_lll110e*(-9.95044486269541e-13*a1_np_12_lll110e*comp1_np_12_lll110e+-5.61963185490918e-14*a2_np_12_lll110e*comp2_np_12_lll110e+1.88033258100814e-13*a3_np_12_lll110e*comp3_np_12_lll110e+4.85803054070896e-14*a4_np_12_lll110e*comp4_np_12_lll110e+-3.96507381671578e-14*a5_np_12_lll110e*comp5_np_12_lll110e)
parameters 	dcgsl_p_12_lll110e_g	  =	alpha_p_12_lll110e*(-9.95044486269541e-13*a1_np_12_lll110e*comp1_np_12_lll110e+-5.61963185490918e-14*a2_np_12_lll110e*comp2_np_12_lll110e+1.88033258100814e-13*a3_np_12_lll110e*comp3_np_12_lll110e+4.85803054070896e-14*a4_np_12_lll110e*comp4_np_12_lll110e+-3.96507381671578e-14*a5_np_12_lll110e*comp5_np_12_lll110e)
parameters 	dcf_p_12_lll110e_g	  =	alpha_p_12_lll110e*(-1.05995551238034e-12*a1_np_12_lll110e*comp1_np_12_lll110e+-5.98622458026023e-14*a2_np_12_lll110e*comp2_np_12_lll110e+2.00299475234519e-13*a3_np_12_lll110e*comp3_np_12_lll110e+5.17494074083155e-14*a4_np_12_lll110e*comp4_np_12_lll110e+-4.40287271888214e-13*a5_np_12_lll110e*comp5_np_12_lll110e)
parameters 	dags_p_12_lll110e_g	  =	alpha_p_12_lll110e*(2.02938564634965e-02*a1_np_12_lll110e*comp1_np_12_lll110e+-1.61883952797681e-02*a2_np_12_lll110e*comp2_np_12_lll110e+-3.04196818953794e-03*a3_np_12_lll110e*comp3_np_12_lll110e+1.07088926501506e-02*a4_np_12_lll110e*comp4_np_12_lll110e+-4.04236625566672e-03*a5_np_12_lll110e*comp5_np_12_lll110e)
parameters 	dwags_p_12_lll110e_g	  =	alpha_p_12_lll110e*(1.54454680259439e-09*a1_np_12_lll110e*comp1_np_12_lll110e+-1.40871475771491e-09*a2_np_12_lll110e*comp2_np_12_lll110e+3.17101293075127e-10*a3_np_12_lll110e*comp3_np_12_lll110e+-3.35851333624143e-09*a4_np_12_lll110e*comp4_np_12_lll110e+2.87640942694018e-10*a5_np_12_lll110e*comp5_np_12_lll110e)
parameters 	dpvsat_p_12_lll110e_g	  =	alpha_p_12_lll110e*(0*a1_np_12_lll110e*comp1_np_12_lll110e+0*a2_np_12_lll110e*comp2_np_12_lll110e+0*a3_np_12_lll110e*comp3_np_12_lll110e+0*a4_np_12_lll110e*comp4_np_12_lll110e+0*a5_np_12_lll110e*comp5_np_12_lll110e)
parameters 	dvsat_p_12_lll110e_g	  =	alpha_p_12_lll110e*(0*a1_np_12_lll110e*comp1_np_12_lll110e+0*a2_np_12_lll110e*comp2_np_12_lll110e+0*a3_np_12_lll110e*comp3_np_12_lll110e+0*a4_np_12_lll110e*comp4_np_12_lll110e+0*a5_np_12_lll110e*comp5_np_12_lll110e)
parameters 	dwu0_p_12_lll110e_g	  =	alpha_p_12_lll110e*(6.82728970537943e-12*a1_np_12_lll110e*comp1_np_12_lll110e+-8.08550461780432e-12*a2_np_12_lll110e*comp2_np_12_lll110e+-1.98371891433877e-12*a3_np_12_lll110e*comp3_np_12_lll110e+5.96771195804456e-12*a4_np_12_lll110e*comp4_np_12_lll110e+-2.5450926745492e-11*a5_np_12_lll110e*comp5_np_12_lll110e)
parameters 	dpu0_p_12_lll110e_g	  =	alpha_p_12_lll110e*(-2.04266653995645e-18*a1_np_12_lll110e*comp1_np_12_lll110e+1.45264632486102e-18*a2_np_12_lll110e*comp2_np_12_lll110e+-1.59870856853261e-19*a3_np_12_lll110e*comp3_np_12_lll110e+-5.0181591811793e-18*a4_np_12_lll110e*comp4_np_12_lll110e+-1.59940499275511e-18*a5_np_12_lll110e*comp5_np_12_lll110e)
parameters 	dlags_p_12_lll110e_g	  =	alpha_p_12_lll110e*(3.4417138579691e-08*a1_np_12_lll110e*comp1_np_12_lll110e+-3.39192301566243e-08*a2_np_12_lll110e*comp2_np_12_lll110e+1.17070501914286e-08*a3_np_12_lll110e*comp3_np_12_lll110e+-8.61378845889113e-08*a4_np_12_lll110e*comp4_np_12_lll110e+4.91746370234663e-09*a5_np_12_lll110e*comp5_np_12_lll110e)
parameters 	dpags_p_12_lll110e_g	  =	alpha_p_12_lll110e*(1.2385310423628e-14*a1_np_12_lll110e*comp1_np_12_lll110e+-9.86692209445045e-15*a2_np_12_lll110e*comp2_np_12_lll110e+9.1234272531396e-16*a3_np_12_lll110e*comp3_np_12_lll110e+2.61434644486819e-14*a4_np_12_lll110e*comp4_np_12_lll110e+8.42792691975388e-15*a5_np_12_lll110e*comp5_np_12_lll110e)
