simulator lang=spectre insensitive=yes
//
parameters alpha_n_33_hgl110e = 0.2
parameters alpha_p_33_hgl110e = 0.2

parameters a1_np_33_hgl110e_xx = 0
parameters a2_np_33_hgl110e_xx = 0
parameters a3_np_33_hgl110e_xx = 0
parameters a4_np_33_hgl110e_xx = 0
parameters a5_np_33_hgl110e_xx = 0
statistics {
process {
vary a1_np_33_hgl110e_xx dist=gauss std=sigma/3
vary a2_np_33_hgl110e_xx dist=gauss std=sigma/3
vary a3_np_33_hgl110e_xx dist=gauss std=sigma/3
vary a4_np_33_hgl110e_xx dist=gauss std=sigma/3
vary a5_np_33_hgl110e_xx dist=gauss std=sigma/3
 }
}
parameters a1_np_33_hgl110e = a1_np_33_hgl110e_xx
parameters a2_np_33_hgl110e = a2_np_33_hgl110e_xx
parameters a3_np_33_hgl110e = a3_np_33_hgl110e_xx
parameters a4_np_33_hgl110e = a4_np_33_hgl110e_xx
parameters a5_np_33_hgl110e = a5_np_33_hgl110e_xx
parameters comp1_np_33_hgl110e	= 11.2383837497353
parameters comp2_np_33_hgl110e	= 6.22363521648482
parameters comp3_np_33_hgl110e	= 1.68412195958218
parameters comp4_np_33_hgl110e	= 0.358927027498859
parameters comp5_np_33_hgl110e	= 1.86567665619209e-14
parameters 	dtox_n_33_hgl110e_g	  =	alpha_n_33_hgl110e*(2.82987617886065e-11*a1_np_33_hgl110e*comp1_np_33_hgl110e+-1.64751593940164e-12*a2_np_33_hgl110e*comp2_np_33_hgl110e+-1.21466107740529e-13*a3_np_33_hgl110e*comp3_np_33_hgl110e+1.39549439016563e-12*a4_np_33_hgl110e*comp4_np_33_hgl110e+-2.02770802988722e-11*a5_np_33_hgl110e*comp5_np_33_hgl110e)
parameters 	dxl_n_33_hgl110e_g	  =	alpha_n_33_hgl110e*(4.31681471464227e-09*a1_np_33_hgl110e*comp1_np_33_hgl110e+2.02177719961282e-09*a2_np_33_hgl110e*comp2_np_33_hgl110e+-1.33622389627224e-10*a3_np_33_hgl110e*comp3_np_33_hgl110e+-3.08213562694644e-10*a4_np_33_hgl110e*comp4_np_33_hgl110e+-2.81051034821054e-09*a5_np_33_hgl110e*comp5_np_33_hgl110e)
parameters 	du0_n_33_hgl110e_g	  =	alpha_n_33_hgl110e*(-3.31251608514909e-04*a1_np_33_hgl110e*comp1_np_33_hgl110e+-3.00428662239151e-04*a2_np_33_hgl110e*comp2_np_33_hgl110e+-3.84589747461059e-05*a3_np_33_hgl110e*comp3_np_33_hgl110e+-4.06837638590453e-05*a4_np_33_hgl110e*comp4_np_33_hgl110e+1.89949132670667e-05*a5_np_33_hgl110e*comp5_np_33_hgl110e)
parameters 	dvth0_n_33_hgl110e_g	  =	alpha_n_33_hgl110e*(1.64687187408226e-03*a1_np_33_hgl110e*comp1_np_33_hgl110e+3.69057294856258e-03*a2_np_33_hgl110e*comp2_np_33_hgl110e+-4.55451141717128e-04*a3_np_33_hgl110e*comp3_np_33_hgl110e+-8.73984526418599e-04*a4_np_33_hgl110e*comp4_np_33_hgl110e+6.69590929272614e-03*a5_np_33_hgl110e*comp5_np_33_hgl110e)
parameters 	drdsw_n_33_hgl110e_g	  =	alpha_n_33_hgl110e*(17.7121647014184*a1_np_33_hgl110e*comp1_np_33_hgl110e+17.7863549689985*a2_np_33_hgl110e*comp2_np_33_hgl110e+21.7136863686743*a3_np_33_hgl110e*comp3_np_33_hgl110e+-28.0396069114175*a4_np_33_hgl110e*comp4_np_33_hgl110e+2.50919701655964*a5_np_33_hgl110e*comp5_np_33_hgl110e)
parameters 	dxw_n_33_hgl110e_g	  =	alpha_n_33_hgl110e*(-1.3041485828042e-09*a1_np_33_hgl110e*comp1_np_33_hgl110e+-1.1478163232618e-09*a2_np_33_hgl110e*comp2_np_33_hgl110e+-9.14748909200104e-10*a3_np_33_hgl110e*comp3_np_33_hgl110e+2.10156004984553e-09*a4_np_33_hgl110e*comp4_np_33_hgl110e+-1.8611592540259e-10*a5_np_33_hgl110e*comp5_np_33_hgl110e)
parameters 	dlvth0_n_33_hgl110e_g	  =	alpha_n_33_hgl110e*(1.44220243455212e-09*a1_np_33_hgl110e*comp1_np_33_hgl110e+1.20237592151874e-09*a2_np_33_hgl110e*comp2_np_33_hgl110e+6.28977908746763e-10*a3_np_33_hgl110e*comp3_np_33_hgl110e+-4.89811094982261e-10*a4_np_33_hgl110e*comp4_np_33_hgl110e+-4.33177766211711e-10*a5_np_33_hgl110e*comp5_np_33_hgl110e)
parameters 	dk3_n_33_hgl110e_g	  =	alpha_n_33_hgl110e*(0.219437178256299*a1_np_33_hgl110e*comp1_np_33_hgl110e+0.180788048040905*a2_np_33_hgl110e*comp2_np_33_hgl110e+-8.42983741744298e-02*a3_np_33_hgl110e*comp3_np_33_hgl110e+2.18689545777609e-03*a4_np_33_hgl110e*comp4_np_33_hgl110e+-9.36549876388093e-02*a5_np_33_hgl110e*comp5_np_33_hgl110e)
parameters 	dpvth0_n_33_hgl110e_g	  =	alpha_n_33_hgl110e*(-9.46042404968335e-17*a1_np_33_hgl110e*comp1_np_33_hgl110e+-7.58527202115826e-17*a2_np_33_hgl110e*comp2_np_33_hgl110e+1.46433934865174e-17*a3_np_33_hgl110e*comp3_np_33_hgl110e+-7.99835037340187e-17*a4_np_33_hgl110e*comp4_np_33_hgl110e+7.47964134155105e-17*a5_np_33_hgl110e*comp5_np_33_hgl110e)
parameters 	dwwl_n_33_hgl110e_g	  =	alpha_n_33_hgl110e*(-4.21341827010783e-22*a1_np_33_hgl110e*comp1_np_33_hgl110e+-2.90035526038797e-22*a2_np_33_hgl110e*comp2_np_33_hgl110e+-9.35486349969882e-23*a3_np_33_hgl110e*comp3_np_33_hgl110e+3.92837590064441e-22*a4_np_33_hgl110e*comp4_np_33_hgl110e+-2.69214483627734e-23*a5_np_33_hgl110e*comp5_np_33_hgl110e)
parameters 	dvsat_n_33_hgl110e_g	  =	alpha_n_33_hgl110e*(-1785.05583062876*a1_np_33_hgl110e*comp1_np_33_hgl110e+-2150.09671941684*a2_np_33_hgl110e*comp2_np_33_hgl110e+-1161.33582330792*a3_np_33_hgl110e*comp3_np_33_hgl110e+1188.51753334334*a4_np_33_hgl110e*comp4_np_33_hgl110e+1264.53595322732*a5_np_33_hgl110e*comp5_np_33_hgl110e)
parameters 	db0_n_33_hgl110e_g	  =	alpha_n_33_hgl110e*(-7.29130369098525e-08*a1_np_33_hgl110e*comp1_np_33_hgl110e+-6.5522898797919e-08*a2_np_33_hgl110e*comp2_np_33_hgl110e+3.20002505331188e-08*a3_np_33_hgl110e*comp3_np_33_hgl110e+8.64299127010288e-08*a4_np_33_hgl110e*comp4_np_33_hgl110e+1.02006930958801e-08*a5_np_33_hgl110e*comp5_np_33_hgl110e)
parameters 	dcgdo_n_33_hgl110e_g	  =	alpha_n_33_hgl110e*(-5.78552463233733e-13*a1_np_33_hgl110e*comp1_np_33_hgl110e+3.36825480944336e-14*a2_np_33_hgl110e*comp2_np_33_hgl110e+2.48330709158827e-15*a3_np_33_hgl110e*comp3_np_33_hgl110e+-2.85301075322738e-14*a4_np_33_hgl110e*comp4_np_33_hgl110e+-6.37841916383659e-13*a5_np_33_hgl110e*comp5_np_33_hgl110e)
parameters 	dcgso_n_33_hgl110e_g	  =	alpha_n_33_hgl110e*(-5.78552463233733e-13*a1_np_33_hgl110e*comp1_np_33_hgl110e+3.36825480944336e-14*a2_np_33_hgl110e*comp2_np_33_hgl110e+2.48330709158827e-15*a3_np_33_hgl110e*comp3_np_33_hgl110e+-2.85301075322738e-14*a4_np_33_hgl110e*comp4_np_33_hgl110e+-6.37841916383659e-13*a5_np_33_hgl110e*comp5_np_33_hgl110e)
parameters 	dags_n_33_hgl110e_g	  =	alpha_n_33_hgl110e*(9.13070709073949e-04*a1_np_33_hgl110e*comp1_np_33_hgl110e+2.81551903751929e-04*a2_np_33_hgl110e*comp2_np_33_hgl110e+6.6194024892214e-04*a3_np_33_hgl110e*comp3_np_33_hgl110e+3.37635463871051e-03*a4_np_33_hgl110e*comp4_np_33_hgl110e+1.40443850336445e-03*a5_np_33_hgl110e*comp5_np_33_hgl110e)
parameters 	dcj_n_33_hgl110e_g	  =	alpha_n_33_hgl110e*(1.33073712695402e-05*a1_np_33_hgl110e*comp1_np_33_hgl110e+2.25245003897772e-05*a2_np_33_hgl110e*comp2_np_33_hgl110e+-1.23682654921578e-06*a3_np_33_hgl110e*comp3_np_33_hgl110e+-4.68492955086717e-06*a4_np_33_hgl110e*comp4_np_33_hgl110e+-2.95858233279333e-05*a5_np_33_hgl110e*comp5_np_33_hgl110e)
parameters 	dcjsw_n_33_hgl110e_g	  =	alpha_n_33_hgl110e*(1.82836789842863e-12*a1_np_33_hgl110e*comp1_np_33_hgl110e+3.09475647794374e-12*a2_np_33_hgl110e*comp2_np_33_hgl110e+-1.69933934562003e-13*a3_np_33_hgl110e*comp3_np_33_hgl110e+-6.43686466974314e-13*a4_np_33_hgl110e*comp4_np_33_hgl110e+-2.46303797806213e-12*a5_np_33_hgl110e*comp5_np_33_hgl110e)
parameters 	dcjswg_n_33_hgl110e_g	  =	alpha_n_33_hgl110e*(2.56020840424715e-12*a1_np_33_hgl110e*comp1_np_33_hgl110e+4.33349412376983e-12*a2_np_33_hgl110e*comp2_np_33_hgl110e+-2.37953361468634e-13*a3_np_33_hgl110e*comp3_np_33_hgl110e+-9.01334738957101e-13*a4_np_33_hgl110e*comp4_np_33_hgl110e+1.48591542770858e-12*a5_np_33_hgl110e*comp5_np_33_hgl110e)
parameters 	dcgdl_n_33_hgl110e_g	  =	alpha_n_33_hgl110e*(-2.26390094308852e-12*a1_np_33_hgl110e*comp1_np_33_hgl110e+1.31801275152132e-13*a2_np_33_hgl110e*comp2_np_33_hgl110e+9.71728861926673e-15*a3_np_33_hgl110e*comp3_np_33_hgl110e+-1.11639551213243e-13*a4_np_33_hgl110e*comp4_np_33_hgl110e+-5.01103216300467e-14*a5_np_33_hgl110e*comp5_np_33_hgl110e)
parameters 	dcgsl_n_33_hgl110e_g	  =	alpha_n_33_hgl110e*(-2.26390094308852e-12*a1_np_33_hgl110e*comp1_np_33_hgl110e+1.31801275152132e-13*a2_np_33_hgl110e*comp2_np_33_hgl110e+9.71728861926673e-15*a3_np_33_hgl110e*comp3_np_33_hgl110e+-1.11639551213243e-13*a4_np_33_hgl110e*comp4_np_33_hgl110e+-5.01103216300467e-14*a5_np_33_hgl110e*comp5_np_33_hgl110e)
parameters 	dpvsat_n_33_hgl110e_g	  =	alpha_n_33_hgl110e*(-2.8653170132193e-12*a1_np_33_hgl110e*comp1_np_33_hgl110e+1.22998891621079e-13*a2_np_33_hgl110e*comp2_np_33_hgl110e+9.55410994627732e-12*a3_np_33_hgl110e*comp3_np_33_hgl110e+2.18335714613698e-12*a4_np_33_hgl110e*comp4_np_33_hgl110e+-2.6282038034037e-12*a5_np_33_hgl110e*comp5_np_33_hgl110e)
parameters 	dtox_p_33_hgl110e_g	  =	alpha_p_33_hgl110e*(2.82987617886066e-11*a1_np_33_hgl110e*comp1_np_33_hgl110e+-1.64751593940165e-12*a2_np_33_hgl110e*comp2_np_33_hgl110e+-1.21466107740834e-13*a3_np_33_hgl110e*comp3_np_33_hgl110e+1.39549439016555e-12*a4_np_33_hgl110e*comp4_np_33_hgl110e+6.26379020375585e-13*a5_np_33_hgl110e*comp5_np_33_hgl110e)
parameters 	dxl_p_33_hgl110e_g	  =	alpha_p_33_hgl110e*(4.12196844105847e-09*a1_np_33_hgl110e*comp1_np_33_hgl110e+-1.71561764177172e-09*a2_np_33_hgl110e*comp2_np_33_hgl110e+3.83827671387197e-09*a3_np_33_hgl110e*comp3_np_33_hgl110e+1.26486911524526e-09*a4_np_33_hgl110e*comp4_np_33_hgl110e+-3.37332625109392e-11*a5_np_33_hgl110e*comp5_np_33_hgl110e)
parameters 	du0_p_33_hgl110e_g	  =	alpha_p_33_hgl110e*(-8.12977149284862e-05*a1_np_33_hgl110e*comp1_np_33_hgl110e+9.3031798157852e-05*a2_np_33_hgl110e*comp2_np_33_hgl110e+-2.09776955405972e-05*a3_np_33_hgl110e*comp3_np_33_hgl110e+-1.57307248187831e-05*a4_np_33_hgl110e*comp4_np_33_hgl110e+4.65375959251497e-05*a5_np_33_hgl110e*comp5_np_33_hgl110e)
parameters 	dvth0_p_33_hgl110e_g	  =	alpha_p_33_hgl110e*(-1.95528826400189e-03*a1_np_33_hgl110e*comp1_np_33_hgl110e+5.10529409863819e-03*a2_np_33_hgl110e*comp2_np_33_hgl110e+-1.28952308122392e-04*a3_np_33_hgl110e*comp3_np_33_hgl110e+-1.28133302040687e-03*a4_np_33_hgl110e*comp4_np_33_hgl110e+8.95007280211189e-03*a5_np_33_hgl110e*comp5_np_33_hgl110e)
parameters 	drdsw_p_33_hgl110e_g	  =	alpha_p_33_hgl110e*(14.4492458845482*a1_np_33_hgl110e*comp1_np_33_hgl110e+-41.9275964729652*a2_np_33_hgl110e*comp2_np_33_hgl110e+10.1288424979549*a3_np_33_hgl110e*comp3_np_33_hgl110e+-59.5393264279718*a4_np_33_hgl110e*comp4_np_33_hgl110e+35.2634692558037*a5_np_33_hgl110e*comp5_np_33_hgl110e)
parameters 	dxw_p_33_hgl110e_g	  =	alpha_p_33_hgl110e*(-2.08780077614386e-09*a1_np_33_hgl110e*comp1_np_33_hgl110e+1.88185964194506e-09*a2_np_33_hgl110e*comp2_np_33_hgl110e+-1.57775069150713e-09*a3_np_33_hgl110e*comp3_np_33_hgl110e+6.23242177150024e-10*a4_np_33_hgl110e*comp4_np_33_hgl110e+-1.0025893110605e-09*a5_np_33_hgl110e*comp5_np_33_hgl110e)
parameters 	dlvth0_p_33_hgl110e_g	  =	alpha_p_33_hgl110e*(-2.27622499126923e-10*a1_np_33_hgl110e*comp1_np_33_hgl110e+5.7127827047837e-10*a2_np_33_hgl110e*comp2_np_33_hgl110e+3.80634329767871e-11*a3_np_33_hgl110e*comp3_np_33_hgl110e+1.28183114813958e-10*a4_np_33_hgl110e*comp4_np_33_hgl110e+-2.91760303039563e-10*a5_np_33_hgl110e*comp5_np_33_hgl110e)
parameters 	dk3_p_33_hgl110e_g	  =	alpha_p_33_hgl110e*(1.24090358649449*a1_np_33_hgl110e*comp1_np_33_hgl110e+-1.18704990111152*a2_np_33_hgl110e*comp2_np_33_hgl110e+-0.29971199806354*a3_np_33_hgl110e*comp3_np_33_hgl110e+0.490817148440697*a4_np_33_hgl110e*comp4_np_33_hgl110e+0.368614937770597*a5_np_33_hgl110e*comp5_np_33_hgl110e)
parameters 	dpvth0_p_33_hgl110e_g	  =	alpha_p_33_hgl110e*(-3.08678816011503e-16*a1_np_33_hgl110e*comp1_np_33_hgl110e+2.94933482341147e-16*a2_np_33_hgl110e*comp2_np_33_hgl110e+3.379128702851e-17*a3_np_33_hgl110e*comp3_np_33_hgl110e+-1.69737741592487e-16*a4_np_33_hgl110e*comp4_np_33_hgl110e+-5.61217543972334e-17*a5_np_33_hgl110e*comp5_np_33_hgl110e)
parameters 	dwwl_p_33_hgl110e_g	  =	alpha_p_33_hgl110e*(6.87808653629e-23*a1_np_33_hgl110e*comp1_np_33_hgl110e+-7.93992361387427e-23*a2_np_33_hgl110e*comp2_np_33_hgl110e+3.22652601711035e-23*a3_np_33_hgl110e*comp3_np_33_hgl110e+-9.82090166448644e-23*a4_np_33_hgl110e*comp4_np_33_hgl110e+5.50381211886204e-23*a5_np_33_hgl110e*comp5_np_33_hgl110e)
parameters 	dcgdl_p_33_hgl110e_g	  =	alpha_p_33_hgl110e*(-2.53695255127992e-12*a1_np_33_hgl110e*comp1_np_33_hgl110e+1.47697973394092e-13*a2_np_33_hgl110e*comp2_np_33_hgl110e+1.08893015966239e-14*a3_np_33_hgl110e*comp3_np_33_hgl110e+-1.25104521529019e-13*a4_np_33_hgl110e*comp4_np_33_hgl110e+-5.61541831999818e-14*a5_np_33_hgl110e*comp5_np_33_hgl110e)
parameters 	dcgsl_p_33_hgl110e_g	  =	alpha_p_33_hgl110e*(-2.53695255127992e-12*a1_np_33_hgl110e*comp1_np_33_hgl110e+1.47697973394092e-13*a2_np_33_hgl110e*comp2_np_33_hgl110e+1.08893015966239e-14*a3_np_33_hgl110e*comp3_np_33_hgl110e+-1.25104521529019e-13*a4_np_33_hgl110e*comp4_np_33_hgl110e+-5.61541831999818e-14*a5_np_33_hgl110e*comp5_np_33_hgl110e)
parameters 	dcgdo_p_33_hgl110e_g	  =	alpha_p_33_hgl110e*(-1.33318611092991e-12*a1_np_33_hgl110e*comp1_np_33_hgl110e+7.76163064784776e-14*a2_np_33_hgl110e*comp2_np_33_hgl110e+5.72240329801214e-15*a3_np_33_hgl110e*comp3_np_33_hgl110e+-6.57432912700211e-14*a4_np_33_hgl110e*comp4_np_33_hgl110e+1.56261861217753e-12*a5_np_33_hgl110e*comp5_np_33_hgl110e)
parameters 	dcgso_p_33_hgl110e_g	  =	alpha_p_33_hgl110e*(-1.33318611092991e-12*a1_np_33_hgl110e*comp1_np_33_hgl110e+7.76163064784776e-14*a2_np_33_hgl110e*comp2_np_33_hgl110e+5.72240329801214e-15*a3_np_33_hgl110e*comp3_np_33_hgl110e+-6.57432912700211e-14*a4_np_33_hgl110e*comp4_np_33_hgl110e+1.56261861217753e-12*a5_np_33_hgl110e*comp5_np_33_hgl110e)
parameters 	dags_p_33_hgl110e_g	  =	alpha_p_33_hgl110e*(3.15906311860679e-03*a1_np_33_hgl110e*comp1_np_33_hgl110e+-2.38313363130205e-03*a2_np_33_hgl110e*comp2_np_33_hgl110e+-1.83480736011922e-04*a3_np_33_hgl110e*comp3_np_33_hgl110e+5.8710720671196e-04*a4_np_33_hgl110e*comp4_np_33_hgl110e+-1.46577781555908e-03*a5_np_33_hgl110e*comp5_np_33_hgl110e)
parameters 	dcj_p_33_hgl110e_g	  =	alpha_p_33_hgl110e*(1.17821607667218e-05*a1_np_33_hgl110e*comp1_np_33_hgl110e+-2.26895143540741e-05*a2_np_33_hgl110e*comp2_np_33_hgl110e+1.06353208888501e-06*a3_np_33_hgl110e*comp3_np_33_hgl110e+5.62514715648051e-06*a4_np_33_hgl110e*comp4_np_33_hgl110e+-9.76004474437882e-06*a5_np_33_hgl110e*comp5_np_33_hgl110e)
parameters 	dcjsw_p_33_hgl110e_g	  =	alpha_p_33_hgl110e*(1.07244440615275e-12*a1_np_33_hgl110e*comp1_np_33_hgl110e+-2.06526147700152e-12*a2_np_33_hgl110e*comp2_np_33_hgl110e+9.68055912723725e-14*a3_np_33_hgl110e*comp3_np_33_hgl110e+5.12016235493309e-13*a4_np_33_hgl110e*comp4_np_33_hgl110e+-1.51533933435312e-13*a5_np_33_hgl110e*comp5_np_33_hgl110e)
parameters 	dcjswg_p_33_hgl110e_g	  =	alpha_p_33_hgl110e*(2.78365719767487e-12*a1_np_33_hgl110e*comp1_np_33_hgl110e+-5.36063216195945e-12*a2_np_33_hgl110e*comp2_np_33_hgl110e+2.51270442900829e-13*a3_np_33_hgl110e*comp3_np_33_hgl110e+1.3289991267429e-12*a4_np_33_hgl110e*comp4_np_33_hgl110e+2.02855306456698e-12*a5_np_33_hgl110e*comp5_np_33_hgl110e)
parameters 	dvsat_p_33_hgl110e_g	  =	alpha_p_33_hgl110e*(773.033678051189*a1_np_33_hgl110e*comp1_np_33_hgl110e+1382.97202271246*a2_np_33_hgl110e*comp2_np_33_hgl110e+1024.15072732232*a3_np_33_hgl110e*comp3_np_33_hgl110e+1960.19674388802*a4_np_33_hgl110e*comp4_np_33_hgl110e+438.534395331775*a5_np_33_hgl110e*comp5_np_33_hgl110e)
parameters 	db0_p_33_hgl110e_g	  =	alpha_p_33_hgl110e*(-9.81656525990616e-10*a1_np_33_hgl110e*comp1_np_33_hgl110e+1.10691600638414e-09*a2_np_33_hgl110e*comp2_np_33_hgl110e+-1.58270614155558e-09*a3_np_33_hgl110e*comp3_np_33_hgl110e+-2.18036958099206e-10*a4_np_33_hgl110e*comp4_np_33_hgl110e+-6.22761584563934e-10*a5_np_33_hgl110e*comp5_np_33_hgl110e)
parameters 	dpags_p_33_hgl110e_g	  =	alpha_p_33_hgl110e*(1.51872896779079e-15*a1_np_33_hgl110e*comp1_np_33_hgl110e+-1.9035536914987e-16*a2_np_33_hgl110e*comp2_np_33_hgl110e+-7.42485810459732e-15*a3_np_33_hgl110e*comp3_np_33_hgl110e+1.33253306915285e-15*a4_np_33_hgl110e*comp4_np_33_hgl110e+8.59108669015496e-17*a5_np_33_hgl110e*comp5_np_33_hgl110e)
