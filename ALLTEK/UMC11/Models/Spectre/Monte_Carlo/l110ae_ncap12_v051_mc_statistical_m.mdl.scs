simulator lang=spectre insensitive=yes
parameters mc_ncap_12_ma = 0
//
statistics {
mismatch {
vary mc_ncap_12_ma dist=gauss std=1/1
 }
}
