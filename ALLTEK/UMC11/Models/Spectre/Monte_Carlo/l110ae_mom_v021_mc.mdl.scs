simulator lang=spectre insensitive=yes
//****************************************************************************************
//*            MOM Capacitor subcircuit Monte Carlo model (symmetric type)
//*            UMC L110E mixed_mode/rf process
//*            2010/08/02   by Eddie Chang / I Chen Hsu
//*
//*            Input Parameter and recommended range:
//*            1. Capacitance (c):   37.09fF ~ 9.58pF   (nm=6)
//*                                  30.86fF ~ 7.973pF  (nm=5)
//*                                  24.51fF ~ 6.334pF  (nm=4)
//*                                  17.98fF ~ 4.64pF   (nm=3)
//*            2. finger number (nf): 198>= nf >=14  (even number only)
//*            3. finger width (w): fixed at 0.2um (before shrinkage)
//*            4. finger space (s): fixed at 0.2um (before shrinkage)
//*            5. Number of metal layer (nm): 3 to 6
//*
//*            Finger Length Range:
//*            1. finger length (l): 78.4um>= l >=4.4um (before shrinkage)
//*
//*            Node definition:
//*            1. port1
//*            2. port2
//*            3. well
//*
//*             Temperature range: -55 ¢J ~ +125 ¢J
//***************************************************************************************
//*
//*
inline subckt momcaps_sy_mml110ae (port1 port2  well)
parameters nf=20 nm=6 w=0.2u s=0.2u wb=0.2u mis_flag=1 bm=1 shielding_flag=0 presim_flag=1 metal_ring_flag=1
+ cho_tb_bm1=324a
+ cv_tb_bm1=41a
+ ratio_bm1=1.2
//*
+ cho_tb_bm2=345a
+ cv_tb_bm2=10a
+ ratio_bm2=1.27
//*
+ m6=(nm==6)?1:0
+ m5=(nm==5)?1:0
+ m4=(nm==4)?1:0
+ m3=(nm==3)?1:0
//*
+ bm1=(bm==1)?1:0
+ bm2=(bm==2)?1:0
+ bm3=(bm==3)?1:0
+ bm4=(bm==4)?1:0
//*
+ factor=bm1*(2.058*m6+1.69*m5+1.35*m4+1*m3)+bm2*(1.67*m5+1.32*m4+1*m3)+bm3*(1.32*m4+1*m3)+bm4*(1*m3)
//* Calculate length (l)
+ l= bm1*((((c+0.45f)/factor-(nf-2)*cv_tb_bm1) / ((nf-3)*cho_tb_bm1 + 2*ratio_bm1*cho_tb_bm1))*1u/0.9)+bm2*((((c+0.45f)/factor-(nf-2)*cv_tb_bm2) / ((nf-3)*cho_tb_bm2 + 2*ratio_bm2*cho_tb_bm2))*1u/0.9)+bm3*((((c+0.45f)/factor-(nf-2)*cv_tb_bm2) / ((nf-3)*cho_tb_bm2 + 2*ratio_bm2*cho_tb_bm2))*1u/0.9)+bm4*((((c+0.45f)/factor-(nf-2)*cv_tb_bm2) / ((nf-3)*cho_tb_bm2 + 2*ratio_bm2*cho_tb_bm2))*1u/0.9)
//* Calculate capactance (c)
+ c= bm1*((((l*0.9)/1u*((nf-3)*cho_tb_bm1 + 2*ratio_bm1*cho_tb_bm1) + (nf-2) *cv_tb_bm1) * factor)-0.45f)+bm2*((((l*0.9)/1u*((nf-3)*cho_tb_bm2 + 2*ratio_bm2*cho_tb_bm2) + (nf-2) *cv_tb_bm2) * factor)-0.45f)+bm3*((((l*0.9)/1u*((nf-3)*cho_tb_bm2 + 2*ratio_bm2*cho_tb_bm2) + (nf-2) *cv_tb_bm2) * factor)-0.45f)+bm4*((((l*0.9)/1u*((nf-3)*cho_tb_bm2 + 2*ratio_bm2*cho_tb_bm2) + (nf-2) *cv_tb_bm2) * factor)-0.45f)
//*
+ l2=l*0.9/1u+0.54
+ w2=(nf-1)*0.36+0.18
+ ma=1/sqrt(l2*w2)
+ ma_bm1=bm1*(m6*(2.2734*pow(ma,2)-0.2418*ma+0.0653)+m5*(2.2734*pow(ma,2)-0.2418*ma+0.0677)+m4*(2.2734*pow(ma,2)-0.2418*ma+0.0726)+m3*(2.2734*pow(ma,2)-0.2418*ma+0.0775))
+ ma_bm2=bm2*(m5*(2.8719*pow(ma,2)-0.3646*ma+0.0687)+m4*(2.8719*pow(ma,2)-0.3646*ma+0.084)+m3*(2.2766*pow(ma,2)-0.1097*ma+0.0889))
+ ma_bm3=bm3*(m4*(2.8719*pow(ma,2)-0.3646*ma+0.084)+m3*(2.2766*pow(ma,2)-0.1097*ma+0.0889))
+ ma_bm4=bm4*(m3*(2.2766*pow(ma,2)-0.1097*ma+0.0889))
+ ma_momcaps_sy_mml110ae=ma_bm1+ma_bm2+ma_bm3+ma_bm4
+ d_ma_symom=ma_momcaps_sy_mml110ae/sqrt(2)/1e2
+ dd_ma_symom=d_ma_symom * ma_sy_mom * mis_flag
+ p_c12=c*(1+dd_ma_symom)
//*
//* Calculate Cox
+ area=l2*w2
+ cf_factor=0.45
+ cf_factor_shield=0.65
+ p_c111=(1-shielding_flag)*bm1*(m6*((nf/2-1)*l*0.9/1u*7.9214e-18+(l*0.9/1u+(2*nf-3)*0.18)*8.039e-18+(nf-1)*l*0.9/1u*cf_factor*6.2854e-18+(l*0.9/1u+(7/2*nf-6)*0.18)*3.8788e-17+(l*0.9/1u+(2*nf-3)*0.18-1.53)*(3.18e-17+2.7168e-17)+(l*0.9/1u+(2*nf-3)*0.18)*(2.3833e-17+2.1255e-17+1.9348e-17))+m5*((nf/2-1)*l*0.9/1u*7.9214e-18+(l*0.9/1u+(2*nf-3)*0.18)*8.039e-18+(nf-1)*l*0.9/1u*cf_factor*6.2854e-18+(l*0.9/1u+(7/2*nf-6)*0.18)*3.8788e-17+(l*0.9/1u+(2*nf-3)*0.18-1.53)*(3.18e-17+2.7168e-17)+(l*0.9/1u+(2*nf-3)*0.18)*(2.3833e-17+2.1255e-17))+m4*((nf/2-1)*l*0.9/1u*7.9214e-18+(l*0.9/1u+(2*nf-3)*0.18)*8.039e-18+(nf-1)*l*0.9/1u*cf_factor*6.2854e-18+(l*0.9/1u+(7/2*nf-6)*0.18)*3.8788e-17+(l*0.9/1u+(2*nf-3)*0.18-1.53)*(3.18e-17+2.7168e-17)+(l*0.9/1u+(2*nf-3)*0.18)*2.3833e-17)+m3*((nf/2-1)*l*0.9/1u*7.9214e-18+(l*0.9/1u+(2*nf-3)*0.18)*8.039e-18+(nf-1)*l*0.9/1u*cf_factor*6.2854e-18+(l*0.9/1u+(7/2*nf-6)*0.18)*3.8788e-17+(l*0.9/1u+(2*nf-3)*0.18-1.53)*(3.18e-17+2.7168e-17)))
+ p_c112=(1-shielding_flag)*bm2*(m5*((nf/2-1)*l*0.9/1u*5.2484e-18+(l*0.9/1u+(2*nf-3)*0.18)*5.2921e-18+(nf-1)*l*0.9/1u*cf_factor*4.793e-18+(l*0.9/1u+(7/2*nf-6)*0.18)*3.18e-17+(l*0.9/1u+(2*nf-3)*0.18-1.53)*(2.7168e-17+2.3833e-17)+(l*0.9/1u+(2*nf-3)*0.18)*(2.1255e-17+1.9348e-17))+m4*((nf/2-1)*l*0.9/1u*5.2484e-18+(l*0.9/1u+(2*nf-3)*0.18)*5.2921e-18+(nf-1)*l*0.9/1u*cf_factor*4.793e-18+(l*0.9/1u+(7/2*nf-6)*0.18)*3.18e-17+(l*0.9/1u+(2*nf-3)*0.18-1.53)*(2.7168e-17+2.3833e-17)+(l*0.9/1u+(2*nf-3)*0.18)*2.1255e-17)+m3*((nf/2-1)*l*0.9/1u*5.2484e-18+(l*0.9/1u+(2*nf-3)*0.18)*5.2921e-18+(nf-1)*l*0.9/1u*cf_factor*4.793e-18+(l*0.9/1u+(7/2*nf-6)*0.18)*3.18e-17+(l*0.9/1u+(2*nf-3)*0.18-1.53)*(2.7168e-17+2.3833e-17)))
+ p_c113=(1-shielding_flag)*bm3*(m4*((nf/2-1)*l*0.9/1u*3.5731e-18+(l*0.9/1u+(2*nf-3)*0.18)*3.6028e-18+(nf-1)*l*0.9/1u*cf_factor*4.2711e-18+(l*0.9/1u+(7/2*nf-6)*0.18)*2.7168e-17+(l*0.9/1u+(2*nf-3)*0.18-1.53)*(2.3833e-17+2.1255e-17)+(l*0.9/1u+(2*nf-3)*0.18)*1.9348e-17)+m3*((nf/2-1)*l*0.9/1u*3.5731e-18+(l*0.9/1u+(2*nf-3)*0.18)*3.6028e-18+(nf-1)*l*0.9/1u*cf_factor*4.2711e-18+(l*0.9/1u+(7/2*nf-6)*0.18)*2.7168e-17+(l*0.9/1u+(2*nf-3)*0.18-1.53)*(2.3833e-17+2.1255e-17)))
+ p_c114=(1-shielding_flag)*bm4*(m3*((nf/2-1)*l*0.9/1u*2.7096e-18+(l*0.9/1u+(2*nf-3)*0.18)*2.7322e-18+(nf-1)*l*0.9/1u*cf_factor*3.97e-18+(l*0.9/1u+(7/2*nf-6)*0.18)*2.3833e-17+(l*0.9/1u+(2*nf-3)*0.18-1.53)*(2.1255e-17+1.9348e-17)))
+ p_c115=shielding_flag*bm2*(m5*((nf/2-1)*l*0.9/1u*2.1656e-17+(l*0.9/1u+(2*nf-3)*0.18)*2.1836e-17+(nf-1)*l*0.9/1u*cf_factor_shield*9.8817e-18+(l*0.9/1u+(7/2*nf-6)*0.18)*4.9959e-17+(l*0.9/1u+(2*nf-3)*0.18-1.53)*(3.5839e-17+2.9742e-17)+(l*0.9/1u+(2*nf-3)*0.18)*(2.5716e-17+2.2965e-17))+m4*((nf/2-1)*l*0.9/1u*2.1656e-17+(l*0.9/1u+(2*nf-3)*0.18)*2.1836e-17+(nf-1)*l*0.9/1u*cf_factor_shield*9.8817e-18+(l*0.9/1u+(7/2*nf-6)*0.18)*4.9959e-17+(l*0.9/1u+(2*nf-3)*0.18-1.53)*(3.5839e-17+2.9742e-17)+(l*0.9/1u+(2*nf-3)*0.18)*2.5716e-17)+m3*((nf/2-1)*l*0.9/1u*2.1656e-17+(l*0.9/1u+(2*nf-3)*0.18)*2.1836e-17+(nf-1)*l*0.9/1u*cf_factor_shield*9.8817e-18+(l*0.9/1u+(7/2*nf-6)*0.18)*4.9959e-17+(l*0.9/1u+(2*nf-3)*0.18-1.53)*(3.5839e-17+2.9742e-17)))
+ p_c116=shielding_flag*bm3*(m4*((nf/2-1)*l*0.9/1u*2.1656e-17+(l*0.9/1u+(2*nf-3)*0.18)*2.1836e-17+(nf-1)*l*0.9/1u*cf_factor_shield*9.8858e-18+(l*0.9/1u+(7/2*nf-6)*0.18)*4.9884e-17+(l*0.9/1u+(2*nf-3)*0.18-1.53)*(3.58e-17+2.9732e-17)+(l*0.9/1u+(2*nf-3)*0.18)*2.5998e-17)+m3*((nf/2-1)*l*0.9/1u*2.1656e-17+(l*0.9/1u+(2*nf-3)*0.18)*2.1836e-17+(nf-1)*l*0.9/1u*cf_factor_shield*9.8858e-18+(l*0.9/1u+(7/2*nf-6)*0.18)*4.9884e-17+(l*0.9/1u+(2*nf-3)*0.18-1.53)*(3.58e-17+2.9732e-17)))
+ p_c117=shielding_flag*bm4*m3*((nf/2-1)*l*0.9/1u*2.1656e-17+(l*0.9/1u+(2*nf-3)*0.18)*2.1836e-17+(nf-1)*l*0.9/1u*cf_factor_shield*9.8920e-18+(l*0.9/1u+(7/2*nf-6)*0.18)*4.9854e-17+(l*0.9/1u+(2*nf-3)*0.18-1.53)*(3.58116e-17+3.0134e-17))
+ p_c118=metal_ring_flag*bm1*(m6*((l*0.9/1u-1.53+(2*nf-3)*0.18)*(3.2991e-17+2.6565e-17+2.6607e-17+2.66e-17+2.6597e-17+2.8838e-17)-(l*0.9/1u+(2*nf-3)*0.18-1.53)*cf_factor*(2.1807e-17+2.0815e-17+1.8482e-17+1.6383e-17+1.4593e-17+1.3321e-17))+m5*((l*0.9/1u-1.53+(2*nf-3)*0.18)*(3.2991e-17+2.6565e-17+2.6607e-17+2.66e-17+2.6597e-17)-(l*0.9/1u+(2*nf-3)*0.18-1.53)*cf_factor*(2.1807e-17+2.0815e-17+1.8482e-17+1.6383e-17+1.4593e-17))+m4*((l*0.9/1u-1.53+(2*nf-3)*0.18)*(3.2991e-17+2.6565e-17+2.6607e-17+2.66e-17)-(l*0.9/1u+(2*nf-3)*0.18-1.53)*cf_factor*(2.1807e-17+2.0815e-17+1.8482e-17+1.6383e-17))+m3*((l*0.9/1u-1.53+(2*nf-3)*0.18)*(3.2991e-17+2.6565e-17+2.6607e-17)-(l*0.9/1u+(2*nf-3)*0.18-1.53)*cf_factor*(2.1807e-17+2.0815e-17+1.8482e-17)))
+ p_c119=metal_ring_flag*bm2*(m5*((l*0.9/1u-1.53+(2*nf-3)*0.18)*(2.6565e-17+2.6607e-17+2.66e-17+2.6597e-17+2.8838e-17)-(l*0.9/1u+(2*nf-3)*0.18-1.53)*cf_factor*(2.0815e-17+1.8482e-17+1.6383e-17+1.4593e-17+1.3321e-17))+m4*((l*0.9/1u-1.53+(2*nf-3)*0.18)*(2.6565e-17+2.6607e-17+2.66e-17+2.6597e-17)-(l*0.9/1u+(2*nf-3)*0.18-1.53)*cf_factor*(2.0815e-17+1.8482e-17+1.6383e-17+1.4593e-17))+m3*((l*0.9/1u-1.53+(2*nf-3)*0.18)*(2.6565e-17+2.6607e-17+2.66e-17)-(l*0.9/1u+(2*nf-3)*0.18-1.53)*cf_factor*(2.0815e-17+1.8482e-17+1.6383e-17)))
+ p_c120=metal_ring_flag*(bm3*(m4*((l*0.9/1u-1.53+(2*nf-3)*0.18)*(2.6607e-17+2.66e-17+2.6597e-17+2.8838e-17)-(l*0.9/1u+(2*nf-3)*0.18-1.53)*cf_factor*(1.8482e-17+1.6383e-17+1.4593e-17+1.3321e-17))+m3*((l*0.9/1u-1.53+(2*nf-3)*0.18)*(2.6607e-17+2.66e-17+2.6597e-17)-(l*0.9/1u+(2*nf-3)*0.18-1.53)*cf_factor*(1.8482e-17+1.6383e-17+1.4593e-17)))+bm4*(m3*((l*0.9/1u-1.53+(2*nf-3)*0.18)*(2.66e-17+2.6597e-17+2.8838e-17)-(l*0.9/1u+(2*nf-3)*0.18-1.53)*cf_factor*(1.6383e-17+1.4593e-17+1.3321e-17))))
+ p_c11=presim_flag*(p_c111+p_c112+p_c113+p_c114+p_c115+p_c116+p_c117+p_c118+p_c119+p_c120)+0.001f
//*
//* ----- Equivalent network ------------------
//*
momcaps_sy_mml110ae (port1 port2) main_c_vp1 c=p_c12*(1+d_c1_vp_mml110ae)
cox1 (port1 well) capacitor c=p_c11*(1+d_cox_vp_mml110ae)
cox2 (port2 well) capacitor c=p_c11*(1+d_cox_vp_mml110ae)
//*
//* Main Capacitor model
model main_c_vp1 capacitor c=1p tc1=-3.098e-5 tc2=-1.122e-9 tnom=25 coeffs=[2.874e-7 -1.089e-6]
//* -------------------------------------------
ends momcaps_sy_mml110ae
//****************************************************************************************
//*            MOM Capacitor subcircuit Monte Carlo model (asymmetric type)
//*            UMC L110E mixed_mode/rf process
//*            2010/08/02   by Eddie Chang / I Chen Hsu
//*
//*            Input Parameter and recommended range:
//*            1. Capacitance (c):   37.79fF ~ 8.463pF  (nm=6)
//*                                  30.69fF ~ 6.872pF  (nm=5)
//*                                  23.58fF ~ 5.28pF   (nm=4)
//*            2. finger number (nf): 199>= nf >=15  (odd number only)
//*            3. finger width (w): fixed at 0.2um (before shrinkage)
//*            4. finger space (s): fixed at 0.2um (before shrinkage)
//*            5. Number of metal layer (nm): 4 to 6
//*
//*            Finger Length Range:
//*            1. finger length (l): 78.4um>= l >=4.4um (before shrinkage)
//*
//*            Node definition:
//*            1. top
//*            2. bottom
//*            3. well
//*
//*            Temperature range: -55 ¢J ~ +125 ¢J
//****************************************************************************************
//*
inline subckt momcaps_as_mml110ae (top bottom well)
parameters nf=21 nm=6 w=0.1u s=0.1u wb=0.1u mis_flag=1 bm=1 metal_ring_flag=1 presim_flag=1
+ cho_tb=582a
+ cv_tb=300a
+ ratio=1.19
//*
+ m6=(nm==6)?1:0
+ m5=(nm==5)?1:0
+ m4=(nm==4)?1:0
//*
+ bm1=(bm==1)?1:0
+ bm2=(bm==2)?1:0
+ bm3=(bm==3)?1:0
//*
+ factor=bm1*(1*m6+0.8*m5+0.598*m4)+bm2*(0.8*m5+0.598*m4)+bm3*(0.598*m4)
//*
* Calculate length (l)
+ l= bm1*((((c+0.45f)/factor-(nf-2)*cv_tb) / ((nf-3)*cho_tb + 2*ratio*cho_tb))*1u/0.9)+bm2*((((c+0.45f)/factor-(nf-2)*cv_tb) / ((nf-3)*cho_tb + 2*ratio*cho_tb))*1u/0.9)+bm3*((((c+0.45f)/factor-(nf-2)*cv_tb) / ((nf-3)*cho_tb + 2*ratio*cho_tb))*1u/0.9)
* Calculate capactance (c)
+ c= bm1*((((l*0.9)/1u*((nf-3)*cho_tb + 2*ratio*cho_tb) + (nf-2) *cv_tb) * factor)-0.45f)+bm2*((((l*0.9)/1u*((nf-3)*cho_tb + 2*ratio*cho_tb) + (nf-2) *cv_tb) * factor)-0.45f)+bm3*((((l*0.9)/1u*((nf-3)*cho_tb + 2*ratio*cho_tb) + (nf-2) *cv_tb) * factor)-0.45f)
//*
+ l2=l*0.9/1u+0.9
+ w2=(nf-1)*0.36+0.18
+ ma=1/sqrt(l2*w2)
+ ma_momcaps_as_mml110ae=m6*(5.329*pow(ma,2)-1.2215*ma+0.1182)+m5*(5.8501*pow(ma,2)-1.3603*ma+0.1278)+m4*(7.2009*pow(ma,2)-1.4105*ma+0.132)
+ d_ma_asmom=ma_momcaps_as_mml110ae/sqrt(2)/1e2
+ dd_ma_asmom=d_ma_asmom * ma_as_mom * mis_flag
+ p_c12=c*(1+dd_ma_asmom)
//*
//* calculate cox
+ wt=w/1u*0.9*(3*int(nf/2)+int(nf/2)+1) lt=l/1u*0.9+5*w/1u*0.9
+ ar=wt*lt pr=2*(wt+lt) dpr=5.8*0.9
+ b1ca=7.9214e-18 b2ca=5.2484e-18 b3ca=3.5731e-18
+ cf1_m1=3.8788e-17 cf1_m2=3.18e-17 cf1_m3=2.7168e-17 cf1_m4=2.3833e-17 cf1_m5=2.1255e-17 cf1_m6=1.9348e-17
+ cc_m1=3.2991e-17  cc_m2=3.6901e-17  cc_m3=3.8275e-17  cc_m4=3.8905e-17  cc_m5=3.9290e-17  cc_m6=4.1772e-17
+ cf1_mr1=1.6981e-17   cf1_mr2=1.0985e-17  cf1_mr3=8.6858e-18  cf1_mr4=7.4503e-18  cf1_mr5=6.662e-18  cf1_mr6=6.0268e-18
+ mr=metal_ring_flag
+ b1m4_ox=b1ca*ar+(cf1_m1*(1-mr)+(cf1_mr1+cc_m1)*mr)*pr+((cf1_m2+cf1_m3+cf1_m4)*(1-mr)+(cf1_mr2+cf1_mr3+cf1_mr4+cc_m2+cc_m3+cc_m4)*mr)*(pr-dpr)
+ b1m5_ox=b1m4_ox+(cf1_m5*(1-mr)+(cf1_mr5+cc_m5)*mr)*(pr-dpr)
+ b1m6_ox=b1m5_ox+(cf1_m6*(1-mr)+(cf1_mr6+cc_m6)*mr)*(pr-dpr)
+ b2m4_ox=b2ca*ar+(cf1_m2*(1-mr)+(cf1_mr2+cc_m2)*mr)*pr+((cf1_m3+cf1_m4+cf1_m5)*(1-mr)+(cf1_mr3+cf1_mr4+cf1_mr5+cc_m3+cc_m4+cc_m5)*mr)*(pr-dpr)
+ b2m5_ox=b2m4_ox+(cf1_m6*(1-mr)+(cf1_mr6+cc_m6)*mr)*(pr-dpr)
+ b3m4_ox=b3ca*ar+(cf1_m3*(1-mr)+(cf1_mr3+cc_m3)*mr)*pr+((cf1_m4+cf1_m5+cf1_m6)*(1-mr)+(cf1_mr4+cf1_mr5+cf1_mr6+cc_m4+cc_m5+cc_m6)*mr)*(pr-dpr)
+ p_cox1=bm1*(m4*b1m4_ox+m5*b1m5_ox+m6*b1m6_ox)+bm2*(m4*b2m4_ox+m5*b2m5_ox)+bm3*(m4*b3m4_ox)
+ p_cox=presim_flag*p_cox1+0.001f
//*
//* ----- Equivalent network ------------------
//*
momcaps_as_mml110ae (top bottom) main_c_vp2 c=p_c12 *(1+d_c1_vp_mml110ae)
cox2 (bottom well) capacitor c=p_cox*(1+d_cox_vp_mml110ae)
//* Main Capacitor model
model main_c_vp2 capacitor c=1p tc1=-3.098e-5 tc2=-1.122e-9 tnom=25 coeffs=[2.874e-7 -1.089e-6]
ends momcaps_as_mml110ae
//*
//****************************************************************************************
//*            Stripe MOM Capacitor subcircuit Monte Carlo model (symmetric type)
//*            UMC L110E mixed_mode/rf process
//*            2010/08/02   by Eddie Chang / I Chen Hsu
//*
//*           Input Parameter and recommended range:
//*           1. Capacitance (c):   37.09fF ~ 9.58pF   (nm=6)
//*                                 30.86fF ~ 7.973pF  (nm=5)
//*                                 24.51fF ~ 6.334pF  (nm=4)
//*                                 17.98fF ~ 4.64pF   (nm=3)
//*                                 17.98fF ~ 4.64pF   (nm=2)
//*           2. finger number (nf): 198>= nf >=14  (even number only)
//*           3. finger width (w): fixed at 0.2um (before shrinkage)
//*           4. finger space (s): fixed at 0.2um (before shrinkage)
//*           5. Number of metal layer (nm): 2 to 6
//*
//*           Finger Length Range:
//*           1. finger length (l): 78.4um>= l >=4.4um (before shrinkage)
//*
//*
//*            Node definition:
//*            1. port1
//*            2. port2
//*            3. well
//*
//*             Temperature range: -55 ¢J ~ +125 ¢J
//***************************************************************************************
inline subckt momcaps_stripe_mml110ae (port1 port2  well)
parameters nf=20 nm=6 w=0.2u s=0.2u wb=0.2u mis_flag=1 bm=1 shielding_flag=0 presim_flag=1 metal_ring_flag=1
+ cho_tb_bm1=663a
+ cv_tb_bm1=20a
+ ratio_bm1=1.44
//*
+ cho_tb_bm2=224a
+ cv_tb_bm2=20a
+ ratio_bm2=1.3
//*
+ m6=(nm==6)?1:0
+ m5=(nm==5)?1:0
+ m4=(nm==4)?1:0
+ m3=(nm==3)?1:0
+ m2=(nm==2)?1:0
//*
+ bm1=(bm==1)?1:0
+ bm2=(bm==2)?1:0
+ bm3=(bm==3)?1:0
+ bm4=(bm==4)?1:0
+ bm5=(bm==5)?1:0
//*
+ factor=bm1*(1*m6+0.8262*m5+0.651*m4+0.4812*m3+0.310*m2)+bm2*(2.5*m5+2.01*m4+1.5028*m3+1*m2)+bm3*(2.01*m4+1.5028*m3+1*m2)+bm4*(1.5028*m3+1*m2)+bm5*(1*m2)
//* calculate length (l)
+ l= bm1*((((c+0.03164f)/factor-(nf-2)*cv_tb_bm1) / ((nf-3)*cho_tb_bm1 + 2*ratio_bm1*cho_tb_bm1-0.00184f/factor))*1u/0.9)+bm2*((((c+0.03164f)/factor-(nf-2)*cv_tb_bm2) / ((nf-3)*cho_tb_bm2 + 2*ratio_bm2*cho_tb_bm2-0.00184f/factor))*1u/0.9)+bm3*((((c+0.03164f)/factor-(nf-2)*cv_tb_bm2) / ((nf-3)*cho_tb_bm2 + 2*ratio_bm2*cho_tb_bm2-0.00184f/factor))*1u/0.9)+bm4*((((c+0.03164f)/factor-(nf-2)*cv_tb_bm2) / ((nf-3)*cho_tb_bm2 + 2*ratio_bm2*cho_tb_bm2-0.00184f/factor))*1u/0.9)+bm5*((((c+0.03164f)/factor-(nf-2)*cv_tb_bm2) / ((nf-3)*cho_tb_bm2 + 2*ratio_bm2*cho_tb_bm2-0.00184f/factor))*1u/0.9)
//* calculate capactance (c)
+ c= bm1*((((l*0.9)/1u*((nf-3)*cho_tb_bm1 + 2*ratio_bm1*cho_tb_bm1) + (nf-2) *cv_tb_bm1) * factor)-0.00184f*l*0.9-0.03164f)+bm2*((((l*0.9)/1u*((nf-3)*cho_tb_bm2 + 2*ratio_bm2*cho_tb_bm2) + (nf-2) *cv_tb_bm2) * factor)-0.00184f*l*0.9-0.03164f)+bm3*((((l*0.9)/1u*((nf-3)*cho_tb_bm2 + 2*ratio_bm2*cho_tb_bm2) + (nf-2) *cv_tb_bm2) * factor)-0.00184f*l*0.9-0.03164f)+bm4*((((l*0.9)/1u*((nf-3)*cho_tb_bm2 + 2*ratio_bm2*cho_tb_bm2) + (nf-2) *cv_tb_bm2) * factor)-0.00184f*l*0.9-0.03164f)+bm5*((((l*0.9)/1u*((nf-3)*cho_tb_bm2 + 2*ratio_bm2*cho_tb_bm2) + (nf-2) *cv_tb_bm2) * factor)-0.00184f*l*0.9-0.03164f)
//*
+ l2=l*0.9/1u+0.54
+ w2=(nf-1)*0.36+0.18
+ ma=1/sqrt(l2*w2)
+ ma_bm1=bm1*(m6*(4.9394*pow(ma,2)-0.6173*ma+0.1038)+m5*(5.6867*pow(ma,2)-0.6844*ma+0.13)+m4*(6.434*pow(ma,2)-0.7515*ma+0.1562)+m3*(8.5775*pow(ma,2)-0.9615*ma+0.1821)+m2*(10.721*pow(ma,2)-1.1715*ma+0.2079))
+ ma_bm2=bm2*(m5*(5.8272*pow(ma,2)-0.8747*ma+0.1277)+m4*(5.8946*pow(ma,2)-0.7578*ma+0.1288)+m3*(8.6637*pow(ma,2)-0.8472*ma+0.1394)+m2*(10.721*pow(ma,2)-1.1715*ma+0.2079))
+ ma_bm3=bm3*(m4*(5.8946*pow(ma,2)-0.7578*ma+0.1288)+m3*(8.6637*pow(ma,2)-0.8472*ma+0.1394)+m2*(10.721*pow(ma,2)-1.1715*ma+0.2079))
+ ma_bm4=bm4*(m3*(8.6637*pow(ma,2)-0.8472*ma+0.1394)+m2*(10.721*pow(ma,2)-1.1715*ma+0.2079))
+ ma_bm5=bm5*(m2*(10.721*pow(ma,2)-1.1715*ma+0.2079))
+ ma_momcaps_sy_mml110ae=ma_bm1+ma_bm2+ma_bm3+ma_bm4+ma_bm5
+ d_ma_symom=ma_momcaps_sy_mml110ae/sqrt(2)/1e2
+ dd_ma_symom=d_ma_symom * ma_sy_mom * mis_flag
+ p_c12=c*(1+dd_ma_symom)
//*
//* Calculate Cox
+ area=l2*w2
+ cf_factor=0.45
+ cf_factor_shield=0.65
+ p_c111=(1-shielding_flag)*bm1*(m6*((nf/2-1)*l*0.9/1u*7.9214e-18+(l*0.9/1u+(2*nf-3)*0.18)*8.039e-18+(nf-1)*l*0.9/1u*cf_factor*6.2854e-18+(l*0.9/1u+(7/2*nf-6)*0.18)*3.8788e-17+(l*0.9/1u+(2*nf-3)*0.18-1.53)*(3.18e-17+2.7168e-17)+(l*0.9/1u+(2*nf-3)*0.18)*(2.3833e-17+2.1255e-17+1.9348e-17))+m5*((nf/2-1)*l*0.9/1u*7.9214e-18+(l*0.9/1u+(2*nf-3)*0.18)*8.039e-18+(nf-1)*l*0.9/1u*cf_factor*6.2854e-18+(l*0.9/1u+(7/2*nf-6)*0.18)*3.8788e-17+(l*0.9/1u+(2*nf-3)*0.18-1.53)*(3.18e-17+2.7168e-17)+(l*0.9/1u+(2*nf-3)*0.18)*(2.3833e-17+2.1255e-17))+m4*((nf/2-1)*l*0.9/1u*7.9214e-18+(l*0.9/1u+(2*nf-3)*0.18)*8.039e-18+(nf-1)*l*0.9/1u*cf_factor*6.2854e-18+(l*0.9/1u+(7/2*nf-6)*0.18)*3.8788e-17+(l*0.9/1u+(2*nf-3)*0.18-1.53)*(3.18e-17+2.7168e-17)+(l*0.9/1u+(2*nf-3)*0.18)*2.3833e-17)+m3*((nf/2-1)*l*0.9/1u*7.9214e-18+(l*0.9/1u+(2*nf-3)*0.18)*8.039e-18+(nf-1)*l*0.9/1u*cf_factor*6.2854e-18+(l*0.9/1u+(7/2*nf-6)*0.18)*3.8788e-17+(l*0.9/1u+(2*nf-3)*0.18-1.53)*(3.18e-17+2.7168e-17)))
+ p_c1111=(1-shielding_flag)*bm1*(m2*((nf/2-1)*l*0.9/1u*7.9214e-18+(l*0.9/1u+(2*nf-3)*0.18)*8.039e-18+(nf-1)*l*0.9/1u*cf_factor*6.2854e-18+(l*0.9/1u+(7/2*nf-6)*0.18)*3.8788e-17+(l*0.9/1u+(2*nf-3)*0.18)*(3.18e-17)))
+ p_c112=(1-shielding_flag)*bm2*(m5*((nf/2-1)*l*0.9/1u*5.2484e-18+(l*0.9/1u+(2*nf-3)*0.18)*5.2921e-18+(nf-1)*l*0.9/1u*cf_factor*4.793e-18+(l*0.9/1u+(7/2*nf-6)*0.18)*3.18e-17+(l*0.9/1u+(2*nf-3)*0.18-1.53)*(2.7168e-17+2.3833e-17)+(l*0.9/1u+(2*nf-3)*0.18)*(2.1255e-17+1.9348e-17))+m4*((nf/2-1)*l*0.9/1u*5.2484e-18+(l*0.9/1u+(2*nf-3)*0.18)*5.2921e-18+(nf-1)*l*0.9/1u*cf_factor*4.793e-18+(l*0.9/1u+(7/2*nf-6)*0.18)*3.18e-17+(l*0.9/1u+(2*nf-3)*0.18-1.53)*(2.7168e-17+2.3833e-17)+(l*0.9/1u+(2*nf-3)*0.18)*2.1255e-17)+m3*((nf/2-1)*l*0.9/1u*5.2484e-18+(l*0.9/1u+(2*nf-3)*0.18)*5.2921e-18+(nf-1)*l*0.9/1u*cf_factor*4.793e-18+(l*0.9/1u+(7/2*nf-6)*0.18)*3.18e-17+(l*0.9/1u+(2*nf-3)*0.18-1.53)*(2.7168e-17+2.3833e-17))+m2*((nf/2-1)*l*0.9/1u*5.2484e-18+(l*0.9/1u+(2*nf-3)*0.18)*5.2921e-18+(nf-1)*l*0.9/1u*cf_factor*4.793e-18+(l*0.9/1u+(7/2*nf-6)*0.18)*3.18e-17+(l*0.9/1u+(2*nf-3)*0.18)*(2.7168e-17)))
+ p_c113=(1-shielding_flag)*bm3*(m4*((nf/2-1)*l*0.9/1u*3.5731e-18+(l*0.9/1u+(2*nf-3)*0.18)*3.6028e-18+(nf-1)*l*0.9/1u*cf_factor*4.2711e-18+(l*0.9/1u+(7/2*nf-6)*0.18)*2.7168e-17+(l*0.9/1u+(2*nf-3)*0.18-1.53)*(2.3833e-17+2.1255e-17)+(l*0.9/1u+(2*nf-3)*0.18)*1.9348e-17)+m3*((nf/2-1)*l*0.9/1u*3.5731e-18+(l*0.9/1u+(2*nf-3)*0.18)*3.6028e-18+(nf-1)*l*0.9/1u*cf_factor*4.2711e-18+(l*0.9/1u+(7/2*nf-6)*0.18)*2.7168e-17+(l*0.9/1u+(2*nf-3)*0.18-1.53)*(2.3833e-17+2.1255e-17))+m2*((nf/2-1)*l*0.9/1u*3.5731e-18+(l*0.9/1u+(2*nf-3)*0.18)*3.6028e-18+(nf-1)*l*0.9/1u*cf_factor*4.2711e-18+(l*0.9/1u+(7/2*nf-6)*0.18)*2.7168e-17+(l*0.9/1u+(2*nf-3)*0.18)*(2.3833e-17)))
+ p_c114=(1-shielding_flag)*(bm4*(m3*((nf/2-1)*l*0.9/1u*2.7096e-18+(l*0.9/1u+(2*nf-3)*0.18)*2.7322e-18+(nf-1)*l*0.9/1u*cf_factor*3.97e-18+(l*0.9/1u+(7/2*nf-6)*0.18)*2.3833e-17+(l*0.9/1u+(2*nf-3)*0.18-1.53)*(2.1255e-17+1.9348e-17))+m2*((nf/2-1)*l*0.9/1u*2.1656e-17+(l*0.9/1u+(2*nf-3)*0.18)*2.1836e-17+(nf-1)*l*0.9/1u*cf_factor_shield*9.8920e-18+(l*0.9/1u+(7/2*nf-6)*0.18)*4.9854e-17+(l*0.9/1u+(2*nf-3)*0.18)*(3.58116e-17)))+bm5*(m2*((nf/2-1)*l*0.9/1u*2.1831e-18+(l*0.9/1u+(2*nf-3)*0.18)*2.2013e-18+(nf-1)*l*0.9/1u*cf_factor*3.7547e-18+(l*0.9/1u+(7/2*nf-6)*0.18)*2.1255e-17+(l*0.9/1u+(2*nf-3)*0.18)*(1.9348e-17))))
+ p_c115=shielding_flag*bm2*(m5*((nf/2-1)*l*0.9/1u*2.1656e-17+(l*0.9/1u+(2*nf-3)*0.18)*2.1836e-17+(nf-1)*l*0.9/1u*cf_factor_shield*9.8817e-18+(l*0.9/1u+(7/2*nf-6)*0.18)*4.9959e-17+(l*0.9/1u+(2*nf-3)*0.18-1.53)*(3.5839e-17+2.9742e-17)+(l*0.9/1u+(2*nf-3)*0.18)*(2.5716e-17+2.2965e-17))+m4*((nf/2-1)*l*0.9/1u*2.1656e-17+(l*0.9/1u+(2*nf-3)*0.18)*2.1836e-17+(nf-1)*l*0.9/1u*cf_factor_shield*9.8817e-18+(l*0.9/1u+(7/2*nf-6)*0.18)*4.9959e-17+(l*0.9/1u+(2*nf-3)*0.18-1.53)*(3.5839e-17+2.9742e-17)+(l*0.9/1u+(2*nf-3)*0.18)*2.5716e-17)+m3*((nf/2-1)*l*0.9/1u*2.1656e-17+(l*0.9/1u+(2*nf-3)*0.18)*2.1836e-17+(nf-1)*l*0.9/1u*cf_factor_shield*9.8817e-18+(l*0.9/1u+(7/2*nf-6)*0.18)*4.9959e-17+(l*0.9/1u+(2*nf-3)*0.18-1.53)*(3.5839e-17+2.9742e-17))+m2*((nf/2-1)*l*0.9/1u*2.1656e-17+(l*0.9/1u+(2*nf-3)*0.18)*2.1836e-17+(nf-1)*l*0.9/1u*cf_factor_shield*9.8817e-18+(l*0.9/1u+(7/2*nf-6)*0.18)*4.9959e-17+(l*0.9/1u+(2*nf-3)*0.18)*(3.5839e-17)))
+ p_c116=shielding_flag*bm3*(m4*((nf/2-1)*l*0.9/1u*2.1656e-17+(l*0.9/1u+(2*nf-3)*0.18)*2.1836e-17+(nf-1)*l*0.9/1u*cf_factor_shield*9.8858e-18+(l*0.9/1u+(7/2*nf-6)*0.18)*4.9884e-17+(l*0.9/1u+(2*nf-3)*0.18-1.53)*(3.58e-17+2.9732e-17)+(l*0.9/1u+(2*nf-3)*0.18)*2.5998e-17)+m3*((nf/2-1)*l*0.9/1u*2.1656e-17+(l*0.9/1u+(2*nf-3)*0.18)*2.1836e-17+(nf-1)*l*0.9/1u*cf_factor_shield*9.8858e-18+(l*0.9/1u+(7/2*nf-6)*0.18)*4.9884e-17+(l*0.9/1u+(2*nf-3)*0.18-1.53)*(3.58e-17+2.9732e-17))+m2*((nf/2-1)*l*0.9/1u*2.1656e-17+(l*0.9/1u+(2*nf-3)*0.18)*2.1836e-17+(nf-1)*l*0.9/1u*cf_factor_shield*9.8858e-18+(l*0.9/1u+(7/2*nf-6)*0.18)*4.9884e-17+(l*0.9/1u+(2*nf-3)*0.18)*(3.58e-17)))
+ p_c117=shielding_flag*(bm4*(m3*((nf/2-1)*l*0.9/1u*2.1656e-17+(l*0.9/1u+(2*nf-3)*0.18)*2.1836e-17+(nf-1)*l*0.9/1u*cf_factor_shield*9.8920e-18+(l*0.9/1u+(7/2*nf-6)*0.18)*4.9854e-17+(l*0.9/1u+(2*nf-3)*0.18-1.53)*(3.58116e-17+3.0134e-17))+m2*((nf/2-1)*l*0.9/1u*2.1656e-17+(l*0.9/1u+(2*nf-3)*0.18)*2.1836e-17+(nf-1)*l*0.9/1u*cf_factor_shield*9.8920e-18+(l*0.9/1u+(7/2*nf-6)*0.18)*4.9854e-17+(l*0.9/1u+(2*nf-3)*0.18)*(3.58116e-17)))+bm5*(m2*((nf/2-1)*l*0.9/1u*2.1656e-17+(l*0.9/1u+(2*nf-3)*0.18)*2.1836e-17+(nf-1)*l*0.9/1u*cf_factor_shield*9.8920e-18+(l*0.9/1u+(7/2*nf-6)*0.18)*4.9854e-17+(l*0.9/1u+(2*nf-3)*0.18)*(3.645e-17))))
+ p_c118=metal_ring_flag*bm1*(m6*((l*0.9/1u-1.53+(2*nf-3)*0.18)*(3.2991e-17+2.6565e-17+2.6607e-17+2.66e-17+2.6597e-17+2.8838e-17)-(l*0.9/1u+(2*nf-3)*0.18-1.53)*cf_factor*(2.1807e-17+2.0815e-17+1.8482e-17+1.6383e-17+1.4593e-17+1.3321e-17))+m5*((l*0.9/1u-1.53+(2*nf-3)*0.18)*(3.2991e-17+2.6565e-17+2.6607e-17+2.66e-17+2.6597e-17)-(l*0.9/1u+(2*nf-3)*0.18-1.53)*cf_factor*(2.1807e-17+2.0815e-17+1.8482e-17+1.6383e-17+1.4593e-17))+m4*((l*0.9/1u-1.53+(2*nf-3)*0.18)*(3.2991e-17+2.6565e-17+2.6607e-17+2.66e-17)-(l*0.9/1u+(2*nf-3)*0.18-1.53)*cf_factor*(2.1807e-17+2.0815e-17+1.8482e-17+1.6383e-17))+m3*((l*0.9/1u-1.53+(2*nf-3)*0.18)*(3.2991e-17+2.6565e-17+2.6607e-17)-(l*0.9/1u+(2*nf-3)*0.18-1.53)*cf_factor*(2.1807e-17+2.0815e-17+1.8482e-17))+m2*((l*0.9/1u-1.53+(2*nf-3)*0.18)*(3.2991e-17+2.6565e-17)-(l*0.9/1u+(2*nf-3)*0.18)*cf_factor*(2.1807e-17+2.0815e-17)))
+ p_c119=metal_ring_flag*bm2*(m5*((l*0.9/1u-1.53+(2*nf-3)*0.18)*(2.6565e-17+2.6607e-17+2.66e-17+2.6597e-17+2.8838e-17)-(l*0.9/1u+(2*nf-3)*0.18-1.53)*cf_factor*(2.0815e-17+1.8482e-17+1.6383e-17+1.4593e-17+1.3321e-17))+m4*((l*0.9/1u-1.53+(2*nf-3)*0.18)*(2.6565e-17+2.6607e-17+2.66e-17+2.6597e-17)-(l*0.9/1u+(2*nf-3)*0.18-1.53)*cf_factor*(2.0815e-17+1.8482e-17+1.6383e-17+1.4593e-17))+m3*((l*0.9/1u-1.53+(2*nf-3)*0.18)*(2.6565e-17+2.6607e-17+2.66e-17)-(l*0.9/1u+(2*nf-3)*0.18-1.53)*cf_factor*(2.0815e-17+1.8482e-17+1.6383e-17))+m2*((l*0.9/1u-1.53+(2*nf-3)*0.18)*(2.6565e-17+2.6607e-17)-(l*0.9/1u+(2*nf-3)*0.18)*cf_factor*(2.0815e-17+1.8482e-17)))
+ p_c120=metal_ring_flag*(bm3*(m4*((l*0.9/1u-1.53+(2*nf-3)*0.18)*(2.6607e-17+2.66e-17+2.6597e-17+2.8838e-17)-(l*0.9/1u+(2*nf-3)*0.18-1.53)*cf_factor*(1.8482e-17+1.6383e-17+1.4593e-17+1.3321e-17))+m3*((l*0.9/1u-1.53+(2*nf-3)*0.18)*(2.6607e-17+2.66e-17+2.6597e-17)-(l*0.9/1u+(2*nf-3)*0.18-1.53)*cf_factor*(1.8482e-17+1.6383e-17+1.4593e-17))+m2*((l*0.9/1u-1.53+(2*nf-3)*0.18)*(2.6607e-17+2.66e-17)-(l*0.9/1u+(2*nf-3)*0.18)*cf_factor*(1.8482e-17+1.6383e-17)))+bm4*(m3*((l*0.9/1u-1.53+(2*nf-3)*0.18)*(2.66e-17+2.6597e-17+2.8838e-17)-(l*0.9/1u+(2*nf-3)*0.18-1.53)*cf_factor*(1.6383e-17+1.4593e-17+1.3321e-17))+m2*((l*0.9/1u-1.53+(2*nf-3)*0.18)*(2.66e-17+2.6597e-17)-(l*0.9/1u+(2*nf-3)*0.18)*cf_factor*(1.6383e-17+1.4593e-17)))+bm5*(m2*((l*0.9/1u-1.53+(2*nf-3)*0.18)*(2.6597e-17+2.8838e-17)-(l*0.9/1u+(2*nf-3)*0.18)*cf_factor*(1.4593e-17+1.3321e-17))))
+ p_c11=presim_flag*(p_c111+p_c1111+p_c112+p_c113+p_c114+p_c115+p_c116+p_c117+p_c118+p_c119+p_c120)+0.001f
//*
//*
//* ----- Equivalent network ------------------
//*
momcaps_stripe_mml110ae (port1 port2) main_c_vp1 c=p_c12*(1+d_c1_vp_mml110ae)
cox1 (port1 well) capacitor c=p_c11*(1+d_cox_vp_mml110ae)
cox2 (port2 well) capacitor c=p_c11*(1+d_cox_vp_mml110ae)
//*
//* Main Capacitor model
model main_c_vp1 capacitor c=1p tc1=-3.098e-5 tc2=-1.122e-9 tnom=25 coeffs=[2.874e-7 -1.089e-6]
//* -------------------------------------------
ends momcaps_stripe_mml110ae
//****************************************************************************************
//*            Mesh MOM Capacitor subcircuit Monte Carlo model (symmetric type)
//*            UMC L110E mixed_mode/rf process
//*               2010/08/02   by Eddie Chang / I Chen Hsu
//*
//*              Input Parameter and recommended range:
//*              1. Capacitance (c):   37.09fF ~ 9.58pF   (nm=6)
//*                                    30.86fF ~ 7.973pF  (nm=5)
//*                                    24.51fF ~ 6.334pF  (nm=4)
//*                                    17.98fF ~ 4.64pF   (nm=3)
//*              2. finger number (nf): 198>= nf >=14  (even number only)
//*              3. finger width (w): fixed at 0.2um (before shrinkage)
//*              4. finger space (s): fixed at 0.2um (before shrinkage)
//*              5. Number of metal layer (nm): 3 to 6
//*
//*              Finger Length Range:
//*              1. finger length (l): 78.4um>= l >=4.4um (before shrinkage)
//*
//*              MOM square case rule:
//*             Pitch=metal width + spacing between metal to metal=0.36um
//*              L is roughly equal to "NF*Pitch"
//*
//*              Node definition:
//*             1. port1
//*              2. port2
//*              3. port3
//*              4. port4
//*              5. well
//*
//*             Temperature range: -55 ¢J ~ +125 ¢J
//***************************************************************************************
inline subckt momcaps_symesh_mml110ae (port1 port2 port3 port4 well)
parameters mh=1 nf=20 nm=6 w=0.2u s=0.2u wb=0.2u mis_flag=1 bm=1 presim_flag=1 shielding_flag=0
+ cho_tb_bm1=324a
+ cv_tb_bm1=41a
+ ratio_bm1=1.2
//*
+ cho_tb_bm2=345a
+ cv_tb_bm2=10a
+ ratio_bm2=1.27
//*
+ m6=(nm==6)?1:0
+ m5=(nm==5)?1:0
+ m4=(nm==4)?1:0
+ m3=(nm==3)?1:0
//*
+ bm1=(bm==1)?1:0
+ bm2=(bm==2)?1:0
+ bm3=(bm==3)?1:0
+ bm4=(bm==4)?1:0
//*
+ c2=c/mh
+ factor=bm1*(2.058*m6+1.69*m5+1.35*m4+1*m3)+bm2*(1.67*m5+1.32*m4+1*m3)+bm3*(1.32*m4+1*m3)+bm4*(1*m3)
//* Calculate length (l)
+ l= bm1*(((c2/factor-(nf-2)*cv_tb_bm1) / ((nf-3)*cho_tb_bm1 + 2*ratio_bm1*cho_tb_bm1))*1u/0.9)+bm2*(((c2/factor-(nf-2)*cv_tb_bm2) / ((nf-3)*cho_tb_bm2 + 2*ratio_bm2*cho_tb_bm2))*1u/0.9)+bm3*(((c2/factor-(nf-2)*cv_tb_bm2) / ((nf-3)*cho_tb_bm2 + 2*ratio_bm2*cho_tb_bm2))*1u/0.9)+bm4*(((c2/factor-(nf-2)*cv_tb_bm2) / ((nf-3)*cho_tb_bm2 + 2*ratio_bm2*cho_tb_bm2))*1u/0.9)
//* Calculate capactance (c)
+ c= bm1*((((l*0.9)/1u*((nf-3)*cho_tb_bm1 + 2*ratio_bm1*cho_tb_bm1) + (nf-2) *cv_tb_bm1) * factor)*mh)+bm2*((((l*0.9)/1u*((nf-3)*cho_tb_bm2 + 2*ratio_bm2*cho_tb_bm2) + (nf-2) *cv_tb_bm2) * factor)*mh)+bm3*((((l*0.9)/1u*((nf-3)*cho_tb_bm2 + 2*ratio_bm2*cho_tb_bm2) + (nf-2) *cv_tb_bm2) * factor)*mh)+bm4*((((l*0.9)/1u*((nf-3)*cho_tb_bm2 + 2*ratio_bm2*cho_tb_bm2) + (nf-2) *cv_tb_bm2) * factor)*mh)
//*
+ l2=l*0.9/1u+0.54
+ w2=(nf-1)*0.36+0.18
+ ma=1/sqrt(l2*w2*mh)
+ ma_bm1=bm1*(m6*(0.5922*ma)+m5*(0.5922*ma)+m4*(0.5922*ma)+m3*(0.5922*ma))
+ ma_bm2=bm2*(m5*(0.5062*ma)+m4*(0.6363*ma)+m3*(0.7667*ma))
+ ma_bm3=bm3*(m4*(0.6363*ma)+m3*(0.7667*ma))
+ ma_bm4=bm4*(m3*(0.7667*ma))
+ ma_momcaps_sy_mml110ae=ma_bm1+ma_bm2+ma_bm3+ma_bm4
+ d_ma_symom=ma_momcaps_sy_mml110ae/sqrt(2)/1e2
+ dd_ma_symom1=d_ma_symom * ma_symesh_mom1 * mis_flag
+ dd_ma_symom3=d_ma_symom * ma_symesh_mom3 * mis_flag
+ p_c12=c2*(1+dd_ma_symom1)
+ p_c34=c2*(1+dd_ma_symom3)
//*
//* Calculate area
+ area=l2*w2
//* Calculate Cox
+ cf_factor=0.45
+ cf_factor_shield=0.65
+ p_c111=(1-shielding_flag)*bm1*(m6*((nf/2-1)*l*0.9/1u*7.9214e-18+(l*0.9/1u+(2*nf-3)*0.18)*8.039e-18+(nf-1)*l*0.9/1u*cf_factor*6.2854e-18+(l*0.9/1u+(7/2*nf-6)*0.18)*3.8788e-17+(l*0.9/1u+(2*nf-3)*0.18-1.53)*(3.18e-17+2.7168e-17)+(l*0.9/1u+(2*nf-3)*0.18)*(2.3833e-17+2.1255e-17+1.9348e-17))+m5*((nf/2-1)*l*0.9/1u*7.9214e-18+(l*0.9/1u+(2*nf-3)*0.18)*8.039e-18+(nf-1)*l*0.9/1u*cf_factor*6.2854e-18+(l*0.9/1u+(7/2*nf-6)*0.18)*3.8788e-17+(l*0.9/1u+(2*nf-3)*0.18-1.53)*(3.18e-17+2.7168e-17)+(l*0.9/1u+(2*nf-3)*0.18)*(2.3833e-17+2.1255e-17))+m4*((nf/2-1)*l*0.9/1u*7.9214e-18+(l*0.9/1u+(2*nf-3)*0.18)*8.039e-18+(nf-1)*l*0.9/1u*cf_factor*6.2854e-18+(l*0.9/1u+(7/2*nf-6)*0.18)*3.8788e-17+(l*0.9/1u+(2*nf-3)*0.18-1.53)*(3.18e-17+2.7168e-17)+(l*0.9/1u+(2*nf-3)*0.18)*2.3833e-17)+m3*((nf/2-1)*l*0.9/1u*7.9214e-18+(l*0.9/1u+(2*nf-3)*0.18)*8.039e-18+(nf-1)*l*0.9/1u*cf_factor*6.2854e-18+(l*0.9/1u+(7/2*nf-6)*0.18)*3.8788e-17+(l*0.9/1u+(2*nf-3)*0.18-1.53)*(3.18e-17+2.7168e-17)))
+ p_c112=(1-shielding_flag)*bm2*(m5*((nf/2-1)*l*0.9/1u*5.2484e-18+(l*0.9/1u+(2*nf-3)*0.18)*5.2921e-18+(nf-1)*l*0.9/1u*cf_factor*4.793e-18+(l*0.9/1u+(7/2*nf-6)*0.18)*3.18e-17+(l*0.9/1u+(2*nf-3)*0.18-1.53)*(2.7168e-17+2.3833e-17)+(l*0.9/1u+(2*nf-3)*0.18)*(2.1255e-17+1.9348e-17))+m4*((nf/2-1)*l*0.9/1u*5.2484e-18+(l*0.9/1u+(2*nf-3)*0.18)*5.2921e-18+(nf-1)*l*0.9/1u*cf_factor*4.793e-18+(l*0.9/1u+(7/2*nf-6)*0.18)*3.18e-17+(l*0.9/1u+(2*nf-3)*0.18-1.53)*(2.7168e-17+2.3833e-17)+(l*0.9/1u+(2*nf-3)*0.18)*2.1255e-17)+m3*((nf/2-1)*l*0.9/1u*5.2484e-18+(l*0.9/1u+(2*nf-3)*0.18)*5.2921e-18+(nf-1)*l*0.9/1u*cf_factor*4.793e-18+(l*0.9/1u+(7/2*nf-6)*0.18)*3.18e-17+(l*0.9/1u+(2*nf-3)*0.18-1.53)*(2.7168e-17+2.3833e-17)))
+ p_c113=(1-shielding_flag)*bm3*(m4*((nf/2-1)*l*0.9/1u*3.5731e-18+(l*0.9/1u+(2*nf-3)*0.18)*3.6028e-18+(nf-1)*l*0.9/1u*cf_factor*4.2711e-18+(l*0.9/1u+(7/2*nf-6)*0.18)*2.7168e-17+(l*0.9/1u+(2*nf-3)*0.18-1.53)*(2.3833e-17+2.1255e-17)+(l*0.9/1u+(2*nf-3)*0.18)*1.9348e-17)+m3*((nf/2-1)*l*0.9/1u*3.5731e-18+(l*0.9/1u+(2*nf-3)*0.18)*3.6028e-18+(nf-1)*l*0.9/1u*cf_factor*4.2711e-18+(l*0.9/1u+(7/2*nf-6)*0.18)*2.7168e-17+(l*0.9/1u+(2*nf-3)*0.18-1.53)*(2.3833e-17+2.1255e-17)))
+ p_c114=(1-shielding_flag)*bm4*(m3*((nf/2-1)*l*0.9/1u*2.7096e-18+(l*0.9/1u+(2*nf-3)*0.18)*2.7322e-18+(nf-1)*l*0.9/1u*cf_factor*3.97e-18+(l*0.9/1u+(7/2*nf-6)*0.18)*2.3833e-17+(l*0.9/1u+(2*nf-3)*0.18-1.53)*(2.1255e-17+1.9348e-17)))
+ p_c115=shielding_flag*bm2*(m5*((nf/2-1)*l*0.9/1u*2.1656e-17+(l*0.9/1u+(2*nf-3)*0.18)*2.1836e-17+(nf-1)*l*0.9/1u*cf_factor_shield*9.8817e-18+(l*0.9/1u+(7/2*nf-6)*0.18)*4.9959e-17+(l*0.9/1u+(2*nf-3)*0.18-1.53)*(3.5839e-17+2.9742e-17)+(l*0.9/1u+(2*nf-3)*0.18)*(2.5716e-17+2.2965e-17))+m4*((nf/2-1)*l*0.9/1u*2.1656e-17+(l*0.9/1u+(2*nf-3)*0.18)*2.1836e-17+(nf-1)*l*0.9/1u*cf_factor_shield*9.8817e-18+(l*0.9/1u+(7/2*nf-6)*0.18)*4.9959e-17+(l*0.9/1u+(2*nf-3)*0.18-1.53)*(3.5839e-17+2.9742e-17)+(l*0.9/1u+(2*nf-3)*0.18)*2.5716e-17)+m3*((nf/2-1)*l*0.9/1u*2.1656e-17+(l*0.9/1u+(2*nf-3)*0.18)*2.1836e-17+(nf-1)*l*0.9/1u*cf_factor_shield*9.8817e-18+(l*0.9/1u+(7/2*nf-6)*0.18)*4.9959e-17+(l*0.9/1u+(2*nf-3)*0.18-1.53)*(3.5839e-17+2.9742e-17)))
+ p_c116=shielding_flag*bm3*(m4*((nf/2-1)*l*0.9/1u*2.1656e-17+(l*0.9/1u+(2*nf-3)*0.18)*2.1836e-17+(nf-1)*l*0.9/1u*cf_factor_shield*9.8858e-18+(l*0.9/1u+(7/2*nf-6)*0.18)*4.9884e-17+(l*0.9/1u+(2*nf-3)*0.18-1.53)*(3.58e-17+2.9732e-17)+(l*0.9/1u+(2*nf-3)*0.18)*2.5998e-17)+m3*((nf/2-1)*l*0.9/1u*2.1656e-17+(l*0.9/1u+(2*nf-3)*0.18)*2.1836e-17+(nf-1)*l*0.9/1u*cf_factor_shield*9.8858e-18+(l*0.9/1u+(7/2*nf-6)*0.18)*4.9884e-17+(l*0.9/1u+(2*nf-3)*0.18-1.53)*(3.58e-17+2.9732e-17)))
+ p_c117=shielding_flag*bm4*m3*((nf/2-1)*l*0.9/1u*2.1656e-17+(l*0.9/1u+(2*nf-3)*0.18)*2.1836e-17+(nf-1)*l*0.9/1u*cf_factor_shield*9.8920e-18+(l*0.9/1u+(7/2*nf-6)*0.18)*4.9854e-17+(l*0.9/1u+(2*nf-3)*0.18-1.53)*(3.58116e-17+3.0134e-17))
+ p_c118=1*bm1*(m6*((l*0.9/1u-1.53+(2*nf-3)*0.18)*(3.2991e-17+2.6565e-17+2.6607e-17+2.66e-17+2.6597e-17+2.8838e-17)-(l*0.9/1u+(2*nf-3)*0.18-1.53)*cf_factor*(2.1807e-17+2.0815e-17+1.8482e-17+1.6383e-17+1.4593e-17+1.3321e-17))+m5*((l*0.9/1u-1.53+(2*nf-3)*0.18)*(3.2991e-17+2.6565e-17+2.6607e-17+2.66e-17+2.6597e-17)-(l*0.9/1u+(2*nf-3)*0.18-1.53)*cf_factor*(2.1807e-17+2.0815e-17+1.8482e-17+1.6383e-17+1.4593e-17))+m4*((l*0.9/1u-1.53+(2*nf-3)*0.18)*(3.2991e-17+2.6565e-17+2.6607e-17+2.66e-17)-(l*0.9/1u+(2*nf-3)*0.18-1.53)*cf_factor*(2.1807e-17+2.0815e-17+1.8482e-17+1.6383e-17))+m3*((l*0.9/1u-1.53+(2*nf-3)*0.18)*(3.2991e-17+2.6565e-17+2.6607e-17)-(l*0.9/1u+(2*nf-3)*0.18-1.53)*cf_factor*(2.1807e-17+2.0815e-17+1.8482e-17)))
+ p_c119=1*bm2*(m5*((l*0.9/1u-1.53+(2*nf-3)*0.18)*(2.6565e-17+2.6607e-17+2.66e-17+2.6597e-17+2.8838e-17)-(l*0.9/1u+(2*nf-3)*0.18-1.53)*cf_factor*(2.0815e-17+1.8482e-17+1.6383e-17+1.4593e-17+1.3321e-17))+m4*((l*0.9/1u-1.53+(2*nf-3)*0.18)*(2.6565e-17+2.6607e-17+2.66e-17+2.6597e-17)-(l*0.9/1u+(2*nf-3)*0.18-1.53)*cf_factor*(2.0815e-17+1.8482e-17+1.6383e-17+1.4593e-17))+m3*((l*0.9/1u-1.53+(2*nf-3)*0.18)*(2.6565e-17+2.6607e-17+2.66e-17)-(l*0.9/1u+(2*nf-3)*0.18-1.53)*cf_factor*(2.0815e-17+1.8482e-17+1.6383e-17)))
+ p_c120=1*(bm3*(m4*((l*0.9/1u-1.53+(2*nf-3)*0.18)*(2.6607e-17+2.66e-17+2.6597e-17+2.8838e-17)-(l*0.9/1u+(2*nf-3)*0.18-1.53)*cf_factor*(1.8482e-17+1.6383e-17+1.4593e-17+1.3321e-17))+m3*((l*0.9/1u-1.53+(2*nf-3)*0.18)*(2.6607e-17+2.66e-17+2.6597e-17)-(l*0.9/1u+(2*nf-3)*0.18-1.53)*cf_factor*(1.8482e-17+1.6383e-17+1.4593e-17)))+bm4*(m3*((l*0.9/1u-1.53+(2*nf-3)*0.18)*(2.66e-17+2.6597e-17+2.8838e-17)-(l*0.9/1u+(2*nf-3)*0.18-1.53)*cf_factor*(1.6383e-17+1.4593e-17+1.3321e-17))))
+ p_c11=presim_flag*(p_c111+p_c112+p_c113+p_c114+p_c115+p_c116+p_c117+p_c118+p_c119+p_c120)+0.001f
//*
//*
//* ----- Equivalent network ------------------
//*
momcaps_symesh_mml110ae (port1 port2) main_c_vp1 c=p_c12*(1+d_c1_vp_mml110ae) m=mh
cox1 (port1 well) capacitor c=p_c11*(1+d_cox_vp_mml110ae) m=mh
cox2 (port2 well) capacitor c=p_c11*(1+d_cox_vp_mml110ae) m=mh
//*
cmain2 (port3 port4) main_c_vp1 c=p_c34*(1+d_c1_vp_mml110ae) m=mh
cox3 (port3 well) capacitor c=p_c11*(1+d_cox_vp_mml110ae) m=mh
cox4 (port4 well) capacitor c=p_c11*(1+d_cox_vp_mml110ae) m=mh
//*
//* Main Capacitor model
model main_c_vp1 capacitor c=1p tc1=-3.098e-5 tc2=-1.122e-9 tnom=25 coeffs=[2.874e-7 -1.089e-6]
//* -------------------------------------------
ends momcaps_symesh_mml110ae
//*
//****************************************************************************************
//*            Mesh MOM Capacitor subcircuit Monte Carlo model (asymmetric type)
//*            UMC L110E mixed_mode/rf process
//*            2010/08/02   by Eddie Chang / I Chen HSu
//*
//*            Input Parameter and recommended range:
//*            1. Capacitance (c):   37.79fF ~ 8.463pF  (nm=6)
//*                                  30.69fF ~ 6.872pF  (nm=5)
//*                                  23.58fF ~ 5.28pF   (nm=4)
//*            2. finger number (nf): 199>= nf >=15  (odd number only)
//*            3. finger width (w): fixed at 0.2um (before shrinkage)
//*            4. finger space (s): fixed at 0.2um (before shrinkage)
//*            5. Number of metal layer (nm): 4 to 6
//*
//*            Finger Length Range:
//*            1. finger length (l): 78.4um>= l >=4.4um (before shrinkage)
//*
//*            Node definition:
//*            1. top1
//*            2. bottom1
//*            3. top2
//*            4. bottom2
//*            5. well
//*
//*             Temperature range: -55 ¢J ~ +125 ¢J
//****************************************************************************************
inline subckt momcaps_asmesh_mml110ae (top1 bottom1 top2 bottom2 well)
parameters mh=1 nf=21 nm=6 w=0.2u s=0.2u wb=0.2u mis_flag=1 bm=1 presim_flag=1
+ cho_tb=582a
+ cv_tb=300a
+ ratio=1.19
//*
+ m6=(nm==6)?1:0
+ m5=(nm==5)?1:0
+ m4=(nm==4)?1:0
//*
+ bm1=(bm==1)?1:0
+ bm2=(bm==2)?1:0
+ bm3=(bm==3)?1:0
//*
+ c2=c/mh
+ factor=bm1*(1*m6+0.8*m5+0.598*m4)+bm2*(0.8*m5+0.598*m4)+bm3*(0.598*m4)
//*
//* Calculate length (l)
+ l= bm1*(((c2/factor-(nf-2)*cv_tb) / ((nf-3)*cho_tb + 2*ratio*cho_tb))*1u/0.9)+bm2*(((c2/factor-(nf-2)*cv_tb) / ((nf-3)*cho_tb + 2*ratio*cho_tb))*1u/0.9)+bm3*(((c2/factor-(nf-2)*cv_tb) / ((nf-3)*cho_tb + 2*ratio*cho_tb))*1u/0.9)
//* Calculate capactance (c)
+ c= bm1*((((l*0.9)/1u*((nf-3)*cho_tb + 2*ratio*cho_tb) + (nf-2) *cv_tb) * factor)*mh)+bm2*((((l*0.9)/1u*((nf-3)*cho_tb + 2*ratio*cho_tb) + (nf-2) *cv_tb) * factor)*mh)+bm3*((((l*0.9)/1u*((nf-3)*cho_tb + 2*ratio*cho_tb) + (nf-2) *cv_tb) * factor)*mh)
//*
+ l2=l*0.9/1u+0.9
+ w2=(nf-1)*0.36+0.18
+ ma=1/sqrt(l2*w2*mh)
+ ma_momcaps_as_mml110ae=m6*(0.3262*ma)+m5*(0.373*ma)+m4*(0.5282*ma)
+ d_ma_asmom=ma_momcaps_as_mml110ae/sqrt(2)/1e2
+ dd_ma_asmom1=d_ma_asmom * ma_asmesh_mom1 * mis_flag
+ dd_ma_asmom3=d_ma_asmom * ma_asmesh_mom3 * mis_flag
+ p_c12=c2*(1+dd_ma_asmom1)
+ p_c34=c2*(1+dd_ma_asmom3)
//*
//* Calculate area
+ area=l2*w2
//* Calculate Cox
+ wt=w/1u*0.9*(3*int(nf/2)+int(nf/2)+1) lt=l/1u*0.9+5*w/1u*0.9
+ ar=wt*lt pr=2*(wt+lt) dpr=5.8*0.9
+ b1ca=7.9214e-18 b2ca=5.2484e-18 b3ca=3.5731e-18
+ cf1_m1=3.8788e-17 cf1_m2=3.18e-17 cf1_m3=2.7168e-17 cf1_m4=2.3833e-17 cf1_m5=2.1255e-17 cf1_m6=1.9348e-17
+ cc_m1=3.2991e-17  cc_m2=3.6901e-17  cc_m3=3.8275e-17  cc_m4=3.8905e-17  cc_m5=3.9290e-17  cc_m6=4.1772e-17
+ cf1_mr1=1.6981e-17   cf1_mr2=1.0985e-17  cf1_mr3=8.6858e-18  cf1_mr4=7.4503e-18  cf1_mr5=6.662e-18  cf1_mr6=6.0268e-18
+ mr=1
+ b1m4_ox=b1ca*ar+(cf1_m1*(1-mr)+(cf1_mr1+cc_m1)*mr)*pr+((cf1_m2+cf1_m3+cf1_m4)*(1-mr)+(cf1_mr2+cf1_mr3+cf1_mr4+cc_m2+cc_m3+cc_m4)*mr)*(pr-dpr)
+ b1m5_ox=b1m4_ox+(cf1_m5*(1-mr)+(cf1_mr5+cc_m5)*mr)*(pr-dpr)
+ b1m6_ox=b1m5_ox+(cf1_m6*(1-mr)+(cf1_mr6+cc_m6)*mr)*(pr-dpr)
+ b2m4_ox=b2ca*ar+(cf1_m2*(1-mr)+(cf1_mr2+cc_m2)*mr)*pr+((cf1_m3+cf1_m4+cf1_m5)*(1-mr)+(cf1_mr3+cf1_mr4+cf1_mr5+cc_m3+cc_m4+cc_m5)*mr)*(pr-dpr)
+ b2m5_ox=b2m4_ox+(cf1_m6*(1-mr)+(cf1_mr6+cc_m6)*mr)*(pr-dpr)
+ b3m4_ox=b3ca*ar+(cf1_m3*(1-mr)+(cf1_mr3+cc_m3)*mr)*pr+((cf1_m4+cf1_m5+cf1_m6)*(1-mr)+(cf1_mr4+cf1_mr5+cf1_mr6+cc_m4+cc_m5+cc_m6)*mr)*(pr-dpr)
+ p_cox1=bm1*(m4*b1m4_ox+m5*b1m5_ox+m6*b1m6_ox)+bm2*(m4*b2m4_ox+m5*b2m5_ox)+bm3*(m4*b3m4_ox)
+ p_cox=presim_flag*p_cox1+0.001f
//*
//*
//* ----- Equivalent network ------------------
//*
momcaps_asmesh_mml110ae (top1 bottom1) main_c_vp2 c=p_c12 *(1+d_c1_vp_mml110ae) m=mh
cox1 (bottom1 well) capacitor c=p_cox*(1+d_cox_vp_mml110ae) m=mh
//*
cmain2 (top2 bottom2) main_c_vp2 c=p_c34 *(1+d_c1_vp_mml110ae) m=mh
cox2 (bottom2 well) capacitor c=p_cox*(1+d_cox_vp_mml110ae) m=mh
//*
//* Main Capacitor model
model main_c_vp2 capacitor c=1p tc1=-3.098e-5 tc2=-1.122e-9 tnom=25 coeffs=[2.874e-7 -1.089e-6]
ends momcaps_asmesh_mml110ae
//****************************************************************************************
//*            Stripe Mesh MOM Capacitor subcircuit Monte Carlo model (symmetric type)
//*            UMC L110E mixed_mode/rf process
//*               2010/08/02   by Eddie Chang / I Chen Hsu
//*
//*              Input Parameter and recommended range:
//*              1. Capacitance (c):   37.09fF ~ 9.58pF   (nm=6)
//*                                    30.86fF ~ 7.973pF  (nm=5)
//*                                    24.51fF ~ 6.334pF  (nm=4)
//*                                    17.98fF ~ 4.64pF   (nm=3)
//*                                    17.98fF ~ 4.64pF   (nm=2)
//*              2. finger number (nf): 198>= nf >=14  (even number only)
//*              3. finger width (w): fixed at 0.2um (before shrinkage)
//*              4. finger space (s): fixed at 0.2um (before shrinkage)
//*              5. Number of metal layer (nm): 2 to 6
//*
//*              Finger Length Range:
//*              1. finger length (l): 78.4um>= l >=4.4um (before shrinkage)
//*
//*              MOM square case rule:
//*             Pitch=metal width + spacing between metal to metal=0.36um
//*              L is roughly equal to "NF*Pitch"
//*
//*              Node definition:
//*             1. port1
//*              2. port2
//*              3. port3
//*              4. port4
//*              5. well
//*
//*             Temperature range: -55 ¢J ~ +125 ¢J
//***************************************************************************************
inline subckt momcaps_stripemesh_mml110ae (port1 port2 port3 port4 well)
parameters mh=1 nf=20 nm=6 w=0.2u s=0.2u wb=0.2u mis_flag=1 bm=1 presim_flag=1 shielding_flag=0
+ cho_tb_bm1=663a
+ cv_tb_bm1=20a
+ ratio_bm1=1.44
//*
+ cho_tb_bm2=224a
+ cv_tb_bm2=20a
+ ratio_bm2=1.3
//*
+ m6=(nm==6)?1:0
+ m5=(nm==5)?1:0
+ m4=(nm==4)?1:0
+ m3=(nm==3)?1:0
+ m2=(nm==2)?1:0
//*
+ bm1=(bm==1)?1:0
+ bm2=(bm==2)?1:0
+ bm3=(bm==3)?1:0
+ bm4=(bm==4)?1:0
+ bm5=(bm==5)?1:0
//*
+ c2=c/mh
+ factor=bm1*(1*m6+0.8262*m5+0.651*m4+0.4812*m3+0.310*m2)+bm2*(2.5*m5+2.01*m4+1.5028*m3+1*m2)+bm3*(2.01*m4+1.5028*m3+1*m2)+bm4*(1.5028*m3+1*m2)+bm5*(1*m2)
//*
//* calculate length (l)
+ l= bm1*((((c2)/factor-(nf-2)*cv_tb_bm1) / ((nf-3)*cho_tb_bm1 + 2*ratio_bm1*cho_tb_bm1))*1u/0.9)+bm2*((((c2)/factor-(nf-2)*cv_tb_bm2) / ((nf-3)*cho_tb_bm2 + 2*ratio_bm2*cho_tb_bm2))*1u/0.9)+bm3*((((c2)/factor-(nf-2)*cv_tb_bm2) / ((nf-3)*cho_tb_bm2 + 2*ratio_bm2*cho_tb_bm2))*1u/0.9)+bm4*((((c2)/factor-(nf-2)*cv_tb_bm2) / ((nf-3)*cho_tb_bm2 + 2*ratio_bm2*cho_tb_bm2))*1u/0.9)+bm5*((((c)/factor-(nf-2)*cv_tb_bm2) / ((nf-3)*cho_tb_bm2 + 2*ratio_bm2*cho_tb_bm2))*1u/0.9)
//* calculate capactance (c)
+ c= bm1*(((((l*0.9)/1u*((nf-3)*cho_tb_bm1 + 2*ratio_bm1*cho_tb_bm1)+(nf-2)*cv_tb_bm1)*factor))*mh)+bm2*(((((l*0.9)/1u*((nf-3)*cho_tb_bm2+2*ratio_bm2*cho_tb_bm2)+(nf-2)*cv_tb_bm2)*factor))*mh)+bm3*(((((l*0.9)/1u*((nf-3)*cho_tb_bm2+2*ratio_bm2*cho_tb_bm2)+(nf-2)*cv_tb_bm2)*factor))*mh)+bm4*(((((l*0.9)/1u*((nf-3)*cho_tb_bm2 + 2*ratio_bm2*cho_tb_bm2)+(nf-2)*cv_tb_bm2)*factor))*mh)+bm5*(((((l*0.9)/1u*((nf-3)*cho_tb_bm2+2*ratio_bm2*cho_tb_bm2)+(nf-2)*cv_tb_bm2)*factor))*mh)
//*
+ l2=l*0.9/1u+0.54
+ w2=(nf-1)*0.36+0.18
+ ma=1/sqrt(l2*w2*mh)
+ ma_bm1=bm1*(m6*(0.72993*ma)+m5*(0.9669*ma)+m4*(1.2036*ma)+m3*(1.4403*ma)+m2*(1.6769*ma))
+ ma_bm2=bm2*(m5*(0.8505ma)+m4*(0.9496*ma)+m3*(1.3088*ma)+m2*(1.6026*ma))
+ ma_bm3=bm3*(m4*(0.9496*ma)+m3*(1.3088*ma)+m2*(1.6026*ma))
+ ma_bm4=bm4*(m3*(1.3088*ma)+m2*(1.6026*ma))
+ ma_bm5=bm5*(m2*(1.6026*ma))
+ ma_momcaps_stripemesh_mml110ae=ma_bm1+ma_bm2+ma_bm3+ma_bm4+ma_bm5
+ d_ma_symom=ma_momcaps_stripemesh_mml110ae/sqrt(2)/1e2
+ dd_ma_symom1=d_ma_symom * ma_symesh_mom1 * mis_flag
+ dd_ma_symom3=d_ma_symom * ma_symesh_mom3 * mis_flag
+ p_c12=c2*(1+dd_ma_symom1)
+ p_c34=c2*(1+dd_ma_symom3)
//*
//* Calculate area
+ area=l2*w2
//* Calculate Cox
+ cf_factor=0.45
+ cf_factor_shield=0.65
+ p_c111=(1-shielding_flag)*bm1*(m6*((nf/2-1)*l*0.9/1u*7.9214e-18+(l*0.9/1u+(2*nf-3)*0.18)*8.039e-18+(nf-1)*l*0.9/1u*cf_factor*6.2854e-18+(l*0.9/1u+(7/2*nf-6)*0.18)*3.8788e-17+(l*0.9/1u+(2*nf-3)*0.18-1.53)*(3.18e-17+2.7168e-17)+(l*0.9/1u+(2*nf-3)*0.18)*(2.3833e-17+2.1255e-17+1.9348e-17))+m5*((nf/2-1)*l*0.9/1u*7.9214e-18+(l*0.9/1u+(2*nf-3)*0.18)*8.039e-18+(nf-1)*l*0.9/1u*cf_factor*6.2854e-18+(l*0.9/1u+(7/2*nf-6)*0.18)*3.8788e-17+(l*0.9/1u+(2*nf-3)*0.18-1.53)*(3.18e-17+2.7168e-17)+(l*0.9/1u+(2*nf-3)*0.18)*(2.3833e-17+2.1255e-17))+m4*((nf/2-1)*l*0.9/1u*7.9214e-18+(l*0.9/1u+(2*nf-3)*0.18)*8.039e-18+(nf-1)*l*0.9/1u*cf_factor*6.2854e-18+(l*0.9/1u+(7/2*nf-6)*0.18)*3.8788e-17+(l*0.9/1u+(2*nf-3)*0.18-1.53)*(3.18e-17+2.7168e-17)+(l*0.9/1u+(2*nf-3)*0.18)*2.3833e-17)+m3*((nf/2-1)*l*0.9/1u*7.9214e-18+(l*0.9/1u+(2*nf-3)*0.18)*8.039e-18+(nf-1)*l*0.9/1u*cf_factor*6.2854e-18+(l*0.9/1u+(7/2*nf-6)*0.18)*3.8788e-17+(l*0.9/1u+(2*nf-3)*0.18-1.53)*(3.18e-17+2.7168e-17)))
+ p_c1111=(1-shielding_flag)*bm1*(m2*((nf/2-1)*l*0.9/1u*7.9214e-18+(l*0.9/1u+(2*nf-3)*0.18)*8.039e-18+(nf-1)*l*0.9/1u*cf_factor*6.2854e-18+(l*0.9/1u+(7/2*nf-6)*0.18)*3.8788e-17+(l*0.9/1u+(2*nf-3)*0.18)*(3.18e-17)))
+ p_c112=(1-shielding_flag)*bm2*(m5*((nf/2-1)*l*0.9/1u*5.2484e-18+(l*0.9/1u+(2*nf-3)*0.18)*5.2921e-18+(nf-1)*l*0.9/1u*cf_factor*4.793e-18+(l*0.9/1u+(7/2*nf-6)*0.18)*3.18e-17+(l*0.9/1u+(2*nf-3)*0.18-1.53)*(2.7168e-17+2.3833e-17)+(l*0.9/1u+(2*nf-3)*0.18)*(2.1255e-17+1.9348e-17))+m4*((nf/2-1)*l*0.9/1u*5.2484e-18+(l*0.9/1u+(2*nf-3)*0.18)*5.2921e-18+(nf-1)*l*0.9/1u*cf_factor*4.793e-18+(l*0.9/1u+(7/2*nf-6)*0.18)*3.18e-17+(l*0.9/1u+(2*nf-3)*0.18-1.53)*(2.7168e-17+2.3833e-17)+(l*0.9/1u+(2*nf-3)*0.18)*2.1255e-17)+m3*((nf/2-1)*l*0.9/1u*5.2484e-18+(l*0.9/1u+(2*nf-3)*0.18)*5.2921e-18+(nf-1)*l*0.9/1u*cf_factor*4.793e-18+(l*0.9/1u+(7/2*nf-6)*0.18)*3.18e-17+(l*0.9/1u+(2*nf-3)*0.18-1.53)*(2.7168e-17+2.3833e-17))+m2*((nf/2-1)*l*0.9/1u*5.2484e-18+(l*0.9/1u+(2*nf-3)*0.18)*5.2921e-18+(nf-1)*l*0.9/1u*cf_factor*4.793e-18+(l*0.9/1u+(7/2*nf-6)*0.18)*3.18e-17+(l*0.9/1u+(2*nf-3)*0.18)*(2.7168e-17)))
+ p_c113=(1-shielding_flag)*bm3*(m4*((nf/2-1)*l*0.9/1u*3.5731e-18+(l*0.9/1u+(2*nf-3)*0.18)*3.6028e-18+(nf-1)*l*0.9/1u*cf_factor*4.2711e-18+(l*0.9/1u+(7/2*nf-6)*0.18)*2.7168e-17+(l*0.9/1u+(2*nf-3)*0.18-1.53)*(2.3833e-17+2.1255e-17)+(l*0.9/1u+(2*nf-3)*0.18)*1.9348e-17)+m3*((nf/2-1)*l*0.9/1u*3.5731e-18+(l*0.9/1u+(2*nf-3)*0.18)*3.6028e-18+(nf-1)*l*0.9/1u*cf_factor*4.2711e-18+(l*0.9/1u+(7/2*nf-6)*0.18)*2.7168e-17+(l*0.9/1u+(2*nf-3)*0.18-1.53)*(2.3833e-17+2.1255e-17))+m2*((nf/2-1)*l*0.9/1u*3.5731e-18+(l*0.9/1u+(2*nf-3)*0.18)*3.6028e-18+(nf-1)*l*0.9/1u*cf_factor*4.2711e-18+(l*0.9/1u+(7/2*nf-6)*0.18)*2.7168e-17+(l*0.9/1u+(2*nf-3)*0.18)*(2.3833e-17)))
+ p_c114=(1-shielding_flag)*(bm4*(m3*((nf/2-1)*l*0.9/1u*2.7096e-18+(l*0.9/1u+(2*nf-3)*0.18)*2.7322e-18+(nf-1)*l*0.9/1u*cf_factor*3.97e-18+(l*0.9/1u+(7/2*nf-6)*0.18)*2.3833e-17+(l*0.9/1u+(2*nf-3)*0.18-1.53)*(2.1255e-17+1.9348e-17))+m2*((nf/2-1)*l*0.9/1u*2.1656e-17+(l*0.9/1u+(2*nf-3)*0.18)*2.1836e-17+(nf-1)*l*0.9/1u*cf_factor_shield*9.8920e-18+(l*0.9/1u+(7/2*nf-6)*0.18)*4.9854e-17+(l*0.9/1u+(2*nf-3)*0.18)*(3.58116e-17)))+bm5*(m2*((nf/2-1)*l*0.9/1u*2.1831e-18+(l*0.9/1u+(2*nf-3)*0.18)*2.2013e-18+(nf-1)*l*0.9/1u*cf_factor*3.7547e-18+(l*0.9/1u+(7/2*nf-6)*0.18)*2.1255e-17+(l*0.9/1u+(2*nf-3)*0.18)*(1.9348e-17))))
+ p_c115=shielding_flag*bm2*(m5*((nf/2-1)*l*0.9/1u*2.1656e-17+(l*0.9/1u+(2*nf-3)*0.18)*2.1836e-17+(nf-1)*l*0.9/1u*cf_factor_shield*9.8817e-18+(l*0.9/1u+(7/2*nf-6)*0.18)*4.9959e-17+(l*0.9/1u+(2*nf-3)*0.18-1.53)*(3.5839e-17+2.9742e-17)+(l*0.9/1u+(2*nf-3)*0.18)*(2.5716e-17+2.2965e-17))+m4*((nf/2-1)*l*0.9/1u*2.1656e-17+(l*0.9/1u+(2*nf-3)*0.18)*2.1836e-17+(nf-1)*l*0.9/1u*cf_factor_shield*9.8817e-18+(l*0.9/1u+(7/2*nf-6)*0.18)*4.9959e-17+(l*0.9/1u+(2*nf-3)*0.18-1.53)*(3.5839e-17+2.9742e-17)+(l*0.9/1u+(2*nf-3)*0.18)*2.5716e-17)+m3*((nf/2-1)*l*0.9/1u*2.1656e-17+(l*0.9/1u+(2*nf-3)*0.18)*2.1836e-17+(nf-1)*l*0.9/1u*cf_factor_shield*9.8817e-18+(l*0.9/1u+(7/2*nf-6)*0.18)*4.9959e-17+(l*0.9/1u+(2*nf-3)*0.18-1.53)*(3.5839e-17+2.9742e-17))+m2*((nf/2-1)*l*0.9/1u*2.1656e-17+(l*0.9/1u+(2*nf-3)*0.18)*2.1836e-17+(nf-1)*l*0.9/1u*cf_factor_shield*9.8817e-18+(l*0.9/1u+(7/2*nf-6)*0.18)*4.9959e-17+(l*0.9/1u+(2*nf-3)*0.18)*(3.5839e-17)))
+ p_c116=shielding_flag*bm3*(m4*((nf/2-1)*l*0.9/1u*2.1656e-17+(l*0.9/1u+(2*nf-3)*0.18)*2.1836e-17+(nf-1)*l*0.9/1u*cf_factor_shield*9.8858e-18+(l*0.9/1u+(7/2*nf-6)*0.18)*4.9884e-17+(l*0.9/1u+(2*nf-3)*0.18-1.53)*(3.58e-17+2.9732e-17)+(l*0.9/1u+(2*nf-3)*0.18)*2.5998e-17)+m3*((nf/2-1)*l*0.9/1u*2.1656e-17+(l*0.9/1u+(2*nf-3)*0.18)*2.1836e-17+(nf-1)*l*0.9/1u*cf_factor_shield*9.8858e-18+(l*0.9/1u+(7/2*nf-6)*0.18)*4.9884e-17+(l*0.9/1u+(2*nf-3)*0.18-1.53)*(3.58e-17+2.9732e-17))+m2*((nf/2-1)*l*0.9/1u*2.1656e-17+(l*0.9/1u+(2*nf-3)*0.18)*2.1836e-17+(nf-1)*l*0.9/1u*cf_factor_shield*9.8858e-18+(l*0.9/1u+(7/2*nf-6)*0.18)*4.9884e-17+(l*0.9/1u+(2*nf-3)*0.18)*(3.58e-17)))
+ p_c117=shielding_flag*(bm4*(m3*((nf/2-1)*l*0.9/1u*2.1656e-17+(l*0.9/1u+(2*nf-3)*0.18)*2.1836e-17+(nf-1)*l*0.9/1u*cf_factor_shield*9.8920e-18+(l*0.9/1u+(7/2*nf-6)*0.18)*4.9854e-17+(l*0.9/1u+(2*nf-3)*0.18-1.53)*(3.58116e-17+3.0134e-17))+m2*((nf/2-1)*l*0.9/1u*2.1656e-17+(l*0.9/1u+(2*nf-3)*0.18)*2.1836e-17+(nf-1)*l*0.9/1u*cf_factor_shield*9.8920e-18+(l*0.9/1u+(7/2*nf-6)*0.18)*4.9854e-17+(l*0.9/1u+(2*nf-3)*0.18)*(3.58116e-17)))+bm5*(m2*((nf/2-1)*l*0.9/1u*2.1656e-17+(l*0.9/1u+(2*nf-3)*0.18)*2.1836e-17+(nf-1)*l*0.9/1u*cf_factor_shield*9.8920e-18+(l*0.9/1u+(7/2*nf-6)*0.18)*4.9854e-17+(l*0.9/1u+(2*nf-3)*0.18)*(3.645e-17))))
+ p_c118=1*bm1*(m6*((l*0.9/1u-1.53+(2*nf-3)*0.18)*(3.2991e-17+2.6565e-17+2.6607e-17+2.66e-17+2.6597e-17+2.8838e-17)-(l*0.9/1u+(2*nf-3)*0.18-1.53)*cf_factor*(2.1807e-17+2.0815e-17+1.8482e-17+1.6383e-17+1.4593e-17+1.3321e-17))+m5*((l*0.9/1u-1.53+(2*nf-3)*0.18)*(3.2991e-17+2.6565e-17+2.6607e-17+2.66e-17+2.6597e-17)-(l*0.9/1u+(2*nf-3)*0.18-1.53)*cf_factor*(2.1807e-17+2.0815e-17+1.8482e-17+1.6383e-17+1.4593e-17))+m4*((l*0.9/1u-1.53+(2*nf-3)*0.18)*(3.2991e-17+2.6565e-17+2.6607e-17+2.66e-17)-(l*0.9/1u+(2*nf-3)*0.18-1.53)*cf_factor*(2.1807e-17+2.0815e-17+1.8482e-17+1.6383e-17))+m3*((l*0.9/1u-1.53+(2*nf-3)*0.18)*(3.2991e-17+2.6565e-17+2.6607e-17)-(l*0.9/1u+(2*nf-3)*0.18-1.53)*cf_factor*(2.1807e-17+2.0815e-17+1.8482e-17))+m2*((l*0.9/1u-1.53+(2*nf-3)*0.18)*(3.2991e-17+2.6565e-17)-(l*0.9/1u+(2*nf-3)*0.18)*cf_factor*(2.1807e-17+2.0815e-17)))
+ p_c119=1*bm2*(m5*((l*0.9/1u-1.53+(2*nf-3)*0.18)*(2.6565e-17+2.6607e-17+2.66e-17+2.6597e-17+2.8838e-17)-(l*0.9/1u+(2*nf-3)*0.18-1.53)*cf_factor*(2.0815e-17+1.8482e-17+1.6383e-17+1.4593e-17+1.3321e-17))+m4*((l*0.9/1u-1.53+(2*nf-3)*0.18)*(2.6565e-17+2.6607e-17+2.66e-17+2.6597e-17)-(l*0.9/1u+(2*nf-3)*0.18-1.53)*cf_factor*(2.0815e-17+1.8482e-17+1.6383e-17+1.4593e-17))+m3*((l*0.9/1u-1.53+(2*nf-3)*0.18)*(2.6565e-17+2.6607e-17+2.66e-17)-(l*0.9/1u+(2*nf-3)*0.18-1.53)*cf_factor*(2.0815e-17+1.8482e-17+1.6383e-17))+m2*((l*0.9/1u-1.53+(2*nf-3)*0.18)*(2.6565e-17+2.6607e-17)-(l*0.9/1u+(2*nf-3)*0.18)*cf_factor*(2.0815e-17+1.8482e-17)))
+ p_c120=1*(bm3*(m4*((l*0.9/1u-1.53+(2*nf-3)*0.18)*(2.6607e-17+2.66e-17+2.6597e-17+2.8838e-17)-(l*0.9/1u+(2*nf-3)*0.18-1.53)*cf_factor*(1.8482e-17+1.6383e-17+1.4593e-17+1.3321e-17))+m3*((l*0.9/1u-1.53+(2*nf-3)*0.18)*(2.6607e-17+2.66e-17+2.6597e-17)-(l*0.9/1u+(2*nf-3)*0.18-1.53)*cf_factor*(1.8482e-17+1.6383e-17+1.4593e-17))+m2*((l*0.9/1u-1.53+(2*nf-3)*0.18)*(2.6607e-17+2.66e-17)-(l*0.9/1u+(2*nf-3)*0.18)*cf_factor*(1.8482e-17+1.6383e-17)))+bm4*(m3*((l*0.9/1u-1.53+(2*nf-3)*0.18)*(2.66e-17+2.6597e-17+2.8838e-17)-(l*0.9/1u+(2*nf-3)*0.18-1.53)*cf_factor*(1.6383e-17+1.4593e-17+1.3321e-17))+m2*((l*0.9/1u-1.53+(2*nf-3)*0.18)*(2.66e-17+2.6597e-17)-(l*0.9/1u+(2*nf-3)*0.18)*cf_factor*(1.6383e-17+1.4593e-17)))+bm5*(m2*((l*0.9/1u-1.53+(2*nf-3)*0.18)*(2.6597e-17+2.8838e-17)-(l*0.9/1u+(2*nf-3)*0.18)*cf_factor*(1.4593e-17+1.3321e-17))))
+ p_c11=presim_flag*(p_c111+p_c1111+p_c112+p_c113+p_c114+p_c115+p_c116+p_c117+p_c118+p_c119+p_c120)+0.001f
//*

//*
//* ----- Equivalent network ------------------
//*
momcaps_stripemesh_mml110ae (port1 port2) main_c_vp1 c=p_c12*(1+d_c1_vp_mml110ae) m=mh
cox1 (port1 well) capacitor c=p_c11*(1+d_cox_vp_mml110ae) m=mh
cox2 (port2 well) capacitor c=p_c11*(1+d_cox_vp_mml110ae) m=mh
//*
cmain2 (port3 port4) main_c_vp1 c=p_c34*(1+d_c1_vp_mml110ae) m=mh
cox3 (port3 well) capacitor c=p_c11*(1+d_cox_vp_mml110ae) m=mh
cox4 (port4 well) capacitor c=p_c11*(1+d_cox_vp_mml110ae) m=mh
//*
//* Main Capacitor model
model main_c_vp1 capacitor c=1p tc1=-3.098e-5 tc2=-1.122e-9 tnom=25 coeffs=[2.874e-7 -1.089e-6]
//* -------------------------------------------
ends momcaps_stripemesh_mml110ae
