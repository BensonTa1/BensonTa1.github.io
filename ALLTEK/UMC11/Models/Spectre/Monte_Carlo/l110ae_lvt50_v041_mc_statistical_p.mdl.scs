//*.prot
simulator lang=spectre insensitive=yes
parameters
+ alpha_n_50_lvtl110ae = 0.2
+ alpha_p_50_lvtl110ae = 0.2

parameters a1_np_50_lvtl110ae_xx = 0
parameters a2_np_50_lvtl110ae_xx = 0
parameters a3_np_50_lvtl110ae_xx = 0
parameters a4_np_50_lvtl110ae_xx = 0
parameters a5_np_50_lvtl110ae_xx = 0
statistics {
    process {
        vary a1_np_50_lvtl110ae_xx dist=gauss std=sigma/3
        vary a2_np_50_lvtl110ae_xx dist=gauss std=sigma/3
        vary a3_np_50_lvtl110ae_xx dist=gauss std=sigma/3
        vary a4_np_50_lvtl110ae_xx dist=gauss std=sigma/3
        vary a5_np_50_lvtl110ae_xx dist=gauss std=sigma/3
    }
}
parameters
+ a1_np_50_lvtl110ae = a1_np_50_lvtl110ae_xx
parameters
+ a2_np_50_lvtl110ae = a2_np_50_lvtl110ae_xx
+ a3_np_50_lvtl110ae = a3_np_50_lvtl110ae_xx
+ a4_np_50_lvtl110ae = a4_np_50_lvtl110ae_xx
+ a5_np_50_lvtl110ae = a5_np_50_lvtl110ae_xx
+ comp1_np_50_lvtl110ae = 12.0960064269708
+ comp2_np_50_lvtl110ae = 6.23218775443371
+ comp3_np_50_lvtl110ae = 1.68224151731065
+ comp4_np_50_lvtl110ae = 0.128560451161925
+ comp5_np_50_lvtl110ae = 1.11171402019086e-14
+   dtox_n_50_lvtl110ae_g   = alpha_n_50_lvtl110ae*(4.16679040880366e-11*a1_np_50_lvtl110ae*comp1_np_50_lvtl110ae+1.46122501055325e-12*a2_np_50_lvtl110ae*comp2_np_50_lvtl110ae+-3.39384239157722e-12*a3_np_50_lvtl110ae*comp3_np_50_lvtl110ae+1.09095843178165e-11*a4_np_50_lvtl110ae*comp4_np_50_lvtl110ae+-4.33579659681573e-11*a5_np_50_lvtl110ae*comp5_np_50_lvtl110ae)
+   dxl_n_50_lvtl110ae_g    = alpha_n_50_lvtl110ae*(2.46029813369115e-09*a1_np_50_lvtl110ae*comp1_np_50_lvtl110ae+-2.18550281124917e-09*a2_np_50_lvtl110ae*comp2_np_50_lvtl110ae+2.94833437583815e-09*a3_np_50_lvtl110ae*comp3_np_50_lvtl110ae+-1.04034841199412e-09*a4_np_50_lvtl110ae*comp4_np_50_lvtl110ae+2.12718491022845e-09*a5_np_50_lvtl110ae*comp5_np_50_lvtl110ae)
+   dxw_n_50_lvtl110ae_g    = alpha_n_50_lvtl110ae*(-1.82510467830205e-09*a1_np_50_lvtl110ae*comp1_np_50_lvtl110ae+1.73301002742858e-09*a2_np_50_lvtl110ae*comp2_np_50_lvtl110ae+-6.36623948243087e-10*a3_np_50_lvtl110ae*comp3_np_50_lvtl110ae+-2.61161312818782e-10*a4_np_50_lvtl110ae*comp4_np_50_lvtl110ae+-1.94659783930344e-09*a5_np_50_lvtl110ae*comp5_np_50_lvtl110ae)
+   dvth0_n_50_lvtl110ae_g    = alpha_n_50_lvtl110ae*(3.5841290638241e-03*a1_np_50_lvtl110ae*comp1_np_50_lvtl110ae+-3.44313778790898e-03*a2_np_50_lvtl110ae*comp2_np_50_lvtl110ae+-1.2853450889173e-03*a3_np_50_lvtl110ae*comp3_np_50_lvtl110ae+1.49936341595553e-03*a4_np_50_lvtl110ae*comp4_np_50_lvtl110ae+-1.60605913984054e-03*a5_np_50_lvtl110ae*comp5_np_50_lvtl110ae)
+   dnlx_n_50_lvtl110ae_g   = alpha_n_50_lvtl110ae*(7.18631728346632e-09*a1_np_50_lvtl110ae*comp1_np_50_lvtl110ae+-6.0439838785397e-09*a2_np_50_lvtl110ae*comp2_np_50_lvtl110ae+-2.10194705250445e-09*a3_np_50_lvtl110ae*comp3_np_50_lvtl110ae+4.91583159702715e-09*a4_np_50_lvtl110ae*comp4_np_50_lvtl110ae+3.52396512559722e-09*a5_np_50_lvtl110ae*comp5_np_50_lvtl110ae)
+   dk3_n_50_lvtl110ae_g    = alpha_n_50_lvtl110ae*(0.129726879447762*a1_np_50_lvtl110ae*comp1_np_50_lvtl110ae+-0.119242286909174*a2_np_50_lvtl110ae*comp2_np_50_lvtl110ae+-8.81631831365258e-02*a3_np_50_lvtl110ae*comp3_np_50_lvtl110ae+3.17330268293187e-02*a4_np_50_lvtl110ae*comp4_np_50_lvtl110ae+6.38156414852372e-03*a5_np_50_lvtl110ae*comp5_np_50_lvtl110ae)
+   dpvth0_n_50_lvtl110ae_g   = alpha_n_50_lvtl110ae*(-2.56361003408231e-16*a1_np_50_lvtl110ae*comp1_np_50_lvtl110ae+2.9967780393848e-16*a2_np_50_lvtl110ae*comp2_np_50_lvtl110ae+3.30779968360621e-17*a3_np_50_lvtl110ae*comp3_np_50_lvtl110ae+-1.55539424261055e-16*a4_np_50_lvtl110ae*comp4_np_50_lvtl110ae+-4.75875378666864e-17*a5_np_50_lvtl110ae*comp5_np_50_lvtl110ae)
+   du0_n_50_lvtl110ae_g    = alpha_n_50_lvtl110ae*(-2.54857757409126e-04*a1_np_50_lvtl110ae*comp1_np_50_lvtl110ae+2.83121081898283e-04*a2_np_50_lvtl110ae*comp2_np_50_lvtl110ae+4.55493044935789e-05*a3_np_50_lvtl110ae*comp3_np_50_lvtl110ae+-1.15069499451346e-04*a4_np_50_lvtl110ae*comp4_np_50_lvtl110ae+-2.38994533789279e-05*a5_np_50_lvtl110ae*comp5_np_50_lvtl110ae)
+   drdsw_n_50_lvtl110ae_g    = alpha_n_50_lvtl110ae*(9.43221863759043*a1_np_50_lvtl110ae*comp1_np_50_lvtl110ae+-8.73114730558797*a2_np_50_lvtl110ae*comp2_np_50_lvtl110ae+-2.78004192432982*a3_np_50_lvtl110ae*comp3_np_50_lvtl110ae+3.51238267153027*a4_np_50_lvtl110ae*comp4_np_50_lvtl110ae+2.11641378276855*a5_np_50_lvtl110ae*comp5_np_50_lvtl110ae)
+   dwwl_n_50_lvtl110ae_g   = alpha_n_50_lvtl110ae*(4.84628850945949e-23*a1_np_50_lvtl110ae*comp1_np_50_lvtl110ae+-6.64156819856513e-23*a2_np_50_lvtl110ae*comp2_np_50_lvtl110ae+9.50138201457767e-23*a3_np_50_lvtl110ae*comp3_np_50_lvtl110ae+-5.2020687380301e-23*a4_np_50_lvtl110ae*comp4_np_50_lvtl110ae+-6.15145946895103e-23*a5_np_50_lvtl110ae*comp5_np_50_lvtl110ae)
+   dvsat_n_50_lvtl110ae_g    = alpha_n_50_lvtl110ae*(-927.570868909612*a1_np_50_lvtl110ae*comp1_np_50_lvtl110ae+1124.7120329306*a2_np_50_lvtl110ae*comp2_np_50_lvtl110ae+-22.743920949402*a3_np_50_lvtl110ae*comp3_np_50_lvtl110ae+-685.37123690756*a4_np_50_lvtl110ae*comp4_np_50_lvtl110ae+1568.96817227729*a5_np_50_lvtl110ae*comp5_np_50_lvtl110ae)
+   db0_n_50_lvtl110ae_g    = alpha_n_50_lvtl110ae*(-1.27262446354864e-09*a1_np_50_lvtl110ae*comp1_np_50_lvtl110ae+1.27256086151859e-09*a2_np_50_lvtl110ae*comp2_np_50_lvtl110ae+1.01524169312545e-09*a3_np_50_lvtl110ae*comp3_np_50_lvtl110ae+-1.13243152637855e-09*a4_np_50_lvtl110ae*comp4_np_50_lvtl110ae+-1.46456036799865e-10*a5_np_50_lvtl110ae*comp5_np_50_lvtl110ae)
+   dpvsat_n_50_lvtl110ae_g   = alpha_n_50_lvtl110ae*(-4.02858390745533e-11*a1_np_50_lvtl110ae*comp1_np_50_lvtl110ae+3.5635470598497e-11*a2_np_50_lvtl110ae*comp2_np_50_lvtl110ae+2.49849626093798e-11*a3_np_50_lvtl110ae*comp3_np_50_lvtl110ae+-3.27168873011206e-11*a4_np_50_lvtl110ae*comp4_np_50_lvtl110ae+-7.63463369230464e-12*a5_np_50_lvtl110ae*comp5_np_50_lvtl110ae)
+   dcj_n_50_lvtl110ae_g    = alpha_n_50_lvtl110ae*(9.08405073106141e-06*a1_np_50_lvtl110ae*comp1_np_50_lvtl110ae+-1.69874384597035e-05*a2_np_50_lvtl110ae*comp2_np_50_lvtl110ae+-4.58190932253134e-06*a3_np_50_lvtl110ae*comp3_np_50_lvtl110ae+4.36992822868636e-06*a4_np_50_lvtl110ae*comp4_np_50_lvtl110ae+-1.16505386315757e-05*a5_np_50_lvtl110ae*comp5_np_50_lvtl110ae)
+   dcjsw_n_50_lvtl110ae_g    = alpha_n_50_lvtl110ae*(1.14635749505736e-12*a1_np_50_lvtl110ae*comp1_np_50_lvtl110ae+-2.14372177970339e-12*a2_np_50_lvtl110ae*comp2_np_50_lvtl110ae+-5.78211884660324e-13*a3_np_50_lvtl110ae*comp3_np_50_lvtl110ae+5.51461030560769e-13*a4_np_50_lvtl110ae*comp4_np_50_lvtl110ae+1.17070608321407e-12*a5_np_50_lvtl110ae*comp5_np_50_lvtl110ae)
+   dcjswg_n_50_lvtl110ae_g   = alpha_n_50_lvtl110ae*(2.0905565106959e-12*a1_np_50_lvtl110ae*comp1_np_50_lvtl110ae+-3.90940133684498e-12*a2_np_50_lvtl110ae*comp2_np_50_lvtl110ae+-1.05445694318761e-12*a3_np_50_lvtl110ae*comp3_np_50_lvtl110ae+1.00567270925923e-12*a4_np_50_lvtl110ae*comp4_np_50_lvtl110ae+-2.32362229724122e-13*a5_np_50_lvtl110ae*comp5_np_50_lvtl110ae)
+   dcgdo_n_50_lvtl110ae_g    = alpha_n_50_lvtl110ae*(-3.68199447022415e-13*a1_np_50_lvtl110ae*comp1_np_50_lvtl110ae+-1.2912150314167e-14*a2_np_50_lvtl110ae*comp2_np_50_lvtl110ae+2.99897707650359e-14*a3_np_50_lvtl110ae*comp3_np_50_lvtl110ae+-9.64028069321228e-14*a4_np_50_lvtl110ae*comp4_np_50_lvtl110ae+-2.41445784443638e-13*a5_np_50_lvtl110ae*comp5_np_50_lvtl110ae)
+   dcgso_n_50_lvtl110ae_g    = alpha_n_50_lvtl110ae*(-3.68199447022415e-13*a1_np_50_lvtl110ae*comp1_np_50_lvtl110ae+-1.2912150314167e-14*a2_np_50_lvtl110ae*comp2_np_50_lvtl110ae+2.99897707650359e-14*a3_np_50_lvtl110ae*comp3_np_50_lvtl110ae+-9.64028069321228e-14*a4_np_50_lvtl110ae*comp4_np_50_lvtl110ae+-2.41445784443638e-13*a5_np_50_lvtl110ae*comp5_np_50_lvtl110ae)
+   dcgdl_n_50_lvtl110ae_g    = alpha_n_50_lvtl110ae*(-3.87486084723589e-12*a1_np_50_lvtl110ae*comp1_np_50_lvtl110ae+-1.35885010449092e-13*a2_np_50_lvtl110ae*comp2_np_50_lvtl110ae+3.15606635193962e-13*a3_np_50_lvtl110ae*comp3_np_50_lvtl110ae+-1.01452477771421e-12*a4_np_50_lvtl110ae*comp4_np_50_lvtl110ae+-1.07644069305736e-12*a5_np_50_lvtl110ae*comp5_np_50_lvtl110ae)
+   dcgsl_n_50_lvtl110ae_g    = alpha_n_50_lvtl110ae*(-3.87486084723589e-12*a1_np_50_lvtl110ae*comp1_np_50_lvtl110ae+-1.35885010449092e-13*a2_np_50_lvtl110ae*comp2_np_50_lvtl110ae+3.15606635193962e-13*a3_np_50_lvtl110ae*comp3_np_50_lvtl110ae+-1.01452477771421e-12*a4_np_50_lvtl110ae*comp4_np_50_lvtl110ae+-1.07644069305736e-12*a5_np_50_lvtl110ae*comp5_np_50_lvtl110ae)
+   deta0_n_50_lvtl110ae_g    = alpha_n_50_lvtl110ae*(2.81435357699977e-03*a1_np_50_lvtl110ae*comp1_np_50_lvtl110ae+-3.25784415504406e-03*a2_np_50_lvtl110ae*comp2_np_50_lvtl110ae+5.10697040192856e-03*a3_np_50_lvtl110ae*comp3_np_50_lvtl110ae+-4.08915869780895e-03*a4_np_50_lvtl110ae*comp4_np_50_lvtl110ae+1.99755243175674e-03*a5_np_50_lvtl110ae*comp5_np_50_lvtl110ae)
+   dpeta0_n_50_lvtl110ae_g   = alpha_n_50_lvtl110ae*(-1.32466398684751e-16*a1_np_50_lvtl110ae*comp1_np_50_lvtl110ae+1.54090512810517e-16*a2_np_50_lvtl110ae*comp2_np_50_lvtl110ae+-2.67001921405718e-16*a3_np_50_lvtl110ae*comp3_np_50_lvtl110ae+1.72880917532733e-16*a4_np_50_lvtl110ae*comp4_np_50_lvtl110ae+2.62723118804997e-16*a5_np_50_lvtl110ae*comp5_np_50_lvtl110ae)
+   djtsswgd_n_50_lvtl110ae_g   = alpha_n_50_lvtl110ae*(-5.93982385469382e-08*a1_np_50_lvtl110ae*comp1_np_50_lvtl110ae+1.05396523648576e-07*a2_np_50_lvtl110ae*comp2_np_50_lvtl110ae+3.73399490550237e-08*a3_np_50_lvtl110ae*comp3_np_50_lvtl110ae+1.52729599105676e-07*a4_np_50_lvtl110ae*comp4_np_50_lvtl110ae+-3.49352239638448e-08*a5_np_50_lvtl110ae*comp5_np_50_lvtl110ae)
+   dtox_p_50_lvtl110ae_g   = alpha_p_50_lvtl110ae*(4.34826013626471e-11*a1_np_50_lvtl110ae*comp1_np_50_lvtl110ae+1.52486346567306e-12*a2_np_50_lvtl110ae*comp2_np_50_lvtl110ae+-3.54164911891867e-12*a3_np_50_lvtl110ae*comp3_np_50_lvtl110ae+1.1384712437698e-11*a4_np_50_lvtl110ae*comp4_np_50_lvtl110ae+1.2079515469603e-11*a5_np_50_lvtl110ae*comp5_np_50_lvtl110ae)
+   dxl_p_50_lvtl110ae_g    = alpha_p_50_lvtl110ae*(2.78099264906443e-10*a1_np_50_lvtl110ae*comp1_np_50_lvtl110ae+2.81610076789227e-10*a2_np_50_lvtl110ae*comp2_np_50_lvtl110ae+3.77025594212679e-11*a3_np_50_lvtl110ae*comp3_np_50_lvtl110ae+4.15280351792287e-11*a4_np_50_lvtl110ae*comp4_np_50_lvtl110ae+-3.74923973964005e-10*a5_np_50_lvtl110ae*comp5_np_50_lvtl110ae)
+   dxw_p_50_lvtl110ae_g    = alpha_p_50_lvtl110ae*(-3.3143129420528e-09*a1_np_50_lvtl110ae*comp1_np_50_lvtl110ae+-3.25615480070569e-09*a2_np_50_lvtl110ae*comp2_np_50_lvtl110ae+-2.66396049775281e-09*a3_np_50_lvtl110ae*comp3_np_50_lvtl110ae+7.9087705757493e-10*a4_np_50_lvtl110ae*comp4_np_50_lvtl110ae+-2.54015883002143e-09*a5_np_50_lvtl110ae*comp5_np_50_lvtl110ae)
+   dvth0_p_50_lvtl110ae_g    = alpha_p_50_lvtl110ae*(-4.94515772541324e-03*a1_np_50_lvtl110ae*comp1_np_50_lvtl110ae+-5.06507606071879e-03*a2_np_50_lvtl110ae*comp2_np_50_lvtl110ae+-4.76308108355416e-04*a3_np_50_lvtl110ae*comp3_np_50_lvtl110ae+-3.26982380621302e-04*a4_np_50_lvtl110ae*comp4_np_50_lvtl110ae+1.72779459218745e-03*a5_np_50_lvtl110ae*comp5_np_50_lvtl110ae)
+   dlvth0_p_50_lvtl110ae_g   = alpha_p_50_lvtl110ae*(-1.84058214151845e-09*a1_np_50_lvtl110ae*comp1_np_50_lvtl110ae+-1.82443410764195e-09*a2_np_50_lvtl110ae*comp2_np_50_lvtl110ae+-3.35486944739564e-10*a3_np_50_lvtl110ae*comp3_np_50_lvtl110ae+-4.6098794071073e-10*a4_np_50_lvtl110ae*comp4_np_50_lvtl110ae+-9.79392745135042e-10*a5_np_50_lvtl110ae*comp5_np_50_lvtl110ae)
+   dk3_p_50_lvtl110ae_g    = alpha_p_50_lvtl110ae*(1.02350818215627e-02*a1_np_50_lvtl110ae*comp1_np_50_lvtl110ae+0.012604284967264*a2_np_50_lvtl110ae*comp2_np_50_lvtl110ae+-1.62925167709786e-02*a3_np_50_lvtl110ae*comp3_np_50_lvtl110ae+1.98464327583453e-02*a4_np_50_lvtl110ae*comp4_np_50_lvtl110ae+3.17485006126976e-03*a5_np_50_lvtl110ae*comp5_np_50_lvtl110ae)
+   dpvth0_p_50_lvtl110ae_g   = alpha_p_50_lvtl110ae*(-1.43339689868781e-16*a1_np_50_lvtl110ae*comp1_np_50_lvtl110ae+-1.54362339553094e-16*a2_np_50_lvtl110ae*comp2_np_50_lvtl110ae+3.3776421689779e-16*a3_np_50_lvtl110ae*comp3_np_50_lvtl110ae+-1.53430232102393e-16*a4_np_50_lvtl110ae*comp4_np_50_lvtl110ae+2.55301160977196e-17*a5_np_50_lvtl110ae*comp5_np_50_lvtl110ae)
+   du0_p_50_lvtl110ae_g    = alpha_p_50_lvtl110ae*(-8.76379218769009e-05*a1_np_50_lvtl110ae*comp1_np_50_lvtl110ae+-1.04701383522037e-04*a2_np_50_lvtl110ae*comp2_np_50_lvtl110ae+-2.8814849478857e-05*a3_np_50_lvtl110ae*comp3_np_50_lvtl110ae+-2.51737253871366e-05*a4_np_50_lvtl110ae*comp4_np_50_lvtl110ae+-1.00708147024851e-04*a5_np_50_lvtl110ae*comp5_np_50_lvtl110ae)
+   drdsw_p_50_lvtl110ae_g    = alpha_p_50_lvtl110ae*(63.9073396367998*a1_np_50_lvtl110ae*comp1_np_50_lvtl110ae+62.3414386586722*a2_np_50_lvtl110ae*comp2_np_50_lvtl110ae+74.2720453636014*a3_np_50_lvtl110ae*comp3_np_50_lvtl110ae+-28.0314031589481*a4_np_50_lvtl110ae*comp4_np_50_lvtl110ae+67.2330022558893*a5_np_50_lvtl110ae*comp5_np_50_lvtl110ae)
+   dwwl_p_50_lvtl110ae_g   = alpha_p_50_lvtl110ae*(2.63441357320747e-22*a1_np_50_lvtl110ae*comp1_np_50_lvtl110ae+2.72380161802765e-22*a2_np_50_lvtl110ae*comp2_np_50_lvtl110ae+2.13391366316983e-22*a3_np_50_lvtl110ae*comp3_np_50_lvtl110ae+-5.31061619402364e-23*a4_np_50_lvtl110ae*comp4_np_50_lvtl110ae+2.20744893668453e-22*a5_np_50_lvtl110ae*comp5_np_50_lvtl110ae)
+   dags_p_50_lvtl110ae_g   = alpha_p_50_lvtl110ae*(7.01741018162719e-04*a1_np_50_lvtl110ae*comp1_np_50_lvtl110ae+7.23205575753813e-04*a2_np_50_lvtl110ae*comp2_np_50_lvtl110ae+5.87284439862331e-05*a3_np_50_lvtl110ae*comp3_np_50_lvtl110ae+2.56988385378526e-05*a4_np_50_lvtl110ae*comp4_np_50_lvtl110ae+-3.01361184737833e-03*a5_np_50_lvtl110ae*comp5_np_50_lvtl110ae)
+   dvsat_p_50_lvtl110ae_g    = alpha_p_50_lvtl110ae*(-1065.698119361*a1_np_50_lvtl110ae*comp1_np_50_lvtl110ae+-1354.88924431575*a2_np_50_lvtl110ae*comp2_np_50_lvtl110ae+-810.76017404136*a3_np_50_lvtl110ae*comp3_np_50_lvtl110ae+-309.666074899823*a4_np_50_lvtl110ae*comp4_np_50_lvtl110ae+2181.6700322336*a5_np_50_lvtl110ae*comp5_np_50_lvtl110ae)
+   db0_p_50_lvtl110ae_g    = alpha_p_50_lvtl110ae*(-3.99287043238614e-10*a1_np_50_lvtl110ae*comp1_np_50_lvtl110ae+-4.12969574466497e-10*a2_np_50_lvtl110ae*comp2_np_50_lvtl110ae+4.47663807595796e-11*a3_np_50_lvtl110ae*comp3_np_50_lvtl110ae+-3.20960555732624e-10*a4_np_50_lvtl110ae*comp4_np_50_lvtl110ae+2.97673832447279e-10*a5_np_50_lvtl110ae*comp5_np_50_lvtl110ae)
+   dpvsat_p_50_lvtl110ae_g   = alpha_p_50_lvtl110ae*(6.06167419998377e-11*a1_np_50_lvtl110ae*comp1_np_50_lvtl110ae+6.29709761657476e-11*a2_np_50_lvtl110ae*comp2_np_50_lvtl110ae+6.34711249046633e-11*a3_np_50_lvtl110ae*comp3_np_50_lvtl110ae+-1.21880988760888e-11*a4_np_50_lvtl110ae*comp4_np_50_lvtl110ae+2.86459674630738e-11*a5_np_50_lvtl110ae*comp5_np_50_lvtl110ae)
+   dcj_p_50_lvtl110ae_g    = alpha_p_50_lvtl110ae*(1.10243274983507e-05*a1_np_50_lvtl110ae*comp1_np_50_lvtl110ae+2.21306814713333e-05*a2_np_50_lvtl110ae*comp2_np_50_lvtl110ae+3.9293599326406e-06*a3_np_50_lvtl110ae*comp3_np_50_lvtl110ae+3.84172455229778e-07*a4_np_50_lvtl110ae*comp4_np_50_lvtl110ae+6.39897291746022e-06*a5_np_50_lvtl110ae*comp5_np_50_lvtl110ae)
+   dcjsw_p_50_lvtl110ae_g    = alpha_p_50_lvtl110ae*(8.43766511803337e-13*a1_np_50_lvtl110ae*comp1_np_50_lvtl110ae+1.69381106572634e-12*a2_np_50_lvtl110ae*comp2_np_50_lvtl110ae+3.00740550793684e-13*a3_np_50_lvtl110ae*comp3_np_50_lvtl110ae+2.94033221100015e-14*a4_np_50_lvtl110ae*comp4_np_50_lvtl110ae+4.89756772782483e-13*a5_np_50_lvtl110ae*comp5_np_50_lvtl110ae)
+   dcjswg_p_50_lvtl110ae_g   = alpha_p_50_lvtl110ae*(1.95722588635024e-12*a1_np_50_lvtl110ae*comp1_np_50_lvtl110ae+3.92901450585038e-12*a2_np_50_lvtl110ae*comp2_np_50_lvtl110ae+6.97606722777618e-13*a3_np_50_lvtl110ae*comp3_np_50_lvtl110ae+6.82048201408149e-14*a4_np_50_lvtl110ae*comp4_np_50_lvtl110ae+1.13605437084311e-12*a5_np_50_lvtl110ae*comp5_np_50_lvtl110ae)
+   dcgdo_p_50_lvtl110ae_g    = alpha_p_50_lvtl110ae*(-5.75267802705021e-13*a1_np_50_lvtl110ae*comp1_np_50_lvtl110ae+-2.01736977051344e-14*a2_np_50_lvtl110ae*comp2_np_50_lvtl110ae+4.68554466095651e-14*a3_np_50_lvtl110ae*comp3_np_50_lvtl110ae+-1.50617909306802e-13*a4_np_50_lvtl110ae*comp4_np_50_lvtl110ae+-1.598100413539e-13*a5_np_50_lvtl110ae*comp5_np_50_lvtl110ae)
+   dcgso_p_50_lvtl110ae_g    = alpha_p_50_lvtl110ae*(-5.75267802705021e-13*a1_np_50_lvtl110ae*comp1_np_50_lvtl110ae+-2.01736977051344e-14*a2_np_50_lvtl110ae*comp2_np_50_lvtl110ae+4.68554466095651e-14*a3_np_50_lvtl110ae*comp3_np_50_lvtl110ae+-1.50617909306802e-13*a4_np_50_lvtl110ae*comp4_np_50_lvtl110ae+-1.598100413539e-13*a5_np_50_lvtl110ae*comp5_np_50_lvtl110ae)
+   dcgdl_p_50_lvtl110ae_g    = alpha_p_50_lvtl110ae*(-1.44708227115476e-12*a1_np_50_lvtl110ae*comp1_np_50_lvtl110ae+-5.07468002823453e-14*a2_np_50_lvtl110ae*comp2_np_50_lvtl110ae+1.17864559387665e-13*a3_np_50_lvtl110ae*comp3_np_50_lvtl110ae+-3.78878333276089e-13*a4_np_50_lvtl110ae*comp4_np_50_lvtl110ae+-9.48920257591187e-13*a5_np_50_lvtl110ae*comp5_np_50_lvtl110ae)
+   dcgsl_p_50_lvtl110ae_g    = alpha_p_50_lvtl110ae*(-1.44708227115476e-12*a1_np_50_lvtl110ae*comp1_np_50_lvtl110ae+-5.07468002823453e-14*a2_np_50_lvtl110ae*comp2_np_50_lvtl110ae+1.17864559387665e-13*a3_np_50_lvtl110ae*comp3_np_50_lvtl110ae+-3.78878333276089e-13*a4_np_50_lvtl110ae*comp4_np_50_lvtl110ae+-9.48920257591187e-13*a5_np_50_lvtl110ae*comp5_np_50_lvtl110ae)
+   dcf_p_50_lvtl110ae_g    = alpha_p_50_lvtl110ae*(0*a1_np_50_lvtl110ae*comp1_np_50_lvtl110ae+0*a2_np_50_lvtl110ae*comp2_np_50_lvtl110ae+0*a3_np_50_lvtl110ae*comp3_np_50_lvtl110ae+0*a4_np_50_lvtl110ae*comp4_np_50_lvtl110ae+0*a5_np_50_lvtl110ae*comp5_np_50_lvtl110ae)
+   deta0_p_50_lvtl110ae_g    = alpha_p_50_lvtl110ae*(-1.17665172526347e-03*a1_np_50_lvtl110ae*comp1_np_50_lvtl110ae+-1.7090214138523e-04*a2_np_50_lvtl110ae*comp2_np_50_lvtl110ae+-7.84950950490463e-05*a3_np_50_lvtl110ae*comp3_np_50_lvtl110ae+4.76588132549636e-04*a4_np_50_lvtl110ae*comp4_np_50_lvtl110ae+6.65893869634889e-04*a5_np_50_lvtl110ae*comp5_np_50_lvtl110ae)
+   dpeta0_p_50_lvtl110ae_g   = alpha_p_50_lvtl110ae*(-1.62609579174196e-16*a1_np_50_lvtl110ae*comp1_np_50_lvtl110ae+-1.42156798720755e-16*a2_np_50_lvtl110ae*comp2_np_50_lvtl110ae+-1.5487559217344e-16*a3_np_50_lvtl110ae*comp3_np_50_lvtl110ae+5.36687664760389e-16*a4_np_50_lvtl110ae*comp4_np_50_lvtl110ae+-7.70590798081227e-17*a5_np_50_lvtl110ae*comp5_np_50_lvtl110ae)
+   djtsswgd_p_50_lvtl110ae_g   = alpha_p_50_lvtl110ae*(-4.00223837860781e-07*a1_np_50_lvtl110ae*comp1_np_50_lvtl110ae+-1.81301812834617e-07*a2_np_50_lvtl110ae*comp2_np_50_lvtl110ae+1.93841634638504e-06*a3_np_50_lvtl110ae*comp3_np_50_lvtl110ae+1.72351269138487e-06*a4_np_50_lvtl110ae*comp4_np_50_lvtl110ae+1.43371524724952e-07*a5_np_50_lvtl110ae*comp5_np_50_lvtl110ae)
//*.unprot
