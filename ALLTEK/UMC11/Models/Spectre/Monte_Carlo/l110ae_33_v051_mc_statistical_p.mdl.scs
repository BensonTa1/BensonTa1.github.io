simulator lang=spectre insensitive=yes
//
parameters alpha_n_33_l110e = 0.2
parameters alpha_p_33_l110e = 0.2

parameters a1_np_33_l110e_xx = 0
parameters a2_np_33_l110e_xx = 0
parameters a3_np_33_l110e_xx = 0
parameters a4_np_33_l110e_xx = 0
parameters a5_np_33_l110e_xx = 0
statistics {
process {
vary a1_np_33_l110e_xx dist=gauss std=sigma/3
vary a2_np_33_l110e_xx dist=gauss std=sigma/3
vary a3_np_33_l110e_xx dist=gauss std=sigma/3
vary a4_np_33_l110e_xx dist=gauss std=sigma/3
vary a5_np_33_l110e_xx dist=gauss std=sigma/3
 }
}
parameters a1_np_33_l110e = a1_np_33_l110e_xx
parameters a2_np_33_l110e = a2_np_33_l110e_xx
parameters a3_np_33_l110e = a3_np_33_l110e_xx
parameters a4_np_33_l110e = a4_np_33_l110e_xx
parameters a5_np_33_l110e = a5_np_33_l110e_xx
parameters comp1_np_33_l110e	= 10.2547075849936
parameters comp2_np_33_l110e	= 5.46079467804135
parameters comp3_np_33_l110e	= 1.00836700160055
parameters comp4_np_33_l110e	= 0.06236842658149
parameters comp5_np_33_l110e	= 8.37705497713204e-15
parameters 	dtox_n_33_l110e_g	  =	alpha_n_33_l110e*(2.06770144925211e-11*a1_np_33_l110e*comp1_np_33_l110e+1.00719520024155e-13*a2_np_33_l110e*comp2_np_33_l110e+-6.27315334549283e-12*a3_np_33_l110e*comp3_np_33_l110e+5.21459370865534e-12*a4_np_33_l110e*comp4_np_33_l110e+-9.22159227762072e-13*a5_np_33_l110e*comp5_np_33_l110e)
parameters 	dxl_n_33_l110e_g	  =	alpha_n_33_l110e*(1.38159844582093e-09*a1_np_33_l110e*comp1_np_33_l110e+-2.58287820314061e-09*a2_np_33_l110e*comp2_np_33_l110e+-5.71515838814407e-10*a3_np_33_l110e*comp3_np_33_l110e+-2.85155771577534e-11*a4_np_33_l110e*comp4_np_33_l110e+1.25470498316769e-10*a5_np_33_l110e*comp5_np_33_l110e)
parameters 	du0_n_33_l110e_g	  =	alpha_n_33_l110e*(-2.72952201286984e-04*a1_np_33_l110e*comp1_np_33_l110e+3.05410444200741e-04*a2_np_33_l110e*comp2_np_33_l110e+-1.61196389609525e-05*a3_np_33_l110e*comp3_np_33_l110e+-5.56722837518289e-05*a4_np_33_l110e*comp4_np_33_l110e+-6.22686735306086e-04*a5_np_33_l110e*comp5_np_33_l110e)
parameters 	dvth0_n_33_l110e_g	  =	alpha_n_33_l110e*(2.73073660711328e-03*a1_np_33_l110e*comp1_np_33_l110e+-4.33413460893432e-03*a2_np_33_l110e*comp2_np_33_l110e+-1.52887802790757e-03*a3_np_33_l110e*comp3_np_33_l110e+4.93300439696654e-04*a4_np_33_l110e*comp4_np_33_l110e+-5.34532442978245e-03*a5_np_33_l110e*comp5_np_33_l110e)
parameters 	drdsw_n_33_l110e_g	  =	alpha_n_33_l110e*(23.8791509162628*a1_np_33_l110e*comp1_np_33_l110e+-21.3174611958193*a2_np_33_l110e*comp2_np_33_l110e+25.9747061439147*a3_np_33_l110e*comp3_np_33_l110e+13.436104887363*a4_np_33_l110e*comp4_np_33_l110e+9.99884416018344*a5_np_33_l110e*comp5_np_33_l110e)
parameters 	dxw_n_33_l110e_g	  =	alpha_n_33_l110e*(-2.36989918543304e-10*a1_np_33_l110e*comp1_np_33_l110e+2.09764025946445e-10*a2_np_33_l110e*comp2_np_33_l110e+-1.06113464529306e-09*a3_np_33_l110e*comp3_np_33_l110e+3.68464505866909e-10*a4_np_33_l110e*comp4_np_33_l110e+7.44985559186367e-13*a5_np_33_l110e*comp5_np_33_l110e)
parameters 	dnlx_n_33_l110e_g	  =	alpha_n_33_l110e*(8.4864268229993e-09*a1_np_33_l110e*comp1_np_33_l110e+-6.06704859400969e-09*a2_np_33_l110e*comp2_np_33_l110e+-1.20105659758797e-09*a3_np_33_l110e*comp3_np_33_l110e+-4.75221117815171e-09*a4_np_33_l110e*comp4_np_33_l110e+-1.13057588325157e-09*a5_np_33_l110e*comp5_np_33_l110e)
parameters 	dk3_n_33_l110e_g	  =	alpha_n_33_l110e*(0.100769075444629*a1_np_33_l110e*comp1_np_33_l110e+-0.094957765107762*a2_np_33_l110e*comp2_np_33_l110e+-6.70655413869412e-02*a3_np_33_l110e*comp3_np_33_l110e+-8.25979424180443e-03*a4_np_33_l110e*comp4_np_33_l110e+-3.80176222916447e-02*a5_np_33_l110e*comp5_np_33_l110e)
parameters 	dpvth0_n_33_l110e_g	  =	alpha_n_33_l110e*(-1.63903042728699e-16*a1_np_33_l110e*comp1_np_33_l110e+1.91247571861475e-16*a2_np_33_l110e*comp2_np_33_l110e+2.61873860855797e-16*a3_np_33_l110e*comp3_np_33_l110e+-1.0169342819521e-16*a4_np_33_l110e*comp4_np_33_l110e+-3.36866623542405e-17*a5_np_33_l110e*comp5_np_33_l110e)
parameters 	dwwl_n_33_l110e_g	  =	alpha_n_33_l110e*(2.65220133833448e-23*a1_np_33_l110e*comp1_np_33_l110e+-1.99689258499709e-23*a2_np_33_l110e*comp2_np_33_l110e+1.64296049640386e-23*a3_np_33_l110e*comp3_np_33_l110e+-1.50724625276321e-23*a4_np_33_l110e*comp4_np_33_l110e+-5.67991355104729e-24*a5_np_33_l110e*comp5_np_33_l110e)
parameters 	dcgdo_n_33_l110e_g	  =	alpha_n_33_l110e*(-6.8923381641737e-13*a1_np_33_l110e*comp1_np_33_l110e+-3.35731733413863e-15*a2_np_33_l110e*comp2_np_33_l110e+2.09105111516425e-13*a3_np_33_l110e*comp3_np_33_l110e+-1.73819790288526e-13*a4_np_33_l110e*comp4_np_33_l110e+3.37258613767931e-13*a5_np_33_l110e*comp5_np_33_l110e)
parameters 	dcgso_n_33_l110e_g	  =	alpha_n_33_l110e*(-6.8923381641737e-13*a1_np_33_l110e*comp1_np_33_l110e+-3.35731733413863e-15*a2_np_33_l110e*comp2_np_33_l110e+2.09105111516425e-13*a3_np_33_l110e*comp3_np_33_l110e+-1.73819790288526e-13*a4_np_33_l110e*comp4_np_33_l110e+3.37258613767931e-13*a5_np_33_l110e*comp5_np_33_l110e)
parameters 	dcj_n_33_l110e_g	  =	alpha_n_33_l110e*(1.07764678774033e-05*a1_np_33_l110e*comp1_np_33_l110e+-2.01464499844968e-05*a2_np_33_l110e*comp2_np_33_l110e+-4.45782354275233e-06*a3_np_33_l110e*comp3_np_33_l110e+-2.2242150183094e-07*a4_np_33_l110e*comp4_np_33_l110e+1.7906787015486e-05*a5_np_33_l110e*comp5_np_33_l110e)
parameters 	dcjsw_n_33_l110e_g	  =	alpha_n_33_l110e*(1.4921263214866e-12*a1_np_33_l110e*comp1_np_33_l110e+-2.78950845939186e-12*a2_np_33_l110e*comp2_np_33_l110e+-6.1723710591956e-13*a3_np_33_l110e*comp3_np_33_l110e+-3.07968233302452e-14*a4_np_33_l110e*comp4_np_33_l110e+1.7217298376546e-12*a5_np_33_l110e*comp5_np_33_l110e)
parameters 	dcjswg_n_33_l110e_g	  =	alpha_n_33_l110e*(3.17767642538814e-12*a1_np_33_l110e*comp1_np_33_l110e+-5.94061986722341e-12*a2_np_33_l110e*comp2_np_33_l110e+-1.31448642927313e-12*a3_np_33_l110e*comp3_np_33_l110e+-6.55858274627325e-14*a4_np_33_l110e*comp4_np_33_l110e+-6.31677849318266e-12*a5_np_33_l110e*comp5_np_33_l110e)
parameters 	dcgdl_n_33_l110e_g	  =	alpha_n_33_l110e*(-2.48124173910253e-12*a1_np_33_l110e*comp1_np_33_l110e+-1.20863424028991e-14*a2_np_33_l110e*comp2_np_33_l110e+7.52778401459139e-13*a3_np_33_l110e*comp3_np_33_l110e+-6.25751245038663e-13*a4_np_33_l110e*comp4_np_33_l110e+1.44245789219959e-13*a5_np_33_l110e*comp5_np_33_l110e)
parameters 	dcgsl_n_33_l110e_g	  =	alpha_n_33_l110e*(-2.48124173910253e-12*a1_np_33_l110e*comp1_np_33_l110e+-1.20863424028991e-14*a2_np_33_l110e*comp2_np_33_l110e+7.52778401459139e-13*a3_np_33_l110e*comp3_np_33_l110e+-6.25751245038663e-13*a4_np_33_l110e*comp4_np_33_l110e+1.44245789219959e-13*a5_np_33_l110e*comp5_np_33_l110e)
parameters 	dtox_p_33_l110e_g	  =	alpha_p_33_l110e*(2.06770144925211e-11*a1_np_33_l110e*comp1_np_33_l110e+1.00719520024158e-13*a2_np_33_l110e*comp2_np_33_l110e+-6.2731533454928e-12*a3_np_33_l110e*comp3_np_33_l110e+5.21459370865561e-12*a4_np_33_l110e*comp4_np_33_l110e+-2.65338865843101e-12*a5_np_33_l110e*comp5_np_33_l110e)
parameters 	dxl_p_33_l110e_g	  =	alpha_p_33_l110e*(6.87668409924276e-10*a1_np_33_l110e*comp1_np_33_l110e+1.29815373623858e-09*a2_np_33_l110e*comp2_np_33_l110e+-1.32452303625652e-10*a3_np_33_l110e*comp3_np_33_l110e+3.61897369155893e-10*a4_np_33_l110e*comp4_np_33_l110e+-2.53692315873133e-10*a5_np_33_l110e*comp5_np_33_l110e)
parameters 	du0_p_33_l110e_g	  =	alpha_p_33_l110e*(-6.13213551212484e-05*a1_np_33_l110e*comp1_np_33_l110e+-7.38756228473063e-05*a2_np_33_l110e*comp2_np_33_l110e+-2.27022996979938e-05*a3_np_33_l110e*comp3_np_33_l110e+-1.92450513602084e-05*a4_np_33_l110e*comp4_np_33_l110e+2.08346897805065e-05*a5_np_33_l110e*comp5_np_33_l110e)
parameters 	dvth0_p_33_l110e_g	  =	alpha_p_33_l110e*(-3.85000547704699e-03*a1_np_33_l110e*comp1_np_33_l110e+-5.87086308072354e-03*a2_np_33_l110e*comp2_np_33_l110e+1.27447836014716e-03*a3_np_33_l110e*comp3_np_33_l110e+-4.35351834804157e-03*a4_np_33_l110e*comp4_np_33_l110e+-1.72458169300004e-02*a5_np_33_l110e*comp5_np_33_l110e)
parameters 	drdsw_p_33_l110e_g	  =	alpha_p_33_l110e*(45.8473856481114*a1_np_33_l110e*comp1_np_33_l110e+25.4835928321825*a2_np_33_l110e*comp2_np_33_l110e+76.0115988920914*a3_np_33_l110e*comp3_np_33_l110e+84.4195258753772*a4_np_33_l110e*comp4_np_33_l110e+8.83873789456829*a5_np_33_l110e*comp5_np_33_l110e)
parameters 	dxw_p_33_l110e_g	  =	alpha_p_33_l110e*(-2.32087787697958e-09*a1_np_33_l110e*comp1_np_33_l110e+-2.12548850750503e-09*a2_np_33_l110e*comp2_np_33_l110e+-3.25689382512983e-09*a3_np_33_l110e*comp3_np_33_l110e+-1.96306214963077e-09*a4_np_33_l110e*comp4_np_33_l110e+-4.66373189712103e-11*a5_np_33_l110e*comp5_np_33_l110e)
parameters 	dnlx_p_33_l110e_g	  =	alpha_p_33_l110e*(2.43342729634145e-09*a1_np_33_l110e*comp1_np_33_l110e+2.11511659149918e-09*a2_np_33_l110e*comp2_np_33_l110e+-2.24576413684297e-10*a3_np_33_l110e*comp3_np_33_l110e+-3.30986989432369e-09*a4_np_33_l110e*comp4_np_33_l110e+-1.15882299068524e-09*a5_np_33_l110e*comp5_np_33_l110e)
parameters 	dk3_p_33_l110e_g	  =	alpha_p_33_l110e*(0.014512364047163*a1_np_33_l110e*comp1_np_33_l110e+1.45332864130865e-02*a2_np_33_l110e*comp2_np_33_l110e+-1.37909494854362e-02*a3_np_33_l110e*comp3_np_33_l110e+-6.42990728963709e-02*a4_np_33_l110e*comp4_np_33_l110e+1.68260441676231e-02*a5_np_33_l110e*comp5_np_33_l110e)
parameters 	dpvth0_p_33_l110e_g	  =	alpha_p_33_l110e*(-1.54259813431536e-16*a1_np_33_l110e*comp1_np_33_l110e+-1.46911313093029e-16*a2_np_33_l110e*comp2_np_33_l110e+1.98406061545196e-16*a3_np_33_l110e*comp3_np_33_l110e+5.88789060963811e-17*a4_np_33_l110e*comp4_np_33_l110e+7.45868641820046e-17*a5_np_33_l110e*comp5_np_33_l110e)
parameters 	dwwl_p_33_l110e_g	  =	alpha_p_33_l110e*(4.91930213604762e-23*a1_np_33_l110e*comp1_np_33_l110e+3.8216452376509e-23*a2_np_33_l110e*comp2_np_33_l110e+5.19688396195953e-23*a3_np_33_l110e*comp3_np_33_l110e+-5.34529416445345e-23*a4_np_33_l110e*comp4_np_33_l110e+-3.07641137801873e-23*a5_np_33_l110e*comp5_np_33_l110e)
parameters 	dcgdl_p_33_l110e_g	  =	alpha_p_33_l110e*(-2.78050706219096e-12*a1_np_33_l110e*comp1_np_33_l110e+-1.35440895893821e-14*a2_np_33_l110e*comp2_np_33_l110e+8.43571840879572e-13*a3_np_33_l110e*comp3_np_33_l110e+-7.01223797981937e-13*a4_np_33_l110e*comp4_np_33_l110e+1.61643434130877e-13*a5_np_33_l110e*comp5_np_33_l110e)
parameters 	dcgsl_p_33_l110e_g	  =	alpha_p_33_l110e*(-2.78050706219096e-12*a1_np_33_l110e*comp1_np_33_l110e+-1.35440895893821e-14*a2_np_33_l110e*comp2_np_33_l110e+8.43571840879572e-13*a3_np_33_l110e*comp3_np_33_l110e+-7.01223797981937e-13*a4_np_33_l110e*comp4_np_33_l110e+1.61643434130877e-13*a5_np_33_l110e*comp5_np_33_l110e)
parameters 	dcgdo_p_33_l110e_g	  =	alpha_p_33_l110e*(-1.25605970703902e-12*a1_np_33_l110e*comp1_np_33_l110e+-6.11837510973421e-15*a2_np_33_l110e*comp2_np_33_l110e+3.81073155227536e-13*a3_np_33_l110e*comp3_np_33_l110e+-3.167691858218e-13*a4_np_33_l110e*comp4_np_33_l110e+1.61184516370823e-13*a5_np_33_l110e*comp5_np_33_l110e)
parameters 	dcgso_p_33_l110e_g	  =	alpha_p_33_l110e*(-1.25605970703902e-12*a1_np_33_l110e*comp1_np_33_l110e+-6.11837510973421e-15*a2_np_33_l110e*comp2_np_33_l110e+3.81073155227536e-13*a3_np_33_l110e*comp3_np_33_l110e+-3.167691858218e-13*a4_np_33_l110e*comp4_np_33_l110e+1.61184516370823e-13*a5_np_33_l110e*comp5_np_33_l110e)
parameters 	dcj_p_33_l110e_g	  =	alpha_p_33_l110e*(1.36570946210961e-05*a1_np_33_l110e*comp1_np_33_l110e+2.57813332016983e-05*a2_np_33_l110e*comp2_np_33_l110e+-2.63050275000543e-06*a3_np_33_l110e*comp3_np_33_l110e+7.18728175143541e-06*a4_np_33_l110e*comp4_np_33_l110e+-1.6266655323811e-05*a5_np_33_l110e*comp5_np_33_l110e)
parameters 	dcjsw_p_33_l110e_g	  =	alpha_p_33_l110e*(1.65040418381826e-12*a1_np_33_l110e*comp1_np_33_l110e+3.1155689669726e-12*a2_np_33_l110e*comp2_np_33_l110e+-3.17885528701564e-13*a3_np_33_l110e*comp3_np_33_l110e+8.6855368597407e-13*a4_np_33_l110e*comp4_np_33_l110e+-1.62415871278476e-12*a5_np_33_l110e*comp5_np_33_l110e)
parameters 	dcjswg_p_33_l110e_g	  =	alpha_p_33_l110e*(4.9374591832563e-12*a1_np_33_l110e*comp1_np_33_l110e+9.32074382619302e-12*a2_np_33_l110e*comp2_np_33_l110e+-9.51007540032186e-13*a3_np_33_l110e*comp3_np_33_l110e+2.59842311053925e-12*a4_np_33_l110e*comp4_np_33_l110e+-2.21165402695403e-12*a5_np_33_l110e*comp5_np_33_l110e)
