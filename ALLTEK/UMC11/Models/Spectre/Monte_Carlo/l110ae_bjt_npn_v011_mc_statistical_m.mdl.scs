simulator lang=spectre insensitive=yes
parameters mc_bf_npn_v45x45 = 0
parameters mc_is_npn_v45x45 = 0
parameters mc_bf_npn_v90x90 = 0
parameters mc_is_npn_v90x90 = 0
parameters mc_bf_npn_v135x135 = 0
parameters mc_is_npn_v135x135 = 0
statistics {
mismatch {
        vary mc_bf_npn_v45x45 dist=gauss std=1/1
        vary mc_is_npn_v45x45 dist=gauss std=1/1
        vary mc_bf_npn_v90x90 dist=gauss std=1/1
        vary mc_is_npn_v90x90 dist=gauss std=1/1
        vary mc_bf_npn_v135x135 dist=gauss std=1/1
        vary mc_is_npn_v135x135 dist=gauss std=1/1
    }
}
