simulator lang=spectre insensitive=yes
//
parameters alpha_n_50_rvtl110ae = 0.2
parameters alpha_p_50_rvtl110ae = 0.2

parameters a1_np_50_rvtl110ae_xx = 0
parameters a2_np_50_rvtl110ae_xx = 0
parameters a3_np_50_rvtl110ae_xx = 0
parameters a4_np_50_rvtl110ae_xx = 0
parameters a5_np_50_rvtl110ae_xx = 0
statistics {
process {
vary a1_np_50_rvtl110ae_xx dist=gauss std=sigma/3
vary a2_np_50_rvtl110ae_xx dist=gauss std=sigma/3
vary a3_np_50_rvtl110ae_xx dist=gauss std=sigma/3
vary a4_np_50_rvtl110ae_xx dist=gauss std=sigma/3
vary a5_np_50_rvtl110ae_xx dist=gauss std=sigma/3
 }
}
parameters a1_np_50_rvtl110ae = a1_np_50_rvtl110ae_xx
parameters a2_np_50_rvtl110ae = a2_np_50_rvtl110ae_xx
parameters a3_np_50_rvtl110ae = a3_np_50_rvtl110ae_xx
parameters a4_np_50_rvtl110ae = a4_np_50_rvtl110ae_xx
parameters a5_np_50_rvtl110ae = a5_np_50_rvtl110ae_xx
parameters comp1_np_50_rvtl110ae	= 12.0290465949883
parameters comp2_np_50_rvtl110ae	= 6.93030037535593
parameters comp3_np_50_rvtl110ae	= 2.15258181578652
parameters comp4_np_50_rvtl110ae	= 1.62461264592168
parameters comp5_np_50_rvtl110ae	= 2.30371987222692e-14
parameters 	dtox_n_50_rvtl110ae_g	  =	alpha_n_50_rvtl110ae*(-4.19496428408745e-11*a1_np_50_rvtl110ae*comp1_np_50_rvtl110ae+4.05493560405446e-13*a2_np_50_rvtl110ae*comp2_np_50_rvtl110ae+1.69296429067036e-12*a3_np_50_rvtl110ae*comp3_np_50_rvtl110ae+9.56201756202246e-12*a4_np_50_rvtl110ae*comp4_np_50_rvtl110ae+3.73394407302932e-11*a5_np_50_rvtl110ae*comp5_np_50_rvtl110ae)
parameters 	dxl_n_50_rvtl110ae_g	  =	alpha_n_50_rvtl110ae*(-1.75589365736259e-09*a1_np_50_rvtl110ae*comp1_np_50_rvtl110ae+1.64706300414142e-09*a2_np_50_rvtl110ae*comp2_np_50_rvtl110ae+2.49881943697394e-10*a3_np_50_rvtl110ae*comp3_np_50_rvtl110ae+6.98919565485774e-10*a4_np_50_rvtl110ae*comp4_np_50_rvtl110ae+5.12881480394896e-10*a5_np_50_rvtl110ae*comp5_np_50_rvtl110ae)
parameters 	dxw_n_50_rvtl110ae_g	  =	alpha_n_50_rvtl110ae*(1.86574561621351e-09*a1_np_50_rvtl110ae*comp1_np_50_rvtl110ae+-1.55846361706879e-09*a2_np_50_rvtl110ae*comp2_np_50_rvtl110ae+1.4428223117295e-09*a3_np_50_rvtl110ae*comp3_np_50_rvtl110ae+-8.93398081371119e-10*a4_np_50_rvtl110ae*comp4_np_50_rvtl110ae+1.07415818041486e-09*a5_np_50_rvtl110ae*comp5_np_50_rvtl110ae)
parameters 	dvth0_n_50_rvtl110ae_g	  =	alpha_n_50_rvtl110ae*(-3.0116083537734e-03*a1_np_50_rvtl110ae*comp1_np_50_rvtl110ae+2.7433972479095e-03*a2_np_50_rvtl110ae*comp2_np_50_rvtl110ae+8.95653702968212e-04*a3_np_50_rvtl110ae*comp3_np_50_rvtl110ae+1.12333527206354e-03*a4_np_50_rvtl110ae*comp4_np_50_rvtl110ae+6.34891941892395e-03*a5_np_50_rvtl110ae*comp5_np_50_rvtl110ae)
parameters 	dnlx_n_50_rvtl110ae_g	  =	alpha_n_50_rvtl110ae*(-5.92484538140708e-09*a1_np_50_rvtl110ae*comp1_np_50_rvtl110ae+4.81194598712793e-09*a2_np_50_rvtl110ae*comp2_np_50_rvtl110ae+-6.38356051648271e-10*a3_np_50_rvtl110ae*comp3_np_50_rvtl110ae+2.43658899603958e-09*a4_np_50_rvtl110ae*comp4_np_50_rvtl110ae+-9.94103404321941e-10*a5_np_50_rvtl110ae*comp5_np_50_rvtl110ae)
parameters 	dk3_n_50_rvtl110ae_g	  =	alpha_n_50_rvtl110ae*(-0.132750385683156*a1_np_50_rvtl110ae*comp1_np_50_rvtl110ae+0.117631996478241*a2_np_50_rvtl110ae*comp2_np_50_rvtl110ae+5.49907168812735e-02*a3_np_50_rvtl110ae*comp3_np_50_rvtl110ae+0.053310415230572*a4_np_50_rvtl110ae*comp4_np_50_rvtl110ae+-1.13189455764501e-02*a5_np_50_rvtl110ae*comp5_np_50_rvtl110ae)
parameters 	dpvth0_n_50_rvtl110ae_g	  =	alpha_n_50_rvtl110ae*(3.93145696513982e-16*a1_np_50_rvtl110ae*comp1_np_50_rvtl110ae+-4.27307130702982e-16*a2_np_50_rvtl110ae*comp2_np_50_rvtl110ae+-4.24849525657182e-17*a3_np_50_rvtl110ae*comp3_np_50_rvtl110ae+-1.65311298349384e-16*a4_np_50_rvtl110ae*comp4_np_50_rvtl110ae+1.65836437708065e-17*a5_np_50_rvtl110ae*comp5_np_50_rvtl110ae)
parameters 	du0_n_50_rvtl110ae_g	  =	alpha_n_50_rvtl110ae*(5.15272318751685e-04*a1_np_50_rvtl110ae*comp1_np_50_rvtl110ae+-4.95774974563045e-04*a2_np_50_rvtl110ae*comp2_np_50_rvtl110ae+-2.63153981058457e-05*a3_np_50_rvtl110ae*comp3_np_50_rvtl110ae+-2.07102500168106e-04*a4_np_50_rvtl110ae*comp4_np_50_rvtl110ae+-7.17462747714164e-05*a5_np_50_rvtl110ae*comp5_np_50_rvtl110ae)
parameters 	dlrdsw_n_50_rvtl110ae_g	  =	alpha_n_50_rvtl110ae*(-5.08128925538723e-06*a1_np_50_rvtl110ae*comp1_np_50_rvtl110ae+3.79389437181192e-06*a2_np_50_rvtl110ae*comp2_np_50_rvtl110ae+-6.16396895058896e-06*a3_np_50_rvtl110ae*comp3_np_50_rvtl110ae+2.51383322604363e-06*a4_np_50_rvtl110ae*comp4_np_50_rvtl110ae+-1.32668993891087e-06*a5_np_50_rvtl110ae*comp5_np_50_rvtl110ae)
parameters 	dwwl_n_50_rvtl110ae_g	  =	alpha_n_50_rvtl110ae*(-1.13210635794345e-23*a1_np_50_rvtl110ae*comp1_np_50_rvtl110ae+9.67264229558735e-23*a2_np_50_rvtl110ae*comp2_np_50_rvtl110ae+1.85551206697469e-22*a3_np_50_rvtl110ae*comp3_np_50_rvtl110ae+1.67368031855405e-23*a4_np_50_rvtl110ae*comp4_np_50_rvtl110ae+4.21391572365777e-23*a5_np_50_rvtl110ae*comp5_np_50_rvtl110ae)
parameters 	dprdsw_n_50_rvtl110ae_g	  =	alpha_n_50_rvtl110ae*(0*a1_np_50_rvtl110ae*comp1_np_50_rvtl110ae+0*a2_np_50_rvtl110ae*comp2_np_50_rvtl110ae+0*a3_np_50_rvtl110ae*comp3_np_50_rvtl110ae+0*a4_np_50_rvtl110ae*comp4_np_50_rvtl110ae+0*a5_np_50_rvtl110ae*comp5_np_50_rvtl110ae)
parameters 	dags_n_50_rvtl110ae_g	  =	alpha_n_50_rvtl110ae*(-2.84349500769022e-03*a1_np_50_rvtl110ae*comp1_np_50_rvtl110ae+2.46572493863637e-03*a2_np_50_rvtl110ae*comp2_np_50_rvtl110ae+-4.76328691144927e-04*a3_np_50_rvtl110ae*comp3_np_50_rvtl110ae+1.23289270514166e-03*a4_np_50_rvtl110ae*comp4_np_50_rvtl110ae+-5.20801397276222e-05*a5_np_50_rvtl110ae*comp5_np_50_rvtl110ae)
parameters 	dlvsat_n_50_rvtl110ae_g	  =	alpha_n_50_rvtl110ae*(8.92139863581361e-05*a1_np_50_rvtl110ae*comp1_np_50_rvtl110ae+-1.51783469594545e-04*a2_np_50_rvtl110ae*comp2_np_50_rvtl110ae+-7.44742425539742e-06*a3_np_50_rvtl110ae*comp3_np_50_rvtl110ae+-4.06673404005011e-05*a4_np_50_rvtl110ae*comp4_np_50_rvtl110ae+1.99105564461727e-05*a5_np_50_rvtl110ae*comp5_np_50_rvtl110ae)
parameters 	dwb0_n_50_rvtl110ae_g	  =	alpha_n_50_rvtl110ae*(5.56460819817805e-16*a1_np_50_rvtl110ae*comp1_np_50_rvtl110ae+-4.90165172289652e-16*a2_np_50_rvtl110ae*comp2_np_50_rvtl110ae+1.18765945595796e-16*a3_np_50_rvtl110ae*comp3_np_50_rvtl110ae+-2.54732918627053e-16*a4_np_50_rvtl110ae*comp4_np_50_rvtl110ae+1.42310174227715e-16*a5_np_50_rvtl110ae*comp5_np_50_rvtl110ae)
parameters 	dpvsat_n_50_rvtl110ae_g	  =	alpha_n_50_rvtl110ae*(6.00501099580995e-11*a1_np_50_rvtl110ae*comp1_np_50_rvtl110ae+-3.09953691401833e-11*a2_np_50_rvtl110ae*comp2_np_50_rvtl110ae+4.7191919482977e-11*a3_np_50_rvtl110ae*comp3_np_50_rvtl110ae+-2.68749167841023e-11*a4_np_50_rvtl110ae*comp4_np_50_rvtl110ae+2.17626880530101e-11*a5_np_50_rvtl110ae*comp5_np_50_rvtl110ae)
parameters 	dleta0_n_50_rvtl110ae_g	  =	alpha_n_50_rvtl110ae*(-1.43385688527335e-10*a1_np_50_rvtl110ae*comp1_np_50_rvtl110ae+1.27714192103386e-10*a2_np_50_rvtl110ae*comp2_np_50_rvtl110ae+-1.3835583869723e-10*a3_np_50_rvtl110ae*comp3_np_50_rvtl110ae+-2.69761827012338e-10*a4_np_50_rvtl110ae*comp4_np_50_rvtl110ae+-9.85973425063487e-11*a5_np_50_rvtl110ae*comp5_np_50_rvtl110ae)
parameters 	dpeta0_n_50_rvtl110ae_g	  =	alpha_n_50_rvtl110ae*(5.64062639167122e-17*a1_np_50_rvtl110ae*comp1_np_50_rvtl110ae+-1.51000757464034e-17*a2_np_50_rvtl110ae*comp2_np_50_rvtl110ae+9.75504779628286e-17*a3_np_50_rvtl110ae*comp3_np_50_rvtl110ae+8.93829680584792e-17*a4_np_50_rvtl110ae*comp4_np_50_rvtl110ae+1.67625127456937e-17*a5_np_50_rvtl110ae*comp5_np_50_rvtl110ae)
parameters 	dcj_n_50_rvtl110ae_g	  =	alpha_n_50_rvtl110ae*(-8.91234148080377e-06*a1_np_50_rvtl110ae*comp1_np_50_rvtl110ae+1.56514721424637e-05*a2_np_50_rvtl110ae*comp2_np_50_rvtl110ae+2.06908584183064e-06*a3_np_50_rvtl110ae*comp3_np_50_rvtl110ae+4.88350790298399e-06*a4_np_50_rvtl110ae*comp4_np_50_rvtl110ae+4.17392972463959e-06*a5_np_50_rvtl110ae*comp5_np_50_rvtl110ae)
parameters 	dcjsw_n_50_rvtl110ae_g	  =	alpha_n_50_rvtl110ae*(-1.1246887272542e-12*a1_np_50_rvtl110ae*comp1_np_50_rvtl110ae+1.97513014076907e-12*a2_np_50_rvtl110ae*comp2_np_50_rvtl110ae+2.61107311365982e-13*a3_np_50_rvtl110ae*comp3_np_50_rvtl110ae+6.1627197519002e-13*a4_np_50_rvtl110ae*comp4_np_50_rvtl110ae+-8.05039525272595e-13*a5_np_50_rvtl110ae*comp5_np_50_rvtl110ae)
parameters 	dcjswg_n_50_rvtl110ae_g	  =	alpha_n_50_rvtl110ae*(-2.05104023082249e-12*a1_np_50_rvtl110ae*comp1_np_50_rvtl110ae+3.60194894965979e-12*a2_np_50_rvtl110ae*comp2_np_50_rvtl110ae+4.76168727574066e-13*a3_np_50_rvtl110ae*comp3_np_50_rvtl110ae+1.12386528255607e-12*a4_np_50_rvtl110ae*comp4_np_50_rvtl110ae+-4.59205736790757e-13*a5_np_50_rvtl110ae*comp5_np_50_rvtl110ae)
parameters 	dcgdo_n_50_rvtl110ae_g	  =	alpha_n_50_rvtl110ae*(5.0527581012818e-13*a1_np_50_rvtl110ae*comp1_np_50_rvtl110ae+-4.88409610572378e-15*a2_np_50_rvtl110ae*comp2_np_50_rvtl110ae+-2.03914466383218e-14*a3_np_50_rvtl110ae*comp3_np_50_rvtl110ae+-1.15172760550971e-13*a4_np_50_rvtl110ae*comp4_np_50_rvtl110ae+-3.34167942446661e-15*a5_np_50_rvtl110ae*comp5_np_50_rvtl110ae)
parameters 	dcgso_n_50_rvtl110ae_g	  =	alpha_n_50_rvtl110ae*(5.0527581012818e-13*a1_np_50_rvtl110ae*comp1_np_50_rvtl110ae+-4.88409610572378e-15*a2_np_50_rvtl110ae*comp2_np_50_rvtl110ae+-2.03914466383218e-14*a3_np_50_rvtl110ae*comp3_np_50_rvtl110ae+-1.15172760550971e-13*a4_np_50_rvtl110ae*comp4_np_50_rvtl110ae+-3.34167942446661e-15*a5_np_50_rvtl110ae*comp5_np_50_rvtl110ae)
parameters 	dcgdl_n_50_rvtl110ae_g	  =	alpha_n_50_rvtl110ae*(1.17506002355391e-12*a1_np_50_rvtl110ae*comp1_np_50_rvtl110ae+-1.13583630365669e-14*a2_np_50_rvtl110ae*comp2_np_50_rvtl110ae+-4.74219689263267e-14*a3_np_50_rvtl110ae*comp3_np_50_rvtl110ae+-2.67843629188303e-13*a4_np_50_rvtl110ae*comp4_np_50_rvtl110ae+2.38281989148499e-13*a5_np_50_rvtl110ae*comp5_np_50_rvtl110ae)
parameters 	dcgsl_n_50_rvtl110ae_g	  =	alpha_n_50_rvtl110ae*(1.17506002355391e-12*a1_np_50_rvtl110ae*comp1_np_50_rvtl110ae+-1.13583630365669e-14*a2_np_50_rvtl110ae*comp2_np_50_rvtl110ae+-4.74219689263267e-14*a3_np_50_rvtl110ae*comp3_np_50_rvtl110ae+-2.67843629188303e-13*a4_np_50_rvtl110ae*comp4_np_50_rvtl110ae+2.38281989148499e-13*a5_np_50_rvtl110ae*comp5_np_50_rvtl110ae)
parameters 	djtsswgd_n_50_rvtl110ae_g	  =	alpha_n_50_rvtl110ae*(2.19747696774456e-08*a1_np_50_rvtl110ae*comp1_np_50_rvtl110ae+-3.74058536565239e-08*a2_np_50_rvtl110ae*comp2_np_50_rvtl110ae+-3.10823823798703e-08*a3_np_50_rvtl110ae*comp3_np_50_rvtl110ae+4.89054840195806e-08*a4_np_50_rvtl110ae*comp4_np_50_rvtl110ae+-6.38783776154064e-09*a5_np_50_rvtl110ae*comp5_np_50_rvtl110ae)
parameters 	djtsswgs_n_50_rvtl110ae_g	  =	alpha_n_50_rvtl110ae*(2.19747696774456e-08*a1_np_50_rvtl110ae*comp1_np_50_rvtl110ae+-3.74058536565239e-08*a2_np_50_rvtl110ae*comp2_np_50_rvtl110ae+-3.10823823798703e-08*a3_np_50_rvtl110ae*comp3_np_50_rvtl110ae+4.89054840195806e-08*a4_np_50_rvtl110ae*comp4_np_50_rvtl110ae+-6.38783776154064e-09*a5_np_50_rvtl110ae*comp5_np_50_rvtl110ae)
parameters 	dtox_p_50_rvtl110ae_g	  =	alpha_p_50_rvtl110ae*(-4.37122328762053e-11*a1_np_50_rvtl110ae*comp1_np_50_rvtl110ae+4.22531104960286e-13*a2_np_50_rvtl110ae*comp2_np_50_rvtl110ae+1.76409724405948e-12*a3_np_50_rvtl110ae*comp3_np_50_rvtl110ae+9.96378300580491e-12*a4_np_50_rvtl110ae*comp4_np_50_rvtl110ae+4.94016159564561e-13*a5_np_50_rvtl110ae*comp5_np_50_rvtl110ae)
parameters 	dxl_p_50_rvtl110ae_g	  =	alpha_p_50_rvtl110ae*(-2.35849051956815e-09*a1_np_50_rvtl110ae*comp1_np_50_rvtl110ae+-2.01481509841009e-09*a2_np_50_rvtl110ae*comp2_np_50_rvtl110ae+-1.28592300032195e-10*a3_np_50_rvtl110ae*comp3_np_50_rvtl110ae+1.64244606247467e-10*a4_np_50_rvtl110ae*comp4_np_50_rvtl110ae+7.07143650079349e-10*a5_np_50_rvtl110ae*comp5_np_50_rvtl110ae)
parameters 	dxw_p_50_rvtl110ae_g	  =	alpha_p_50_rvtl110ae*(7.75422306820457e-11*a1_np_50_rvtl110ae*comp1_np_50_rvtl110ae+6.57758559274916e-11*a2_np_50_rvtl110ae*comp2_np_50_rvtl110ae+3.81796591144456e-11*a3_np_50_rvtl110ae*comp3_np_50_rvtl110ae+-5.16496913356365e-11*a4_np_50_rvtl110ae*comp4_np_50_rvtl110ae+6.12457931004636e-11*a5_np_50_rvtl110ae*comp5_np_50_rvtl110ae)
parameters 	dvth0_p_50_rvtl110ae_g	  =	alpha_p_50_rvtl110ae*(4.88884779343077e-03*a1_np_50_rvtl110ae*comp1_np_50_rvtl110ae+4.2234318585471e-03*a2_np_50_rvtl110ae*comp2_np_50_rvtl110ae+1.28429482357995e-04*a3_np_50_rvtl110ae*comp3_np_50_rvtl110ae+-2.33949804717339e-04*a4_np_50_rvtl110ae*comp4_np_50_rvtl110ae+-7.39909365401154e-04*a5_np_50_rvtl110ae*comp5_np_50_rvtl110ae)
parameters 	dlvth0_p_50_rvtl110ae_g	  =	alpha_p_50_rvtl110ae*(1.57422381260898e-09*a1_np_50_rvtl110ae*comp1_np_50_rvtl110ae+1.31905303533917e-09*a2_np_50_rvtl110ae*comp2_np_50_rvtl110ae+3.56694079074061e-10*a3_np_50_rvtl110ae*comp3_np_50_rvtl110ae+-1.96116543226646e-10*a4_np_50_rvtl110ae*comp4_np_50_rvtl110ae+-1.73242372002001e-10*a5_np_50_rvtl110ae*comp5_np_50_rvtl110ae)
parameters 	dk3_p_50_rvtl110ae_g	  =	alpha_p_50_rvtl110ae*(-0.038210816931207*a1_np_50_rvtl110ae*comp1_np_50_rvtl110ae+-3.83472158912605e-02*a2_np_50_rvtl110ae*comp2_np_50_rvtl110ae+2.61868145059666e-02*a3_np_50_rvtl110ae*comp3_np_50_rvtl110ae+4.86983532052485e-03*a4_np_50_rvtl110ae*comp4_np_50_rvtl110ae+9.16633099254187e-03*a5_np_50_rvtl110ae*comp5_np_50_rvtl110ae)
parameters 	dpvth0_p_50_rvtl110ae_g	  =	alpha_p_50_rvtl110ae*(6.28335096136959e-17*a1_np_50_rvtl110ae*comp1_np_50_rvtl110ae+7.57474366222144e-17*a2_np_50_rvtl110ae*comp2_np_50_rvtl110ae+-2.62914296046163e-16*a3_np_50_rvtl110ae*comp3_np_50_rvtl110ae+3.51879008066606e-17*a4_np_50_rvtl110ae*comp4_np_50_rvtl110ae+-9.62163048003524e-17*a5_np_50_rvtl110ae*comp5_np_50_rvtl110ae)
parameters 	du0_p_50_rvtl110ae_g	  =	alpha_p_50_rvtl110ae*(9.36966378020017e-05*a1_np_50_rvtl110ae*comp1_np_50_rvtl110ae+9.5935981844816e-05*a2_np_50_rvtl110ae*comp2_np_50_rvtl110ae+1.88099545307179e-05*a3_np_50_rvtl110ae*comp3_np_50_rvtl110ae+-3.721397965447e-06*a4_np_50_rvtl110ae*comp4_np_50_rvtl110ae+-4.72968159901345e-05*a5_np_50_rvtl110ae*comp5_np_50_rvtl110ae)
parameters 	drdsw_p_50_rvtl110ae_g	  =	alpha_p_50_rvtl110ae*(-42.5887344998325*a1_np_50_rvtl110ae*comp1_np_50_rvtl110ae+-34.0964746712414*a2_np_50_rvtl110ae*comp2_np_50_rvtl110ae+-53.5041837297155*a3_np_50_rvtl110ae*comp3_np_50_rvtl110ae+9.53679075394076*a4_np_50_rvtl110ae*comp4_np_50_rvtl110ae+-5.27028546682334*a5_np_50_rvtl110ae*comp5_np_50_rvtl110ae)
parameters 	dpu0_p_50_rvtl110ae_g	  =	alpha_p_50_rvtl110ae*(2.23622063720769e-17*a1_np_50_rvtl110ae*comp1_np_50_rvtl110ae+1.83570065169174e-17*a2_np_50_rvtl110ae*comp2_np_50_rvtl110ae+7.56984602985427e-18*a3_np_50_rvtl110ae*comp3_np_50_rvtl110ae+-2.1413208681603e-18*a4_np_50_rvtl110ae*comp4_np_50_rvtl110ae+-4.38193228821384e-18*a5_np_50_rvtl110ae*comp5_np_50_rvtl110ae)
parameters 	dags_p_50_rvtl110ae_g	  =	alpha_p_50_rvtl110ae*(-7.75521295443572e-04*a1_np_50_rvtl110ae*comp1_np_50_rvtl110ae+-6.74055299697805e-04*a2_np_50_rvtl110ae*comp2_np_50_rvtl110ae+-4.8968310592913e-05*a3_np_50_rvtl110ae*comp3_np_50_rvtl110ae+4.44558507284653e-05*a4_np_50_rvtl110ae*comp4_np_50_rvtl110ae+7.21622872937034e-05*a5_np_50_rvtl110ae*comp5_np_50_rvtl110ae)
parameters 	dvsat_p_50_rvtl110ae_g	  =	alpha_p_50_rvtl110ae*(269.540901275133*a1_np_50_rvtl110ae*comp1_np_50_rvtl110ae+394.699953409762*a2_np_50_rvtl110ae*comp2_np_50_rvtl110ae+472.458059866107*a3_np_50_rvtl110ae*comp3_np_50_rvtl110ae+-44.1160699396648*a4_np_50_rvtl110ae*comp4_np_50_rvtl110ae+8.86809771275069*a5_np_50_rvtl110ae*comp5_np_50_rvtl110ae)
parameters 	dwags_p_50_rvtl110ae_g	  =	alpha_p_50_rvtl110ae*(-1.18947393275567e-11*a1_np_50_rvtl110ae*comp1_np_50_rvtl110ae+-1.06199685363926e-11*a2_np_50_rvtl110ae*comp2_np_50_rvtl110ae+2.61111048709562e-11*a3_np_50_rvtl110ae*comp3_np_50_rvtl110ae+-2.32861369077093e-12*a4_np_50_rvtl110ae*comp4_np_50_rvtl110ae+-7.26069301998906e-11*a5_np_50_rvtl110ae*comp5_np_50_rvtl110ae)
parameters 	dpvsat_p_50_rvtl110ae_g	  =	alpha_p_50_rvtl110ae*(9.60136211469093e-11*a1_np_50_rvtl110ae*comp1_np_50_rvtl110ae+7.49758318749403e-11*a2_np_50_rvtl110ae*comp2_np_50_rvtl110ae+5.05490690384639e-11*a3_np_50_rvtl110ae*comp3_np_50_rvtl110ae+-1.0723559771236e-11*a4_np_50_rvtl110ae*comp4_np_50_rvtl110ae+-5.59344620051116e-11*a5_np_50_rvtl110ae*comp5_np_50_rvtl110ae)
parameters 	djtsswgd_p_50_rvtl110ae_g	  =	alpha_p_50_rvtl110ae*(4.69689751585422e-07*a1_np_50_rvtl110ae*comp1_np_50_rvtl110ae+7.85604758479707e-07*a2_np_50_rvtl110ae*comp2_np_50_rvtl110ae+-6.57284861429415e-07*a3_np_50_rvtl110ae*comp3_np_50_rvtl110ae+1.66441410478266e-06*a4_np_50_rvtl110ae*comp4_np_50_rvtl110ae+-3.85257983259853e-07*a5_np_50_rvtl110ae*comp5_np_50_rvtl110ae)
parameters 	djtsswgs_p_50_rvtl110ae_g	  =	alpha_p_50_rvtl110ae*(4.69689751585422e-07*a1_np_50_rvtl110ae*comp1_np_50_rvtl110ae+7.85604758479707e-07*a2_np_50_rvtl110ae*comp2_np_50_rvtl110ae+-6.57284861429415e-07*a3_np_50_rvtl110ae*comp3_np_50_rvtl110ae+1.66441410478266e-06*a4_np_50_rvtl110ae*comp4_np_50_rvtl110ae+-3.85257983259853e-07*a5_np_50_rvtl110ae*comp5_np_50_rvtl110ae)
parameters 	dwu0_p_50_rvtl110ae_g	  =	alpha_p_50_rvtl110ae*(2.10540890287654e-11*a1_np_50_rvtl110ae*comp1_np_50_rvtl110ae+1.79281677888528e-11*a2_np_50_rvtl110ae*comp2_np_50_rvtl110ae+4.39092718712665e-12*a3_np_50_rvtl110ae*comp3_np_50_rvtl110ae+-1.19434258949496e-12*a4_np_50_rvtl110ae*comp4_np_50_rvtl110ae+-2.40286944551363e-12*a5_np_50_rvtl110ae*comp5_np_50_rvtl110ae)
parameters 	deta0_p_50_rvtl110ae_g	  =	alpha_p_50_rvtl110ae*(-5.93830504275157e-07*a1_np_50_rvtl110ae*comp1_np_50_rvtl110ae+-3.22723064255594e-05*a2_np_50_rvtl110ae*comp2_np_50_rvtl110ae+3.76054846067684e-05*a3_np_50_rvtl110ae*comp3_np_50_rvtl110ae+7.75806892009478e-05*a4_np_50_rvtl110ae*comp4_np_50_rvtl110ae+9.37204419319273e-06*a5_np_50_rvtl110ae*comp5_np_50_rvtl110ae)
parameters 	dcj_p_50_rvtl110ae_g	  =	alpha_p_50_rvtl110ae*(-1.13585659007447e-05*a1_np_50_rvtl110ae*comp1_np_50_rvtl110ae+-1.9447212882965e-05*a2_np_50_rvtl110ae*comp2_np_50_rvtl110ae+-1.68938495346393e-06*a3_np_50_rvtl110ae*comp3_np_50_rvtl110ae+-9.94343422186149e-07*a4_np_50_rvtl110ae*comp4_np_50_rvtl110ae+2.69630495560915e-06*a5_np_50_rvtl110ae*comp5_np_50_rvtl110ae)
parameters 	dcjsw_p_50_rvtl110ae_g	  =	alpha_p_50_rvtl110ae*(-8.69348042372065e-13*a1_np_50_rvtl110ae*comp1_np_50_rvtl110ae+-1.48842702477871e-12*a2_np_50_rvtl110ae*comp2_np_50_rvtl110ae+-1.29300081976933e-13*a3_np_50_rvtl110ae*comp3_np_50_rvtl110ae+-7.61038422523384e-14*a4_np_50_rvtl110ae*comp4_np_50_rvtl110ae+2.0636649514383e-13*a5_np_50_rvtl110ae*comp5_np_50_rvtl110ae)
parameters 	dcjswg_p_50_rvtl110ae_g	  =	alpha_p_50_rvtl110ae*(-2.31952377218792e-12*a1_np_50_rvtl110ae*comp1_np_50_rvtl110ae+-3.97129998443544e-12*a2_np_50_rvtl110ae*comp2_np_50_rvtl110ae+-3.44987967158714e-13*a3_np_50_rvtl110ae*comp3_np_50_rvtl110ae+-2.03054084964034e-13*a4_np_50_rvtl110ae*comp4_np_50_rvtl110ae+1.97064754254473e-12*a5_np_50_rvtl110ae*comp5_np_50_rvtl110ae)
parameters 	dcgdo_p_50_rvtl110ae_g	  =	alpha_p_50_rvtl110ae*(3.33376279282479e-13*a1_np_50_rvtl110ae*comp1_np_50_rvtl110ae+-3.22248117710441e-15*a2_np_50_rvtl110ae*comp2_np_50_rvtl110ae+-1.34540868040898e-14*a3_np_50_rvtl110ae*comp3_np_50_rvtl110ae+-7.59899160370138e-14*a4_np_50_rvtl110ae*comp4_np_50_rvtl110ae+-6.26354350306827e-14*a5_np_50_rvtl110ae*comp5_np_50_rvtl110ae)
parameters 	dcgso_p_50_rvtl110ae_g	  =	alpha_p_50_rvtl110ae*(3.33376279282479e-13*a1_np_50_rvtl110ae*comp1_np_50_rvtl110ae+-3.22248117710441e-15*a2_np_50_rvtl110ae*comp2_np_50_rvtl110ae+-1.34540868040898e-14*a3_np_50_rvtl110ae*comp3_np_50_rvtl110ae+-7.59899160370138e-14*a4_np_50_rvtl110ae*comp4_np_50_rvtl110ae+-6.26354350306827e-14*a5_np_50_rvtl110ae*comp5_np_50_rvtl110ae)
parameters 	dcgdl_p_50_rvtl110ae_g	  =	alpha_p_50_rvtl110ae*(1.38198809370175e-12*a1_np_50_rvtl110ae*comp1_np_50_rvtl110ae+-1.33585707673064e-14*a2_np_50_rvtl110ae*comp2_np_50_rvtl110ae+-5.57729776542596e-14*a3_np_50_rvtl110ae*comp3_np_50_rvtl110ae+-3.15010892288365e-13*a4_np_50_rvtl110ae*comp4_np_50_rvtl110ae+-2.59650823515512e-13*a5_np_50_rvtl110ae*comp5_np_50_rvtl110ae)
parameters 	dcgsl_p_50_rvtl110ae_g	  =	alpha_p_50_rvtl110ae*(1.38198809370175e-12*a1_np_50_rvtl110ae*comp1_np_50_rvtl110ae+-1.33585707673064e-14*a2_np_50_rvtl110ae*comp2_np_50_rvtl110ae+-5.57729776542596e-14*a3_np_50_rvtl110ae*comp3_np_50_rvtl110ae+-3.15010892288365e-13*a4_np_50_rvtl110ae*comp4_np_50_rvtl110ae+-2.59650823515512e-13*a5_np_50_rvtl110ae*comp5_np_50_rvtl110ae)
