//
simulator lang=spectre insensitive=yes
inline subckt pcap_12 ( port1 port2 )
parameters wf=1u          lf=1u                     nf=2
+ mf=1                    nrd=hdif/(wf*0.9)         nrs=hdif/(wf*0.9)
+ ad=2*hdif*(wf*0.9)      as=2*hdif*(wf*0.9)        pd=2*(2*hdif+(wf*0.9))
+ ps=2*(2*hdif+(wf*0.9))  dtemp=0                   sa=2u
+ sb=2u                   mis_flag=1                hdif=1.25e-07
+ toxc=3.0e-09+dtoxe_pcap_12                        pva=0.12994935
+ pvb=-1.4910196+tpvb*(temp-25)                     pvc=-0.38905731+tpvc*(temp-25)
+ pvd=4.6039149           pve=0.68592355            pvf=-1.0891352
+ pvg=-0.42168328         pvh=1.3371982             pvi=0.13187879
+ pvj=0.10195103          tpvb=0.000                tpvc=-0e-05
+ dcw=3.691e-2+dxw_pcap_12                          cww=-4.267e-3
+ cwl=3.562e-4            cwwl=-7.321e-4            dcl=-3.659e-2+dxl_pcap_12
+ cll=2.073e-4            clw=-7.684e-4             clwl=1.478e-5
+ weff=(wf*0.9*1e6)+dcw+cww/(wf*0.9*1e6)+cwl/(lf*0.9*1e6+0.012)+cwwl/(wf*0.9*1e6)/(lf*0.9*1e6+0.012)
+ leff=(lf*0.9*1e6+0.012)+dcl+cll/(lf*0.9*1e6+0.012)+clw/(wf*0.9*1e6)+clwl/(wf*0.9*1e6)/(lf*0.9*1e6+0.012)
+ cl3=2.806e-6            cl2=-1.218e-4             cl1=8.638e-5
+ cl0=2.865e-4            cw0=-4.218e-6             cwl0=5.153e-2
+ ccom=(((cl3*pow((lf*0.9*1e6+0.012),3)+cl2*pow((lf*0.9*1e6+0.012),2)+cl1*(lf*0.9*1e6+0.012)+cl0)*((wf*0.9*1e6)+dcw)+cw0/(wf*0.9*1e6))*(1+cwl0/((wf*0.9*1e6)*(lf*0.9*1e6+0.012))))
+ cotn=10/1.414           potn=-0.84                rsh=8.5
+ tcig=1+1.55e-3*(temp+dtemp-25)                  area=wf*0.9*(lf*0.9+0.012u)*nf*1e4*tcig
+ toxg=(3e-09+dtoxe_pcap_12)*1e2                    vdf0=2.630
+ vdfl=-5e-09             vdfw=1.025e-09            vaf0=0.2192
+ vafl=-150e-12           vafw=20.0e-12             vdr0=4.395
+ vdrl=32e-09             vdrw=168e-09              var0=0.1357
+ varl=-449.5e-12         varw=2.4e-12              vdf=(vdf0+vdfl/(lf*0.9+0.012u)+vdfw/(wf*0.9))*2.6e7*toxg
+ vaf=(vaf0+vafl/(lf*0.9+0.012u)+vafw/(wf*0.9))*2.6e7*toxg
+ vdr=(vdr0+vdrl/(lf*0.9+0.012u)+vdrw/(wf*0.9))*2.6e7*toxg
+ var=(var0+varl/(lf*0.9+0.012u)+varw/(wf*0.9))*2.6e7*toxg
+ igf=2.1e-7*area*exp(-vdf)*pow(1/toxg,2.0)         igr=2.1e-7*area/(lf*0.9+0.012u)*exp(-vdr)*pow(1/toxg,2.0)
//  ****************
//  ** MISMATCH ****
//  ****************
pcap_12 ( port1 port2 ) bsource c=((((pva+pvc*pow(v(port1,port2),1)+pve*pow(v(port1,port2),2)
+ +pvg*pow(v(port1,port2),3)+pvi*pow(v(port1,port2),4))/(1+pvb*pow(v(port1,port2),1)
+ +pvd*pow(v(port1,port2),2)+pvf*pow(v(port1,port2),3)+pvh*pow(v(port1,port2),4)
+ +pvj*pow(v(port1,port2),5)))/4.5/1.812/2*weff*leff+ccom)*3.0e-09
+ /toxc*nf*1e-12*(1+dcmina_pcap_12*(-0.017194-0.030593*pow(v(port1,port2),1)
+ -0.043599*pow(v(port1,port2),2)-0.047529*pow(v(port1,port2),3)-0.0188403
+ *pow(v(port1,port2),4))/(1-1.624097*pow(v(port1,port2),1)+4.577238*
+  pow(v(port1,port2),2)-1.6464057*pow(v(port1,port2),3)+1.0531567*pow(v(port1,port2),4))))
+ *(1+mc_pcap_12_ma*mis_flag*0.01*((0.0107*exp(0.8386*v(port1,port2)))
+ +cotn*(1e+15*((((pva+pvc*pow(v(port1,port2),1)+pve*pow(v(port1,port2),2)
+ +pvg*pow(v(port1,port2),3)+pvi*pow(v(port1,port2),4))/(1+pvb*pow(v(port1,port2),1)
+ +pvd*pow(v(port1,port2),2)+pvf*pow(v(port1,port2),3)+pvh*pow(v(port1,port2),4)
+ +pvj*pow(v(port1,port2),5)))/4.5/1.812/2*weff*leff+ccom)*3.0e-09
+ /toxc*nf*1e-12*(1+dcmina_pcap_12*(-0.017194-0.030593*pow(v(port1,port2),1)
+ -0.043599*pow(v(port1,port2),2)-0.047529*pow(v(port1,port2),3)-0.0188403
+ *pow(v(port1,port2),4))/(1-1.624097*pow(v(port1,port2),1)+4.577238*
+  pow(v(port1,port2),2)-1.6464057*pow(v(port1,port2),3)+1.0531567*pow(v(port1,port2),4))))
+ *mf) ** potn))

gigcd ( port2 port1 ) bsource i =igf*pow((abs(v(port2,port1))+v(port2,port1))
+ /2,vaf)-igr*pow((abs(v(port2,port1))-v(port2,port1))/2,var)
gigcs ( port2 port1 ) bsource i =igf*pow((abs(v(port2,port1))+v(port2,port1))
+ /2,vaf)-igr*pow((abs(v(port2,port1))-v(port2,port1))/2,var)

ends pcap_12
