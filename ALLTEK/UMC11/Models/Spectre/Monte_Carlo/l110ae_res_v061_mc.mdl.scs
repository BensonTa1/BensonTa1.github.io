//****************************************************************************************************************
//*             non-salicide n+poly resistor subcircuit netlist for typical case                                *
//****************************************************************************************************************
//*  process: 0.11 um logic and mixed-mode metal metal capacitor al enhancement process resistor model
//*  non-salicide n+poly resistor  is copied from l110eal_res_vt11
//* temperature range: -55c ~ 135c ; nominal temperature  =  25c.
//*
simulator lang=spectre insensitive=yes
inline subckt rnnpo_l110e ( n1 n2 well )
parameters w  =  1.00e-05  l  =  1.00e-05 mis_flag=1 mf=1
parameters arnnpo = 5.780e-02
parameters dr_ma_nnpo_xx = arnnpo/sqrt(2*w*0.9*l*0.9*mf*1e12)
parameters pr_ma_nnpo = dr_ma_nnpo_xx * mc_res_ma_nnpo  * mis_flag

parameters rend  =  1.5e-5+drend_rnnpo_l110e rs  =  113+drs_rnnpo_l110e dw  =  -7.05e-8+ddw_rnnpo_l110e
parameters vcr1  =  0   vcr2  =  -0.0258e-12  tc1  =  1.6e-4  tc2  =  2.81e-7
parameters tcoef   =  1.0+tc1*(temp-25.0)+tc2*pow((temp-25.0),2)
+ca     =   1.1524e-04

parameters jmax=5.0e-4
parameters i1=jmax*w*1e6
parameters r=((2*rend/(w*0.9+dw))+(rs*l*0.9/(w*0.9+dw)))
parameters vmax=i1*r

c1 ( n1 well ) capacitor c=ca*(w*0.9+dw)*l*0.9/2 m=1
rnnpo_l110e ( n1 n2 ) res2 r=((2*rend/(w*0.9+dw))+(rs*l*0.9/(w*0.9+dw)))*((1.0+(vcr1*v(n1,n2)/(l*0.9)))+((vcr2*pow((v(n1,n2))/(l*0.9),2))))*tcoef*(1+pr_ma_nnpo) bv_max=vmax m=1
//****************************************************************************************************************
model res2 resistor
+ w=w l=l
+kf=1.37e-022   af=1.95000e+000 fexp=9.35e-001 wdexp=0.95500e+000 ldexp=1.0100e+000

c2 ( n2 well ) capacitor c=ca*(w*0.9+dw)*l*0.9/2 m=1

ends rnnpo_l110e
//*
//*
//****************************************************************************************************************
//*             non-salicide p+poly resistor subcircuit netlist for typical case                                *
//****************************************************************************************************************
//*  process: 0.11 um logic and mixed-mode metal metal capacitor al enhancement process resistor model
//*  non-salicide p+poly resistor  is copied from l110eal_res_vt11
//*  temperature range: -55c ~ 135c ; nominal temperature  =  25c.
//*
inline subckt rnppo_l110e ( n1 n2 well )
parameters w  =  1.00e-05  l  =  1.00e-05 mis_flag=1  mf=1
parameters arnppo = 1.220e-02
parameters dr_ma_nppo_xx = arnppo/sqrt(2*w*0.9*l*0.9*mf*1e12)
parameters pr_ma_nppo = dr_ma_nppo_xx * mc_res_ma_nppo  * mis_flag

parameters rend  =  3.65e-5+drend_rnppo_l110e rs  =  239+drs_rnppo_l110e dw  =  -4.05e-8+ddw_rnppo_l110e
parameters vcr1  =  0   vcr2  =  0.0586e-12  tc1  =  9.67e-5  tc2  =  5.60e-7
parameters tcoef   =  1.0+tc1*(temp-25.0)+tc2*pow((temp-25.0),2)
+ca     =   1.1524e-04

parameters jmax=5.0e-4
parameters i1=jmax*w*1e6
parameters r=((2*rend/(w*0.9+dw))+(rs*l*0.9/(w*0.9+dw)))
parameters vmax=i1*r

c1 ( n1 well ) capacitor c=ca*(w*0.9+dw)*l*0.9/2 m=1
rnppo_l110e ( n1 n2 ) res2 r=((2*rend/(w*0.9+dw))+(rs*l*0.9/(w*0.9+dw)))*((1.0+(vcr1*v(n1,n2)/(l*0.9)))+((vcr2*pow((v(n1,n2))/(l*0.9),2))))*tcoef*(1+pr_ma_nppo) bv_max=vmax m=1
//****************************************************************************************************************
model res2 resistor
+ w=w l=l
+kf=3.25e-023   af=1.95000e+000 fexp=9.3000e-001 wdexp=0.96500e+000 ldexp=1.0100e+000

c2 ( n2 well ) capacitor c=ca*(w*0.9+dw)*l*0.9/2 m=1

ends rnppo_l110e
//*
//*
//****************************************************************************************************************
//*             non-salicide n+diffusion resistor subcircuit netlist for typical case                                *
//****************************************************************************************************************
//*  process: 0.11 um logic and mixed-mode metal metal capacitor al enhancement process resistor model
//*  non-salicide n+diffusion resistor  is copied from l110eal_res_vt11
//*  temperature range: -55c ~ 135c ; nominal temperature  =  25c.
//*
inline subckt rnnd_l110e ( n1 n2 pw )
parameters w=1.00e-05  l=1.00e-05 mis_flag=1  mf=1
parameters arnnd = 2.870e-02
parameters dr_ma_nnd_xx = arnnd/sqrt(2*w*0.9*l*0.9*mf*1e12)
parameters pr_ma_nnd = dr_ma_nnd_xx * mc_res_ma_nnd  * mis_flag

parameters rend  =  1.34e-5+drend_rnnd_l110e rs  =  95+drs_rnnd_l110e dw  =  -1.7e-8+ddw_rnnd_l110e
parameters vcr1  =  0   vcr2  =  0.0146  tc1  =  1.41e-3  tc2  =  4.35e-7
parameters tcoef   =  1.0+tc1*(temp-25.0)+tc2*pow((temp-25.0),2)
parameters tc11=6032.8*((w*0.9+dw)*l*0.9/2)+2e-7

parameters jmax=1.0e-3
parameters i1=jmax*w*1e6
parameters r=((2*rend/(w*0.9+dw))+(rs*l*0.9/(w*0.9+dw)))
parameters vmax=i1*r

r3 ( pw n3 ) resistor r=(8.2+2e-12/((w*0.9+dw)*l*0.9/2))  tc1=tc11 m=1
d3 ( n3 n1 ) dion_l110e area=(w+dw)*l/2 perim=(w+dw)+l m=1
rnnd_l110e ( n1 n2 ) bsource r=((2*rend/(w*0.9+dw))+(rs*l*0.9/(w*0.9+dw)))*(1.0+vcr1*v(n1,n2)+vcr2*pow((v(n1,n2)),2))*tcoef*(1+pr_ma_nnd) bv_max=vmax m=1
d2 ( n4 n2 ) dion_l110e area=(w+dw)*l/2 perim=(w+dw)+l m=1
r2 ( pw n4 ) resistor r=(8.2+2e-12/((w*0.9+dw)*l*0.9/2))  tc1=tc11 m=1

model dion_l110e diode level = 3
+ hcomp=1.0000e+00 imax=1.00e+14
//**************************************************************
//*               GENERAL PARAMETERS
//**************************************************************
+area    = 3.6e-008        perim      = 0.00076         tnom    = 25
//**************************************************************
//*               DC PARAMETERS
//**************************************************************
+is      = 8.81e-008            isw     = 9.61e-014             ik      = 1.4945e7          bv      = 13.36
+ibv     = 27.778          ikr     = 2780            n       = 1.008                   rs      =0
//**************************************************************
//*               CAPACITANCE PARAMETERS
//**************************************************************
+cjo      = 0.00072  cjp     = 9.94e-011  vj      = 0.56            vjsw     = 0.54
+mj      = 0.258           mjsw    = 0.13
//**************************************************************
//*               NOISE PARAMETERS
//**************************************************************
//**************************************************************
//*               TEMPERATURE PARAMETERS
//**************************************************************
+tlev    = 1               tlevc   = 1               trs     =0               tbv1     = -0.000684
+xti     = 3               cta     = 0.0009555       ctp     = 0.00073248      eg      = 1.16
+pta     = 0.001632        ptp    = 0.00031

ends rnnd_l110e
//*
//*
//****************************************************************************************************************
//*             non-salicide p+diffusion resistor subcircuit netlist for typical case                                *
//****************************************************************************************************************
//*  process: 0.11 um logic and mixed-mode metal metal capacitor al enhancement process resistor model
//*  non-salicide p+diffusion resistor  is copied from l110eal_res_vt11
//*  temperature range: -55c ~ 135c ; nominal temperature  =  25c.
//*
inline subckt rnpd_l110e ( n1 n2 nw )
parameters w=1.00e-05  l=1.00e-05 mis_flag=1  mf=1
parameters arnpd = 1.530e-02
parameters dr_ma_npd_xx = arnpd/sqrt(2*w*0.9*l*0.9*mf*1e12)
parameters pr_ma_npd = dr_ma_npd_xx * mc_res_ma_npd  * mis_flag

parameters rend  =  1.07e-5+drend_rnpd_l110e rs  =  115+drs_rnpd_l110e dw  =  -1.5e-8+ddw_rnpd_l110e
parameters vcr1  =  0   vcr2  =  0.0143  tc1  =  1.47e-3  tc2  =  6.31e-7
parameters tcoef   =  1.0+tc1*(temp-25.0)+tc2*pow((temp-25.0),2)
parameters tc11=1e-12

parameters jmax=1.0e-3
parameters i1=jmax*w*1e6
parameters r=((2*rend/(w*0.9+dw))+(rs*l*0.9/(w*0.9+dw)))
parameters vmax=i1*r

r3 ( n3 nw ) resistor r=(4.8+2e-12/((w*0.9+dw)*l*0.9/2))  tc1=tc11 m=1
d3 ( n1 n3 ) diop_l110e area=(w+dw)*l/2 perim=(w+dw)+l m=1
rnpd_l110e ( n1 n2 ) bsource r=((2*rend/(w*0.9+dw))+(rs*l*0.9/(w*0.9+dw)))*(1.0+vcr1*v(n1,n2)+vcr2*pow((v(n1,n2)),2))*tcoef*(1+pr_ma_npd) bv_max=vmax m=1
d2 ( n2 n4 ) diop_l110e area=(w+dw)*l/2 perim=(w+dw)+l m=1
r2 ( n4 nw ) resistor r=(4.8+2e-12/((w*0.9+dw)*l*0.9/2))  tc1=tc11 m=1

model diop_l110e diode level = 3
+ hcomp=1.0000e+00 imax=1.00e+14
//**************************************************************
//*               GENERAL PARAMETERS
//**************************************************************
+area    = 3.6e-008        perim      = 0.00076         tnom    = 25
//**************************************************************
//*               DC PARAMETERS
//**************************************************************
+is      = 1.21e-007           isw     = 1.08e-013                  ik      = 1.4908e007
+bv      = 10.64
+ibv     = 27.778          ikr     = 2780            n       = 1.017              rs      = 0
//**************************************************************
//*               CAPACITANCE PARAMETERS
//**************************************************************
+cjo      = 9.69e-004  cjp     = 1.18e-010  vj      = 0.698           vjsw     = 0.75
+mj      = 0.308           mjsw    = 0.1
//**************************************************************
//*               NOISE PARAMETERS
//**************************************************************
//**************************************************************
//*               TEMPERATURE PARAMETERS
//**************************************************************
+tlev    = 1               tlevc   = 1               trs     = 0               tbv1     = -0.000645
+xti     = 3               cta     = 0.0010049       ctp     = 0.0005243       eg      = 1.16
+pta     = 0.0017088       ptp    = 0.0025864

ends rnpd_l110e
//*
//*
//****************************************************************************************************************
//*             non-salicide hr poly resistor subcircuit netlist for typical case                                *
//****************************************************************************************************************
//*  process: 0.11 um logic and mixed-mode metal metal capacitor al enhancement process resistor model
//*  non-salicide hr poly resistor  is copied from l110eal_res_vt11
//*  temperature range: -55c ~ 135c ; nominal temperature  =  25c.
//*
inline subckt rnhr1000_l110e ( n1 n2 well )
parameters w=1.00e-05  l=1.00e-05 mis_flag=1  mf=1
parameters arnhr1000 = 2.070e-02
parameters dr_ma_nhr_xx = arnhr1000/sqrt(2*w*0.9*l*0.9*mf*1e12)
parameters pr_ma_nhr = dr_ma_nhr_xx * mc_res_ma_nhr  * mis_flag

parameters rend=2.02e-4+drend_rnhr1000_l110e rs=984+drs_rnhr1000_l110e dw=-4.7e-8+ddw_rnhr1000_l110e
parameters vcr1=0   vcr2=-0.107e-12  tc1=-4.96e-4  tc2=1.25e-6
parameters tcoef = 1.0+tc1*(temp-25.0)+tc2*pow((temp-25.0),2)
+ca   = 1.1524e-04

parameters jmax=5.0e-4
parameters i1=jmax*w*1e6
parameters r=((2*rend/(w*0.9+dw))+(rs*((l*0.9)-0.8e-6)/(w*0.9+dw)))
parameters vmax=i1*r

c1 ( n1 well ) capacitor c=ca*(w*0.9+dw)*l*0.9/2 m=1
rnhr1000_l110e ( n1 n2 ) res2 r=((2*rend/(w*0.9+dw))+(rs*((l*0.9)-0.8e-6)/(w*0.9+dw)))*(1.0+vcr1*v(n1,n2)/(l*0.9)+vcr2*pow(v(n1,n2)/(l*0.9),2))*tcoef*(1+pr_ma_nhr) bv_max=vmax m=1
//************************************************************************************************
model res2 resistor
+ w=w l=l
+kf=1.05e-022   af=1.94000e+000 fexp=9.600e-001 wdexp=0.9900000e+000 ldexp=1.0100e+000

c2 ( n2 well ) capacitor c=ca*(w*0.9+dw)*l*0.9/2 m=1

ends rnhr1000_l110e
//*
//*
//****************************************************************************************************************
//*              salicide n+ diffusion resistor subcircuit netlist                                               *
//****************************************************************************************************************
//* process: 0.11 um logic and mixed-mode 1p8m metal metal capacitor fsg enhancement process
//* salicide n+ diffusion resistor  is copied from l110e_res_v031
//* temperature range: -50c ~ 125c ; nominal temperature=25c.
//*
inline subckt rsnd_mml110e ( n1 n2 pw )
parameters w=1.00e-06  l=2.00e-06 mis_flag=1  mf=1
parameters arsnd = 1.370e-02
parameters dr_ma_snd_xx = arsnd/sqrt(2*w*0.9*l*0.9*mf*1e12)
parameters pr_ma_snd = dr_ma_snd_xx * mc_res_ma_snd  * mis_flag

parameters rs=8.3+drs_rsnd_mml110e
parameters dw=0
parameters tc1=2.879e-03  tc2=1.379e-6
parameters tcoef = 1.0+tc1*(temp-25.0)+tc2*pow((temp-25.0),2)
parameters tc11=6032.8*((w*0.9+dw)*l*0.9/2)+2e-7

parameters jmax=2.0e-3
parameters i1=jmax*w*1e6
parameters r=(rs*l*0.9/(w*0.9+dw))
parameters vmax=i1*r

r3 ( pw n3 ) resistor r=(8.2+2e-12/((w*0.9+dw)*l*0.9/2))  tc1=tc11 m=1
d3 ( n3 n1 ) dion_l110e area=(w+dw)*l/2 perim=(w+dw)+l m=1
rsnd_mml110e ( n1 n2 ) bsource r=(rs*l*0.9/(w*0.9+dw))*tcoef*(1+pr_ma_snd) bv_max=vmax m=1
d2 ( n4 n2 ) dion_l110e area=(w+dw)*l/2 perim=(w+dw)+l m=1
r2 ( pw n4 ) resistor r=(8.2+2e-12/((w*0.9+dw)*l*0.9/2))  tc1=tc11 m=1

model dion_l110e diode level = 3
+ hcomp=1.0000e+00 imax=1.00e+14
//**************************************************************
//*               GENERAL PARAMETERS
//**************************************************************
+area    = 3.6e-008        perim      = 0.00076         tnom    = 25
//**************************************************************
//*               DC PARAMETERS
//**************************************************************
+is      = 8.81e-008            isw     = 9.61e-014             ik      = 1.4945e7          bv      = 13.36
+ibv     = 27.778          ikr     = 2780            n       = 1.008                   rs      =0
//**************************************************************
//*               CAPACITANCE PARAMETERS
//**************************************************************
+cjo      = 0.00072  cjp     = 9.94e-011  vj      = 0.56            vjsw     = 0.54
+mj      = 0.258           mjsw    = 0.13
//**************************************************************
//*               NOISE PARAMETERS
//**************************************************************
//**************************************************************
//*               TEMPERATURE PARAMETERS
//**************************************************************
+tlev    = 1               tlevc   = 1               trs     =0               tbv1     = -0.000684
+xti     = 3               cta     = 0.0009555       ctp     = 0.00073248      eg      = 1.16
+pta     = 0.001632        ptp    = 0.00031

ends rsnd_mml110e
//*
//*
//****************************************************************************************************************
//*              salicide p+ diffusion resistor subcircuit netlist                                               *
//****************************************************************************************************************
//* process: 0.11 um logic and mixed-mode 1p8m metal metal capacitor fsg enhancement process
//* salicide p+ diffusion resistor  is copied from l110e_res_v031
//* temperature range: -50c ~ 125c ; nominal temperature=25c.
//*
inline subckt rspd_mml110e ( n1 n2 nw )
parameters w=1.00e-06  l=2.00e-06 mis_flag=1  mf=1
parameters arspd = 1.520e-02
parameters dr_ma_spd_xx = arspd/sqrt(2*w*0.9*l*0.9*mf*1e12)
parameters pr_ma_spd = dr_ma_spd_xx * mc_res_ma_spd  * mis_flag

parameters rs=7.2+drs_rspd_mml110e
parameters  dw=0
parameters tc1=2.891e-03  tc2=1.457e-6
parameters tcoef = 1.0+tc1*(temp-25.0)+tc2*pow((temp-25.0),2)
parameters tc11=1e-12

parameters jmax=2.0e-3
parameters i1=jmax*w*1e6
parameters r=(rs*l*0.9/(w*0.9+dw))
parameters vmax=i1*r

r3 ( n3 nw ) resistor r=(4.8+2e-12/((w*0.9+dw)*l*0.9/2))  tc1=tc11 m=1
d3 ( n1 n3 ) diop_l110e area=(w+dw)*l/2 perim=(w+dw)+l m=1
rspd_mml110e ( n1 n2 ) bsource r=(rs*l*0.9/(w*0.9+dw))*tcoef*(1+pr_ma_spd) bv_max=vmax m=1
d2 ( n2 n4 ) diop_l110e area=(w+dw)*l/2 perim=(w+dw)+l m=1
r2 ( n4 nw ) resistor r=(4.8+2e-12/((w*0.9+dw)*l*0.9/2))  tc1=tc11 m=1

model diop_l110e diode level = 3
+ hcomp=1.0000e+00 imax=1.00e+14
//**************************************************************
//*               GENERAL PARAMETERS
//**************************************************************
+area    = 3.6e-008        perim      = 0.00076         tnom    = 25
//**************************************************************
//*               DC PARAMETERS
//**************************************************************
+is      = 1.21e-007           isw     = 1.08e-013                  ik      = 1.4908e007
+bv      = 10.64
+ibv     = 27.778          ikr     = 2780            n       = 1.017              rs      = 0
//**************************************************************
//*               CAPACITANCE PARAMETERS
//**************************************************************
+cjo      = 9.69e-004  cjp     = 1.18e-010  vj      = 0.698           vjsw     = 0.75
+mj      = 0.308           mjsw    = 0.1
//**************************************************************
//*               NOISE PARAMETERS
//**************************************************************
//**************************************************************
//*               TEMPERATURE PARAMETERS
//**************************************************************
+tlev    = 1               tlevc   = 1               trs     = 0               tbv1     = -0.000645
+xti     = 3               cta     = 0.0010049       ctp     = 0.0005243       eg      = 1.16
+pta     = 0.0017088       ptp    = 0.0025864

ends rspd_mml110e
//*
//*
//****************************************************************************************************************
//*              salicide n+ poly resistor subcircuit netlist                                                    *
//****************************************************************************************************************
//* process: 0.11 um logic and mixed-mode 1p8m metal metal capacitor fsg enhancement process
//* salicide n+ poly resistor  is copied from l110e_res_v031
//* temperature range: -50c ~ 125c ; nominal temperature=25c.
//*
inline subckt rsnpo_mml110e ( n1 n2 well )
parameters w=1.00e-06  l=2.00e-06 mis_flag=1  mf=1
parameters arsnpo = 1.130e-02
parameters dr_ma_snpo_xx = arsnpo/sqrt(2*w*0.9*l*0.9*mf*1e12)
parameters pr_ma_snpo = dr_ma_snpo_xx * mc_res_ma_snpo  * mis_flag

parameters rs=8.7+drs_rsnpo_mml110e
parameters ca=1.0367e-4 dw=0
parameters tc1=2.667e-03  tc2=1.163e-6
parameters tcoef = 1.0+tc1*(temp-25.0)+tc2*pow((temp-25.0),2)

parameters jmax=2.0e-3
parameters i1=jmax*w*1e6
parameters r=(rs*l*0.9/(w*0.9+dw))
parameters vmax=i1*r

c1 ( n1 well ) capacitor c=ca*(w*0.9+dw)*l*0.9/2 m=1
rsnpo_mml110e ( n1 n2 ) bsource r=(rs*l*0.9/(w*0.9+dw))*tcoef*(1+pr_ma_snpo) bv_max=vmax m=1
c2 ( n2 well ) capacitor c=ca*(w*0.9+dw)*l*0.9/2 m=1

ends rsnpo_mml110e
//*
//*
//****************************************************************************************************************
//*              salicide p+ poly resistor subcircuit netlist                                                    *
//****************************************************************************************************************
//* process: 0.11 um logic and mixed-mode 1p8m metal metal capacitor fsg enhancement process
//* salicide p+ poly resistor  is copied from l110e_res_v031
//* temperature range: -50c ~ 125c ; nominal temperature=25c.
//*
inline subckt rsppo_mml110e ( n1 n2 well )
parameters w=1.00e-06  l=2.00e-06 mis_flag=1  mf=1
parameters arsppo = 1.130e-02
parameters dr_ma_sppo_xx = arsppo/sqrt(2*w*0.9*l*0.9*mf*1e12)
parameters pr_ma_sppo = dr_ma_sppo_xx * mc_res_ma_sppo  * mis_flag

parameters rs=7.3+drs_rsppo_mml110e
parameters ca=1.0367e-4 dw=0
parameters tc1=2.746e-03  tc2=1.631e-6
parameters tcoef = 1.0+tc1*(temp-25.0)+tc2*pow((temp-25.0),2)

parameters jmax=2.0e-3
parameters i1=jmax*w*1e6
parameters r=(rs*l*0.9/(w*0.9+dw))
parameters vmax=i1*r

c1 ( n1 well ) capacitor c=ca*(w*0.9+dw)*l*0.9/2 m=1
rsppo_mml110e ( n1 n2 ) bsource r=(rs*l*0.9/(w*0.9+dw))*tcoef*(1+pr_ma_sppo) bv_max=vmax m=1
c2 ( n2 well ) capacitor c=ca*(w*0.9+dw)*l*0.9/2 m=1

ends rsppo_mml110e
//*
//*
//****************************************************************************************************************
//*               nwell resistor subcircuit netlist                                                    *
//****************************************************************************************************************
//* process: 0.11 um logic and mixed-mode 1p8m metal metal capacitor fsg enhancement process
//* nwell resistor  is copied from l110e_res_v031
//* temperature range: -50c ~ 125c ; nominal temperature=25c.
//*
inline subckt rnwell_mml110e ( n1 n2 sub )
parameters w=20.00e-06  l=2.00e-06 mis_flag=1  mf=1
parameters arnwell = 0.000e+00
parameters dr_ma_snwell_xx = arnwell/sqrt(2*w*0.9*l*0.9*mf*1e12)
parameters pr_ma_snwell = dr_ma_snwell_xx * mc_res_ma_snwell  * mis_flag

parameters rs=370+drs_rnwell_mml110e
parameters dw=-0.51e-6
parameters vc0=1.9571e-3  vc1=-3.4571e-4  vc2=5.7143e-5  tc1=1.485e-03  tc2=9.097e-6
parameters tcoef = 1.0+tc1*(temp-25.0)+tc2*pow((temp-25.0),2)

parameters jmax=5.0e-5
parameters i1=jmax*w*1e6
parameters r=(rs*l*0.9/(w*0.9+dw))
parameters vmax=i1*r

d1 ( sub n1 ) dionw_l110e area=(w+dw)*l/2 perim=(w+dw)+l m=1
rnwell_mml110e ( n1 n2 ) bsource r=(rs*l*0.9/(w*0.9+dw))*(1.0+(vc0+vc1*min(v(n1),v(n2))+vc2*pow(min(v(n1),v(n2)),2))*abs(v(n1,n2)))*tcoef*(1+pr_ma_snwell) bv_max=vmax m=1
d2 ( sub n2 ) dionw_l110e area=(w+dw)*l/2 perim=(w+dw)+l m=1

model dionw_l110e diode level = 3
+ hcomp=1.0000e+00 imax=1.00e+14
//**************************************************************
//*               GENERAL PARAMETERS
//**************************************************************
+area    = 1.68e-007       perim      = 0.00469         tnom    = 25
//**************************************************************
//*               DC PARAMETERS
//**************************************************************
+is      = 2.05e-006       isw     = 5.34e-011       ik      = 17856           bv      = 9.662
+ibv     = 5.952           ikr     = 595.2           n       = 1.0525          rs      = 3.0891e-007
//**************************************************************
//*               CAPACITANCE PARAMETERS
//**************************************************************
+cjo      = 8.28e-005  cjp     = 9.92e-010  vj      = 0.588           vjsw     = 0.62
+mj      = 0.474           mjsw    = 0.27
//**************************************************************
//*               NOISE PARAMETERS
//**************************************************************
//**************************************************************
//*               TEMPERATURE PARAMETERS
//**************************************************************
+tlev    = 1               tlevc   = 1               trs     = 0.00322         tbv1     = -0.000539
+xti     = 5.4936          cta     = 0.00332         ctp     = 0.001           eg      = 1.16
+pta     = 0.0028          ptp    = 0.001
ends rnwell_mml110e

//****************************************************************************************************************
//*             M1 RESISTOR SUBCIRCUIT NETLIST FOR TYPICAL CASE
//****************************************************************************************************************
inline subckt r_m1_l110e ( n1 n2 )
parameters w=1.44e-07  l=1.00e-05 mis_flag=1  mf=1
//.prot
parameters arsm1 = 0.000e+00
parameters dr_ma_sm1_xx = arsm1/sqrt(2*w*0.9*l*0.9*mf*1e12)
parameters pr_ma_sm1 = dr_ma_sm1_xx * mc_res_ma_sm1  * mis_flag
//.unprot
parameters rs=(170e-03+drs_rsm1_l110e)
parameters tc1= 3.203e-03  tc2=-4.119e-07
parameters tcoef = 1.0+tc1*(temp-25.0)+tc2*pow((temp-25.0),2)

r_m1_l110e ( n1 n2 ) resistor r=(rs*(l*0.9)/(w*0.9))*tcoef*(1+pr_ma_sm1) m=1

ends r_m1_l110e

//****************************************************************************************************************
//*             1X RESISTOR SUBCIRCUIT NETLIST FOR TYPICAL CASE
//****************************************************************************************************************
inline subckt r_1x_l110e ( n1 n2 )
parameters w=1.8e-07  l=1.00e-05 mis_flag=1  mf=1
//.prot
parameters ars1x = 0.000e+00
parameters dr_ma_s1x_xx = ars1x/sqrt(2*w*0.9*l*0.9*mf*1e12)
parameters pr_ma_s1x = dr_ma_s1x_xx * mc_res_ma_s1x  * mis_flag
//.unprot
parameters rs=(130e-03+drs_rsm2_l110e)
parameters tc1= 3.304e-03  tc2=-4.983e-07
parameters tcoef = 1.0+tc1*(temp-25.0)+tc2*pow((temp-25.0),2)

r_1x_l110e ( n1 n2 ) resistor r=(rs*(l*0.9)/(w*0.9))*tcoef*(1+pr_ma_s1x) m=1

ends r_1x_l110e

//****************************************************************************************************************
//*             2X AS TOP METAL WITH 8KA THICKNESS RESISTOR SUBCIRCUIT NETLIST FOR TYPICAL CASE
//****************************************************************************************************************
inline subckt r_2x_l110e ( n1 n2 )
parameters w=3.96e-07  l=1.00e-05 mis_flag=1  mf=1
//.prot
parameters ars2x = 0.000e+00
parameters dr_ma_s2x_xx = ars2x/sqrt(2*w*0.9*l*0.9*mf*1e12)
parameters pr_ma_s2x = dr_ma_s2x_xx * mc_res_ma_s2x  * mis_flag
//.unprot
parameters rs=(35e-03+drs_rsm6t_8k_l110e)
parameters tc1= 3.415e-03  tc2=-2.26e-07
parameters tcoef = 1.0+tc1*(temp-25.0)+tc2*pow((temp-25.0),2)

r_2x_l110e ( n1 n2 ) resistor r=(rs*(l*0.9)/(w*0.9))*tcoef*(1+pr_ma_s2x) m=1

ends r_2x_l110e
