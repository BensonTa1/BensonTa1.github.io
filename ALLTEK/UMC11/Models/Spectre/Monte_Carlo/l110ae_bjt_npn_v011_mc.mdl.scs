//*****************************************************************
//*      Emitter Area=4.5X4.5 um**2  ,Base Area=11.7X11.7 um**2             *
//*****************************************************************
//*DEVICE 1
simulator lang=spectre insensitive=yes
inline subckt npn_sv45x45_l110ae ( c b e )
parameters  mis_flag=1
parameters abf_v45x45=7.9612e-3
parameters ais_v45x45=1.8456e-3
parameters p_bf_v45x45=abf_v45x45 * mc_bf_npn_v45x45  * mis_flag
parameters p_is_v45x45=ais_v45x45 * mc_is_npn_v45x45  * mis_flag
npn_sv45x45_l110ae (c b e) npn_sv45x45_l110ae_main

model npn_sv45x45_l110ae_main bjt type=npn level = 1
+ struct=vertical
//**************************************************************
//*               GENERAL PARAMETERS
//**************************************************************
+tref  = 25
//**************************************************************
//*               CAPACITANCE PARAMETERS
//**************************************************************
+cjc   = 1.59710e-013*(1+dcjc_npn_sv4p5x4p5_l110ae) cje   = 1.51470e-018*(1+dcje_npn_sv4p5x4p5_l110ae) fc    = 0.5                  mjc   = 0.3081
+mje   = 0.278                vjc   = 0.59388              vje   = 0.608
//**************************************************************
//*               Noise PARAMETERS
//**************************************************************
//**************************************************************
//*               DC PARAMETERS
//**************************************************************
+is    = 3.8313e-018*(1+dis_npn_sv4p5x4p5_l110ae)*(1+p_is_v45x45) rb    = 147.53               re    = 8.01132*(1+dre_npn_sv4p5x4p5_l110ae)
+irb   = 2.5065e-005          rc    = 21.3913*(1+drc_npn_sv4p5x4p5_l110ae) rbm   = 0                    bf    = 8.8952*(1+dbf_npn_sv4p5x4p5_l110ae)*(1+p_bf_v45x45)
+nf    = 0.99778*(1+dnf_npn_sv4p5x4p5_l110ae) vaf   = 31.92                ikf   = 1.0048               ise   = 1.7954e-016*(1+dise_npn_sv4p5x4p5_l110ae)
+ne    = 1.4471               br    = 1.9958               nr    = 1                    var   = 24.728
+ikr   = 1.0045               nkf   = 1.0004               isc   = 2.5028e-017          nc    = 1.024
//**************************************************************
//*               tempATURE PARAMETERS
//**************************************************************
+xtb   = 0                    xti   = 3.0042               eg    = 1.17                 ctc   = 0.00085358
+cte   = 0.0009               tlev  = 0                    tlevc = 1                    tvjc  = 0.001512
+tvje  = 0.001494             tnf1  = -8.6177e-005         tnr1  = -3.405e-005          tne1  = 1e-006
+tnc1  = -3.528e-008          tbf1  = 0.0056               tbr1  = 0.00032832           tikf1 = -0.004768
+trb1  = 0.0068405            trc1  = 0.00231              trm1  = 0                    tnf2  = 2.5732e-007
+tnr2  = -9.0551e-008         tne2  = 5e-011               tnc2  = 0                    tbf2  = 1.6118e-006
+tbr2  = -1.7e-006            tikf2 = 0
//**************************************************************
//*
//*
//*****************************************************************
//*      Emitter Area=9X9 um**2  ,Base Area=16.2X16.2 um**2             *
//*****************************************************************
ends npn_sv45x45_l110ae

//*DEVICE 2
inline subckt npn_sv90x90_l110ae ( c b e )
parameters  mis_flag=1
parameters abf_v90x90=4.7860e-3
parameters ais_v90x90=8.7560e-4
parameters p_bf_v90x90=abf_v90x90 * mc_bf_npn_v90x90  * mis_flag
parameters p_is_v90x90=ais_v90x90 * mc_is_npn_v90x90  * mis_flag
npn_sv90x90_l110ae (c b e) npn_sv90x90_l110ae_main

model npn_sv90x90_l110ae_main bjt type=npn level = 1
+ struct=vertical
//**************************************************************
//*               GENERAL PARAMETERS
//**************************************************************
+tref  = 25
//**************************************************************
//*               CAPACITANCE PARAMETERS
//**************************************************************
+cjc   = 3.06189e-013*(1+dcjc_npn_sv9x9_l110ae) cje   = 6.05880e-018*(1+dcje_npn_sv9x9_l110ae) fc    = 0.5                  mjc   = 0.3081
+mje   = 0.278                vjc   = 0.59388              vje   = 0.608
//**************************************************************
//*               Noise PARAMETERS
//**************************************************************
//**************************************************************
//*               DC PARAMETERS
//**************************************************************
+is    = 1.6257e-017*(1+dis_npn_sv9x9_l110ae)*(1+p_is_v90x90) rb    = 69.311               re    = 5.90031*(1+dre_npn_sv9x9_l110ae)
+irb   = 2.5065e-005          rc    = 20.6233*(1+drc_npn_sv9x9_l110ae) rbm   = 0                    bf    = 8.0543*(1+dbf_npn_sv9x9_l110ae)*(1+p_bf_v90x90)
+nf    = 1.004*(1+dnf_npn_sv9x9_l110ae) vaf   = 48                   ikf   = 1.0048               ise   = 4.8428e-016*(1+dise_npn_sv9x9_l110ae)
+ne    = 1.5115               br    = 12.32                nr    = 0.99996              var   = 34.731
+ikr   = 1.0045               nkf   = 1.0004               isc   = 4.3379e-017          nc    = 1.012
//**************************************************************
//*               tempATURE PARAMETERS
//**************************************************************
+xtb   = 0                    xti   = 3.0504               eg    = 1.17                 ctc   = 0.00085358
+cte   = 0.0009               tlev  = 0                    tlevc = 1                    tvjc  = 0.001512
+tvje  = 0.001494             tnf1  = -1.6888e-005         tnr1  = -4.081e-005          tne1  = 0.0005
+tnc1  = -6.5866e-006         tbf1  = 0.0052477            tbr1  = 0.00072              tikf1 = -0.004768
+trb1  = 0.000797             trc1  = 0.00231              trm1  = 0                    tnf2  = 1.728e-007
+tnr2  = -1.2005e-7           tne2  = 0                    tnc2  = 0                    tbf2  = 2.578e-008
+tbr2  = -2.5e-006            tikf2 = 0
//**************************************************************
//*
//*
//*****************************************************************
//*      Emitter Area=13.5X13.5 um**2  ,Base Area=20.7X20.7 um**2             *
//*****************************************************************
ends npn_sv90x90_l110ae

//*DEVICE 3
inline subckt npn_sv135x135_l110ae ( c b e )
parameters  mis_flag=1
parameters abf_v135x135=3.1270e-3
parameters ais_v135x135=5.2839e-4
parameters p_bf_v135x135=abf_v135x135 * mc_bf_npn_v135x135  * mis_flag
parameters p_is_v135x135=ais_v135x135 * mc_is_npn_v135x135  * mis_flag
npn_sv135x135_l110ae (c b e) npn_sv135x135_l110ae_main

model npn_sv135x135_l110ae_main bjt type=npn level = 1
+ struct=vertical
//**************************************************************
//*               GENERAL PARAMETERS
//**************************************************************
+tref  = 25
//**************************************************************
//*               CAPACITANCE PARAMETERS
//**************************************************************
+cjc   = 4.99919e-013*(1+dcjc_npn_sv13p5x13p5_l110ae) cje   = 1.36323e-017*(1+dcje_npn_sv13p5x13p5_l110ae) fc    = 0.5                  mjc   = 0.3081
+mje   = 0.278                vjc   = 0.59388              vje   = 0.608
//**************************************************************
//*               Noise PARAMETERS
//**************************************************************
//**************************************************************
//*               DC PARAMETERS
//**************************************************************
+is    = 3.135e-017*(1+dis_npn_sv13p5x13p5_l110ae)*(1+p_is_v135x135) rb    = 36.99                re    = 4.75261*(1+dre_npn_sv13p5x13p5_l110ae)
+irb   = 2.5065e-005          rc    = 20.5847*(1+drc_npn_sv13p5x13p5_l110ae) rbm   = 0                    bf    = 7.6854*(1+dbf_npn_sv13p5x13p5_l110ae)*(1+p_bf_v135x135)
+nf    = 0.998*(1+dnf_npn_sv13p5x13p5_l110ae) vaf   = 33.61                ikf   = 1.0048               ise   = 7.8135e-016*(1+dise_npn_sv13p5x13p5_l110ae)
+ne    = 1.5535               br    = 4.3                  nr    = 0.99743              var   = 33.62
+ikr   = 1.0045               nkf   = 1.0004               isc   = 3.3387e-017          nc    = 0.9905
//**************************************************************
//*               tempATURE PARAMETERS
//**************************************************************
+xtb   = 0                    xti   = 3.005                eg    = 1.17                 ctc   = 0.00085358
+cte   = 0.0009               tlev  = 0                    tlevc = 1                    tvjc  = 0.001512
+tvje  = 0.001494             tnf1  = -7.8782e-005         tnr1  = -0.0013901           tne1  = 0.00045693
+tnc1  = -9.4649e-005         tbf1  = 0.0052477            tbr1  = 0.00072              tikf1 = -0.004768
+trb1  = 0.0011492            trc1  = 0.00231              trm1  = 0                    tnf2  = -2e-007
+tnr2  = -1.3984e-006         tne2  = -4e-012              tnc2  = -1.2e-006            tbf2  = 2.4609e-007
+tbr2  = -2.5e-006            tikf2 = 0
//**************************************************************
ends npn_sv135x135_l110ae
