simulator lang=spectre insensitive=yes
inline subckt ncap_33 ( port1 port2 )
parameters wf=5u lf=2u nf=4 mf=1 mis_flag=1 tox0=7.49e-09+dtoxe_ncap_33 toxc=7.49e-09+dtoxe_ncap_33
parameters pva=0.12000753 pvb=0.67169332+tpvb * (temp - 25) pvc=0.15559681+tpvc * (temp - 25)
parameters pvd=1.1255255 pve=0.13970573 pvf=0.025327788 pvg=0.014590854 pvh=-0.027265864
parameters pvi=-0.0049672659 pvj=-0.0062160517 pvk=-0.001070722 tpvb=-0.0004201 tpvc=-4.158e-005
parameters dcw= - 0.06908 + 1e6 * dxw_ncap_33 cww=-0.005138 cwl=-0.165 cwwl=0.7361 dcl= - 0.01338 + 1e6 * dxl_ncap_33 cll=0.000636 clw=3.138e-007 clwl=-0.001153
parameters weff=wf  * 0.9 * 1e6+dcw+cww / (wf * 0.9 * 1e6)+cwl / l+cwwl / (wf * 0.9 * 1e6) / l
parameters leff=l+dcl+cll / l+clw / (wf * 0.9 * 1e6)+clwl / (wf * 0.9 * 1e6)  / l
parameters cl3=9.561e-06 cl2=-191.3e-6 cl1=-1.96e-06 cl0=0.00106 cw0=0.002554 cwl0=-1.8e-05
parameters w=wf*0.9*1e6 l=lf*0.9*1e6+0.012
parameters ccom=0.25 * (((cl3 * pow(l,3)+cl2 * pow(l,2) +cl1 * l+cl0) * (w+dcw)+cw0 / w) * (1+cwl0 / (w * l)))
parameters cmina=0+dcmina_ncap_33 cminb=-1.43977 cminc=-0.194022 cmind=0.34732787
//******************
//**** MISMATCH ****
//******************
parameters
+ cotn = 10.454/1.414
+ potn = -0.9757

ncap_33 ( port1 port2 ) bsource c=(((pva+pvc * pow(v(port1,port2),1)+pve * pow(v(port1,port2),2)+pvg * pow(v(port1,port2),3)+pvi * pow(v(port1,port2),4)+pvk * pow(v(port1,port2),5)) / (1+pvb * pow(v(port1,port2),1)+pvd * pow(v(port1,port2),2)+pvf * pow(v(port1,port2),3) +pvh * pow(v(port1,port2),4)+pvj * pow(v(port1,port2),5)) * weff * leff / (4.5  * 1.812 * 4)+ccom) * (tox0 / toxc) * nf * 1e-12) * (1+cmina * (cminb+atan((v(port1,port2)- cminc) / cmind))) * (1+mc_ncap_33_ma*mis_flag*0.01*((0.02*exp(-0.7108*v(port1, port2)))+cotn*(1e+15*(((pva+pvc * pow(v(port1,port2),1)+pve * pow(v(port1,port2),2)+pvg * pow(v(port1,port2),3)+pvi * pow(v(port1,port2),4)+pvk * pow(v(port1,port2),5)) / (1+pvb * pow(v(port1,port2),1)+pvd * pow(v(port1,port2),2)+pvf * pow(v(port1,port2),3) +pvh * pow(v(port1,port2),4)+pvj * pow(v(port1,port2),5)) * weff * leff / (4.5  * 1.812 * 4)+ccom) * (tox0 / toxc) * nf * 1e-12) * (1+cmina * (cminb+atan((v(port1,port2)- cminc) / cmind))) *mf)**potn))

ends ncap_33
