simulator lang=spectre insensitive=yes
inline subckt n_nvt_12_l110e ( d g s b )
parameters w=0u l=0u
+ dtemp=0 nf=1 mf=1 mis_flag=1
+ nf_odd=nf-2*int(nf/2) nf_even=1-nf_odd
+ sa=0 sb=0 sd=0
+ a_unit=sd*w   p_unit=2*(sd+w)  a_sa_edge=sa*w   p_sa_edge=2*(sa+w)
+ a_sb_edge=sb*w   p_sb_edge=2*(sb+w)
+ ad=(nf_odd*(a_unit*((nf+1)/2-1)+a_sb_edge) + nf_even*(a_unit*nf/2))/nf
+ as=(nf_odd*(a_unit*((nf+1)/2-1)+a_sa_edge) + nf_even*(a_unit*(nf/2-1)+a_sa_edge+a_sb_edge))/nf
+ pd=(nf_odd*(p_unit*((nf+1)/2-1)+p_sb_edge) + nf_even*(p_unit*nf/2))/nf
+ ps=(nf_odd*(p_unit*((nf+1)/2-1)+p_sa_edge) + nf_even*(p_unit*(nf/2-1)+p_sa_edge+p_sb_edge))/nf
//
//

parameters beta  = 1
parameters compl1	= 3.9350935264017
parameters compl2	= 0.717662133921867
parameters compl3	= 1.89464678063027e-14
parameters compl4	= 1.38909519731871e-16
parameters compl5	= 8.51594551542944e-31
parameters l_factor_n=1/sqrt(2*w*0.9*l*0.9*mf*1e+12)
parameters  b1_np_nvt_12_l110e = b1_np_nvt_12_l110e_xx
parameters  b2_np_nvt_12_l110e = b2_np_nvt_12_l110e_xx
parameters  b3_np_nvt_12_l110e = b3_np_nvt_12_l110e_xx
parameters  b4_np_nvt_12_l110e = b4_np_nvt_12_l110e_xx
parameters  b5_np_nvt_12_l110e = b5_np_nvt_12_l110e_xx
parameters  dtox_n_nvt_12_l110e_l = beta*(0*b1_np_nvt_12_l110e*compl1+0*b2_np_nvt_12_l110e*compl2+0*b3_np_nvt_12_l110e*compl3+0*b4_np_nvt_12_l110e*compl4+0*b5_np_nvt_12_l110e*compl5)* mis_flag*l_factor_n
parameters  dxl_n_nvt_12_l110e_l = beta*(0*b1_np_nvt_12_l110e*compl1+0*b2_np_nvt_12_l110e*compl2+0*b3_np_nvt_12_l110e*compl3+0*b4_np_nvt_12_l110e*compl4+0*b5_np_nvt_12_l110e*compl5)* mis_flag*l_factor_n
parameters  dxw_n_nvt_12_l110e_l = beta*(0*b1_np_nvt_12_l110e*compl1+0*b2_np_nvt_12_l110e*compl2+0*b3_np_nvt_12_l110e*compl3+0*b4_np_nvt_12_l110e*compl4+0*b5_np_nvt_12_l110e*compl5)* mis_flag*l_factor_n
parameters  dvth0_n_nvt_12_l110e_l = beta*(-3.57002558886016e-03*b1_np_nvt_12_l110e*compl1+-2.64427937061102e-03*b2_np_nvt_12_l110e*compl2+3.5882654467988e-03*b3_np_nvt_12_l110e*compl3+-3.80120667694294e-03*b4_np_nvt_12_l110e*compl4+-1.24961442468425e-03*b5_np_nvt_12_l110e*compl5)* mis_flag*l_factor_n
parameters  du0_n_nvt_12_l110e_l = beta*(-1.81827085063613e-04*b1_np_nvt_12_l110e*compl1+-1.45345508889345e-04*b2_np_nvt_12_l110e*compl2+3.32950369651426e-05*b3_np_nvt_12_l110e*compl3+2.48242070565049e-04*b4_np_nvt_12_l110e*compl4+8.21278591094739e-05*b5_np_nvt_12_l110e*compl5)* mis_flag*l_factor_n
parameters  dlvth0_n_nvt_12_l110e_l = beta*(-4.1340665534531e-05*b1_np_nvt_12_l110e*compl1+7.12506106398954e-05*b2_np_nvt_12_l110e*compl2+2.0555886899688e-05*b3_np_nvt_12_l110e*compl3+7.06410481844222e-06*b4_np_nvt_12_l110e*compl4+2.37519982211099e-06*b5_np_nvt_12_l110e*compl5)* mis_flag*l_factor_n
parameters  drdsw_n_nvt_12_l110e_l = beta*(1.72696070508971*b1_np_nvt_12_l110e*compl1+0.100846091942162*b2_np_nvt_12_l110e*compl2+2.79613364843636*b3_np_nvt_12_l110e*compl3+0.771501070549954*b4_np_nvt_12_l110e*compl4+0.260477362420714*b5_np_nvt_12_l110e*compl5)* mis_flag*l_factor_n
parameters  dk3_n_nvt_12_l110e_l = beta*(0*b1_np_nvt_12_l110e*compl1+0*b2_np_nvt_12_l110e*compl2+0*b3_np_nvt_12_l110e*compl3+0*b4_np_nvt_12_l110e*compl4+0*b5_np_nvt_12_l110e*compl5)* mis_flag*l_factor_n
parameters  dpvth0_n_nvt_12_l110e_l = beta*(0*b1_np_nvt_12_l110e*compl1+0*b2_np_nvt_12_l110e*compl2+0*b3_np_nvt_12_l110e*compl3+0*b4_np_nvt_12_l110e*compl4+0*b5_np_nvt_12_l110e*compl5)* mis_flag*l_factor_n
parameters  dwwl_n_nvt_12_l110e_l = beta*(0*b1_np_nvt_12_l110e*compl1+0*b2_np_nvt_12_l110e*compl2+0*b3_np_nvt_12_l110e*compl3+0*b4_np_nvt_12_l110e*compl4+0*b5_np_nvt_12_l110e*compl5)* mis_flag*l_factor_n
parameters  dcj_n_nvt_12_l110e_l = beta*(0*b1_np_nvt_12_l110e*compl1+0*b2_np_nvt_12_l110e*compl2+0*b3_np_nvt_12_l110e*compl3+0*b4_np_nvt_12_l110e*compl4+0*b5_np_nvt_12_l110e*compl5)* mis_flag*l_factor_n
parameters  dcjsw_n_nvt_12_l110e_l = beta*(0*b1_np_nvt_12_l110e*compl1+0*b2_np_nvt_12_l110e*compl2+0*b3_np_nvt_12_l110e*compl3+0*b4_np_nvt_12_l110e*compl4+0*b5_np_nvt_12_l110e*compl5)* mis_flag*l_factor_n
parameters  dcjswg_n_nvt_12_l110e_l = beta*(0*b1_np_nvt_12_l110e*compl1+0*b2_np_nvt_12_l110e*compl2+0*b3_np_nvt_12_l110e*compl3+0*b4_np_nvt_12_l110e*compl4+0*b5_np_nvt_12_l110e*compl5)* mis_flag*l_factor_n
parameters  dcgdo_n_nvt_12_l110e_l = beta*(0*b1_np_nvt_12_l110e*compl1+0*b2_np_nvt_12_l110e*compl2+0*b3_np_nvt_12_l110e*compl3+0*b4_np_nvt_12_l110e*compl4+0*b5_np_nvt_12_l110e*compl5)* mis_flag*l_factor_n
parameters  dcgso_n_nvt_12_l110e_l = beta*(0*b1_np_nvt_12_l110e*compl1+0*b2_np_nvt_12_l110e*compl2+0*b3_np_nvt_12_l110e*compl3+0*b4_np_nvt_12_l110e*compl4+0*b5_np_nvt_12_l110e*compl5)* mis_flag*l_factor_n
parameters  dtox_n_nvt_12_l110e = (global_flag_n_nvt_12_l110e*dtox_n_nvt_12_l110e_g  + local_flag_n_nvt_12_l110e*dtox_n_nvt_12_l110e_l)*(1-total_flag_n_nvt_12_l110e)+ total_flag_n_nvt_12_l110e*dtox_n_nvt_12_l110e_t
parameters  dxl_n_nvt_12_l110e = (global_flag_n_nvt_12_l110e*dxl_n_nvt_12_l110e_g  + local_flag_n_nvt_12_l110e*dxl_n_nvt_12_l110e_l)*(1-total_flag_n_nvt_12_l110e)+ total_flag_n_nvt_12_l110e*dxl_n_nvt_12_l110e_t
parameters  dxw_n_nvt_12_l110e = (global_flag_n_nvt_12_l110e*dxw_n_nvt_12_l110e_g  + local_flag_n_nvt_12_l110e*dxw_n_nvt_12_l110e_l)*(1-total_flag_n_nvt_12_l110e)+ total_flag_n_nvt_12_l110e*dxw_n_nvt_12_l110e_t
parameters  dvth0_n_nvt_12_l110e = (global_flag_n_nvt_12_l110e*dvth0_n_nvt_12_l110e_g  + local_flag_n_nvt_12_l110e*dvth0_n_nvt_12_l110e_l)*(1-total_flag_n_nvt_12_l110e)+ total_flag_n_nvt_12_l110e*dvth0_n_nvt_12_l110e_t
parameters  du0_n_nvt_12_l110e = (global_flag_n_nvt_12_l110e*du0_n_nvt_12_l110e_g  + local_flag_n_nvt_12_l110e*du0_n_nvt_12_l110e_l)*(1-total_flag_n_nvt_12_l110e)+ total_flag_n_nvt_12_l110e*du0_n_nvt_12_l110e_t
parameters  dlvth0_n_nvt_12_l110e = (global_flag_n_nvt_12_l110e*dlvth0_n_nvt_12_l110e_g  + local_flag_n_nvt_12_l110e*dlvth0_n_nvt_12_l110e_l)*(1-total_flag_n_nvt_12_l110e)+ total_flag_n_nvt_12_l110e*dlvth0_n_nvt_12_l110e_t
parameters  drdsw_n_nvt_12_l110e = (global_flag_n_nvt_12_l110e*drdsw_n_nvt_12_l110e_g  + local_flag_n_nvt_12_l110e*drdsw_n_nvt_12_l110e_l)*(1-total_flag_n_nvt_12_l110e)+ total_flag_n_nvt_12_l110e*drdsw_n_nvt_12_l110e_t
parameters  dk3_n_nvt_12_l110e = (global_flag_n_nvt_12_l110e*dk3_n_nvt_12_l110e_g  + local_flag_n_nvt_12_l110e*dk3_n_nvt_12_l110e_l)*(1-total_flag_n_nvt_12_l110e)+ total_flag_n_nvt_12_l110e*dk3_n_nvt_12_l110e_t
parameters  dpvth0_n_nvt_12_l110e = (global_flag_n_nvt_12_l110e*dpvth0_n_nvt_12_l110e_g  + local_flag_n_nvt_12_l110e*dpvth0_n_nvt_12_l110e_l)*(1-total_flag_n_nvt_12_l110e)+ total_flag_n_nvt_12_l110e*dpvth0_n_nvt_12_l110e_t
parameters  dwwl_n_nvt_12_l110e = (global_flag_n_nvt_12_l110e*dwwl_n_nvt_12_l110e_g  + local_flag_n_nvt_12_l110e*dwwl_n_nvt_12_l110e_l)*(1-total_flag_n_nvt_12_l110e)+ total_flag_n_nvt_12_l110e*dwwl_n_nvt_12_l110e_t
parameters  dcj_n_nvt_12_l110e = (global_flag_n_nvt_12_l110e*dcj_n_nvt_12_l110e_g  + local_flag_n_nvt_12_l110e*dcj_n_nvt_12_l110e_l)*(1-total_flag_n_nvt_12_l110e)+ total_flag_n_nvt_12_l110e*dcj_n_nvt_12_l110e_t
parameters  dcjsw_n_nvt_12_l110e = (global_flag_n_nvt_12_l110e*dcjsw_n_nvt_12_l110e_g  + local_flag_n_nvt_12_l110e*dcjsw_n_nvt_12_l110e_l)*(1-total_flag_n_nvt_12_l110e)+ total_flag_n_nvt_12_l110e*dcjsw_n_nvt_12_l110e_t
parameters  dcjswg_n_nvt_12_l110e = (global_flag_n_nvt_12_l110e*dcjswg_n_nvt_12_l110e_g  + local_flag_n_nvt_12_l110e*dcjswg_n_nvt_12_l110e_l)*(1-total_flag_n_nvt_12_l110e)+ total_flag_n_nvt_12_l110e*dcjswg_n_nvt_12_l110e_t
parameters  dcgdo_n_nvt_12_l110e = (global_flag_n_nvt_12_l110e*dcgdo_n_nvt_12_l110e_g  + local_flag_n_nvt_12_l110e*dcgdo_n_nvt_12_l110e_l)*(1-total_flag_n_nvt_12_l110e)+ total_flag_n_nvt_12_l110e*dcgdo_n_nvt_12_l110e_t
parameters  dcgso_n_nvt_12_l110e = (global_flag_n_nvt_12_l110e*dcgso_n_nvt_12_l110e_g  + local_flag_n_nvt_12_l110e*dcgso_n_nvt_12_l110e_l)*(1-total_flag_n_nvt_12_l110e)+ total_flag_n_nvt_12_l110e*dcgso_n_nvt_12_l110e_t

//
n_nvt_12_l110e ( d g s b ) n_nvt_12_l110e_main trise=dtemp w=w l=l as=as ad=ad ps=ps pd=pd
+ m=1 dtemp=dtemp
model n_nvt_12_l110e_main bsim3v3 type=n
+ version    = 3.24                                                        binunit    = 1
+ paramchk   = 0                                                           mobmod     = 1
+ capmod     = 3                                                           nqsmod     = 0
+ lmin       = 1.08e-6                                                     lmax       = 5e-5
+ wmin       = 0.9e-6                                                      wmax       = 1e-4
+ tox        = 2.64e-9+dtox_n_nvt_12_l110e                                 toxm       = 2.64e-9
+ xj         = 1.07e-7                                                     nch        = 1.7e17
+ wint       = 9.187242e-8                                                 wl         = -2.489921e-16
+ wln        = 1.354859                                                    ww         = -2.6612e-14
+ wwn        = 1                                                           wwl        = -1.4664e-22+dwwl_n_nvt_12_l110e
+ lint       = 1.575401e-7                                                 ll         = -3.675e-13
+ lln        = 0.886479                                                    lw         = 0
+ lwn        = 1                                                           lwl        = -4.60561e-20
+ llc        = -5.48e-14                                                   lwc        = 0
+ lwlc       = 0                                                           wlc        = 0
+ wwc        = 0                                                           wwlc       = 0
+ dwg        = -2.319682e-8                                                dwb        = 6.625453e-9
+ lref       = 1e20                                                        wref       = 1e20
+ xl         = -2.5e-8+1.2e-8+dxl_n_nvt_12_l110e                           xw         = -1.8e-8+dxw_n_nvt_12_l110e
+ elm        = 5                                                           vth0       = -8.57558e-2+dvth0_n_nvt_12_l110e
+ lvth0      = -4e-3+dlvth0_n_nvt_12_l110e                                 k1         = 0.067774
+ k2         = -0.018551                                                   k3         = 2.705416+dk3_n_nvt_12_l110e
+ k3b        = -8.65695                                                    w0         = 8.116925e-7
+ nlx        = 7.61671e-6                                                  dvt0       = 8.345975
+ dvt1       = 0.252612                                                    dvt2       = 0.17664
+ dvt0w      = -5.57213e-2                                                 dvt1w      = 1.74074e5
+ dvt2w      = -0.1416                                                     ngate      = 5e20
+ pvth0      = 0+dpvth0_n_nvt_12_l110e                                     u0         = 4.53649e-2+du0_n_nvt_12_l110e
+ ua         = 5.99365e-10                                                 ub         = 1.682905e-18
+ uc         = -1.555715e-11                                               puc        = -1.9e-11
+ vsat       = 6.999999e5                                                  a0         = 4.2
+ ags        = 1.46                                                        b0         = 2.588143e-6
+ b1         = 1.295654e-6                                                 keta       = -2.86623e-2
+ a1         = 1.00003e-2                                                  a2         = 6.71974e-2
+ rdsw       = 212.592+drdsw_n_nvt_12_l110e                                prwb       = -0.395949
+ prwg       = 0                                                           wr         = 1.584116
+ voff       = -0.078708                                                   nfactor    = 2
+ eta0       = 6.8                                                         etab       = 0
+ dsub       = 0.43                                                        cit        = 1.26225e-4
+ cdsc       = 0.01                                                        cdscb      = 0
+ cdscd      = 0.09                                                        pclm       = 1.702045
+ pdiblc1    = 0.282131                                                    pdiblc2    = 0.112143
+ pdiblcb    = 0.025                                                       drout      = 0.54535
+ pscbe1     = 3e8                                                         pscbe2     = 1.948382e-6
+ pvag       = 7                                                           delta      = 0.01
+ alpha0     = -2e-11                                                      alpha1     = 0.012
+ beta0      = 10.2                                                        ldif       = 7e-8
+ hdif       = 1.8e-6                                                      rsh        = 8.5
+ rd         = 0                                                           rs         = 0
+ rsc        = 0                                                           rdc        = 0
+ xpart      = 1                                                           cgso       = 1.1e-10+dcgso_n_nvt_12_l110e
+ cgdo       = 1.1e-10+dcgdo_n_nvt_12_l110e                                cgbo       = 0
+ cj         = 1.318605e-4+dcj_n_nvt_12_l110e                              mj         = 0.297081
+ mjsw       = 4.88325e-2                                                  cjsw       = 3.122074e-10+dcjsw_n_nvt_12_l110e
+ cjswg      = 1.241452e-10+dcjswg_n_nvt_12_l110e                          mjswg      = 0.377627
+ js         = 1.788e-6                                                    jsw        = 1.77e-12
+ pbsw       = 0.33                                                        pb         = 0.34
+ pbswg      = 0.31                                                        ckappa     = 0.6
+ clc        = 1e-7                                                        cle        = 0.6
+ dlc        = 7.58e-10                                                    dwc        = 0
+ vfbcv      = -1                                                          noff       = 2.655
+ voffcv     = -0.1                                                        imelt      = 1
+ acde       = 0.5                                                         moin       = 15
+ cgsl       = 9e-11                                                       cgdl       = 9e-11
+ tnom       = 25                                                          ute        = -2.45
+ wute       = 0.1764                                                      kt1        = -0.291776
+ kt1l       = -1.7e-8                                                     kt2        = -1.57696e-2
+ ua1        = -2.62736e-10                                                wua1       = 2.121117e-10
+ pua1       = 4.501709e-10                                                ub1        = -2.4352e-18
+ uc1        = -5.6e-11                                                    luc1       = 6.79e-11
+ puc1       = 1.581898e-10                                                at         = 1.5972e5
+ prt        = 0                                                           nj         = 1.03
+ xti        = 5.5                                                         tpb        = 1.55e-3
+ tpbsw      = 1.9e-3                                                      tpbswg     = 1.65e-3
+ tcj        = 1.8e-3                                                      tcjsw      = 3.2e-4
+ tcjswg     = 2.45e-3
ends
