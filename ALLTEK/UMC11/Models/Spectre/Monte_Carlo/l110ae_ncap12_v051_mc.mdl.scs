//
simulator lang=spectre insensitive=yes
//
inline subckt ncap_12 ( port1 port2 )
parameters  wf=1u lf=1u nf=2 mf =1 mis_flag=1 nrd=hdif / (wf*0.9) nrs=hdif / (wf*0.9) ad=2 * hdif * (wf*0.9) as=2 * hdif * (wf*0.9) pd=2 * (2 * hdif+(wf*0.9)) ps=2 * (2 * hdif+(wf*0.9)) dtemp=0 sa=2u sb=2u
parameters  toxc=2.83e-09+dtoxe_ncap_12 pva=0.24471966 pvb=0.72116211+tpvb * (temp - 25)
parameters  pvc=0.66326301+tpvc * (temp - 25) pvd=4.9124924 pve=1.2121193 pvf=-1.2402805
parameters  pvg=0.099855236 pvh=-0.84471911 pvi=-0.49592303 pvj=-0.65302372 pvk=-0.25419574
parameters  tpvb=0.0002 tpvc=-5.279e-05 dcw=-0.01618+1e6 * dxw_ncap_12 cww=0.1 cwl=-0.004271
parameters  cwwl=0.01599 dcl=-0.02211+1e6 * dxl_ncap_12 cll=-0.002303 clw=0.05 clwl=-0.003822
parameters  weff=(wf * 0.9 * 1e6)+dcw+cww / (wf * 0.9 * 1e6)+cwl / (lf * 0.9 * 1e6+ 0.012)+cwwl / (wf * 0.9 * 1e6) / (lf * 0.9 * 1e6+0.012)
parameters  leff=(lf * 0.9 * 1e6 +0.012)+dcl+cll / (lf * 0.9 * 1e6+0.012)+clw / (wf * 0.9 * 1e6)+clwl / (wf * 0.9 * 1e6) / (lf * 0.9 * 1e6+0.012)
parameters  cl3=9.594e-05 cl2=-0.0004231 cl1=-0.000206 cl0=0.001223 cw0=0 cwl0=0
parameters  ccom=(((cl3 * pow((lf * 0.9 * 1e6+0.012),3)+cl2  * pow((lf * 0.9 * 1e6+0.012),2)+cl1 * (lf * 0.9 * 1e6+0.012)+cl0) * ((wf * 0.9 * 1e6)+dcw)+cw0 / (wf * 0.9 * 1e6)) * (1+cwl0 / ((wf * 0.9 * 1e6) * (lf * 0.9 * 1e6+0.012))))
parameters  cmina=0+dcmina_ncap_12 cminb=-1.409080588 cminc=-0.040071884
parameters  cmind=0.18900929
parameters  rsh=7.6 hdif=1.25e-07 tcig=1 + 2.25e-3 * (temp + dtemp - 25)
parameters  area=wf * 0.9 * (lf*0.9+0.012u) * nf * 1e4 * tcig
parameters  toxg=(2.83e-09+dtoxe_ncap_12) *  1e2 vdf0=2.8  vdfl=-1e-008 vdfw=-1.7e-007 vaf0=0.6 vafl=5e-009 vafw=1e-008 vdr0=5.2
parameters  vdrl=4e-008 vdrw=-1.7e-007 var0=0.2 varl=0e-008 varw=8e-008 vdf=(vdf0+vdfl / (lf*0.9+0.012u)+vdfw / (wf * 0.9)) * 2.6e7 * toxg
parameters  vaf=(vaf0+vafl / (lf*0.9+0.012u)+vafw / (wf * 0.9)) * 2.6e7 * toxg
parameters  vdr=(vdr0+vdrl / (lf*0.9+0.012u)+vdrw / (wf * 0.9)) * 2.6e7 * toxg var=(var0+varl / (lf*0.9+0.012u)+varw / (wf * 0.9)) * 2.6e7 * toxg igf=2.1e-7 * area * exp( - vdf) * pow(1 / toxg,2.0)
parameters  igr=2.1e-7 * area / (lf*0.9+0.012u) * exp( - vdr) * pow(1 / toxg,2.0)

//******************
//**** MISMATCH ****
//******************
parameters cotn = 11.0/1.414
parameters potn = -0.96

ncap_12 ( port1 port2 ) bsource c=((pva+pvc * pow(v(port1,port2),1)+pve * pow(v(port1,port2),2)
++pvg * pow(v(port1,port2),3)+pvi * pow(v(port1,port2),4)+pvk * pow(v(port1,port2),5))
+ / (1+pvb * pow(v(port1,port2),1)+pvd * pow(v(port1,port2),2)+pvf * pow(v(port1,port2),3)
++pvh * pow(v(port1,port2),4)+pvj * pow(v(port1,port2),5)) * 2.83e-09 * weff
+ * leff / toxc / 4.5 / 1.812 / 4+ccom * 2.83e-09 / toxc / 4) * nf * 1e-12 * (1
++cmina * (cminb+atan((v(port1,port2) - cminc) / cmind)))*(1+mc_ncap_12_ma*mis_flag*0.01*((0.008*exp(-0.8108*v(port1, port2)))+cotn*(1e+15*((pva+pvc*pow(v(port1, port2),1)+pve*pow(v(port1, port2),2)+pvg*pow(v(port1, port2),3)+pvi*pow(v(port1, port2),4)+pvk*pow(v(port1, port2),5))/(1+pvb*pow(v(port1, port2),1)+pvd*pow(v(port1, port2),2)+pvf*pow(v(port1, port2),3)+pvh*pow(v(port1, port2),4)+pvj*pow(v(port1, port2),5))*2.83e-09*weff*leff/toxc/4.5/1.812/4+ccom*2.83e-09/toxc/4)*nf*1e-12*(1+cmina*(cminb+atan((v(port1, port2)-cminc)/cmind)))*mf)**potn))

// Igate simulation
gigcd ( port1 port2 ) bsource i = igf * pow((abs(v(port2,port1)) - v(port2,port1))
+ / 2,vaf) - igr * pow((abs(v(port2,port1)) + v(port2,port1)) / 2,var)
gigcs ( port1 port2 ) bsource i = igf * pow((abs(v(port2,port1)) - v(port2,port1))
+ / 2,vaf) - igr * pow((abs(v(port2,port1)) + v(port2,port1)) / 2,var)

ends ncap_12
