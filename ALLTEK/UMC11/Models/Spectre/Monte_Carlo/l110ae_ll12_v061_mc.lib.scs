simulator lang=spectre insensitive=yes
library mylib

section tt
parameters dtox_n_12_lll110e_t=0
parameters du0_n_12_lll110e_t=0
parameters dvth0_n_12_lll110e_t=0
parameters dxl_n_12_lll110e_t=0
parameters dxw_n_12_lll110e_t=0
parameters dnlx_n_12_lll110e_t=0
parameters dk3_n_12_lll110e_t=0
parameters dpvth0_n_12_lll110e_t=0
parameters dwwl_n_12_lll110e_t=0
parameters dcj_n_12_lll110e_t=0
parameters dcjsw_n_12_lll110e_t=0
parameters dcjswg_n_12_lll110e_t=0
parameters dcgdo_n_12_lll110e_t=0
parameters dcgso_n_12_lll110e_t=0
parameters dcf_n_12_lll110e_t=0
parameters dcgdl_n_12_lll110e_t=0
parameters dcgsl_n_12_lll110e_t=0
parameters dvsat_n_12_lll110e_t=0
parameters dags_n_12_lll110e_t=0
parameters drdsw_n_12_lll110e_t=0
parameters dwags_n_12_lll110e_t=0
parameters dpvsat_n_12_lll110e_t=0
parameters dtox_p_12_lll110e_t=0
parameters dxl_p_12_lll110e_t=0
parameters du0_p_12_lll110e_t=0
parameters dvth0_p_12_lll110e_t=0
parameters drdsw_p_12_lll110e_t=0
parameters dxw_p_12_lll110e_t=0
parameters dnlx_p_12_lll110e_t=0
parameters dk3_p_12_lll110e_t=0
parameters dpvth0_p_12_lll110e_t=0
parameters dwwl_p_12_lll110e_t=0
parameters dcgdo_p_12_lll110e_t=0
parameters dcgso_p_12_lll110e_t=0
parameters dcj_p_12_lll110e_t=0
parameters dcjsw_p_12_lll110e_t=0
parameters dcjswg_p_12_lll110e_t=0
parameters dcgdl_p_12_lll110e_t=0
parameters dcgsl_p_12_lll110e_t=0
parameters dcf_p_12_lll110e_t=0
parameters dags_p_12_lll110e_t=0
parameters dwags_p_12_lll110e_t=0
parameters dpvsat_p_12_lll110e_t=0
parameters dvsat_p_12_lll110e_t=0
parameters dwu0_p_12_lll110e_t=0
parameters dpu0_p_12_lll110e_t=0
parameters dlags_p_12_lll110e_t=0
parameters dpags_p_12_lll110e_t=0
//
endsection tt
//  *******************************
section ff
parameters dtox_n_12_lll110e_t=-8.0000e-11
parameters du0_n_12_lll110e_t=0.5761e-03
parameters dvth0_n_12_lll110e_t=-2.0050e-02
parameters dxl_n_12_lll110e_t=-6.0599e-10
parameters dxw_n_12_lll110e_t=1.1618e-08
parameters dnlx_n_12_lll110e_t=-8.8082e-09
parameters dk3_n_12_lll110e_t=-6.5590e+00
parameters dpvth0_n_12_lll110e_t=-9.1999e-16
parameters dwwl_n_12_lll110e_t=8.8091e-19
parameters dcj_n_12_lll110e_t=-7.2000e-05
parameters dcjsw_n_12_lll110e_t=-9.94e-012
parameters dcjswg_n_12_lll110e_t=-4.11e-011
parameters dcgdo_n_12_lll110e_t=1.86501e-011
parameters dcgso_n_12_lll110e_t=1.86501e-011
parameters dcf_n_12_lll110e_t=9.0586e-012
parameters dcgdl_n_12_lll110e_t=3.1552e-012
parameters dcgsl_n_12_lll110e_t=3.1552e-012
parameters dvsat_n_12_lll110e_t=-7.08e+3
parameters dags_n_12_lll110e_t=-0.1705
parameters drdsw_n_12_lll110e_t=-0.7
parameters dwags_n_12_lll110e_t=-6.05e-9
parameters dpvsat_n_12_lll110e_t=-3.8e-11
parameters dtox_p_12_lll110e_t=-8.49000e-11
parameters dxl_p_12_lll110e_t=-6.00000e-10
parameters du0_p_12_lll110e_t=3.98880e-04
parameters dvth0_p_12_lll110e_t=2.00890e-02
parameters drdsw_p_12_lll110e_t=-8.825720e+01
parameters dxw_p_12_lll110e_t=2.20010e-9
parameters dnlx_p_12_lll110e_t=-5.51230e-09
parameters dk3_p_12_lll110e_t=-2.43320e+00
parameters dpvth0_p_12_lll110e_t=1.83340e-15
parameters dwwl_p_12_lll110e_t=7.04970e-23
parameters dcgdo_p_12_lll110e_t=1.6275e-11
parameters dcgso_p_12_lll110e_t=1.6275e-11
parameters dcj_p_12_lll110e_t=-9.6900e-05
parameters dcjsw_p_12_lll110e_t=-1.18000e-11
parameters dcjswg_p_12_lll110e_t=-5.31e-011
parameters dcgdl_p_12_lll110e_t=8.3591e-012
parameters dcgsl_p_12_lll110e_t=8.3591e-012
parameters dcf_p_12_lll110e_t=8.9044e-012
parameters dags_p_12_lll110e_t=-0.169
parameters dwags_p_12_lll110e_t=-1.05e-8
parameters dpvsat_p_12_lll110e_t=0
parameters dvsat_p_12_lll110e_t=0
parameters dwu0_p_12_lll110e_t=-5.8e-11
parameters dpu0_p_12_lll110e_t=1.7e-17
parameters dlags_p_12_lll110e_t=-2.19e-7
parameters dpags_p_12_lll110e_t=-1.00e-13
//
endsection ff
//  *******************************
section ss
parameters dtox_n_12_lll110e_t=8.0000e-11
parameters du0_n_12_lll110e_t=-0.8035e-03
parameters dvth0_n_12_lll110e_t=2.0051e-02
parameters dxl_n_12_lll110e_t=1.0485e-09
parameters dxw_n_12_lll110e_t=-1.6414e-08
parameters dnlx_n_12_lll110e_t=8.5609e-09
parameters dk3_n_12_lll110e_t=6.5618e+00
parameters dpvth0_n_12_lll110e_t=8.9634e-16
parameters dwwl_n_12_lll110e_t=-2.5050e-19
parameters dcj_n_12_lll110e_t=7.2000e-05
parameters dcjsw_n_12_lll110e_t=9.94e-012
parameters dcjswg_n_12_lll110e_t=4.11e-011
parameters dcgdo_n_12_lll110e_t=-1.86501e-011
parameters dcgso_n_12_lll110e_t=-1.86501e-011
parameters dcf_n_12_lll110e_t=-9.0586e-012
parameters dcgdl_n_12_lll110e_t=-3.1552e-012
parameters dcgsl_n_12_lll110e_t=-3.1552e-012
parameters dvsat_n_12_lll110e_t=9.9e+3
parameters dags_n_12_lll110e_t=0.1815
parameters drdsw_n_12_lll110e_t=1.8
parameters dwags_n_12_lll110e_t=6.15e-9
parameters dpvsat_n_12_lll110e_t=6.1e-10
parameters dtox_p_12_lll110e_t=8.49000e-11
parameters dxl_p_12_lll110e_t=3.00000e-09
parameters du0_p_12_lll110e_t=-5.14430e-04
parameters dvth0_p_12_lll110e_t=-2.01100e-02
parameters drdsw_p_12_lll110e_t=1.03470e+02
parameters dxw_p_12_lll110e_t=-1.66090e-09
parameters dnlx_p_12_lll110e_t=6.00120e-09
parameters dk3_p_12_lll110e_t=2.32430e+00
parameters dpvth0_p_12_lll110e_t=-1.77190e-15
parameters dwwl_p_12_lll110e_t=6.84880e-23
parameters dcgdo_p_12_lll110e_t=-1.6275e-11
parameters dcgso_p_12_lll110e_t=-1.6275e-11
parameters dcj_p_12_lll110e_t=9.6900e-05
parameters dcjsw_p_12_lll110e_t=1.18000e-11
parameters dcjswg_p_12_lll110e_t=5.31e-011
parameters dcgdl_p_12_lll110e_t=-8.3591e-012
parameters dcgsl_p_12_lll110e_t=-8.3591e-012
parameters dcf_p_12_lll110e_t=-8.9044e-012
parameters dags_p_12_lll110e_t=0.1675
parameters dwags_p_12_lll110e_t=1.5e-8
parameters dpvsat_p_12_lll110e_t=0
parameters dvsat_p_12_lll110e_t=0
parameters dwu0_p_12_lll110e_t=5.25e-11
parameters dpu0_p_12_lll110e_t=-2.26e-17
parameters dlags_p_12_lll110e_t=3.48e-7
parameters dpags_p_12_lll110e_t=1.05e-13
//
endsection ss
//  *******************************
section fnsp
parameters dtox_n_12_lll110e_t=0
parameters du0_n_12_lll110e_t=0.4981e-03
parameters dvth0_n_12_lll110e_t=-1.9000e-02
parameters dxl_n_12_lll110e_t=-1.0061e-10
parameters dxw_n_12_lll110e_t=0.640e-08
parameters dnlx_n_12_lll110e_t=-6.3970e-09
parameters dk3_n_12_lll110e_t=-3.0274e+00
parameters dpvth0_n_12_lll110e_t=-4.7111e-16
parameters dwwl_n_12_lll110e_t=3.9845e-19
parameters dcj_n_12_lll110e_t=-7.2000e-05
parameters dcjsw_n_12_lll110e_t=-9.94e-012
parameters dcjswg_n_12_lll110e_t=-4.11e-011
parameters dcgdo_n_12_lll110e_t=0
parameters dcgso_n_12_lll110e_t=0
parameters dcf_n_12_lll110e_t=0
parameters dcgdl_n_12_lll110e_t=0
parameters dcgsl_n_12_lll110e_t=0
parameters dvsat_n_12_lll110e_t=-1.65e+3
parameters dags_n_12_lll110e_t=-0.0805
parameters drdsw_n_12_lll110e_t=-0.80
parameters dwags_n_12_lll110e_t=-3.025e-9
parameters dpvsat_n_12_lll110e_t=-7.5e-11
parameters dtox_p_12_lll110e_t=0.00000e+00
parameters dxl_p_12_lll110e_t=1.50000e-09
parameters du0_p_12_lll110e_t=-2.90230e-04
parameters dvth0_p_12_lll110e_t=-1.93110e-02
parameters drdsw_p_12_lll110e_t=0.33770e+02
parameters dxw_p_12_lll110e_t=-0.83090e-09
parameters dnlx_p_12_lll110e_t=3.54220e-09
parameters dk3_p_12_lll110e_t=1.17910e+00
parameters dpvth0_p_12_lll110e_t=-8.49900e-16
parameters dwwl_p_12_lll110e_t=2.50840e-23
parameters dcgdo_p_12_lll110e_t=0
parameters dcgso_p_12_lll110e_t=0
parameters dcj_p_12_lll110e_t=9.6900e-05
parameters dcjsw_p_12_lll110e_t=1.18000e-11
parameters dcjswg_p_12_lll110e_t=5.31e-011
parameters dcgdl_p_12_lll110e_t=0
parameters dcgsl_p_12_lll110e_t=0
parameters dcf_p_12_lll110e_t=0
parameters dags_p_12_lll110e_t=0.0717
parameters dwags_p_12_lll110e_t=0.85e-8
parameters dpvsat_p_12_lll110e_t=0
parameters dvsat_p_12_lll110e_t=0
parameters dwu0_p_12_lll110e_t=3.40e-11
parameters dpu0_p_12_lll110e_t=-0.85e-17
parameters dlags_p_12_lll110e_t=2.09e-7
parameters dpags_p_12_lll110e_t=0.370e-13
//
endsection fnsp
//  *******************************
section snfp
parameters dtox_n_12_lll110e_t=0
parameters du0_n_12_lll110e_t=-0.5417e-03
parameters dvth0_n_12_lll110e_t=1.9000e-02
parameters dxl_n_12_lll110e_t=0.2785e-09
parameters dxw_n_12_lll110e_t=-0.7514e-08
parameters dnlx_n_12_lll110e_t=6.5683e-09
parameters dk3_n_12_lll110e_t=3.1034e+00
parameters dpvth0_n_12_lll110e_t=4.7572e-16
parameters dwwl_n_12_lll110e_t=-2.8050e-19
parameters dcj_n_12_lll110e_t=7.2000e-05
parameters dcjsw_n_12_lll110e_t=9.94e-012
parameters dcjswg_n_12_lll110e_t=4.11e-011
parameters dcgdo_n_12_lll110e_t=0
parameters dcgso_n_12_lll110e_t=0
parameters dcf_n_12_lll110e_t=0
parameters dcgdl_n_12_lll110e_t=0
parameters dcgsl_n_12_lll110e_t=0
parameters dvsat_n_12_lll110e_t=2.50e+3
parameters dags_n_12_lll110e_t=0.0855
parameters drdsw_n_12_lll110e_t=0.7
parameters dwags_n_12_lll110e_t=3.07e-9
parameters dpvsat_n_12_lll110e_t=2.00e-10
parameters dtox_p_12_lll110e_t=0.00000e+00
parameters dxl_p_12_lll110e_t=-3.00000e-10
parameters du0_p_12_lll110e_t=2.56440e-04
parameters dvth0_p_12_lll110e_t=1.96890e-02
parameters drdsw_p_12_lll110e_t=-5.212720e+01
parameters dxw_p_12_lll110e_t=1.10010e-9
parameters dnlx_p_12_lll110e_t=-2.95250e-09
parameters dk3_p_12_lll110e_t=-1.09344e+00
parameters dpvth0_p_12_lll110e_t=9.64610e-16
parameters dwwl_p_12_lll110e_t=1.27070e-23
parameters dcgdo_p_12_lll110e_t=0
parameters dcgso_p_12_lll110e_t=0
parameters dcj_p_12_lll110e_t=-9.6900e-05
parameters dcjsw_p_12_lll110e_t=-1.18000e-11
parameters dcjswg_p_12_lll110e_t=-5.31e-011
parameters dcgdl_p_12_lll110e_t=0
parameters dcgsl_p_12_lll110e_t=0
parameters dcf_p_12_lll110e_t=0
parameters dags_p_12_lll110e_t=-0.0782
parameters dwags_p_12_lll110e_t=-0.442e-8
parameters dpvsat_p_12_lll110e_t=0
parameters dvsat_p_12_lll110e_t=0
parameters dwu0_p_12_lll110e_t=-3.3e-11
parameters dpu0_p_12_lll110e_t=0.77e-17
parameters dlags_p_12_lll110e_t=-1.008e-7
parameters dpags_p_12_lll110e_t=-0.546e-13
//
endsection snfp
//
//  **********************************local****************************************************
section tt_g
parameters dtox_n_12_lll110e_g=0.0000000e+000
parameters du0_n_12_lll110e_g=0.0000000e+000
parameters dvth0_n_12_lll110e_g=0.0000000e+000
parameters dxl_n_12_lll110e_g=0.0000000e+000
parameters dxw_n_12_lll110e_g=0.0000000e+000
parameters dnlx_n_12_lll110e_g=0.0000000e+000
parameters dk3_n_12_lll110e_g=0.0000000e+000
parameters dpvth0_n_12_lll110e_g=0.0000000e+000
parameters dwwl_n_12_lll110e_g=0.0000000e+000
parameters dcj_n_12_lll110e_g=0.0000000e+000
parameters dcjsw_n_12_lll110e_g=0.0000000e+000
parameters dcjswg_n_12_lll110e_g=0.0000000e+000
parameters dcgdo_n_12_lll110e_g=0.0000000e+000
parameters dcgso_n_12_lll110e_g=0.0000000e+000
parameters dcf_n_12_lll110e_g=0.0000000e+000
parameters dcgdl_n_12_lll110e_g=0.0000000e+000
parameters dcgsl_n_12_lll110e_g=0.0000000e+000
parameters dvsat_n_12_lll110e_g=0.0000000e+000
parameters dags_n_12_lll110e_g=0.0000000e+000
parameters drdsw_n_12_lll110e_g=0.0000000e+000
parameters dwags_n_12_lll110e_g=0.0000000e+000
parameters dpvsat_n_12_lll110e_g=0.0000000e+000
parameters dtox_p_12_lll110e_g=0.0000000e+000
parameters dxl_p_12_lll110e_g=0.0000000e+000
parameters du0_p_12_lll110e_g=0.0000000e+000
parameters dvth0_p_12_lll110e_g=0.0000000e+000
parameters drdsw_p_12_lll110e_g=0.0000000e+000
parameters dxw_p_12_lll110e_g=0.0000000e+000
parameters dnlx_p_12_lll110e_g=0.0000000e+000
parameters dk3_p_12_lll110e_g=0.0000000e+000
parameters dpvth0_p_12_lll110e_g=0.0000000e+000
parameters dwwl_p_12_lll110e_g=0.0000000e+000
parameters dcgdo_p_12_lll110e_g=0.0000000e+000
parameters dcgso_p_12_lll110e_g=0.0000000e+000
parameters dcj_p_12_lll110e_g=0.0000000e+000
parameters dcjsw_p_12_lll110e_g=0.0000000e+000
parameters dcjswg_p_12_lll110e_g=0.0000000e+000
parameters dcgdl_p_12_lll110e_g=0.0000000e+000
parameters dcgsl_p_12_lll110e_g=0.0000000e+000
parameters dcf_p_12_lll110e_g=0.0000000e+000
parameters dags_p_12_lll110e_g=0.0000000e+000
parameters dwags_p_12_lll110e_g=0.0000000e+000
parameters dpvsat_p_12_lll110e_g=0.0000000e+000
parameters dvsat_p_12_lll110e_g=0.0000000e+000
parameters dwu0_p_12_lll110e_g=0.0000000e+000
parameters dpu0_p_12_lll110e_g=0.0000000e+000
parameters dlags_p_12_lll110e_g=0.0000000e+000
parameters dpags_p_12_lll110e_g=0.0000000e+000
//
//
endsection tt_g
//
section ff_g
parameters dtox_n_12_lll110e_g=-8.0000000e-011
parameters du0_n_12_lll110e_g=5.6721324e-004
parameters dvth0_n_12_lll110e_g=-2.0039879e-002
parameters dxl_n_12_lll110e_g=-6.0599000e-010
parameters dxw_n_12_lll110e_g=1.1830646e-008
parameters dnlx_n_12_lll110e_g=-9.0304638e-009
parameters dk3_n_12_lll110e_g=-6.6205204e+000
parameters dpvth0_n_12_lll110e_g=-2.9211094e-016
parameters dwwl_n_12_lll110e_g=1.1198012e-018
parameters dcj_n_12_lll110e_g=-7.2000000e-005
parameters dcjsw_n_12_lll110e_g=-9.9400000e-012
parameters dcjswg_n_12_lll110e_g=-4.1100000e-011
parameters dcgdo_n_12_lll110e_g=1.8650100e-011
parameters dcgso_n_12_lll110e_g=1.8650100e-011
parameters dcf_n_12_lll110e_g=9.0586000e-012
parameters dcgdl_n_12_lll110e_g=3.1552000e-012
parameters dcgsl_n_12_lll110e_g=3.1552000e-012
parameters dvsat_n_12_lll110e_g=-7.0800000e+003
parameters dags_n_12_lll110e_g=-1.7050000e-001
parameters drdsw_n_12_lll110e_g=-7.4838960e-001
parameters dwags_n_12_lll110e_g=-6.0500000e-009
parameters dpvsat_n_12_lll110e_g=-3.8000000e-011
parameters dtox_p_12_lll110e_g=-8.4900000e-011
parameters dxl_p_12_lll110e_g=-6.0000000e-010
parameters du0_p_12_lll110e_g=4.0246442e-004
parameters dvth0_p_12_lll110e_g=2.0069863e-002
parameters drdsw_p_12_lll110e_g=-8.7129227e+001
parameters dxw_p_12_lll110e_g=2.2001000e-009
parameters dnlx_p_12_lll110e_g=-5.6141328e-009
parameters dk3_p_12_lll110e_g=-2.4407528e+000
parameters dpvth0_p_12_lll110e_g=1.4257009e-015
parameters dwwl_p_12_lll110e_g=7.0497000e-023
parameters dcgdo_p_12_lll110e_g=1.6275000e-011
parameters dcgso_p_12_lll110e_g=1.6275000e-011
parameters dcj_p_12_lll110e_g=-9.6900000e-005
parameters dcjsw_p_12_lll110e_g=-1.1800000e-011
parameters dcjswg_p_12_lll110e_g=-5.3100000e-011
parameters dcgdl_p_12_lll110e_g=8.3591000e-012
parameters dcgsl_p_12_lll110e_g=8.3591000e-012
parameters dcf_p_12_lll110e_g=8.9044000e-012
parameters dags_p_12_lll110e_g=-1.6900000e-001
parameters dwags_p_12_lll110e_g=-1.0500000e-008
parameters dpvsat_p_12_lll110e_g=0.0000000e+000
parameters dvsat_p_12_lll110e_g=0.0000000e+000
parameters dwu0_p_12_lll110e_g=-5.9615394e-011
parameters dpu0_p_12_lll110e_g=1.6637577e-017
parameters dlags_p_12_lll110e_g=-2.1900000e-007
parameters dpags_p_12_lll110e_g=-1.0000000e-013
//
//
endsection ff_g
//
section ss_g
parameters dtox_n_12_lll110e_g=8.0000000e-011
parameters du0_n_12_lll110e_g=-7.9462193e-004
parameters dvth0_n_12_lll110e_g=2.0031605e-002
parameters dxl_n_12_lll110e_g=1.0485000e-009
parameters dxw_n_12_lll110e_g=-1.6668040e-008
parameters dnlx_n_12_lll110e_g=8.8192969e-009
parameters dk3_n_12_lll110e_g=6.6704462e+000
parameters dpvth0_n_12_lll110e_g=2.1614407e-016
parameters dwwl_n_12_lll110e_g=-7.9552370e-019
parameters dcj_n_12_lll110e_g=7.2000000e-005
parameters dcjsw_n_12_lll110e_g=9.9400000e-012
parameters dcjswg_n_12_lll110e_g=4.1100000e-011
parameters dcgdo_n_12_lll110e_g=-1.8650100e-011
parameters dcgso_n_12_lll110e_g=-1.8650100e-011
parameters dcf_n_12_lll110e_g=-9.0586000e-012
parameters dcgdl_n_12_lll110e_g=-3.1552000e-012
parameters dcgsl_n_12_lll110e_g=-3.1552000e-012
parameters dvsat_n_12_lll110e_g=9.9000000e+003
parameters dags_n_12_lll110e_g=1.8150000e-001
parameters drdsw_n_12_lll110e_g=2.0938187e+000
parameters dwags_n_12_lll110e_g=6.1500000e-009
parameters dpvsat_n_12_lll110e_g=6.1000000e-010
parameters dtox_p_12_lll110e_g=8.4900000e-011
parameters dxl_p_12_lll110e_g=3.0000000e-009
parameters du0_p_12_lll110e_g=-5.2102970e-004
parameters dvth0_p_12_lll110e_g=-2.0079831e-002
parameters drdsw_p_12_lll110e_g=1.0149969e+002
parameters dxw_p_12_lll110e_g=-1.6609000e-009
parameters dnlx_p_12_lll110e_g=6.0993515e-009
parameters dk3_p_12_lll110e_g=2.3282886e+000
parameters dpvth0_p_12_lll110e_g=-1.3964519e-015
parameters dwwl_p_12_lll110e_g=6.8488000e-023
parameters dcgdo_p_12_lll110e_g=-1.6275000e-011
parameters dcgso_p_12_lll110e_g=-1.6275000e-011
parameters dcj_p_12_lll110e_g=9.6900000e-005
parameters dcjsw_p_12_lll110e_g=1.1800000e-011
parameters dcjswg_p_12_lll110e_g=5.3100000e-011
parameters dcgdl_p_12_lll110e_g=-8.3591000e-012
parameters dcgsl_p_12_lll110e_g=-8.3591000e-012
parameters dcf_p_12_lll110e_g=-8.9044000e-012
parameters dags_p_12_lll110e_g=1.6750000e-001
parameters dwags_p_12_lll110e_g=1.5000000e-008
parameters dpvsat_p_12_lll110e_g=0.0000000e+000
parameters dvsat_p_12_lll110e_g=0.0000000e+000
parameters dwu0_p_12_lll110e_g=5.3047447e-011
parameters dpu0_p_12_lll110e_g=-1.7214471e-017
parameters dlags_p_12_lll110e_g=3.4800000e-007
parameters dpags_p_12_lll110e_g=1.0500000e-013
//
//
endsection ss_g
//
section fnsp_g
parameters dtox_n_12_lll110e_g=0.0000000e+000
parameters du0_n_12_lll110e_g=5.6147174e-004
parameters dvth0_n_12_lll110e_g=-1.8373049e-002
parameters dxl_n_12_lll110e_g=-1.0061000e-010
parameters dxw_n_12_lll110e_g=6.5279380e-009
parameters dnlx_n_12_lll110e_g=-6.4251331e-009
parameters dk3_n_12_lll110e_g=-3.0464471e+000
parameters dpvth0_n_12_lll110e_g=-1.4190119e-016
parameters dwwl_n_12_lll110e_g=4.9303950e-019
parameters dcj_n_12_lll110e_g=-7.2000000e-005
parameters dcjsw_n_12_lll110e_g=-9.9400000e-012
parameters dcjswg_n_12_lll110e_g=-4.1100000e-011
parameters dcgdo_n_12_lll110e_g=0.0000000e+000
parameters dcgso_n_12_lll110e_g=0.0000000e+000
parameters dcf_n_12_lll110e_g=0.0000000e+000
parameters dcgdl_n_12_lll110e_g=0.0000000e+000
parameters dcgsl_n_12_lll110e_g=0.0000000e+000
parameters dvsat_n_12_lll110e_g=-1.6500000e+003
parameters dags_n_12_lll110e_g=-8.0500000e-002
parameters drdsw_n_12_lll110e_g=-2.0299516e+000
parameters dwags_n_12_lll110e_g=-3.0250000e-009
parameters dpvsat_n_12_lll110e_g=-7.5000000e-011
parameters dtox_p_12_lll110e_g=0.0000000e+000
parameters dxl_p_12_lll110e_g=1.5000000e-009
parameters du0_p_12_lll110e_g=-3.1077041e-004
parameters dvth0_p_12_lll110e_g=-1.8943634e-002
parameters drdsw_p_12_lll110e_g=5.7236327e+001
parameters dxw_p_12_lll110e_g=-8.3090000e-010
parameters dnlx_p_12_lll110e_g=3.2795140e-009
parameters dk3_p_12_lll110e_g=1.1411906e+000
parameters dpvth0_p_12_lll110e_g=-7.2185086e-016
parameters dwwl_p_12_lll110e_g=2.5084000e-023
parameters dcgdo_p_12_lll110e_g=0.0000000e+000
parameters dcgso_p_12_lll110e_g=0.0000000e+000
parameters dcj_p_12_lll110e_g=9.6900000e-005
parameters dcjsw_p_12_lll110e_g=1.1800000e-011
parameters dcjswg_p_12_lll110e_g=5.3100000e-011
parameters dcgdl_p_12_lll110e_g=0.0000000e+000
parameters dcgsl_p_12_lll110e_g=0.0000000e+000
parameters dcf_p_12_lll110e_g=0.0000000e+000
parameters dags_p_12_lll110e_g=7.1700000e-002
parameters dwags_p_12_lll110e_g=8.5000000e-009
parameters dpvsat_p_12_lll110e_g=0.0000000e+000
parameters dvsat_p_12_lll110e_g=0.0000000e+000
parameters dwu0_p_12_lll110e_g=3.3981626e-011
parameters dpu0_p_12_lll110e_g=-5.0250860e-018
parameters dlags_p_12_lll110e_g=2.0900000e-007
parameters dpags_p_12_lll110e_g=3.7000000e-014
//
//
endsection fnsp_g
//
section snfp_g
parameters dtox_n_12_lll110e_g=0.0000000e+000
parameters du0_n_12_lll110e_g=-6.0243451e-004
parameters dvth0_n_12_lll110e_g=1.8434543e-002
parameters dxl_n_12_lll110e_g=2.7850000e-010
parameters dxw_n_12_lll110e_g=-7.2847731e-009
parameters dnlx_n_12_lll110e_g=6.6094407e-009
parameters dk3_n_12_lll110e_g=3.2804108e+000
parameters dpvth0_n_12_lll110e_g=1.0132296e-016
parameters dwwl_n_12_lll110e_g=-3.2380309e-019
parameters dcj_n_12_lll110e_g=7.2000000e-005
parameters dcjsw_n_12_lll110e_g=9.9400000e-012
parameters dcjswg_n_12_lll110e_g=4.1100000e-011
parameters dcgdo_n_12_lll110e_g=0.0000000e+000
parameters dcgso_n_12_lll110e_g=0.0000000e+000
parameters dcf_n_12_lll110e_g=0.0000000e+000
parameters dcgdl_n_12_lll110e_g=0.0000000e+000
parameters dcgsl_n_12_lll110e_g=0.0000000e+000
parameters dvsat_n_12_lll110e_g=2.5000000e+003
parameters dags_n_12_lll110e_g=8.5500000e-002
parameters drdsw_n_12_lll110e_g=1.7780523e+000
parameters dwags_n_12_lll110e_g=3.0700000e-009
parameters dpvsat_n_12_lll110e_g=2.0000000e-010
parameters dtox_p_12_lll110e_g=0.0000000e+000
parameters dxl_p_12_lll110e_g=-3.0000000e-010
parameters du0_p_12_lll110e_g=2.9353980e-004
parameters dvth0_p_12_lll110e_g=1.8746084e-002
parameters drdsw_p_12_lll110e_g=-5.3537901e+001
parameters dxw_p_12_lll110e_g=1.1001000e-009
parameters dnlx_p_12_lll110e_g=-2.9626178e-009
parameters dk3_p_12_lll110e_g=-1.1294137e+000
parameters dpvth0_p_12_lll110e_g=7.0089501e-016
parameters dwwl_p_12_lll110e_g=1.2707000e-023
parameters dcgdo_p_12_lll110e_g=0.0000000e+000
parameters dcgso_p_12_lll110e_g=0.0000000e+000
parameters dcj_p_12_lll110e_g=-9.6900000e-005
parameters dcjsw_p_12_lll110e_g=-1.1800000e-011
parameters dcjswg_p_12_lll110e_g=-5.3100000e-011
parameters dcgdl_p_12_lll110e_g=0.0000000e+000
parameters dcgsl_p_12_lll110e_g=0.0000000e+000
parameters dcf_p_12_lll110e_g=0.0000000e+000
parameters dags_p_12_lll110e_g=-7.8200000e-002
parameters dwags_p_12_lll110e_g=-4.4200000e-009
parameters dpvsat_p_12_lll110e_g=0.0000000e+000
parameters dvsat_p_12_lll110e_g=0.0000000e+000
parameters dwu0_p_12_lll110e_g=-3.9244674e-011
parameters dpu0_p_12_lll110e_g=8.5783706e-018
parameters dlags_p_12_lll110e_g=-1.0080000e-007
parameters dpags_p_12_lll110e_g=-5.4600000e-014
//
//
endsection snfp_g
//  *****************************************************************************************
endlibrary mylib
