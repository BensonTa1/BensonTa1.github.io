simulator lang=spectre insensitive=yes
// Model: l_occtout_trans_rfvil
// UMC 0.11um 1P8M top metal 41K octagonal transformer, secondary tapped
// Date: 2009-12-27
// Model coverage:
// od: (128.58 - 320) * 1e-06 (Before shrinkage)
// w: (6 - 12) * 1e-06 (Before shrinkage)
// nt_in: 1 - 4 (Integer)
// Frequency range: 1 MHz - 0.8 * resonance (maximum 30.0 GHz)
subckt l_occtout_trans_rfvil (p1 p2 s1 s2 cts gnd)
parameters od=0.00025 od_=0.003125*(od/1e-06-0) w=8e-06 w_=0.0833333*(w/1e-06-0) nt_in=2  \
t0=(nt_in==1) \
t1=(od_+3.733333e-01*w_>=0.9801) \
t2=(od_+7.733333e-01*w_>=0.945039) \
t3=(od_+7.733333e-01*w_>=1.04512) \
t4=(od_+7.733333e-01*w_>=0.944939) \
t5=(od_+3.466667e-01*w_>=0.982358) \
t6=(od_+7.733333e-01*w_>=1.07004) \
t7=(od_+7.733333e-01*w_>=0.994978) \
t8=(od_+7.733333e-01*w_>=0.994878) \
t9=(od_+3.161905e-01*w_>=0.981379) \
t10=(od_+3.405128e-01*w_>=0.982286) \
t11=(od_+7.733333e-01*w_>=1.09496) \
t12=(od_+7.733333e-01*w_>=1.04492) \
t13=(od_+3.688889e-01*w_>=0.985953) \
t14=(od_+7.733333e-01*w_>=1.11987) \
t15=(od_+7.733333e-01*w_>=1.04482) \
t16=(od_+3.321212e-01*w_>=0.980514) \
t17=(od_+3.653333e-01*w_>=0.987875) \
t18=(od_+7.733333e-01*w_>=1.09486) \
t19=(od_+3.600000e-01*w_>=0.988457) \
t20=(od_+7.733333e-01*w_>=1.14479) \
t21=(od_+7.733333e-01*w_>=1.09476) \
t22=(od_+3.200000e-01*w_>=0.97591) \
t23=(od_+7.733333e-01*w_>=1.04462) \
t24=(od_+7.733333e-01*w_>=1.06964) \
t25=(od_+3.511111e-01*w_>=0.986362) \
t26=(od_+7.733333e-01*w_>=1.19473) \
t27=(od_+7.733333e-01*w_>=1.09466) \
t28=(od_+3.009524e-01*w_>=0.966046) \
t29=(od_+7.733333e-01*w_>=1.11968) \
t30=(od_+7.733333e-01*w_>=1.14469) \
t31=(od_+7.733333e-01*w_>=1.19463) \
t32=(od_+2.666667e-01*w_>=0.944612) \
t33=(od_+4.444444e-01*w_>=1.04294) \
t34=(od_+7.200000e-01*w_>=1.20565) \
t35=(od_+3.333333e-01*w_>=0.977569) \
t36=(od_+7.200000e-01*w_>=1.20555) \
t37=(od_+3.066667e-01*w_>=0.961504) \
t38=(od_+6.133333e-01*w_>=1.17292) \
t39=(od_+6.133333e-01*w_>=1.17283) \
t40=(od_>=0.750031) \
t41=(od_+3.066667e-01*w_>=0.961368) \
t42=(od_+4.444444e-01*w_>=1.04271) \
t43=(od_>=0.781281) \
t44=(od_>=0.749969) \
t45=(od_+3.333333e-01*w_>=0.977292) \
t46=(od_>=0.812531) \
t47=(od_>=0.781219) \
t48=(od_+2.666667e-01*w_>=0.944277) \
t49=(od_+3.511111e-01*w_>=0.98594) \
t50=(od_>=0.843781) \
t51=(od_>=0.812469) \
t52=(od_>=0.843719) \
t53=(od_+3.009524e-01*w_>=0.965569) \
t54=(od_+3.600000e-01*w_>=0.987893) \
t55=(od_>=0.875031) \
t56=(od_+3.653333e-01*w_>=0.987166) \
t57=(od_>=0.906281) \
t58=(od_+3.200000e-01*w_>=0.97529) \
t59=(od_>=0.874969) \
t60=(od_+3.688889e-01*w_>=0.985101) \
t61=(od_>=0.937531) \
t62=(od_+3.321212e-01*w_>=0.979751) \
t63=(od_>=0.906219) \
t64=(od_+3.405128e-01*w_>=0.981379) \
t65=(od_>=0.968781) \
t66=(od_>=0.937469) \
t67=(od_+3.466667e-01*w_>=0.981308) \
t68=(od_+3.733333e-01*w_>=0.978961) \
t69=(od_+3.161905e-01*w_>=0.980417) \
t70=(od_>=0.968719) \
t71=(nt_in==2) \
t72=(od_+5.600000e-01*w_>=0.968258) \
t73=(od_+5.733333e-01*w_>=0.996608) \
t74=(od_+5.733333e-01*w_>=1.03821) \
t75=(od_+5.733333e-01*w_>=1.16303) \
t76=(od_+5.866667e-01*w_>=1.02488) \
t77=(od_+5.600000e-01*w_>=0.968176) \
t78=(od_+5.733333e-01*w_>=1.03789) \
t79=(od_+5.733333e-01*w_>=0.996442) \
t80=(od_+5.866667e-01*w_>=1.02479) \
t81=(od_+5.600000e-01*w_>=1.05082) \
t82=(od_+5.733333e-01*w_>=1.07965) \
t83=(od_+5.600000e-01*w_>=1.05074) \
t84=(od_+5.733333e-01*w_>=1.03773) \
t85=(od_+5.866667e-01*w_>=1.1084) \
t86=(od_+5.733333e-01*w_>=1.24575) \
t87=(od_+5.733333e-01*w_>=1.12094) \
t88=(od_+5.733333e-01*w_>=1.24591) \
t89=(od_+5.733333e-01*w_>=1.03788) \
t90=(od_+5.733333e-01*w_>=1.07949) \
t91=(od_+5.866667e-01*w_>=1.10831) \
t92=(od_+5.733333e-01*w_>=1.2043) \
t93=(od_+5.600000e-01*w_>=1.13339) \
t94=(od_+5.733333e-01*w_>=1.1627) \
t95=(od_+5.733333e-01*w_>=1.12077) \
t96=(od_+5.733333e-01*w_>=1.28719) \
t97=(od_+5.600000e-01*w_>=1.13331) \
t98=(od_+5.733333e-01*w_>=1.24559) \
t99=(od_+5.866667e-01*w_>=1.19192) \
t100=(od_+5.733333e-01*w_>=1.20398) \
t101=(od_+5.733333e-01*w_>=1.24574) \
t102=(od_+5.733333e-01*w_>=1.16253) \
t103=(od_+5.866667e-01*w_>=1.19184) \
t104=(od_+5.600000e-01*w_>=1.21596) \
t105=(od_+5.733333e-01*w_>=1.20381) \
t106=(od_+5.733333e-01*w_>=1.28702) \
t107=(od_+5.866667e-01*w_>=1.27544) \
t108=(od_+5.600000e-01*w_>=1.21588) \
t109=(od_+5.733333e-01*w_>=1.32879) \
t110=(od_+5.733333e-01*w_>=1.20397) \
t111=(od_+5.600000e-01*w_>=1.29852) \
t112=(od_+5.733333e-01*w_>=1.24558) \
t113=(od_+5.866667e-01*w_>=1.27536) \
t114=(od_+5.733333e-01*w_>=1.37007) \
t115=(od_+5.866667e-01*w_>=1.35896) \
t116=(od_+5.733333e-01*w_>=1.24525) \
t117=(od_+5.600000e-01*w_>=1.29844) \
t118=(od_+5.733333e-01*w_>=1.28686) \
t119=(od_+5.733333e-01*w_>=1.1622) \
t120=(od_+5.733333e-01*w_>=1.24541) \
t121=(od_+5.866667e-01*w_>=1.35888) \
t122=(od_+5.600000e-01*w_>=1.38109) \
t123=(od_+5.733333e-01*w_>=1.32862) \
t124=(od_+5.733333e-01*w_>=1.28669) \
t125=(od_+5.733333e-01*w_>=1.24509) \
t126=(od_+5.600000e-01*w_>=1.38101) \
t127=(od_+5.733333e-01*w_>=1.3699) \
t128=(nt_in==3) \
t129=(od_+4.533333e-01*w_>=1.09784) \
t130=(od_+4.533333e-01*w_>=1.11672) \
t131=(od_+4.533333e-01*w_>=1.13552) \
t132=(od_+4.533333e-01*w_>=1.09777) \
t133=(od_+4.533333e-01*w_>=1.15439) \
t134=(od_+4.533333e-01*w_>=1.19214) \
t135=(od_+4.533333e-01*w_>=1.17326) \
t136=(od_+4.533333e-01*w_>=1.11657) \
t137=(od_+4.533333e-01*w_>=1.13544) \
t138=(od_+4.533333e-01*w_>=1.17319) \
t139=(od_+4.533333e-01*w_>=1.17311) \
t140=(od_+4.533333e-01*w_>=1.15424) \
t141=(od_+4.533333e-01*w_>=1.21086) \
t142=(od_+4.533333e-01*w_>=1.17304) \
t143=(od_+4.533333e-01*w_>=1.24853) \
t144=(od_+4.533333e-01*w_>=1.21078) \
t145=(od_+4.533333e-01*w_>=1.24846) \
t146=(od_+4.533333e-01*w_>=1.19184) \
t147=(nt_in==4) \
s0=t0*(1-t1)*(1-t2)*(1-t3) \
nos0=(1-s0) \
s1=t0*t4*(1-t5)*(1-t6)*(1-t7)*nos0 \
nos1=(1-s1)*nos0 \
s2=t0*t8*(1-t9)*(1-t10)*(1-t11)*(1-t12)*(1-t13)*nos1 \
nos2=(1-s2)*nos1 \
s3=t0*(1-t14)*t15*(1-t16)*(1-t17)*(1-t18)*nos2 \
nos3=(1-s3)*nos2 \
s4=t0*(1-t19)*(1-t20)*t21*(1-t22)*nos3 \
nos4=(1-s4)*nos3 \
s5=t0*t23*t24*(1-t25)*(1-t26)*t27*(1-t28)*t29*t30*nos4 \
nos5=(1-s5)*nos4 \
s6=t0*t31*(1-t32)*(1-t33)*(1-t34)*(1-t35)*nos5 \
nos6=(1-s6)*nos5 \
s7=t0*t36*(1-t37)*(1-t38)*nos6 \
nos7=(1-s7)*nos6 \
s8=t0*t39*(1-t40)*nos7 \
nos8=(1-s8)*nos7 \
s9=t0*t41*t42*(1-t43)*t44*nos8 \
nos9=(1-s9)*nos8 \
s10=t0*t45*(1-t46)*t47*nos9 \
nos10=(1-s10)*nos9 \
s11=t0*t48*t49*(1-t50)*t51*nos10 \
nos11=(1-s11)*nos10 \
s12=t0*t52*t53*t54*(1-t55)*nos11 \
nos12=(1-s12)*nos11 \
s13=t0*t56*(1-t57)*t58*t59*nos12 \
nos13=(1-s13)*nos12 \
s14=t0*t60*(1-t61)*t62*t63*nos13 \
nos14=(1-s14)*nos13 \
s15=t0*t64*(1-t65)*t66*nos14 \
nos15=(1-s15)*nos14 \
s16=t0*t67*t68*t69*t70*nos15 \
nos16=(1-s16)*nos15 \
s17=t71*(1-t72)*(1-t73)*(1-t74)*(1-t75)*nos16 \
nos17=(1-s17)*nos16 \
s18=t71*(1-t76)*t77*(1-t78)*nos17 \
nos18=(1-s18)*nos17 \
s19=t71*t79*t80*(1-t81)*(1-t82)*nos18 \
nos19=(1-s19)*nos18 \
s20=t71*t83*t84*(1-t85)*(1-t86)*(1-t87)*nos19 \
nos20=(1-s20)*nos19 \
s21=t71*(1-t88)*t89*t90*t91*(1-t92)*(1-t93)*(1-t94)*nos20 \
nos21=(1-s21)*nos20 \
s22=t71*t95*(1-t96)*t97*(1-t98)*(1-t99)*(1-t100)*nos21 \
nos22=(1-s22)*nos21 \
s23=t71*(1-t101)*t102*t103*(1-t104)*nos22 \
nos23=(1-s23)*nos22 \
s24=t71*t105*(1-t106)*(1-t107)*t108*nos23 \
nos24=(1-s24)*nos23 \
s25=t71*(1-t109)*t110*(1-t111)*t112*t113*nos24 \
nos25=(1-s25)*nos24 \
s26=t71*(1-t114)*(1-t115)*t116*t117*t118*nos25 \
nos26=(1-s26)*nos25 \
s27=t71*t119*t120*t121*(1-t122)*t123*nos26 \
nos27=(1-s27)*nos26 \
s28=t71*t124*t125*t126*t127*nos27 \
nos28=(1-s28)*nos27 \
s29=t128*(1-t129)*(1-t130)*nos28 \
nos29=(1-s29)*nos28 \
s30=t128*(1-t131)*t132*(1-t133)*(1-t134)*(1-t135)*nos29 \
nos30=(1-s30)*nos29 \
s31=t128*t136*t137*(1-t138)*nos30 \
nos31=(1-s31)*nos30 \
s32=t128*t139*t140*(1-t141)*nos31 \
nos32=(1-s32)*nos31 \
s33=t128*t142*(1-t143)*t144*nos32 \
nos33=(1-s33)*nos32 \
s34=t128*t145*t146*nos33 \
nos34=(1-s34)*nos33 \
s35=t147*nos34 \
nos35=(1-s35)*nos34 \
v0_part1=(-5.781025e-02)*s0+2.722605e-02*s1+(-7.935615e-02)*s2+1.538151e-03*s3+(-5.463992e-03)*s4+(-3.006387e-04)*s5+(-4.827730e-03)*s6+(-6.700493e-09)*s7+3.374031e-02*s8+1.395670e-02*s9 \
v0_part2=v0_part1+2.432386e-02*s10+1.200325e-01*s11+3.637883e-02*s12+1.760610e-02*s13+(-2.509955e-02)*s14+(-2.131375e-03)*s15+4.577639e-02*s16+(-3.292232e-01)*s17+(-2.610459e-02)*s18+(-1.890708e-01)*s19 \
v0_part3=v0_part2+(-1.223238e-01)*s20+(-1.244947e-01)*s21+9.984348e-03*s22+6.050835e-03*s23+(-9.758543e-04)*s24+5.785410e-03*s25+(-1.244025e-01)*s26+1.056669e-02*s27+(-2.751638e-03)*s28+(-3.861864e-03)*s29 \
v0=v0_part3+(-7.702498e-02)*s30+(-1.000309e-01)*s31+(-5.023512e-01)*s32+(-1.120974e-04)*s33+(-1.877696e-04)*s34+(-2.370568e-01)*s35 \
v1_part1=4.067501e-01*s0+5.646979e-01*s1+7.561159e-01*s2+5.347273e-01*s3+6.013758e-01*s4+5.430536e-01*s5+5.090827e-01*s6+5.273388e-01*s7+4.542444e-01*s8+5.116491e-01*s9 \
v1_part2=v1_part1+5.280376e-01*s10+4.839523e-01*s11+5.891080e-01*s12+5.928871e-01*s13+6.781215e-01*s14+6.412006e-01*s15+5.965733e-01*s16+2.210378e+00*s17+1.974934e+00*s18+2.173936e+00*s19 \
v1_part3=v1_part2+1.906385e+00*s20+1.900404e+00*s21+1.805915e+00*s22+1.865281e+00*s23+1.959784e+00*s24+1.886456e+00*s25+1.781440e+00*s26+1.800121e+00*s27+1.702020e+00*s28+4.487362e+00*s29 \
v1=v1_part3+3.059863e+00*s30+3.865333e+00*s31+4.022069e+00*s32+3.961280e+00*s33+2.965575e+00*s34+6.883543e+00*s35 \
v2_part1=(-1.033250e-01)*s0+(-1.863898e-01)*s1+(-1.882736e-01)*s2+(-1.212340e-01)*s3+(-1.468932e-01)*s4+(-1.294127e-01)*s5+(-1.049830e-01)*s6+(-1.432256e-01)*s7+(-1.141330e-01)*s8+(-1.460264e-01)*s9 \
v2_part2=v2_part1+(-1.790758e-01)*s10+(-2.318641e-01)*s11+(-2.305349e-01)*s12+(-1.984010e-01)*s13+(-2.393989e-01)*s14+(-2.314387e-01)*s15+(-2.446140e-01)*s16+(-8.448414e-01)*s17+(-1.066877e+00)*s18+(-1.051007e+00)*s19 \
v2_part3=v2_part2+(-8.597542e-01)*s20+(-8.123035e-01)*s21+(-8.665695e-01)*s22+(-9.793200e-01)*s23+(-1.059644e+00)*s24+(-9.366754e-01)*s25+(-6.835399e-01)*s26+(-8.841899e-01)*s27+(-7.122348e-01)*s28+(-3.824754e+00)*s29 \
v2=v2_part3+(-1.369580e+00)*s30+(-2.586030e+00)*s31+(-2.113238e+00)*s32+(-2.902180e+00)*s33+(-1.549085e+00)*s34+(-5.201788e+00)*s35 \
v3_part1=0.000000e+00*s0+0.000000e+00*s1+0.000000e+00*s2+(-6.844203e-01)*s3+0.000000e+00*s4+0.000000e+00*s5+(-5.767426e-01)*s6+(-5.976447e-01)*s7+0.000000e+00*s8+(-6.339639e-01)*s9 \
v3_part2=v3_part1+9.254171e-04*s10+(-7.799120e-01)*s11+2.502539e-01*s12+(-8.862756e-01)*s13+(-9.712360e-01)*s14+(-1.009042e+00)*s15+5.347039e-01*s16+(-1.094106e+00)*s17+(-3.149663e+00)*s18+(-1.282724e+00)*s19 \
v3_part3=v3_part2+(-2.109401e+00)*s20+(-2.378900e+00)*s21+(-2.556664e+00)*s22+(-2.576060e+00)*s23+(-2.255283e+00)*s24+(-2.071601e+00)*s25+(-1.666375e+00)*s26+(-1.848506e+00)*s27+(-6.797216e-01)*s28+(-3.108008e+00)*s29 \
v3=v3_part3+(-4.208532e+00)*s30+(-1.730464e+00)*s31+6.237341e-01*s32+(-2.553014e+00)*s33+(-5.287187e+00)*s34+(-5.297121e+00)*s35 \
v4_part1=0.000000e+00*s0+0.000000e+00*s1+0.000000e+00*s2+8.607741e-01*s3+0.000000e+00*s4+0.000000e+00*s5+7.704641e-01*s6+8.079524e-01*s7+0.000000e+00*s8+7.246940e-01*s9 \
v4_part2=v4_part1+8.495618e-03*s10+8.287701e-01*s11+1.253541e-01*s12+8.949794e-01*s13+9.551302e-01*s14+9.620739e-01*s15+1.588829e-02*s16+1.763870e+00*s17+4.238632e+00*s18+(-4.293013e-01)*s19 \
v4_part3=v4_part2+1.894157e+00*s20+2.255802e+00*s21+2.267835e+00*s22+2.402901e+00*s23+1.831902e+00*s24+1.335565e+00*s25+9.929005e-01*s26+1.572947e+00*s27+6.066376e-01*s28+3.661431e+00*s29 \
v4=v4_part3+2.888776e+00*s30+(-7.742763e-01)*s31+(-3.896342e+00)*s32+1.173237e+00*s33+4.149228e+00*s34+4.312121e+00*s35 \
v5_part1=0.000000e+00*s0+0.000000e+00*s1+0.000000e+00*s2+4.260530e-01*s3+0.000000e+00*s4+0.000000e+00*s5+3.942960e-01*s6+3.909356e-01*s7+0.000000e+00*s8+4.637743e-01*s9 \
v5_part2=v5_part1+3.894066e-01*s10+5.107649e-01*s11+7.520223e-02*s12+5.457072e-01*s13+5.647802e-01*s14+5.850483e-01*s15+(-3.947613e-02)*s16+9.976932e-01*s17+1.196502e+00*s18+1.955545e+00*s19 \
v5_part3=v5_part2+1.499606e+00*s20+1.483624e+00*s21+1.590123e+00*s22+1.541425e+00*s23+1.654452e+00*s24+1.812390e+00*s25+1.729718e+00*s26+1.483862e+00*s27+1.228900e+00*s28+2.004787e+00*s29 \
v5=v5_part3+2.918378e+00*s30+3.416886e+00*s31+3.722775e+00*s32+2.911016e+00*s33+2.791388e+00*s34+3.490303e+00*s35 \
v6_part1=(-1.157498e-02)*s0+(-1.871321e-02)*s1+(-4.704766e-02)*s2+(-2.063978e-02)*s3+(-2.920077e-02)*s4+(-4.292969e-02)*s5+(-1.011000e-02)*s6+(-1.956313e-02)*s7+4.719717e-05*s8+(-9.997771e-03)*s9 \
v6_part2=v6_part1+(-6.849379e-02)*s10+(-3.181164e-02)*s11+(-2.504087e-02)*s12+(-3.442113e-02)*s13+(-2.107738e-03)*s14+(-1.007448e-04)*s15+(-1.485101e-02)*s16+(-6.079093e-03)*s17+(-2.406924e-01)*s18+1.514325e-01*s19 \
v6_part3=v6_part2+(-1.728768e-02)*s20+(-1.177699e-01)*s21+3.106261e-02*s22+(-1.262277e+00)*s23+5.188984e-01*s24+(-2.592360e-01)*s25+(-1.231576e-01)*s26+(-2.782702e-01)*s27+(-8.560153e-01)*s28+(-4.839609e-01)*s29 \
v6=v6_part3+5.422186e-01*s30+(-8.053941e-01)*s31+(-1.323242e+00)*s32+(-7.341774e-01)*s33+(-7.166476e-01)*s34+(-1.849156e+00)*s35 \
v7_part1=9.232914e-01*s0+9.005447e-01*s1+8.955941e-01*s2+8.866497e-01*s3+8.607291e-01*s4+8.859051e-01*s5+8.000202e-01*s6+7.952672e-01*s7+8.389263e-01*s8+8.399941e-01*s9 \
v7_part2=v7_part1+9.484410e-01*s10+9.415793e-01*s11+9.404390e-01*s12+9.570579e-01*s13+9.252314e-01*s14+9.509428e-01*s15+9.663164e-01*s16+2.915259e+00*s17+3.400184e+00*s18+2.935912e+00*s19 \
v7_part3=v7_part2+3.046557e+00*s20+3.091271e+00*s21+3.144143e+00*s22+4.208790e+00*s23+2.809394e+00*s24+3.388515e+00*s25+3.068656e+00*s26+3.162020e+00*s27+4.068376e+00*s28+6.273691e+00*s29 \
v7=v7_part3+6.217256e+00*s30+7.383522e+00*s31+7.025770e+00*s32+6.568713e+00*s33+6.570780e+00*s34+1.004870e+01*s35 \
v8_part1=(-3.144044e-01)*s0+(-2.965318e-01)*s1+(-2.418274e-01)*s2+(-2.820172e-01)*s3+(-2.526732e-01)*s4+(-2.487600e-01)*s5+(-2.235518e-01)*s6+(-2.100563e-01)*s7+(-2.707202e-01)*s8+(-2.681373e-01)*s9 \
v8_part2=v8_part1+(-2.962974e-01)*s10+(-3.342099e-01)*s11+(-3.347942e-01)*s12+(-3.382876e-01)*s13+(-3.432581e-01)*s14+(-3.737817e-01)*s15+(-3.752796e-01)*s16+(-1.598757e+00)*s17+(-1.747078e+00)*s18+(-1.872928e+00)*s19 \
v8_part3=v8_part2+(-1.689908e+00)*s20+(-1.593071e+00)*s21+(-1.869871e+00)*s22+(-1.221255e+00)*s23+(-2.131367e+00)*s24+(-1.730519e+00)*s25+(-1.559673e+00)*s26+(-1.472940e+00)*s27+(-1.792633e+00)*s28+(-4.113356e+00)*s29 \
v8=v8_part3+(-5.805657e+00)*s30+(-5.194072e+00)*s31+(-3.791220e+00)*s32+(-4.073126e+00)*s33+(-4.156938e+00)*s34+(-6.379330e+00)*s35 \
v9_part1=(-5.663164e-01)*s0+(-1.321930e+00)*s1+(-9.248502e-01)*s2+(-1.533038e+00)*s3+(-1.151341e+00)*s4+(-9.576224e-01)*s5+(-1.641874e-01)*s6+(-5.776210e-01)*s7+(-7.113944e-01)*s8+(-8.864660e-01)*s9 \
v9_part2=v9_part1+(-1.334017e+00)*s10+(-1.106324e+00)*s11+(-8.770562e-01)*s12+(-1.165099e+00)*s13+(-1.093832e+00)*s14+(-1.239107e+00)*s15+(-1.360601e+00)*s16+2.392257e+00*s17+(-1.053855e+01)*s18+(-6.830772e-01)*s19 \
v9_part3=v9_part2+(-3.381471e+00)*s20+(-3.858402e+00)*s21+(-5.222459e+00)*s22+(-5.652123e+00)*s23+(-3.924552e+00)*s24+(-2.700419e+00)*s25+(-1.328111e+00)*s26+(-1.649321e+00)*s27+(-1.000895e+00)*s28+(-2.065901e+00)*s29 \
v9=v9_part3+(-1.557954e+01)*s30+(-9.375614e+00)*s31+4.006508e+00*s32+(-5.720990e-01)*s33+(-1.163700e+01)*s34+(-5.602199e-01)*s35 \
v10_part1=1.818013e-01*s0+4.113847e-01*s1+3.925926e-01*s2+9.537283e-01*s3+6.472774e-01*s4+5.412773e-01*s5+7.889102e-02*s6+8.034702e-01*s7+4.322467e-01*s8+6.756548e-01*s9 \
v10_part2=v10_part1+1.060415e+00*s10+6.312359e-01*s11+3.346909e-01*s12+6.485555e-01*s13+5.622688e-01*s14+6.716291e-01*s15+7.528032e-01*s16+(-3.369117e+00)*s17+1.304736e+01*s18+(-8.297074e+00)*s19 \
v10_part3=v10_part2+1.657645e+00*s20+2.288504e+00*s21+2.928361e+00*s22+5.155640e+00*s23+1.816645e+00*s24+(-6.862220e-01)*s25+(-1.440191e+00)*s26+(-1.159549e-01)*s27+(-3.133170e-01)*s28+2.931017e+00*s29 \
v10=v10_part3+3.467650e+00*s30+(-2.549515e+00)*s31+(-1.300749e+01)*s32+(-3.658834e+00)*s33+7.865507e+00*s34+1.394045e+01*s35 \
v11_part1=1.121674e+00*s0+1.426837e+00*s1+1.196225e+00*s2+1.346882e+00*s3+1.217410e+00*s4+1.177213e+00*s5+7.383708e-01*s6+6.755781e-01*s7+1.005229e+00*s8+9.835630e-01*s9 \
v11_part2=v11_part1+1.112686e+00*s10+1.209169e+00*s11+1.232767e+00*s12+1.244872e+00*s13+1.246412e+00*s14+1.276223e+00*s15+1.308227e+00*s16+2.009333e+00*s17+3.029140e+00*s18+5.736373e+00*s19 \
v11_part3=v11_part2+3.249847e+00*s20+3.175212e+00*s21+3.737861e+00*s22+2.870545e+00*s23+3.594784e+00*s24+4.184138e+00*s25+3.647649e+00*s26+3.044005e+00*s27+2.778789e+00*s28+3.374691e+00*s29 \
v11=v11_part3+1.053975e+01*s30+1.033541e+01*s31+7.966522e+00*s32+5.770722e+00*s33+5.641146e+00*s34+1.316343e+00*s35 \
v12_part1=0.000000e+00*s0+0.000000e+00*s1+0.000000e+00*s2+0.000000e+00*s3+(-8.906435e+00)*s4+0.000000e+00*s5+(-1.073838e+01)*s6+(-1.265042e+01)*s7+0.000000e+00*s8+(-3.253099e+00)*s9 \
v12_part2=v12_part1+0.000000e+00*s10+0.000000e+00*s11+0.000000e+00*s12+0.000000e+00*s13+0.000000e+00*s14+0.000000e+00*s15+0.000000e+00*s16+0.000000e+00*s17+0.000000e+00*s18+0.000000e+00*s19 \
v12_part3=v12_part2+0.000000e+00*s20+0.000000e+00*s21+0.000000e+00*s22+0.000000e+00*s23+0.000000e+00*s24+0.000000e+00*s25+0.000000e+00*s26+0.000000e+00*s27+0.000000e+00*s28+0.000000e+00*s29 \
v12=v12_part3+0.000000e+00*s30+0.000000e+00*s31+0.000000e+00*s32+0.000000e+00*s33+0.000000e+00*s34+(-9.861358e+01)*s35 \
v13_part1=0.000000e+00*s0+0.000000e+00*s1+0.000000e+00*s2+0.000000e+00*s3+3.463480e+01*s4+0.000000e+00*s5+1.845374e+01*s6+2.146238e+01*s7+0.000000e+00*s8+3.601085e+01*s9 \
v13_part2=v13_part1+0.000000e+00*s10+0.000000e+00*s11+0.000000e+00*s12+0.000000e+00*s13+0.000000e+00*s14+0.000000e+00*s15+0.000000e+00*s16+0.000000e+00*s17+0.000000e+00*s18+0.000000e+00*s19 \
v13_part3=v13_part2+0.000000e+00*s20+0.000000e+00*s21+0.000000e+00*s22+0.000000e+00*s23+0.000000e+00*s24+0.000000e+00*s25+0.000000e+00*s26+0.000000e+00*s27+0.000000e+00*s28+0.000000e+00*s29 \
v13=v13_part3+0.000000e+00*s30+0.000000e+00*s31+0.000000e+00*s32+0.000000e+00*s33+0.000000e+00*s34+2.036128e+02*s35 \
v14_part1=0.000000e+00*s0+0.000000e+00*s1+0.000000e+00*s2+0.000000e+00*s3+6.779885e+00*s4+0.000000e+00*s5+(-9.708660e-01)*s6+3.045160e-01*s7+0.000000e+00*s8+(-5.193634e-03)*s9 \
v14_part2=v14_part1+0.000000e+00*s10+0.000000e+00*s11+0.000000e+00*s12+0.000000e+00*s13+0.000000e+00*s14+0.000000e+00*s15+0.000000e+00*s16+0.000000e+00*s17+0.000000e+00*s18+0.000000e+00*s19 \
v14_part3=v14_part2+0.000000e+00*s20+0.000000e+00*s21+0.000000e+00*s22+0.000000e+00*s23+0.000000e+00*s24+0.000000e+00*s25+0.000000e+00*s26+0.000000e+00*s27+0.000000e+00*s28+0.000000e+00*s29 \
v14=v14_part3+0.000000e+00*s30+0.000000e+00*s31+0.000000e+00*s32+0.000000e+00*s33+0.000000e+00*s34+(-5.926648e+01)*s35 \
v15_part1=(-1.110170e+00)*s0+2.566465e+00*s1+1.005168e+01*s2+3.640152e+00*s3+7.493564e+00*s4+0.000000e+00*s5+0.000000e+00*s6+0.000000e+00*s7+0.000000e+00*s8+(-2.995489e-02)*s9 \
v15_part2=v15_part1+0.000000e+00*s10+0.000000e+00*s11+0.000000e+00*s12+0.000000e+00*s13+0.000000e+00*s14+(-4.817142e-02)*s15+0.000000e+00*s16+(-3.332483e-02)*s17+1.266961e+01*s18+8.948950e+00*s19 \
v15_part3=v15_part2+(-1.479371e+01)*s20+2.073532e+01*s21+(-2.087341e+01)*s22+(-2.243857e+01)*s23+(-1.952109e+01)*s24+(-1.131804e+01)*s25+1.462925e+01*s26+1.708537e+01*s27+3.672516e+00*s28+(-3.518805e+00)*s29 \
v15=v15_part3+(-1.329577e+02)*s30+9.137282e+01*s31+3.037434e+01*s32+2.591221e+00*s33+(-1.950286e+00)*s34+0.000000e+00*s35 \
v16_part1=3.916666e+01*s0+9.088795e+00*s1+(-9.848514e+00)*s2+(-9.563752e+00)*s3+3.163345e+00*s4+0.000000e+00*s5+0.000000e+00*s6+0.000000e+00*s7+0.000000e+00*s8+3.798437e+00*s9 \
v16_part2=v16_part1+0.000000e+00*s10+0.000000e+00*s11+0.000000e+00*s12+0.000000e+00*s13+0.000000e+00*s14+2.536674e+00*s15+0.000000e+00*s16+3.577603e+01*s17+1.185505e+01*s18+7.580978e+01*s19 \
v16_part3=v16_part2+6.302353e+01*s20+6.347643e+01*s21+8.238170e+01*s22+7.602612e+01*s23+8.398221e+01*s24+8.172305e+01*s25+1.678141e+01*s26+8.285911e+00*s27+2.012355e+01*s28+9.037404e+01*s29 \
v16=v16_part3+2.523655e+02*s30+1.103331e+02*s31+6.925844e+01*s32+1.169777e+02*s33+1.432597e+02*s34+0.000000e+00*s35 \
v17_part1=(-5.317587e-01)*s0+(-2.531289e-01)*s1+3.283031e+00*s2+1.240054e+01*s3+2.342703e-01*s4+0.000000e+00*s5+0.000000e+00*s6+0.000000e+00*s7+0.000000e+00*s8+2.193668e-02*s9 \
v17_part2=v17_part1+0.000000e+00*s10+0.000000e+00*s11+0.000000e+00*s12+0.000000e+00*s13+0.000000e+00*s14+7.682244e-01*s15+0.000000e+00*s16+5.376359e-01*s17+9.407064e+00*s18+(-6.008708e+01)*s19 \
v17_part3=v17_part2+(-1.489684e+00)*s20+(-6.364397e+01)*s21+(-1.406498e+01)*s22+(-6.265997e+00)*s23+(-1.874395e+01)*s24+(-3.180229e+01)*s25+3.588298e-01*s26+1.004908e+01*s27+1.717196e+01*s28+(-9.470204e+00)*s29 \
v17=v17_part3+(-1.364004e+01)*s30+(-1.863591e+02)*s31+(-1.106303e+01)*s32+(-3.848563e+01)*s33+(-6.952388e+01)*s34+0.000000e+00*s35 \
v18_part1=(-2.568224e-02)*s0+(-7.334892e-02)*s1+0.000000e+00*s2+(-4.518944e-02)*s3+(-4.408613e-02)*s4+(-2.779636e-02)*s5+(-4.197502e-02)*s6+1.448127e-02*s7+(-7.720617e-02)*s8+(-5.054208e-02)*s9 \
v18_part2=v18_part1+(-6.926706e-02)*s10+(-9.136837e-02)*s11+(-5.925194e-02)*s12+(-5.952568e-02)*s13+(-1.702325e-02)*s14+(-3.621945e-02)*s15+(-7.728905e-02)*s16+6.608804e-02*s17+(-1.083807e-01)*s18+(-1.711139e-02)*s19 \
v18_part3=v18_part2+(-9.860923e-02)*s20+(-6.864551e-02)*s21+3.729500e-03*s22+(-2.146696e-01)*s23+(-3.407688e-03)*s24+(-1.726880e-01)*s25+(-1.170983e-01)*s26+(-4.615222e-02)*s27+2.199552e-02*s28+(-4.428732e-01)*s29 \
v18=v18_part3+(-5.727242e-01)*s30+(-6.015182e-01)*s31+(-7.782376e-01)*s32+(-8.391807e-01)*s33+(-2.086881e-01)*s34+(-1.711716e-01)*s35 \
v19_part1=8.671872e-01*s0+1.543376e-01*s1+0.000000e+00*s2+1.507970e-01*s3+1.283160e-01*s4+1.331923e-01*s5+1.459903e-01*s6+6.767598e-02*s7+1.709813e-01*s8+1.363622e-01*s9 \
v19_part2=v19_part1+1.454486e-01*s10+1.529331e-01*s11+1.153305e-01*s12+1.253871e-01*s13+6.460450e-02*s14+9.203587e-02*s15+1.359126e-01*s16+3.932357e-02*s17+3.547074e-01*s18+2.452528e-01*s19 \
v19_part3=v19_part2+3.793865e-01*s20+3.779403e-01*s21+3.421873e-01*s22+4.940726e-01*s23+3.148186e-01*s24+4.775679e-01*s25+4.274355e-01*s26+3.521342e-01*s27+3.322976e-01*s28+5.499572e-01*s29 \
v19=v19_part3+1.532141e+00*s30+1.249480e+00*s31+1.397884e+00*s32+1.161344e+00*s33+1.037091e+00*s34+6.547795e-01*s35 \
v20_part1=(-1.996521e-01)*s0+(-2.640914e-02)*s1+0.000000e+00*s2+(-6.307845e-02)*s3+(-6.119953e-02)*s4+(-6.914455e-02)*s5+(-5.314549e-02)*s6+(-4.945436e-02)*s7+(-2.634363e-02)*s8+(-2.591678e-02)*s9 \
v20_part2=v20_part1+(-7.118435e-03)*s10+3.626828e-03*s11+(-1.315347e-03)*s12+(-1.795222e-02)*s13+(-2.509145e-03)*s14+(-7.727413e-03)*s15+(-5.882214e-03)*s16+2.865287e-03*s17+(-6.611660e-02)*s18+(-8.162766e-02)*s19 \
v20_part3=v20_part2+(-1.007677e-01)*s20+(-1.636092e-01)*s21+(-2.410108e-01)*s22+(-8.014960e-02)*s23+(-1.745740e-01)*s24+(-1.506031e-01)*s25+(-1.559805e-01)*s26+(-1.617306e-01)*s27+(-2.228265e-01)*s28+3.896955e-01*s29 \
v20=v20_part3+(-9.724015e-01)*s30+(-4.801947e-01)*s31+(-4.382702e-01)*s32+2.365356e-03*s33+(-7.755411e-01)*s34+(-8.064456e-01)*s35 \
v21_part1=(-6.156462e-01)*s0+(-6.354890e-01)*s1+(-6.816339e-01)*s2+0.000000e+00*s3+(-6.948881e-01)*s4+(-7.558850e-01)*s5+0.000000e+00*s6+0.000000e+00*s7+(-5.642582e-01)*s8+0.000000e+00*s9 \
v21_part2=v21_part1+(-8.827076e-01)*s10+0.000000e+00*s11+(-1.103568e+00)*s12+0.000000e+00*s13+0.000000e+00*s14+0.000000e+00*s15+(-1.723377e+00)*s16+0.000000e+00*s17+0.000000e+00*s18+0.000000e+00*s19 \
v21_part3=v21_part2+0.000000e+00*s20+0.000000e+00*s21+0.000000e+00*s22+0.000000e+00*s23+0.000000e+00*s24+0.000000e+00*s25+0.000000e+00*s26+0.000000e+00*s27+(-1.481923e+00)*s28+0.000000e+00*s29 \
v21=v21_part3+0.000000e+00*s30+0.000000e+00*s31+0.000000e+00*s32+0.000000e+00*s33+0.000000e+00*s34+0.000000e+00*s35 \
v22_part1=1.137008e+00*s0+9.312399e-01*s1+9.071094e-01*s2+0.000000e+00*s3+8.452237e-01*s4+1.027129e+00*s5+0.000000e+00*s6+0.000000e+00*s7+6.497849e-01*s8+0.000000e+00*s9 \
v22_part2=v22_part1+9.529845e-01*s10+0.000000e+00*s11+7.530611e-01*s12+0.000000e+00*s13+0.000000e+00*s14+0.000000e+00*s15+1.087829e+00*s16+0.000000e+00*s17+0.000000e+00*s18+0.000000e+00*s19 \
v22_part3=v22_part2+0.000000e+00*s20+0.000000e+00*s21+0.000000e+00*s22+0.000000e+00*s23+0.000000e+00*s24+0.000000e+00*s25+0.000000e+00*s26+0.000000e+00*s27+1.094085e+00*s28+0.000000e+00*s29 \
v22=v22_part3+0.000000e+00*s30+0.000000e+00*s31+0.000000e+00*s32+0.000000e+00*s33+0.000000e+00*s34+0.000000e+00*s35 \
v23_part1=2.920193e-01*s0+3.646491e-01*s1+4.041117e-01*s2+0.000000e+00*s3+4.465339e-01*s4+4.097388e-01*s5+0.000000e+00*s6+0.000000e+00*s7+4.512197e-01*s8+0.000000e+00*s9 \
v23_part2=v23_part1+1.261497e-01*s10+0.000000e+00*s11+4.658103e-01*s12+0.000000e+00*s13+0.000000e+00*s14+0.000000e+00*s15+6.568812e-01*s16+0.000000e+00*s17+0.000000e+00*s18+0.000000e+00*s19 \
v23_part3=v23_part2+0.000000e+00*s20+0.000000e+00*s21+0.000000e+00*s22+0.000000e+00*s23+0.000000e+00*s24+0.000000e+00*s25+0.000000e+00*s26+0.000000e+00*s27+4.197039e-01*s28+0.000000e+00*s29 \
v23=v23_part3+0.000000e+00*s30+0.000000e+00*s31+0.000000e+00*s32+0.000000e+00*s33+0.000000e+00*s34+0.000000e+00*s35 \
v24_part1=(-7.713910e-02)*s0+(-7.797836e-02)*s1+(-8.137185e-02)*s2+(-9.859812e-02)*s3+(-1.515158e-01)*s4+(-9.683385e-02)*s5+(-6.914872e-02)*s6+(-1.082197e-01)*s7+(-7.961957e-02)*s8+2.271578e-04*s9 \
v24_part2=v24_part1+(-1.400244e-02)*s10+(-1.111181e-01)*s11+(-1.243813e-01)*s12+(-7.584247e-02)*s13+(-1.041148e-01)*s14+(-1.005523e-01)*s15+(-6.214802e-02)*s16+(-4.806055e-01)*s17+(-5.294062e-02)*s18+(-6.930345e-01)*s19 \
v24_part3=v24_part2+(-3.990652e-01)*s20+(-4.829322e-01)*s21+(-1.943777e-01)*s22+8.930147e-01*s23+(-4.095042e-01)*s24+(-6.765200e-01)*s25+(-7.682208e-01)*s26+(-2.184736e-01)*s27+6.267498e-01*s28+(-8.464449e-01)*s29 \
v24=v24_part3+(-1.838907e+00)*s30+(-1.714129e+00)*s31+(-1.887910e+00)*s32+(-1.526137e+00)*s33+(-3.507388e-01)*s34+(-4.029278e-01)*s35 \
v25_part1=9.653067e-01*s0+1.040903e+00*s1+1.080761e+00*s2+1.113649e+00*s3+1.183534e+00*s4+1.147004e+00*s5+1.112407e+00*s6+1.160323e+00*s7+1.046859e+00*s8+9.986057e-01*s9 \
v25_part2=v25_part1+1.070500e+00*s10+1.204278e+00*s11+1.227810e+00*s12+1.171199e+00*s13+1.218284e+00*s14+1.188124e+00*s15+1.165789e+00*s16+3.409387e+00*s17+2.891034e+00*s18+3.635500e+00*s19 \
v25_part3=v25_part2+3.514124e+00*s20+3.651668e+00*s21+3.322767e+00*s22+2.429883e+00*s23+3.581555e+00*s24+3.810001e+00*s25+3.804324e+00*s26+3.433756e+00*s27+1.925196e+00*s28+6.622217e+00*s29 \
v25=v25_part3+7.003775e+00*s30+7.078967e+00*s31+8.020024e+00*s32+7.613700e+00*s33+6.274240e+00*s34+1.096557e+01*s35 \
v26_part1=(-1.881021e-01)*s0+(-2.394070e-01)*s1+(-2.692677e-01)*s2+(-2.678467e-01)*s3+(-2.454813e-01)*s4+(-3.018280e-01)*s5+(-3.053652e-01)*s6+(-2.913319e-01)*s7+(-2.389358e-01)*s8+(-2.720592e-01)*s9 \
v26_part2=v26_part1+(-3.236114e-01)*s10+(-3.385988e-01)*s11+(-3.480295e-01)*s12+(-3.478119e-01)*s13+(-3.654686e-01)*s14+(-3.356627e-01)*s15+(-3.494592e-01)*s16+(-1.177991e+00)*s17+(-1.325895e+00)*s18+(-1.090545e+00)*s19 \
v26_part3=v26_part2+(-1.454077e+00)*s20+(-1.476214e+00)*s21+(-1.521349e+00)*s22+(-2.052150e+00)*s23+(-1.511751e+00)*s24+(-1.405144e+00)*s25+(-1.281940e+00)*s26+(-1.563641e+00)*s27+(-9.007545e-01)*s28+(-3.741603e+00)*s29 \
v26=v26_part3+(-2.558775e+00)*s30+(-2.925780e+00)*s31+(-4.120590e+00)*s32+(-4.114862e+00)*s33+(-3.943688e+00)*s34+(-1.049972e+01)*s35 \
v27_part1=2.741455e+00*s0+2.577774e-01*s1+(-2.718839e+00)*s2+(-1.457017e+00)*s3+(-2.756761e+00)*s4+(-2.793091e+00)*s5+(-3.304696e+00)*s6+(-5.406239e+00)*s7+1.518755e-03*s8+1.574892e+00*s9 \
v27_part2=v27_part1+(-1.162520e-01)*s10+(-1.935985e-01)*s11+(-1.375802e+00)*s12+(-3.110595e-03)*s13+(-3.353212e+00)*s14+(-2.477643e+00)*s15+4.102655e-02*s16+2.131030e+00*s17+1.048375e+00*s18+6.781773e+00*s19 \
v27_part3=v27_part2+(-1.947043e+00)*s20+(-4.650942e+00)*s21+(-2.400362e+00)*s22+(-1.331014e+00)*s23+(-3.034519e+00)*s24+8.171011e-01*s25+(-7.577372e-03)*s26+8.555374e-03*s27+9.344870e-02*s28+3.035870e+00*s29 \
v27=v27_part3+2.269694e+01*s30+3.615238e+01*s31+3.063871e+01*s32+1.395528e+00*s33+(-3.328878e+00)*s34+(-3.398457e+00)*s35 \
v28_part1=2.171268e+00*s0+8.041855e-01*s1+4.119877e+00*s2+2.974853e+00*s3+2.480016e+00*s4+4.047268e+00*s5+2.491301e+00*s6+5.967825e+00*s7+1.494166e+00*s8+(-2.035858e-04)*s9 \
v28_part2=v28_part1+5.143189e-01*s10+1.006886e+00*s11+2.170238e+00*s12+5.122057e-01*s13+3.942440e+00*s14+3.325341e+00*s15+7.599041e-01*s16+7.958314e+00*s17+7.262094e+00*s18+(-1.347112e+01)*s19 \
v28_part3=v28_part2+4.461363e+00*s20+7.671252e+00*s21+6.228994e+00*s22+1.599334e+00*s23+7.706680e+00*s24+(-1.606156e+00)*s25+(-2.585625e+00)*s26+1.603085e-02*s27+1.490436e+00*s28+5.353283e+00*s29 \
v28=v28_part3+(-5.468282e+00)*s30+(-3.111719e+01)*s31+(-4.613007e+01)*s32+(-1.591050e+00)*s33+4.487240e+00*s34+(-4.170335e+00)*s35 \
v29_part1=2.566437e-01*s0+2.164955e+00*s1+2.833584e+00*s2+2.507225e+00*s3+3.873246e+00*s4+3.018598e+00*s5+3.960064e+00*s6+3.945198e+00*s7+1.956502e+00*s8+1.968184e+00*s9 \
v29_part2=v29_part1+2.965389e+00*s10+2.745235e+00*s11+2.783778e+00*s12+2.822607e+00*s13+3.002729e+00*s14+2.744796e+00*s15+2.689714e+00*s16+6.082334e-01*s17+1.186853e+00*s18+6.013161e+00*s19 \
v29_part3=v29_part2+3.729952e+00*s20+3.851675e+00*s21+3.008230e+00*s22+4.692464e+00*s23+2.469521e+00*s24+5.231605e+00*s25+6.535660e+00*s26+4.954760e+00*s27+3.846013e+00*s28+2.858411e+00*s29 \
v29=v29_part3+(-3.299115e+00)*s30+2.050372e+00*s31+1.338498e+01*s32+6.732352e+00*s33+5.831852e+00*s34+9.167103e+00*s35 \
v30_part1=(-6.806867e+00)*s0+0.000000e+00*s1+0.000000e+00*s2+0.000000e+00*s3+0.000000e+00*s4+0.000000e+00*s5+0.000000e+00*s6+0.000000e+00*s7+(-4.474199e+00)*s8+0.000000e+00*s9 \
v30_part2=v30_part1+(-2.168080e+01)*s10+0.000000e+00*s11+0.000000e+00*s12+0.000000e+00*s13+0.000000e+00*s14+(-2.523876e+00)*s15+0.000000e+00*s16+(-9.764406e-01)*s17+(-1.141972e+01)*s18+(-1.599911e+01)*s19 \
v30_part3=v30_part2+(-1.389172e+01)*s20+(-1.324184e+01)*s21+(-1.523327e+01)*s22+(-3.137450e+01)*s23+(-4.710109e+01)*s24+(-7.916992e+00)*s25+(-2.461999e+01)*s26+(-1.866405e+01)*s27+2.080931e+01*s28+(-4.255506e+00)*s29 \
v30=v30_part3+(-3.494902e+01)*s30+(-2.589430e+01)*s31+(-6.594710e+00)*s32+(-6.607174e+00)*s33+(-4.209270e+01)*s34+0.000000e+00*s35 \
v31_part1=4.141525e+01*s0+0.000000e+00*s1+0.000000e+00*s2+0.000000e+00*s3+0.000000e+00*s4+0.000000e+00*s5+0.000000e+00*s6+0.000000e+00*s7+1.386963e+01*s8+0.000000e+00*s9 \
v31_part2=v31_part1+3.034416e+01*s10+0.000000e+00*s11+0.000000e+00*s12+0.000000e+00*s13+0.000000e+00*s14+2.853055e+00*s15+0.000000e+00*s16+3.579707e+01*s17+4.476363e+01*s18+5.565412e+01*s19 \
v31_part3=v31_part2+4.370591e+01*s20+4.833152e+01*s21+5.527450e+01*s22+6.457293e+01*s23+7.661214e+01*s24+5.096545e+01*s25+5.992768e+01*s26+4.779455e+01*s27+1.658646e+01*s28+3.450900e+01*s29 \
v31=v31_part3+8.615144e+01*s30+1.191633e+02*s31+8.349991e+01*s32+7.192314e+01*s33+1.267105e+02*s34+0.000000e+00*s35 \
v32_part1=(-1.247122e+01)*s0+0.000000e+00*s1+0.000000e+00*s2+0.000000e+00*s3+0.000000e+00*s4+0.000000e+00*s5+0.000000e+00*s6+0.000000e+00*s7+(-5.519313e+00)*s8+0.000000e+00*s9 \
v32_part2=v32_part1+1.333274e-01*s10+0.000000e+00*s11+0.000000e+00*s12+0.000000e+00*s13+0.000000e+00*s14+1.916892e+00*s15+0.000000e+00*s16+(-2.065318e+01)*s17+(-1.516957e+01)*s18+(-2.014153e+01)*s19 \
v32_part3=v32_part2+(-7.753150e+00)*s20+(-1.729311e+01)*s21+(-2.319565e+01)*s22+(-8.726780e+00)*s23+(-2.730114e+00)*s24+(-2.959480e+01)*s25+(-1.708481e+01)*s26+(-1.059890e+01)*s27+(-2.351223e+01)*s28+(-2.471213e-01)*s29 \
v32=v32_part3+(-1.528040e+01)*s30+(-8.458769e+01)*s31+(-6.381454e+01)*s32+(-4.434309e+01)*s33+(-6.989137e+01)*s34+0.000000e+00*s35 \
v33_part1=0.000000e+00*s0+(-7.593106e+00)*s1+4.599499e+00*s2+(-2.298733e+01)*s3+(-1.077221e+01)*s4+(-4.151309e+00)*s5+(-3.723538e+01)*s6+(-1.322394e+01)*s7+1.001916e-03*s8+1.643935e+01*s9 \
v33_part2=v33_part1+(-8.858112e-04)*s10+(-5.004800e+01)*s11+(-2.450576e+01)*s12+(-2.759369e+01)*s13+(-1.434172e+01)*s14+(-1.649707e+01)*s15+(-3.857964e+01)*s16+1.542034e+01*s17+1.018350e+01*s18+1.095517e+01*s19 \
v33_part3=v33_part2+1.166803e+01*s20+(-7.596667e-02)*s21+7.193464e+01*s22+4.948609e+01*s23+4.230849e-01*s24+(-3.941566e+01)*s25+(-1.628109e+01)*s26+8.507381e-03*s27+(-1.564000e+01)*s28+2.740523e+00*s29 \
v33=v33_part3+(-3.910639e+01)*s30+1.428211e+02*s31+(-4.558386e+01)*s32+2.735294e-01*s33+7.545226e+01*s34+0.000000e+00*s35 \
v34_part1=0.000000e+00*s0+1.101323e+02*s1+9.385911e+01*s2+1.474218e+02*s3+1.145638e+02*s4+1.120980e+02*s5+1.730371e+02*s6+1.380205e+02*s7+6.843531e+01*s8+1.910183e+01*s9 \
v34_part2=v34_part1+7.554285e+01*s10+1.431875e+02*s11+1.153259e+02*s12+1.231857e+02*s13+1.041594e+02*s14+1.058583e+02*s15+1.302752e+02*s16+(-1.266421e+00)*s17+6.653591e+01*s18+5.978776e+00*s19 \
v34_part3=v34_part2+6.091551e+01*s20+3.902237e+01*s21+(-1.661230e+01)*s22+5.270675e+00*s23+4.528717e+01*s24+5.027313e+01*s25+7.476139e+01*s26+1.037379e+02*s27+1.252228e+02*s28+6.119028e+01*s29 \
v34=v34_part3+5.226471e+01*s30+(-2.472104e+02)*s31+5.701053e+01*s32+3.655733e-01*s33+(-1.318023e+02)*s34+0.000000e+00*s35 \
v35_part1=0.000000e+00*s0+(-9.033033e+00)*s1+(-1.377917e+01)*s2+(-1.183451e+01)*s3+(-3.017238e+00)*s4+(-8.732510e-01)*s5+(-3.008127e+00)*s6+2.057037e-05*s7+3.995946e+01*s8+5.671359e+01*s9 \
v35_part2=v35_part1+4.058443e+01*s10+3.736281e+01*s11+3.224036e+01*s12+2.467270e+01*s13+3.018332e+01*s14+2.505946e+01*s15+2.898187e+01*s16+9.747069e+01*s17+3.189400e+01*s18+1.059564e+02*s19 \
v35_part3=v35_part2+3.123353e+01*s20+8.523374e+01*s21+3.559368e+01*s22+4.635607e+01*s23+6.827911e+01*s24+1.263247e+02*s25+7.355172e+01*s26+1.514809e+01*s27+1.210298e+01*s28+3.925444e+01*s29 \
v35=v35_part3+8.335172e+01*s30+2.390721e+02*s31+9.207211e+01*s32+1.096771e+02*s33+1.935845e+02*s34+0.000000e+00*s35 \
v36_part1=0.000000e+00*s0+0.000000e+00*s1+0.000000e+00*s2+0.000000e+00*s3+0.000000e+00*s4+0.000000e+00*s5+0.000000e+00*s6+0.000000e+00*s7+0.000000e+00*s8+0.000000e+00*s9 \
v36_part2=v36_part1+0.000000e+00*s10+0.000000e+00*s11+0.000000e+00*s12+0.000000e+00*s13+0.000000e+00*s14+0.000000e+00*s15+0.000000e+00*s16+0.000000e+00*s17+0.000000e+00*s18+0.000000e+00*s19 \
v36_part3=v36_part2+0.000000e+00*s20+0.000000e+00*s21+0.000000e+00*s22+0.000000e+00*s23+0.000000e+00*s24+0.000000e+00*s25+0.000000e+00*s26+0.000000e+00*s27+0.000000e+00*s28+0.000000e+00*s29 \
v36=v36_part3+9.543695e-01*s30+0.000000e+00*s31+0.000000e+00*s32+0.000000e+00*s33+0.000000e+00*s34+2.223051e+01*s35 \
v37_part1=0.000000e+00*s0+0.000000e+00*s1+0.000000e+00*s2+0.000000e+00*s3+0.000000e+00*s4+0.000000e+00*s5+0.000000e+00*s6+0.000000e+00*s7+0.000000e+00*s8+0.000000e+00*s9 \
v37_part2=v37_part1+0.000000e+00*s10+0.000000e+00*s11+0.000000e+00*s12+0.000000e+00*s13+0.000000e+00*s14+0.000000e+00*s15+0.000000e+00*s16+0.000000e+00*s17+0.000000e+00*s18+0.000000e+00*s19 \
v37_part3=v37_part2+0.000000e+00*s20+0.000000e+00*s21+0.000000e+00*s22+0.000000e+00*s23+0.000000e+00*s24+0.000000e+00*s25+0.000000e+00*s26+0.000000e+00*s27+0.000000e+00*s28+0.000000e+00*s29 \
v37=v37_part3+1.454768e+00*s30+0.000000e+00*s31+0.000000e+00*s32+0.000000e+00*s33+0.000000e+00*s34+9.340245e+01*s35 \
v38_part1=0.000000e+00*s0+0.000000e+00*s1+0.000000e+00*s2+0.000000e+00*s3+0.000000e+00*s4+0.000000e+00*s5+0.000000e+00*s6+0.000000e+00*s7+0.000000e+00*s8+0.000000e+00*s9 \
v38_part2=v38_part1+0.000000e+00*s10+0.000000e+00*s11+0.000000e+00*s12+0.000000e+00*s13+0.000000e+00*s14+0.000000e+00*s15+0.000000e+00*s16+0.000000e+00*s17+0.000000e+00*s18+0.000000e+00*s19 \
v38_part3=v38_part2+0.000000e+00*s20+0.000000e+00*s21+0.000000e+00*s22+0.000000e+00*s23+0.000000e+00*s24+0.000000e+00*s25+0.000000e+00*s26+0.000000e+00*s27+0.000000e+00*s28+0.000000e+00*s29 \
v38=v38_part3+(-4.157677e-02)*s30+0.000000e+00*s31+0.000000e+00*s32+0.000000e+00*s33+0.000000e+00*s34+(-1.523440e+00)*s35 \
v39_part1=0.000000e+00*s0+0.000000e+00*s1+0.000000e+00*s2+0.000000e+00*s3+0.000000e+00*s4+0.000000e+00*s5+0.000000e+00*s6+0.000000e+00*s7+0.000000e+00*s8+0.000000e+00*s9 \
v39_part2=v39_part1+0.000000e+00*s10+0.000000e+00*s11+0.000000e+00*s12+0.000000e+00*s13+0.000000e+00*s14+0.000000e+00*s15+0.000000e+00*s16+0.000000e+00*s17+0.000000e+00*s18+0.000000e+00*s19 \
v39_part3=v39_part2+0.000000e+00*s20+0.000000e+00*s21+0.000000e+00*s22+0.000000e+00*s23+0.000000e+00*s24+0.000000e+00*s25+0.000000e+00*s26+0.000000e+00*s27+0.000000e+00*s28+0.000000e+00*s29 \
v39=v39_part3+0.000000e+00*s30+0.000000e+00*s31+0.000000e+00*s32+0.000000e+00*s33+0.000000e+00*s34+0.000000e+00*s35 \
v40_part1=0.000000e+00*s0+0.000000e+00*s1+0.000000e+00*s2+0.000000e+00*s3+0.000000e+00*s4+0.000000e+00*s5+0.000000e+00*s6+0.000000e+00*s7+0.000000e+00*s8+0.000000e+00*s9 \
v40_part2=v40_part1+0.000000e+00*s10+0.000000e+00*s11+0.000000e+00*s12+0.000000e+00*s13+0.000000e+00*s14+0.000000e+00*s15+0.000000e+00*s16+0.000000e+00*s17+0.000000e+00*s18+0.000000e+00*s19 \
v40_part3=v40_part2+0.000000e+00*s20+0.000000e+00*s21+0.000000e+00*s22+0.000000e+00*s23+0.000000e+00*s24+0.000000e+00*s25+0.000000e+00*s26+0.000000e+00*s27+0.000000e+00*s28+0.000000e+00*s29 \
v40=v40_part3+0.000000e+00*s30+0.000000e+00*s31+0.000000e+00*s32+0.000000e+00*s33+0.000000e+00*s34+0.000000e+00*s35 \
v41_part1=0.000000e+00*s0+0.000000e+00*s1+0.000000e+00*s2+0.000000e+00*s3+0.000000e+00*s4+0.000000e+00*s5+0.000000e+00*s6+0.000000e+00*s7+0.000000e+00*s8+0.000000e+00*s9 \
v41_part2=v41_part1+0.000000e+00*s10+0.000000e+00*s11+0.000000e+00*s12+0.000000e+00*s13+0.000000e+00*s14+0.000000e+00*s15+0.000000e+00*s16+0.000000e+00*s17+0.000000e+00*s18+0.000000e+00*s19 \
v41_part3=v41_part2+0.000000e+00*s20+0.000000e+00*s21+0.000000e+00*s22+0.000000e+00*s23+0.000000e+00*s24+0.000000e+00*s25+0.000000e+00*s26+0.000000e+00*s27+0.000000e+00*s28+0.000000e+00*s29 \
v41=v41_part3+0.000000e+00*s30+0.000000e+00*s31+0.000000e+00*s32+0.000000e+00*s33+0.000000e+00*s34+0.000000e+00*s35 \
v42_part1=(-2.221835e-01)*s0+1.488862e+00*s1+1.499899e+00*s2+1.688412e+00*s3+1.379659e+00*s4+7.903438e-01*s5+2.117665e+00*s6+1.378302e-01*s7+2.667138e+00*s8+2.774354e+00*s9 \
v42_part2=v42_part1+2.290871e+00*s10+6.328646e-01*s11+1.400903e+00*s12+1.730536e+00*s13+1.770619e+00*s14+1.878235e+00*s15+1.944140e+00*s16+1.573079e+00*s17+1.616186e+00*s18+1.131224e+00*s19 \
v42_part3=v42_part2+1.500551e+00*s20+1.123376e+00*s21+8.661336e-01*s22+1.873095e+00*s23+1.181095e+00*s24+6.936527e-01*s25+1.122075e+00*s26+5.578112e-01*s27+9.250526e-01*s28+1.029203e+00*s29 \
v42=v42_part3+1.432127e+00*s30+6.153998e-01*s31+1.488796e+00*s32+1.090885e+00*s33+9.531169e-01*s34+(-2.952144e-01)*s35 \
v43_part1=(-1.067558e-01)*s0+(-1.131935e+00)*s1+(-1.400594e+00)*s2+(-9.555153e-01)*s3+(-8.936289e-01)*s4+(-2.256180e-01)*s5+(-1.270680e+00)*s6+2.457484e-04*s7+(-1.264529e+00)*s8+(-2.119709e+00)*s9 \
v43_part2=v43_part1+(-1.087057e+00)*s10+6.801981e-01*s11+(-2.945414e-01)*s12+(-5.574230e-01)*s13+(-7.200137e-01)*s14+(-7.567024e-01)*s15+(-8.336861e-01)*s16+(-5.993090e-01)*s17+(-1.434503e+00)*s18+(-9.130853e-01)*s19 \
v43_part3=v43_part2+(-6.787191e-01)*s20+(-3.423527e-01)*s21+(-1.089869e-01)*s22+(-1.026692e+00)*s23+(-4.706030e-01)*s24+1.289073e-02*s25+(-6.559431e-03)*s26+1.046538e-01*s27+(-3.207437e-01)*s28+(-9.841816e-01)*s29 \
v43=v43_part3+(-6.816265e-01)*s30+(-3.193908e-01)*s31+(-7.190870e-01)*s32+(-4.477111e-01)*s33+1.336220e-02*s34+1.465054e+00*s35 \
v44_part1=4.621402e-02*s0+1.430291e+00*s1+1.696546e+00*s2+9.148224e-01*s3+1.187327e+00*s4+1.566275e+00*s5+7.254793e-01*s6+2.324620e+00*s7+4.290441e-03*s8+7.618908e-01*s9 \
v44_part2=v44_part1+3.233136e-01*s10+4.766878e-01*s11+5.569811e-01*s12+3.729049e-01*s13+4.858658e-01*s14+4.256497e-01*s15+4.748356e-01*s16+(-6.963408e-03)*s17+7.763231e-01*s18+1.073344e+00*s19 \
v44_part3=v44_part2+2.350941e-01*s20+3.749922e-01*s21+4.152834e-01*s22+1.200764e-01*s23+4.286440e-01*s24+4.762617e-01*s25+(-9.585980e-03)*s26+6.028079e-01*s27+4.788325e-01*s28+1.223059e+00*s29 \
v44=v44_part3+9.571808e-03*s30+9.116608e-01*s31+4.478123e-03*s32+3.463844e-01*s33+(-2.717180e-02)*s34+(-1.242834e+00)*s35 \
v45_part1=(-3.150633e+03)*s0+7.924489e-01*s1+(-4.740331e-01)*s2+(-2.443487e-01)*s3+9.013069e-03*s4+1.218607e+00*s5+(-3.303226e-01)*s6+3.903827e+00*s7+(-1.598305e-03)*s8+(-1.762100e+00)*s9 \
v45_part2=v45_part1+(-1.135102e+00)*s10+2.140114e+00*s11+7.464336e-01*s12+(-4.578053e-01)*s13+(-3.120740e-01)*s14+(-2.172145e-01)*s15+(-4.630519e-01)*s16+(-1.834652e-01)*s17+(-2.840903e+00)*s18+8.595283e-02*s19 \
v45_part3=v45_part2+(-4.230535e+00)*s20+3.460992e-02*s21+2.999292e-01*s22+(-9.615963e+00)*s23+(-3.903353e+00)*s24+2.264650e+00*s25+2.139251e-02*s26+1.898670e+00*s27+(-1.291726e+00)*s28+1.630889e-02*s29 \
v45=v45_part3+1.144070e+00*s30+(-5.863817e-01)*s31+1.187850e+00*s32+3.977406e-01*s33+9.056134e+00*s34+(-3.812608e+02)*s35 \
v46_part1=(-2.175060e+03)*s0+(-3.927784e+00)*s1+(-2.109035e+00)*s2+(-3.962066e+00)*s3+(-3.367720e+00)*s4+(-5.566677e+00)*s5+(-4.669523e+00)*s6+(-8.637774e+00)*s7+(-4.687831e+00)*s8+(-2.012292e+00)*s9 \
v46_part2=v46_part1+(-3.855064e+00)*s10+(-6.260834e+00)*s11+(-4.514491e+00)*s12+(-3.489724e+00)*s13+(-3.169468e+00)*s14+(-3.281269e+00)*s15+(-2.570792e+00)*s16+(-1.047146e+01)*s17+(-2.599456e-01)*s18+(-3.363477e+00)*s19 \
v46_part3=v46_part2+(-7.183147e+00)*s20+(-1.053661e+01)*s21+(-8.089205e+00)*s22+2.758521e-01*s23+(-3.439047e+00)*s24+(-8.927237e+00)*s25+(-8.854055e+00)*s26+(-9.020493e+00)*s27+(-1.999742e+00)*s28+(-8.550909e+00)*s29 \
v46=v46_part3+(-1.139037e+01)*s30+(-4.182072e+00)*s31+(-2.135253e+01)*s32+(-2.502916e+01)*s33+(-4.759572e+01)*s34+(-1.772049e+03)*s35 \
v47_part1=(-6.104902e+03)*s0+2.966198e-01*s1+6.791083e-01*s2+1.939452e+00*s3+1.210187e+00*s4+1.218324e+00*s5+2.429176e+00*s6+(-3.606212e-03)*s7+2.060934e+00*s8+1.368527e+00*s9 \
v47_part2=v47_part1+2.330847e+00*s10+1.164094e+00*s11+1.238559e+00*s12+1.877618e+00*s13+1.492067e+00*s14+1.402849e+00*s15+8.757044e-01*s16+7.952296e+00*s17+1.701942e+00*s18+(-3.023809e-01)*s19 \
v47_part3=v47_part2+1.075807e+01*s20+8.401600e+00*s21+5.596612e+00*s22+9.515425e+00*s23+5.706965e+00*s24+4.019286e+00*s25+6.480664e+00*s26+4.112945e+00*s27+1.224955e+00*s28+4.591104e+00*s29 \
v47=v47_part3+7.828887e+00*s30+(-6.308151e-01)*s31+2.269157e+01*s32+2.764623e+01*s33+4.438244e+01*s34+(-1.885343e+03)*s35 \
v48_part1=(-5.518265e+03)*s0+(-5.324140e+01)*s1+(-9.519934e+02)*s2+(-5.337310e+03)*s3+(-2.062375e+03)*s4+(-7.797194e+01)*s5+(-1.000000e+04)*s6+(-4.516500e+03)*s7+(-2.236929e+01)*s8+(-1.140998e+03)*s9 \
v48_part2=v48_part1+(-1.000000e+04)*s10+(-2.048679e+03)*s11+(-1.464695e+03)*s12+(-4.708204e+01)*s13+(-8.801817e+03)*s14+(-3.913195e+02)*s15+(-1.312896e+02)*s16+(-1.000000e+04)*s17+(-3.322001e+03)*s18+(-1.000000e+04)*s19 \
v48_part3=v48_part2+(-8.271538e+02)*s20+(-1.000000e+04)*s21+(-9.207399e+03)*s22+(-4.386588e+03)*s23+(-1.000000e+04)*s24+(-1.745471e+03)*s25+(-1.000000e+04)*s26+(-2.195978e+03)*s27+(-3.457278e+02)*s28+(-5.557271e+02)*s29 \
v48=v48_part3+(-2.123449e+03)*s30+(-1.000000e+04)*s31+(-6.866629e+03)*s32+(-3.085101e+03)*s33+(-8.156282e+03)*s34+(-1.000000e+04)*s35 \
v49_part1=(-5.122572e+03)*s0+(-6.011875e+01)*s1+(-2.189174e+03)*s2+(-1.000000e+04)*s3+(-4.018692e+03)*s4+(-1.447135e+03)*s5+(-1.000000e+04)*s6+(-4.544394e+03)*s7+(-6.168993e+01)*s8+(-5.574030e+03)*s9 \
v49_part2=v49_part1+(-7.087945e+03)*s10+(-7.413742e+03)*s11+(-8.676135e+02)*s12+(-1.947204e+02)*s13+(-1.000000e+04)*s14+(-3.393441e+03)*s15+(-3.358644e+02)*s16+(-1.000000e+04)*s17+(-1.992333e+03)*s18+(-1.000000e+04)*s19 \
v49_part3=v49_part2+(-4.018631e+03)*s20+(-1.000000e+04)*s21+(-6.125339e+03)*s22+(-1.000000e+04)*s23+(-1.000000e+04)*s24+(-5.454258e+03)*s25+(-1.000000e+04)*s26+(-3.811434e+03)*s27+(-1.673856e+03)*s28+(-2.782841e+03)*s29 \
v49=v49_part3+(-6.446866e+03)*s30+(-1.000000e+04)*s31+(-1.000000e+04)*s32+(-1.000000e+04)*s33+(-1.000000e+04)*s34+(-1.000000e+04)*s35 \
v50_part1=(-5.594497e+03)*s0+(-7.868957e+01)*s1+(-7.408027e+02)*s2+(-1.000000e+04)*s3+(-2.432218e+03)*s4+(-1.151904e+02)*s5+(-1.000000e+04)*s6+(-4.655110e+03)*s7+2.546209e-06*s8+(-5.920881e+02)*s9 \
v50_part2=v50_part1+(-1.000000e+04)*s10+(-5.644172e+02)*s11+(-3.778804e+02)*s12+(-4.693064e+01)*s13+(-1.000000e+04)*s14+(-3.095710e+03)*s15+(-2.290366e+02)*s16+(-1.000000e+04)*s17+(-1.484753e+03)*s18+(-1.000000e+04)*s19 \
v50_part3=v50_part2+(-6.507011e+02)*s20+(-1.000000e+04)*s21+(-6.380236e+03)*s22+(-5.030086e+03)*s23+(-1.000000e+04)*s24+(-1.844865e+03)*s25+(-1.000000e+04)*s26+(-6.320932e+03)*s27+(-7.781006e+02)*s28+(-3.357405e+03)*s29 \
v50=v50_part3+(-5.009010e+03)*s30+(-1.000000e+04)*s31+(-5.966340e+03)*s32+(-9.415431e+03)*s33+(-6.903747e+03)*s34+(-4.527018e+03)*s35 \
v51_part1=(-1.476139e+00)*s0+2.467191e-01*s1+(-7.739813e-02)*s2+(-2.961539e-01)*s3+(-2.437006e+00)*s4+(-3.799958e-01)*s5+3.505646e+00*s6+(-3.523244e-05)*s7+2.920338e-04*s8+0.000000e+00*s9 \
v51_part2=v51_part1+3.738178e-01*s10+(-2.873898e+00)*s11+(-3.737186e+00)*s12+(-1.449906e+00)*s13+(-9.207404e-01)*s14+(-9.867595e-01)*s15+(-1.525031e+00)*s16+(-1.479474e+00)*s17+(-2.679300e+00)*s18+(-1.406906e+00)*s19 \
v51_part3=v51_part2+(-3.915581e+00)*s20+(-7.894458e-01)*s21+(-4.024319e+00)*s22+2.549026e+00*s23+(-6.346544e+00)*s24+(-5.914960e+00)*s25+(-1.428256e+00)*s26+(-9.355652e-01)*s27+(-1.174322e+01)*s28+(-1.220845e+00)*s29 \
v51=v51_part3+(-6.876871e+00)*s30+(-1.903466e+00)*s31+3.416123e+00*s32+(-1.261596e+00)*s33+(-5.241233e+00)*s34+1.000000e+04*s35 \
v52_part1=9.518482e+00*s0+5.231689e+00*s1+7.123659e+00*s2+7.089741e+00*s3+(-8.374981e-01)*s4+7.712542e+00*s5+(-4.133324e-01)*s6+2.088123e+00*s7+4.665481e+00*s8+0.000000e+00*s9 \
v52_part2=v52_part1+6.106483e+00*s10+8.675953e+00*s11+9.390793e+00*s12+6.801899e+00*s13+5.919627e+00*s14+6.465008e+00*s15+6.786414e+00*s16+1.243729e+01*s17+1.385669e+01*s18+1.504268e+01*s19 \
v52_part3=v52_part2+1.673876e+01*s20+1.583821e+01*s21+1.682466e+01*s22+1.027524e+01*s23+1.812647e+01*s24+1.797827e+01*s25+1.269504e+01*s26+1.332520e+01*s27+2.426078e+01*s28+1.752133e+01*s29 \
v52=v52_part3+2.530380e+01*s30+1.948181e+01*s31+1.574589e+01*s32+1.824741e+01*s33+2.785283e+01*s34+1.002158e+03*s35 \
v53_part1=(-1.063587e+00)*s0+9.423949e-02*s1+(-1.073299e+00)*s2+(-5.813273e-01)*s3+8.157431e+00*s4+(-1.186331e+00)*s5+3.543844e-01*s6+2.456039e+00*s7+1.040257e+00*s8+0.000000e+00*s9 \
v53_part2=v53_part1+(-5.532758e-03)*s10+1.391770e+00*s11+1.000545e+00*s12+7.976660e-01*s13+9.774353e-01*s14+7.368420e-01*s15+8.044426e-01*s16+1.134523e+00*s17+1.615004e+00*s18+(-2.190363e+00)*s19 \
v53_part3=v53_part2+(-1.757946e-02)*s20+(-4.145089e+00)*s21+(-2.621217e-01)*s22+(-1.984007e+00)*s23+1.463088e+00*s24+7.534633e-01*s25+6.416162e-01*s26+(-5.332595e-01)*s27+2.318593e-01*s28+(-1.328498e-02)*s29 \
v53=v53_part3+(-8.510286e-01)*s30+(-1.137988e+00)*s31+(-4.263290e+00)*s32+1.099848e-02*s33+(-7.494802e+00)*s34+1.618608e+03*s35 \
v54_part1=0.000000e+00*s0+0.000000e+00*s1+0.000000e+00*s2+0.000000e+00*s3+6.597676e+00*s4+0.000000e+00*s5+0.000000e+00*s6+0.000000e+00*s7+0.000000e+00*s8+7.170667e+02*s9 \
v54_part2=v54_part1+0.000000e+00*s10+0.000000e+00*s11+0.000000e+00*s12+0.000000e+00*s13+0.000000e+00*s14+0.000000e+00*s15+0.000000e+00*s16+2.898659e-03*s17+0.000000e+00*s18+0.000000e+00*s19 \
v54_part3=v54_part2+0.000000e+00*s20+0.000000e+00*s21+(-1.412015e-02)*s22+1.408587e-01*s23+(-5.833482e-02)*s24+(-7.008231e-03)*s25+0.000000e+00*s26+0.000000e+00*s27+0.000000e+00*s28+0.000000e+00*s29 \
v54=v54_part3+0.000000e+00*s30+0.000000e+00*s31+0.000000e+00*s32+0.000000e+00*s33+0.000000e+00*s34+6.172345e-01*s35 \
v55_part1=0.000000e+00*s0+0.000000e+00*s1+0.000000e+00*s2+0.000000e+00*s3+(-7.713005e+00)*s4+0.000000e+00*s5+0.000000e+00*s6+0.000000e+00*s7+0.000000e+00*s8+5.077537e+02*s9 \
v55_part2=v55_part1+0.000000e+00*s10+0.000000e+00*s11+0.000000e+00*s12+0.000000e+00*s13+0.000000e+00*s14+0.000000e+00*s15+0.000000e+00*s16+4.107963e-03*s17+0.000000e+00*s18+0.000000e+00*s19 \
v55_part3=v55_part2+0.000000e+00*s20+0.000000e+00*s21+(-1.848896e-01)*s22+(-1.846408e-01)*s23+(-3.827613e-02)*s24+(-6.580857e-02)*s25+0.000000e+00*s26+0.000000e+00*s27+0.000000e+00*s28+0.000000e+00*s29 \
v55=v55_part3+0.000000e+00*s30+0.000000e+00*s31+0.000000e+00*s32+0.000000e+00*s33+0.000000e+00*s34+5.661321e-01*s35 \
v56_part1=0.000000e+00*s0+0.000000e+00*s1+0.000000e+00*s2+0.000000e+00*s3+7.751694e+00*s4+0.000000e+00*s5+0.000000e+00*s6+0.000000e+00*s7+0.000000e+00*s8+7.120301e+02*s9 \
v56_part2=v56_part1+0.000000e+00*s10+0.000000e+00*s11+0.000000e+00*s12+0.000000e+00*s13+0.000000e+00*s14+0.000000e+00*s15+0.000000e+00*s16+(-7.473465e-03)*s17+0.000000e+00*s18+0.000000e+00*s19 \
v56_part3=v56_part2+0.000000e+00*s20+0.000000e+00*s21+2.903232e-01*s22+5.896512e-02*s23+1.400246e-01*s24+1.022136e-01*s25+0.000000e+00*s26+0.000000e+00*s27+0.000000e+00*s28+0.000000e+00*s29 \
v56=v56_part3+0.000000e+00*s30+0.000000e+00*s31+0.000000e+00*s32+0.000000e+00*s33+0.000000e+00*s34+2.605304e-02*s35 \
v57_part1=4.003796e+02*s0+8.685523e+02*s1+2.962674e+03*s2+7.354499e+03*s3+1.840037e+01*s4+2.557633e+02*s5+8.565904e+03*s6+3.136779e+03*s7+3.171433e+02*s8+3.300571e+02*s9 \
v57_part2=v57_part1+2.758535e+02*s10+1.945616e+03*s11+6.313540e+03*s12+1.097242e+02*s13+8.907825e+03*s14+1.622033e+03*s15+8.704255e+03*s16+1.000000e+04*s17+5.407937e+01*s18+8.537140e+03*s19 \
v57_part3=v57_part2+4.995020e+01*s20+(-1.246775e+03)*s21+1.214650e+03*s22+6.553311e+02*s23+9.849729e+03*s24+1.413095e+03*s25+6.526884e+02*s26+7.123897e+02*s27+1.419317e+02*s28+7.353599e+02*s29 \
v57=v57_part3+1.847146e+03*s30+2.739553e+03*s31+3.519966e+03*s32+2.445718e+03*s33+7.158480e+03*s34+(-1.328000e+01)*s35 \
v58_part1=1.236392e+02*s0+4.882244e+01*s1+9.023979e+02*s2+7.858535e+03*s3+(-3.488003e+00)*s4+5.280422e-01*s5+7.295366e+03*s6+1.000000e+04*s7+2.351351e+03*s8+1.032307e+02*s9 \
v58_part2=v58_part1+2.803158e+02*s10+3.174662e+03*s11+1.000000e+04*s12+3.223979e+02*s13+8.907825e+03*s14+1.124580e+03*s15+8.639242e+03*s16+9.177229e+03*s17+1.655410e+02*s18+8.029459e+03*s19 \
v58_part3=v58_part2+1.252215e+03*s20+(-1.169282e+03)*s21+4.274071e+03*s22+4.749389e+01*s23+1.984306e+03*s24+8.655871e+02*s25+1.702311e+03*s26+1.989775e+02*s27+4.867431e+02*s28+7.211259e+00*s29 \
v58=v58_part3+6.149760e+01*s30+3.684010e+03*s31+8.212312e+01*s32+5.744970e+01*s33+4.227748e+03*s34+2.480190e+01*s35 \
v59_part1=1.685516e+02*s0+2.664749e+03*s1+6.880158e+02*s2+1.000000e+04*s3+1.931204e+02*s4+2.527837e+03*s5+1.000000e+04*s6+5.053348e+03*s7+4.311670e+02*s8+2.166036e+02*s9 \
v59_part2=v59_part1+6.250000e+02*s10+1.687160e+02*s11+5.583936e+03*s12+2.979149e+02*s13+8.907825e+03*s14+8.485839e+02*s15+4.717213e+02*s16+1.000000e+04*s17+5.044561e+02*s18+7.977970e+03*s19 \
v59_part3=v59_part2+1.206770e+02*s20+8.209026e+03*s21+5.219173e+02*s22+1.000000e+04*s23+1.000000e+04*s24+1.712277e+03*s25+5.821819e+03*s26+2.022898e+02*s27+7.717916e+01*s28+1.250183e+03*s29 \
v59=v59_part3+2.156322e+03*s30+9.913022e+02*s31+4.436265e+03*s32+3.597504e+03*s33+7.589485e+03*s34+1.414263e+01*s35 \
v60_part1=1.919415e+00*s0+3.091034e+00*s1+3.158794e+00*s2+4.493540e+00*s3+5.487867e+00*s4+2.538997e+00*s5+3.324549e+00*s6+2.003115e+00*s7+9.648060e-01*s8+7.842359e+00*s9 \
v60_part2=v60_part1+4.099338e+00*s10+3.551449e+00*s11+2.746429e+00*s12+3.007349e+00*s13+2.429480e+00*s14+2.017516e+00*s15+2.409211e+00*s16+3.587274e+00*s17+(-1.775936e+00)*s18+5.398022e+00*s19 \
v60_part3=v60_part2+2.708619e+00*s20+2.952186e+00*s21+2.301482e+00*s22+3.324265e+00*s23+1.671795e+00*s24+2.088692e+00*s25+1.981870e+00*s26+3.044497e+00*s27+1.980624e+00*s28+3.030997e+00*s29 \
v60=v60_part3+(-8.010768e-02)*s30+8.168459e-01*s31+5.935049e+00*s32+3.573319e+00*s33+7.172167e-01*s34+4.503266e-01*s35 \
v61_part1=2.483572e+00*s0+6.435329e-01*s1+2.709080e+00*s2+2.321090e+00*s3+3.796199e+00*s4+3.056145e+00*s5+8.573203e-01*s6+1.266917e+00*s7+1.956674e+00*s8+(-4.336316e-04)*s9 \
v61_part2=v61_part1+1.757225e-02*s10+2.543534e-03*s11+(-1.980522e-01)*s12+(-1.578628e-02)*s13+5.472954e-01*s14+1.139950e+00*s15+(-3.021802e-02)*s16+(-3.713680e+00)*s17+3.994958e+00*s18+(-3.533695e+00)*s19 \
v61_part3=v61_part2+(-7.764585e-01)*s20+(-3.874506e-01)*s21+(-1.383867e-01)*s22+(-1.558945e+00)*s23+(-1.085677e-01)*s24+(-6.114079e-01)*s25+(-1.201080e+00)*s26+(-1.576992e+00)*s27+1.131510e-01*s28+(-1.827988e+00)*s29 \
v61=v61_part3+7.032649e-02*s30+(-4.033067e-01)*s31+(-3.706905e+00)*s32+(-2.167390e+00)*s33+2.194237e-01*s34+(-4.779480e-01)*s35 \
v62_part1=(-2.173763e+00)*s0+(-2.285010e+00)*s1+(-4.215986e+00)*s2+(-5.539435e+00)*s3+(-5.740897e+00)*s4+(-3.123649e+00)*s5+(-2.227144e+00)*s6+(-9.836589e-01)*s7+(-2.001658e-01)*s8+(-4.168295e+00)*s9 \
v62_part2=v62_part1+(-1.498620e+00)*s10+(-1.006204e+00)*s11+(-5.626795e-01)*s12+(-1.089281e+00)*s13+(-1.155179e+00)*s14+(-1.258758e+00)*s15+(-6.265115e-01)*s16+1.691217e+00*s17+2.001800e+00*s18+(-1.801973e+00)*s19 \
v62_part3=v62_part2+(-5.344502e-01)*s20+(-1.439643e+00)*s21+(-8.626813e-01)*s22+(-4.493959e-01)*s23+1.066394e-01*s24+1.314918e-01*s25+9.698419e-01*s26+7.225300e-02*s27+(-4.090381e-01)*s28+1.094770e-01*s29 \
v62=v62_part3+2.816988e+00*s30+1.702492e+00*s31+(-2.002746e+00)*s32+(-2.536924e-01)*s33+6.556463e-01*s34+2.086255e-01*s35 \
v63_part1=4.582300e-01*s0+0.000000e+00*s1+0.000000e+00*s2+0.000000e+00*s3+0.000000e+00*s4+0.000000e+00*s5+0.000000e+00*s6+0.000000e+00*s7+1.978375e+02*s8+(-1.528508e+01)*s9 \
v63_part2=v63_part1+0.000000e+00*s10+0.000000e+00*s11+0.000000e+00*s12+6.634252e+01*s13+0.000000e+00*s14+0.000000e+00*s15+0.000000e+00*s16+0.000000e+00*s17+0.000000e+00*s18+2.466924e+03*s19 \
v63_part3=v63_part2+6.920797e+00*s20+0.000000e+00*s21+0.000000e+00*s22+0.000000e+00*s23+0.000000e+00*s24+6.481314e+00*s25+0.000000e+00*s26+0.000000e+00*s27+1.070160e+02*s28+0.000000e+00*s29 \
v63=v63_part3+1.767348e+02*s30+0.000000e+00*s31+0.000000e+00*s32+3.077542e+00*s33+1.178890e+03*s34+6.039849e+02*s35 \
v64_part1=8.198972e-01*s0+0.000000e+00*s1+0.000000e+00*s2+0.000000e+00*s3+0.000000e+00*s4+0.000000e+00*s5+0.000000e+00*s6+0.000000e+00*s7+2.386283e+02*s8+2.743105e+01*s9 \
v64_part2=v64_part1+0.000000e+00*s10+0.000000e+00*s11+0.000000e+00*s12+9.360078e+01*s13+0.000000e+00*s14+0.000000e+00*s15+0.000000e+00*s16+0.000000e+00*s17+0.000000e+00*s18+8.478308e+02*s19 \
v64_part3=v64_part2+2.423457e+00*s20+0.000000e+00*s21+0.000000e+00*s22+0.000000e+00*s23+0.000000e+00*s24+8.710973e+00*s25+0.000000e+00*s26+0.000000e+00*s27+1.799957e+01*s28+0.000000e+00*s29 \
v64=v64_part3+5.578201e+01*s30+0.000000e+00*s31+0.000000e+00*s32+8.135289e-01*s33+3.466743e+03*s34+5.500301e+03*s35 \
v65_part1=1.061156e+01*s0+0.000000e+00*s1+0.000000e+00*s2+0.000000e+00*s3+0.000000e+00*s4+0.000000e+00*s5+0.000000e+00*s6+0.000000e+00*s7+1.043422e+02*s8+(-2.361172e+00)*s9 \
v65_part2=v65_part1+0.000000e+00*s10+0.000000e+00*s11+0.000000e+00*s12+2.580722e+02*s13+0.000000e+00*s14+0.000000e+00*s15+0.000000e+00*s16+0.000000e+00*s17+0.000000e+00*s18+2.267097e+03*s19 \
v65_part3=v65_part2+6.507370e+00*s20+0.000000e+00*s21+0.000000e+00*s22+0.000000e+00*s23+0.000000e+00*s24+5.444674e+01*s25+0.000000e+00*s26+0.000000e+00*s27+2.897392e+01*s28+0.000000e+00*s29 \
v65=v65_part3+1.820186e+02*s30+0.000000e+00*s31+0.000000e+00*s32+1.199247e+02*s33+9.505353e+02*s34+4.196168e+03*s35 \
v66_part1=6.104697e+00*s0+0.000000e+00*s1+0.000000e+00*s2+0.000000e+00*s3+0.000000e+00*s4+0.000000e+00*s5+0.000000e+00*s6+0.000000e+00*s7+2.948647e+00*s8+0.000000e+00*s9 \
v66_part2=v66_part1+0.000000e+00*s10+0.000000e+00*s11+0.000000e+00*s12+2.322343e+02*s13+0.000000e+00*s14+0.000000e+00*s15+0.000000e+00*s16+0.000000e+00*s17+2.816560e+00*s18+1.000000e+04*s19 \
v66_part3=v66_part2+4.194209e+02*s20+0.000000e+00*s21+3.346006e+03*s22+9.459455e-01*s23+0.000000e+00*s24+3.228082e+02*s25+0.000000e+00*s26+0.000000e+00*s27+3.752398e+00*s28+4.162121e+01*s29 \
v66=v66_part3+5.406114e+00*s30+0.000000e+00*s31+1.769860e+03*s32+2.915233e+02*s33+8.076239e+02*s34+2.533743e+03*s35 \
v67_part1=3.074563e+00*s0+0.000000e+00*s1+0.000000e+00*s2+0.000000e+00*s3+0.000000e+00*s4+0.000000e+00*s5+0.000000e+00*s6+0.000000e+00*s7+4.858291e+01*s8+0.000000e+00*s9 \
v67_part2=v67_part1+0.000000e+00*s10+0.000000e+00*s11+0.000000e+00*s12+2.201507e+01*s13+0.000000e+00*s14+0.000000e+00*s15+0.000000e+00*s16+0.000000e+00*s17+1.538590e+00*s18+1.000000e+04*s19 \
v67_part3=v67_part2+1.695803e+02*s20+0.000000e+00*s21+2.357701e+03*s22+1.763206e-01*s23+0.000000e+00*s24+1.025065e+03*s25+0.000000e+00*s26+0.000000e+00*s27+9.151484e+00*s28+1.338519e+01*s29 \
v67=v67_part3+7.758348e+00*s30+0.000000e+00*s31+7.086050e+01*s32+2.315403e+01*s33+8.420069e+01*s34+7.155662e+03*s35 \
v68_part1=(-1.585261e-01)*s0+0.000000e+00*s1+0.000000e+00*s2+0.000000e+00*s3+0.000000e+00*s4+0.000000e+00*s5+0.000000e+00*s6+0.000000e+00*s7+1.481628e+01*s8+0.000000e+00*s9 \
v68_part2=v68_part1+0.000000e+00*s10+0.000000e+00*s11+0.000000e+00*s12+2.172503e+02*s13+0.000000e+00*s14+0.000000e+00*s15+0.000000e+00*s16+0.000000e+00*s17+2.706420e-01*s18+1.000000e+04*s19 \
v68_part3=v68_part2+1.723156e+02*s20+0.000000e+00*s21+4.663683e+03*s22+4.846741e+01*s23+0.000000e+00*s24+1.351805e+03*s25+0.000000e+00*s26+0.000000e+00*s27+9.843055e+01*s28+1.337894e+01*s29 \
v68=v68_part3+2.789822e+00*s30+0.000000e+00*s31+3.921959e+03*s32+8.664852e+01*s33+7.292065e+01*s34+8.074319e+03*s35 \
v69_part1=8.494898e-01*s0+(-5.089389e-01)*s1+(-1.221164e-01)*s2+(-3.571009e+00)*s3+5.153304e-01*s4+4.717269e-01*s5+(-3.722682e-01)*s6+(-1.409933e-03)*s7+3.182457e-03*s8+(-9.210171e-01)*s9 \
v69_part2=v69_part1+(-2.023743e+00)*s10+(-3.555620e+00)*s11+8.116161e+00*s12+(-3.886105e+00)*s13+(-1.628827e+00)*s14+(-1.331406e-01)*s15+(-4.188395e+00)*s16+(-2.299028e+00)*s17+(-3.754815e-01)*s18+(-1.364447e+01)*s19 \
v69_part3=v69_part2+(-3.413154e+00)*s20+(-4.723154e+00)*s21+(-2.133020e+00)*s22+(-3.103605e+00)*s23+(-6.306004e+00)*s24+(-4.738575e+00)*s25+(-1.276773e+01)*s26+(-6.663195e+00)*s27+4.207159e+00*s28+(-7.500117e+00)*s29 \
v69=v69_part3+(-1.497088e+00)*s30+(-1.386032e+01)*s31+(-2.449516e+01)*s32+(-2.809470e+01)*s33+4.167631e-01*s34+5.015635e+00*s35 \
v70_part1=1.125880e+01*s0+1.538434e+01*s1+1.012134e+01*s2+1.499119e+01*s3+6.985830e+00*s4+1.116815e+01*s5+1.311272e+01*s6+1.352034e+01*s7+1.081888e+01*s8+5.148241e+00*s9 \
v70_part2=v70_part1+1.415464e+01*s10+1.717191e+01*s11+4.384200e+00*s12+1.832829e+01*s13+1.515055e+01*s14+1.379778e+01*s15+1.870950e+01*s16+3.217544e+01*s17+3.090585e+01*s18+4.814403e+01*s19 \
v70_part3=v70_part2+3.536945e+01*s20+3.345222e+01*s21+3.341691e+01*s22+3.924582e+01*s23+4.102017e+01*s24+3.836874e+01*s25+4.873305e+01*s26+3.780593e+01*s27+2.106553e+01*s28+5.234195e+01*s29 \
v70=v70_part3+7.347289e+01*s30+7.838915e+01*s31+7.232501e+01*s32+7.607232e+01*s33+5.166352e+01*s34+6.994876e+00*s35 \
v71_part1=4.595769e+00*s0+1.487765e+00*s1+5.182701e+00*s2+5.899394e+00*s3+(-8.461872e-02)*s4+2.466653e+00*s5+3.020232e+00*s6+2.146787e+00*s7+4.231302e+00*s8+2.703938e+00*s9 \
v71_part2=v71_part1+2.865832e+00*s10+2.290003e+00*s11+3.064467e+00*s12+3.174657e+00*s13+4.513529e+00*s14+3.791062e+00*s15+3.931058e+00*s16+(-2.976973e-01)*s17+(-1.406725e+00)*s18+1.877362e+00*s19 \
v71_part3=v71_part2+(-2.337132e-02)*s20+4.453315e+00*s21+2.063335e+00*s22+(-4.761413e+00)*s23+(-1.780234e+00)*s24+(-5.439914e-01)*s25+(-1.802974e+00)*s26+2.382833e+00*s27+9.136279e+00*s28+(-2.456172e+00)*s29 \
v71=v71_part3+(-4.430085e+01)*s30+(-2.958973e+01)*s31+(-1.304779e+00)*s32+(-1.707393e+00)*s33+(-1.074374e+01)*s34+(-7.857529e+00)*s35 \
v72_part1=0.000000e+00*s0+0.000000e+00*s1+0.000000e+00*s2+0.000000e+00*s3+(-2.304367e-03)*s4+0.000000e+00*s5+0.000000e+00*s6+0.000000e+00*s7+0.000000e+00*s8+1.818812e-01*s9 \
v72_part2=v72_part1+0.000000e+00*s10+0.000000e+00*s11+0.000000e+00*s12+0.000000e+00*s13+0.000000e+00*s14+0.000000e+00*s15+0.000000e+00*s16+0.000000e+00*s17+0.000000e+00*s18+0.000000e+00*s19 \
v72_part3=v72_part2+0.000000e+00*s20+0.000000e+00*s21+0.000000e+00*s22+0.000000e+00*s23+0.000000e+00*s24+0.000000e+00*s25+0.000000e+00*s26+0.000000e+00*s27+0.000000e+00*s28+0.000000e+00*s29 \
v72=v72_part3+0.000000e+00*s30+0.000000e+00*s31+0.000000e+00*s32+0.000000e+00*s33+0.000000e+00*s34+0.000000e+00*s35 \
v73_part1=0.000000e+00*s0+0.000000e+00*s1+0.000000e+00*s2+0.000000e+00*s3+5.430728e-02*s4+0.000000e+00*s5+0.000000e+00*s6+0.000000e+00*s7+0.000000e+00*s8+(-8.141328e-02)*s9 \
v73_part2=v73_part1+0.000000e+00*s10+0.000000e+00*s11+0.000000e+00*s12+0.000000e+00*s13+0.000000e+00*s14+0.000000e+00*s15+0.000000e+00*s16+0.000000e+00*s17+0.000000e+00*s18+0.000000e+00*s19 \
v73_part3=v73_part2+0.000000e+00*s20+0.000000e+00*s21+0.000000e+00*s22+0.000000e+00*s23+0.000000e+00*s24+0.000000e+00*s25+0.000000e+00*s26+0.000000e+00*s27+0.000000e+00*s28+0.000000e+00*s29 \
v73=v73_part3+0.000000e+00*s30+0.000000e+00*s31+0.000000e+00*s32+0.000000e+00*s33+0.000000e+00*s34+0.000000e+00*s35 \
v74_part1=0.000000e+00*s0+0.000000e+00*s1+0.000000e+00*s2+0.000000e+00*s3+(-4.539730e-02)*s4+0.000000e+00*s5+0.000000e+00*s6+0.000000e+00*s7+0.000000e+00*s8+(-6.283288e-02)*s9 \
v74_part2=v74_part1+0.000000e+00*s10+0.000000e+00*s11+0.000000e+00*s12+0.000000e+00*s13+0.000000e+00*s14+0.000000e+00*s15+0.000000e+00*s16+0.000000e+00*s17+0.000000e+00*s18+0.000000e+00*s19 \
v74_part3=v74_part2+0.000000e+00*s20+0.000000e+00*s21+0.000000e+00*s22+0.000000e+00*s23+0.000000e+00*s24+0.000000e+00*s25+0.000000e+00*s26+0.000000e+00*s27+0.000000e+00*s28+0.000000e+00*s29 \
v74=v74_part3+0.000000e+00*s30+0.000000e+00*s31+0.000000e+00*s32+0.000000e+00*s33+0.000000e+00*s34+0.000000e+00*s35 \
v75_part1=(-4.238111e-01)*s0+(-1.868929e+00)*s1+(-1.811854e+00)*s2+(-4.791856e-01)*s3+(-1.153239e+00)*s4+(-2.253341e+00)*s5+(-2.725891e+00)*s6+(-1.376093e+00)*s7+(-3.000827e+00)*s8+(-3.757995e+00)*s9 \
v75_part2=v75_part1+(-7.118826e-01)*s10+(-6.754951e-01)*s11+(-1.893826e+00)*s12+(-7.339710e-01)*s13+(-1.232439e+00)*s14+(-1.278775e+00)*s15+(-6.824744e-01)*s16+(-1.747096e+00)*s17+(-1.830028e+00)*s18+9.016730e-01*s19 \
v75_part3=v75_part2+(-3.332183e-03)*s20+(-9.777195e-01)*s21+(-1.149598e+00)*s22+1.041618e+00*s23+2.786005e+00*s24+6.149679e-02*s25+1.923929e+00*s26+(-9.574295e-01)*s27+6.264243e-01*s28+(-3.935050e+00)*s29 \
v75=v75_part3+3.678781e+00*s30+(-4.469019e+00)*s31+2.126058e+00*s32+1.485005e+00*s33+(-8.601098e-01)*s34+(-7.510784e+00)*s35 \
v76_part1=2.349032e+00*s0+7.380966e+00*s1+8.550712e+00*s2+7.109898e+00*s3+7.832408e+00*s4+8.941698e+00*s5+9.264718e+00*s6+7.922113e+00*s7+9.330928e+00*s8+1.156383e+01*s9 \
v76_part2=v76_part1+5.628340e+00*s10+5.370064e+00*s11+6.704234e+00*s12+5.553051e+00*s13+6.205674e+00*s14+6.017564e+00*s15+5.311813e+00*s16+9.335809e+00*s17+8.629036e+00*s18+3.220534e+00*s19 \
v76_part3=v76_part2+6.307067e+00*s20+6.068785e+00*s21+6.062355e+00*s22+4.304055e+00*s23+2.535030e+00*s24+4.392284e+00*s25+4.619342e+00*s26+7.140548e+00*s27+5.142173e+00*s28+1.547119e+01*s29 \
v76=v76_part3+6.355383e-01*s30+4.579623e+00*s31+4.102600e+00*s32+6.074427e+00*s33+4.091179e+00*s34+5.834177e+01*s35 \
v77_part1=6.659868e-01*s0+8.285912e-04*s1+(-1.057812e+00)*s2+(-1.811522e+00)*s3+(-9.051239e-01)*s4+(-3.401761e-01)*s5+(-2.425605e-01)*s6+(-8.858029e-01)*s7+(-1.709314e-03)*s8+2.401303e-03*s9 \
v77_part2=v77_part1+6.858599e-01*s10+1.059147e+00*s11+6.926248e-01*s12+3.554027e-01*s13+1.498916e-01*s14+1.800395e-01*s15+3.987839e-01*s16+(-8.702938e-02)*s17+8.310001e-01*s18+2.375512e+00*s19 \
v77_part3=v77_part2+(-2.006251e-02)*s20+2.198938e+00*s21+2.021043e+00*s22+9.326080e-01*s23+5.954764e-01*s24+2.507222e+00*s25+(-1.973350e-02)*s26+9.461538e-01*s27+1.173425e+00*s28+(-3.630791e+00)*s29 \
v77=v77_part3+3.881370e+00*s30+1.232923e+01*s31+1.599538e+00*s32+(-4.588406e-01)*s33+6.152608e+00*s34+6.890613e+00*s35 \
v78_part1=0.000000e+00*s0+0.000000e+00*s1+0.000000e+00*s2+0.000000e+00*s3+0.000000e+00*s4+0.000000e+00*s5+0.000000e+00*s6+0.000000e+00*s7+0.000000e+00*s8+0.000000e+00*s9 \
v78_part2=v78_part1+0.000000e+00*s10+0.000000e+00*s11+0.000000e+00*s12+0.000000e+00*s13+0.000000e+00*s14+0.000000e+00*s15+0.000000e+00*s16+0.000000e+00*s17+0.000000e+00*s18+0.000000e+00*s19 \
v78_part3=v78_part2+0.000000e+00*s20+0.000000e+00*s21+0.000000e+00*s22+0.000000e+00*s23+0.000000e+00*s24+0.000000e+00*s25+0.000000e+00*s26+0.000000e+00*s27+0.000000e+00*s28+0.000000e+00*s29 \
v78=v78_part3+0.000000e+00*s30+0.000000e+00*s31+0.000000e+00*s32+0.000000e+00*s33+6.021394e-01*s34+0.000000e+00*s35 \
v79_part1=0.000000e+00*s0+0.000000e+00*s1+0.000000e+00*s2+0.000000e+00*s3+0.000000e+00*s4+0.000000e+00*s5+0.000000e+00*s6+0.000000e+00*s7+0.000000e+00*s8+0.000000e+00*s9 \
v79_part2=v79_part1+0.000000e+00*s10+0.000000e+00*s11+0.000000e+00*s12+0.000000e+00*s13+0.000000e+00*s14+0.000000e+00*s15+0.000000e+00*s16+0.000000e+00*s17+0.000000e+00*s18+0.000000e+00*s19 \
v79_part3=v79_part2+0.000000e+00*s20+0.000000e+00*s21+0.000000e+00*s22+0.000000e+00*s23+0.000000e+00*s24+0.000000e+00*s25+0.000000e+00*s26+0.000000e+00*s27+0.000000e+00*s28+0.000000e+00*s29 \
v79=v79_part3+0.000000e+00*s30+0.000000e+00*s31+0.000000e+00*s32+0.000000e+00*s33+(-5.092841e-01)*s34+0.000000e+00*s35 \
v80_part1=0.000000e+00*s0+0.000000e+00*s1+0.000000e+00*s2+0.000000e+00*s3+0.000000e+00*s4+0.000000e+00*s5+0.000000e+00*s6+0.000000e+00*s7+0.000000e+00*s8+0.000000e+00*s9 \
v80_part2=v80_part1+0.000000e+00*s10+0.000000e+00*s11+0.000000e+00*s12+0.000000e+00*s13+0.000000e+00*s14+0.000000e+00*s15+0.000000e+00*s16+0.000000e+00*s17+0.000000e+00*s18+0.000000e+00*s19 \
v80_part3=v80_part2+0.000000e+00*s20+0.000000e+00*s21+0.000000e+00*s22+0.000000e+00*s23+0.000000e+00*s24+0.000000e+00*s25+0.000000e+00*s26+0.000000e+00*s27+0.000000e+00*s28+0.000000e+00*s29 \
v80=v80_part3+0.000000e+00*s30+0.000000e+00*s31+0.000000e+00*s32+0.000000e+00*s33+(-2.814389e-02)*s34+0.000000e+00*s35 \
v81_part1=0.000000e+00*s0+0.000000e+00*s1+0.000000e+00*s2+0.000000e+00*s3+0.000000e+00*s4+0.000000e+00*s5+0.000000e+00*s6+0.000000e+00*s7+0.000000e+00*s8+0.000000e+00*s9 \
v81_part2=v81_part1+0.000000e+00*s10+0.000000e+00*s11+0.000000e+00*s12+0.000000e+00*s13+0.000000e+00*s14+0.000000e+00*s15+0.000000e+00*s16+0.000000e+00*s17+0.000000e+00*s18+0.000000e+00*s19 \
v81_part3=v81_part2+0.000000e+00*s20+0.000000e+00*s21+0.000000e+00*s22+0.000000e+00*s23+0.000000e+00*s24+0.000000e+00*s25+0.000000e+00*s26+0.000000e+00*s27+0.000000e+00*s28+0.000000e+00*s29 \
v81=v81_part3+0.000000e+00*s30+0.000000e+00*s31+0.000000e+00*s32+0.000000e+00*s33+0.000000e+00*s34+0.000000e+00*s35 \
v82_part1=0.000000e+00*s0+0.000000e+00*s1+0.000000e+00*s2+0.000000e+00*s3+0.000000e+00*s4+0.000000e+00*s5+0.000000e+00*s6+0.000000e+00*s7+0.000000e+00*s8+0.000000e+00*s9 \
v82_part2=v82_part1+0.000000e+00*s10+0.000000e+00*s11+0.000000e+00*s12+0.000000e+00*s13+0.000000e+00*s14+0.000000e+00*s15+0.000000e+00*s16+0.000000e+00*s17+0.000000e+00*s18+0.000000e+00*s19 \
v82_part3=v82_part2+0.000000e+00*s20+0.000000e+00*s21+0.000000e+00*s22+0.000000e+00*s23+0.000000e+00*s24+0.000000e+00*s25+0.000000e+00*s26+0.000000e+00*s27+0.000000e+00*s28+0.000000e+00*s29 \
v82=v82_part3+0.000000e+00*s30+0.000000e+00*s31+0.000000e+00*s32+0.000000e+00*s33+0.000000e+00*s34+0.000000e+00*s35 \
v83_part1=0.000000e+00*s0+0.000000e+00*s1+0.000000e+00*s2+0.000000e+00*s3+0.000000e+00*s4+0.000000e+00*s5+0.000000e+00*s6+0.000000e+00*s7+0.000000e+00*s8+0.000000e+00*s9 \
v83_part2=v83_part1+0.000000e+00*s10+0.000000e+00*s11+0.000000e+00*s12+0.000000e+00*s13+0.000000e+00*s14+0.000000e+00*s15+0.000000e+00*s16+0.000000e+00*s17+0.000000e+00*s18+0.000000e+00*s19 \
v83_part3=v83_part2+0.000000e+00*s20+0.000000e+00*s21+0.000000e+00*s22+0.000000e+00*s23+0.000000e+00*s24+0.000000e+00*s25+0.000000e+00*s26+0.000000e+00*s27+0.000000e+00*s28+0.000000e+00*s29 \
v83=v83_part3+0.000000e+00*s30+0.000000e+00*s31+0.000000e+00*s32+0.000000e+00*s33+0.000000e+00*s34+0.000000e+00*s35 \
v84_part1=0.000000e+00*s0+0.000000e+00*s1+0.000000e+00*s2+0.000000e+00*s3+0.000000e+00*s4+0.000000e+00*s5+0.000000e+00*s6+0.000000e+00*s7+0.000000e+00*s8+0.000000e+00*s9 \
v84_part2=v84_part1+0.000000e+00*s10+0.000000e+00*s11+0.000000e+00*s12+0.000000e+00*s13+0.000000e+00*s14+0.000000e+00*s15+0.000000e+00*s16+0.000000e+00*s17+0.000000e+00*s18+0.000000e+00*s19 \
v84_part3=v84_part2+0.000000e+00*s20+0.000000e+00*s21+0.000000e+00*s22+0.000000e+00*s23+0.000000e+00*s24+0.000000e+00*s25+0.000000e+00*s26+0.000000e+00*s27+0.000000e+00*s28+0.000000e+00*s29 \
v84=v84_part3+0.000000e+00*s30+0.000000e+00*s31+0.000000e+00*s32+0.000000e+00*s33+0.000000e+00*s34+0.000000e+00*s35 \
v85_part1=0.000000e+00*s0+0.000000e+00*s1+0.000000e+00*s2+0.000000e+00*s3+0.000000e+00*s4+0.000000e+00*s5+0.000000e+00*s6+0.000000e+00*s7+0.000000e+00*s8+0.000000e+00*s9 \
v85_part2=v85_part1+0.000000e+00*s10+0.000000e+00*s11+0.000000e+00*s12+0.000000e+00*s13+0.000000e+00*s14+0.000000e+00*s15+0.000000e+00*s16+0.000000e+00*s17+0.000000e+00*s18+0.000000e+00*s19 \
v85_part3=v85_part2+0.000000e+00*s20+0.000000e+00*s21+0.000000e+00*s22+0.000000e+00*s23+0.000000e+00*s24+0.000000e+00*s25+0.000000e+00*s26+0.000000e+00*s27+0.000000e+00*s28+0.000000e+00*s29 \
v85=v85_part3+0.000000e+00*s30+0.000000e+00*s31+0.000000e+00*s32+0.000000e+00*s33+0.000000e+00*s34+0.000000e+00*s35 \
v86_part1=0.000000e+00*s0+0.000000e+00*s1+0.000000e+00*s2+0.000000e+00*s3+0.000000e+00*s4+0.000000e+00*s5+0.000000e+00*s6+0.000000e+00*s7+0.000000e+00*s8+0.000000e+00*s9 \
v86_part2=v86_part1+0.000000e+00*s10+0.000000e+00*s11+0.000000e+00*s12+0.000000e+00*s13+0.000000e+00*s14+0.000000e+00*s15+0.000000e+00*s16+0.000000e+00*s17+0.000000e+00*s18+0.000000e+00*s19 \
v86_part3=v86_part2+0.000000e+00*s20+0.000000e+00*s21+0.000000e+00*s22+0.000000e+00*s23+0.000000e+00*s24+0.000000e+00*s25+0.000000e+00*s26+0.000000e+00*s27+0.000000e+00*s28+0.000000e+00*s29 \
v86=v86_part3+0.000000e+00*s30+0.000000e+00*s31+0.000000e+00*s32+0.000000e+00*s33+0.000000e+00*s34+0.000000e+00*s35 \
v87_part1=1.154540e+00*s0+2.084555e+00*s1+2.122665e+00*s2+3.014010e-01*s3+9.716231e-01*s4+1.797888e+00*s5+4.267425e+00*s6+2.328012e+00*s7+1.604253e+00*s8+3.677373e-01*s9 \
v87_part2=v87_part1+2.063042e+00*s10+1.441635e+00*s11+7.972512e+00*s12+1.788988e+00*s13+2.525541e+00*s14+2.955878e+00*s15+1.193755e+00*s16+2.597520e+00*s17+1.957756e+00*s18+(-2.740567e+00)*s19 \
v87_part3=v87_part2+1.921638e+00*s20+9.729099e-01*s21+2.034285e+00*s22+1.862552e+00*s23+1.400542e+00*s24+(-7.259525e-01)*s25+6.164216e-02*s26+8.493907e-01*s27+1.276759e+01*s28+2.752685e+00*s29 \
v87=v87_part3+(-5.627634e-01)*s30+(-4.372433e+00)*s31+(-1.498630e+00)*s32+3.501109e+00*s33+6.589605e+00*s34+1.297081e+00*s35 \
v88_part1=7.020393e-01*s0+(-8.196169e-03)*s1+(-2.310875e+00)*s2+(-4.472149e-01)*s3+(-3.541487e-01)*s4+(-1.850805e+00)*s5+(-3.880412e+00)*s6+2.938859e-02*s7+6.709466e-03*s8+2.514062e-01*s9 \
v88_part2=v88_part1+(-1.195158e+00)*s10+(-1.508105e-02)*s11+(-6.974747e+00)*s12+4.998273e-02*s13+(-9.077615e-01)*s14+(-1.316477e+00)*s15+8.936056e-01*s16+2.297834e+00*s17+1.477066e+00*s18+8.398181e+00*s19 \
v88_part3=v88_part2+8.343649e-01*s20+1.190204e+00*s21+1.971212e+00*s22+3.867916e+00*s23+3.876270e+00*s24+5.170074e+00*s25+4.884105e+00*s26+1.757188e+00*s27+(-1.087444e+01)*s28+1.101113e-01*s29 \
v88=v88_part3+8.493810e+00*s30+1.109220e+01*s31+3.599804e+00*s32+1.428712e+00*s33+(-3.069987e+00)*s34+6.534334e+00*s35 \
v89_part1=4.455597e+00*s0+(-2.564881e-02)*s1+1.686926e+00*s2+2.668010e+00*s3+5.020910e-02*s4+1.166364e+00*s5+2.720243e-01*s6+(-5.196942e-01)*s7+2.024481e-02*s8+5.656514e-03*s9 \
v89_part2=v89_part1+(-1.861501e-02)*s10+(-3.072816e-01)*s11+(-2.559732e-01)*s12+(-5.832916e-02)*s13+3.377225e-01*s14+1.041400e-01*s15+(-6.124218e-02)*s16+(-3.884174e+00)*s17+(-1.525378e+00)*s18+(-1.512842e+00)*s19 \
v89_part3=v89_part2+(-9.576300e-02)*s20+7.942573e-01*s21+(-1.217261e+00)*s22+(-3.644163e+00)*s23+(-2.998230e+00)*s24+(-1.575311e+00)*s25+(-2.518155e+00)*s26+(-1.860106e-01)*s27+4.455765e-02*s28+(-6.983335e-01)*s29 \
v89=v89_part3+(-6.673633e+00)*s30+(-4.302457e+00)*s31+2.613287e+00*s32+(-2.479462e+00)*s33+1.012971e-02*s34+(-5.418788e+00)*s35 \
v90_part1=0.000000e+00*s0+0.000000e+00*s1+0.000000e+00*s2+0.000000e+00*s3+0.000000e+00*s4+0.000000e+00*s5+0.000000e+00*s6+0.000000e+00*s7+0.000000e+00*s8+0.000000e+00*s9 \
v90_part2=v90_part1+0.000000e+00*s10+0.000000e+00*s11+0.000000e+00*s12+0.000000e+00*s13+0.000000e+00*s14+0.000000e+00*s15+0.000000e+00*s16+0.000000e+00*s17+0.000000e+00*s18+0.000000e+00*s19 \
v90_part3=v90_part2+0.000000e+00*s20+0.000000e+00*s21+0.000000e+00*s22+0.000000e+00*s23+0.000000e+00*s24+0.000000e+00*s25+0.000000e+00*s26+0.000000e+00*s27+0.000000e+00*s28+0.000000e+00*s29 \
v90=v90_part3+0.000000e+00*s30+0.000000e+00*s31+0.000000e+00*s32+0.000000e+00*s33+0.000000e+00*s34+0.000000e+00*s35 \
v91_part1=0.000000e+00*s0+0.000000e+00*s1+0.000000e+00*s2+0.000000e+00*s3+0.000000e+00*s4+0.000000e+00*s5+0.000000e+00*s6+0.000000e+00*s7+0.000000e+00*s8+0.000000e+00*s9 \
v91_part2=v91_part1+0.000000e+00*s10+0.000000e+00*s11+0.000000e+00*s12+0.000000e+00*s13+0.000000e+00*s14+0.000000e+00*s15+0.000000e+00*s16+0.000000e+00*s17+0.000000e+00*s18+0.000000e+00*s19 \
v91_part3=v91_part2+0.000000e+00*s20+0.000000e+00*s21+0.000000e+00*s22+0.000000e+00*s23+0.000000e+00*s24+0.000000e+00*s25+0.000000e+00*s26+0.000000e+00*s27+0.000000e+00*s28+0.000000e+00*s29 \
v91=v91_part3+0.000000e+00*s30+0.000000e+00*s31+0.000000e+00*s32+0.000000e+00*s33+0.000000e+00*s34+0.000000e+00*s35 \
v92_part1=0.000000e+00*s0+0.000000e+00*s1+0.000000e+00*s2+0.000000e+00*s3+0.000000e+00*s4+0.000000e+00*s5+0.000000e+00*s6+0.000000e+00*s7+0.000000e+00*s8+0.000000e+00*s9 \
v92_part2=v92_part1+0.000000e+00*s10+0.000000e+00*s11+0.000000e+00*s12+0.000000e+00*s13+0.000000e+00*s14+0.000000e+00*s15+0.000000e+00*s16+0.000000e+00*s17+0.000000e+00*s18+0.000000e+00*s19 \
v92_part3=v92_part2+0.000000e+00*s20+0.000000e+00*s21+0.000000e+00*s22+0.000000e+00*s23+0.000000e+00*s24+0.000000e+00*s25+0.000000e+00*s26+0.000000e+00*s27+0.000000e+00*s28+0.000000e+00*s29 \
v92=v92_part3+0.000000e+00*s30+0.000000e+00*s31+0.000000e+00*s32+0.000000e+00*s33+0.000000e+00*s34+0.000000e+00*s35 \
_p0=v0+v1*od_+v2*w_ \
_p1=0.5*(_p0+sqrt(_p0*_p0+0.001)) \
_p2=v3+v4*od_+v5/w_ \
_p3=1.15*0.975*0.5*(_p2+sqrt(_p2*_p2+0.001)) \
_p4=v6+v7*od_+v8*w_ \
_p5=0.5*(_p4+sqrt(_p4*_p4+0.001)) \
_p6=v9+v10*od_+v11/w_ \
_p7=1.15*0.975*0.5*(_p6+sqrt(_p6*_p6+0.001)) \
_p8=v12+v13*od_+v14*w_ \
_p9=0.5*(_p8+sqrt(_p8*_p8+0.001)) \
_p10=v15+v16*od_+v17*w_ \
_p11=0.5*(_p10+sqrt(_p10*_p10+0.001)) \
_p12=1.05*1e-09*_p1 \
_p13=v18+v19*od_+v20*w_ \
_p14=0.5*(_p13+sqrt(_p13*_p13+0.001)) \
_p15=1.05*1e-09*_p14 \
_p16=v21+v22*od_+v23/w_ \
_p17=1.15*0.975*0.5*(_p16+sqrt(_p16*_p16+0.001)) \
_p18=1.05*1e-09*_p5 \
_p19=v24+v25*od_+v26*w_ \
_p20=0.5*(_p19+sqrt(_p19*_p19+0.001)) \
_p21=1.05*1e-09*_p20 \
_p22=v27+v28*od_+v29/w_ \
_p23=1.15*0.975*0.5*(_p22+sqrt(_p22*_p22+0.001)) \
_p24=1e-15*_p9 \
_p25=v30+v31*od_+v32*w_ \
_p26=0.5*(_p25+sqrt(_p25*_p25+0.001)) \
_p27=1e-15*_p26 \
_p28=v33+v34*od_+v35*w_ \
_p29=0.5*(_p28+sqrt(_p28*_p28+0.001)) \
_p30=1e-15*_p29 \
_p31=1e-15*_p11 \
_p32=v36+v37*od_+v38*w_ \
_p33=0.5*(_p32+sqrt(_p32*_p32+0.001)) \
_p34=1e-15*_p33 \
_p35=v39+v40*od_+v41*w_ \
_p36=0.5*(_p35+sqrt(_p35*_p35+0.001)) \
_p37=1.05*1e-10*_p36 \
_p39=v42+v43*od_+v44*w_ \
_p40=atan(_p39-0.5)/1.5708 \
_p41=v45+v46*od_+v47*w_ \
_p42=atan(_p41-0.5)/1.5708 \
_p43=v48+v49*od_+v50*w_ \
_p44=atan(_p43-0.5)/1.5708 \
_p38_xsc1=1.0 \
_p38_sc1=1.0 \
_p38_xsc2=_p38_xsc1+_p40*_p40 \
_p38_sc2=1.0/sqrt(_p38_xsc2) \
_p38_xsc3=_p38_xsc2+_p42*_p42 \
_p38_sc3=1.0/sqrt(_p38_xsc3) \
_p38_xsc4=_p38_xsc3+_p44*_p44 \
_p38_sc4=1.0/sqrt(_p38_xsc4) \
_p45=(1.0*_p40)*1.0*_p38_sc2 \
_p46=(1.0*_p42)*1.0*_p38_sc3 \
_p47=(1.0*_p44)*1.0*_p38_sc4 \
_p48=(_p40*_p42+1.0*_p40)*_p38_sc2*_p38_sc3 \
_p49=(_p40*_p44+1.0*_p42)*_p38_sc2*_p38_sc4 \
_p50=(_p42*_p44+_p40*_p42+1.0*_p40)*_p38_sc3*_p38_sc4 \
_p51=v51+v52*od_+v53*w_ \
_p52=0.5*(_p51+sqrt(_p51*_p51+0.001)) \
_p53=v54+v55*od_+v56*w_ \
_p54=0.5*(_p53+sqrt(_p53*_p53+0.001)) \
_p55=v57+v58*od_+v59*w_ \
_p56=0.5*(_p55+sqrt(_p55*_p55+0.001)) \
_p57=v60+v61*od_+v62*w_ \
_p58=0.5*(_p57+sqrt(_p57*_p57+0.001)) \
_p59=v63+v64*od_+v65*w_ \
_p60=0.5*(_p59+sqrt(_p59*_p59+0.001)) \
_p61=v66+v67*od_+v68*w_ \
_p62=0.5*(_p61+sqrt(_p61*_p61+0.001)) \
_p63=v69+v70*od_+v71*w_ \
_p64=0.5*(_p63+sqrt(_p63*_p63+0.001)) \
_p65=v72+v73*od_+v74*w_ \
_p66=0.5*(_p65+sqrt(_p65*_p65+0.001)) \
_p67=v75+v76*od_+v77*w_ \
_p68=0.5*(_p67+sqrt(_p67*_p67+0.001)) \
_p69=v78+v79*od_+v80*w_ \
_p70=0.5*(_p69+sqrt(_p69*_p69+0.001)) \
_p71=v81+v82*od_+v83*w_ \
_p72=0.5*(_p71+sqrt(_p71*_p71+0.001)) \
_p73=v84+v85*od_+v86*w_ \
_p74=0.5*(_p73+sqrt(_p73*_p73+0.001)) \
_p75=1e-14*_p52 \
_p76=0.9*100*_p54 \
_p77=1e-14*_p56 \
_p78=0.9*100*_p58 \
_p79=1e-14*_p60 \
_p80=0.9*100*_p62 \
_p81=1e-14*_p64 \
_p82=0.9*100*_p66 \
_p83=1e-14*_p68 \
_p84=0.9*100*_p70 \
_p85=1e-14*_p72 \
_p86=0.9*100*_p74 \
_p87=v87+v88*od_+v89*w_ \
_p88=0.5*(_p87+sqrt(_p87*_p87+0.001)) \
_p89=v90+v91*od_+v92*w_ \
_p90=0.5*(_p89+sqrt(_p89*_p89+0.001)) \
_p91=0.9*100*_p88 \
_p92=1e-15*_p90
lp1 (p1 _np1) inductor l=_p12
rp1 (_np1 _np2) resistor r=_p3
lp2 (_np3 p2) inductor l=_p15
rp2 (_np3 _np2) resistor r=_p17
ls1 (s1 _ns1) inductor l=_p18
rs1 (_ns1 _ns2) resistor r=_p7
ls2 (_ns3 s2) inductor l=_p21
rs2 (_ns3 _ns2) resistor r=_p23
c1 (p1 s1) capacitor c=_p24
c2 (p2 s2) capacitor c=_p27
c3 (_np2 _ns2) capacitor c=_p30
c4 (p1 s2) capacitor c=_p31
c5 (p2 s1) capacitor c=_p34
lcts (_ns2 cts) inductor l=_p37
k12_ks mutual_inductor coupling=_p45 ind1=lp1 ind2=lp2
k13_ks mutual_inductor coupling=_p46 ind1=lp1 ind2=ls1
k14_ks mutual_inductor coupling=_p47 ind1=lp1 ind2=ls2
k23_ks mutual_inductor coupling=_p48 ind1=lp2 ind2=ls1
k24_ks mutual_inductor coupling=_p49 ind1=lp2 ind2=ls2
k34_ks mutual_inductor coupling=_p50 ind1=ls1 ind2=ls2
c_1_sub (p1 _n1_1_sub) capacitor c=_p75
rs_1_sub (_n1_1_sub _nbulk) resistor r=_p76
c_2_sub (p2 _n1_2_sub) capacitor c=_p77
rs_2_sub (_n1_2_sub _nbulk) resistor r=_p78
c_3_sub (_np2 _n1_3_sub) capacitor c=_p79
rs_3_sub (_n1_3_sub _nbulk) resistor r=_p80
c_4_sub (s1 _n1_4_sub) capacitor c=_p81
rs_4_sub (_n1_4_sub _nbulk) resistor r=_p82
c_5_sub (s2 _n1_5_sub) capacitor c=_p83
rs_5_sub (_n1_5_sub _nbulk) resistor r=_p84
c_6_sub (_ns2 _n1_6_sub) capacitor c=_p85
rs_6_sub (_n1_6_sub _nbulk) resistor r=_p86
rs_1_sub1 (_nbulk gnd) resistor r=_p91
cs_1_sub1 (_nbulk gnd) capacitor c=_p92
ends l_occtout_trans_rfvil
