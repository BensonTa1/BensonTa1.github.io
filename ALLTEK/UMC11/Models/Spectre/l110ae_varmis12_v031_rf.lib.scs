//  ******************************************************************************
simulator lang=spectre insensitive=yes
//  TYP: Typical capacitor
//  MIN: Minimum capacitor
//  MAX: Maximum capacitor
//  ******************************************************************************

library mylib

section typ
parameters dtoxe_varmis_12_rf=0.0000e+00
parameters dxl_varmis_12_rf=0.0000e+00
parameters dxw_varmis_12_rf=0.0000e+00
parameters dcmina_varmis_12_rf=0.0000e+00
parameters dcj_varmis_12_rf=0.0000e+00
parameters dcjsw_varmis_12_rf=0.0000e+00
parameters dr_gate_varmis_12_rf=0.0000e+00
include "l110ae_varmis12_v031_rf.mdl.scs"
endsection typ

section min
parameters dtoxe_varmis_12_rf=+8.40000e-11
parameters dxl_varmis_12_rf=-4.86300e-08
parameters dxw_varmis_12_rf=-9.2800e-08
parameters dcmina_varmis_12_rf=0.082820672
parameters dcj_varmis_12_rf=0.1
parameters dcjsw_varmis_12_rf=0.1
parameters dr_gate_varmis_12_rf=0.15
include "l110ae_varmis12_v031_rf.mdl.scs"
endsection min

section max
parameters dtoxe_varmis_12_rf=-8.49000e-11
parameters dxl_varmis_12_rf=+4.005070e-08
parameters dxw_varmis_12_rf=+9.2800e-08
parameters dcmina_varmis_12_rf=-0.068470000
parameters dcj_varmis_12_rf=-0.1
parameters dcjsw_varmis_12_rf=-0.1
parameters dr_gate_varmis_12_rf=-0.15
include "l110ae_varmis12_v031_rf.mdl.scs"
endsection max
endlibrary mylib
