simulator lang=spectre insensitive=yes
library mylib

section tt_bip
parameters is_pnp_sv45x45_l110e=1
parameters bf_pnp_sv45x45_l110e=1
parameters nf_pnp_sv45x45_l110e=1
parameters re_pnp_sv45x45_l110e=1
parameters rc_pnp_sv45x45_l110e=1
parameters cje_pnp_sv45x45_l110e=1
parameters cjc_pnp_sv45x45_l110e=1
parameters is_pnp_sv90x90_l110e=1
parameters bf_pnp_sv90x90_l110e=1
parameters nf_pnp_sv90x90_l110e=1
parameters re_pnp_sv90x90_l110e=1
parameters rc_pnp_sv90x90_l110e=1
parameters cje_pnp_sv90x90_l110e=1
parameters cjc_pnp_sv90x90_l110e=1
parameters is_pnp_sv135x135_l110e=1
parameters bf_pnp_sv135x135_l110e=1
parameters nf_pnp_sv135x135_l110e=1
parameters re_pnp_sv135x135_l110e=1
parameters rc_pnp_sv135x135_l110e=1
parameters cje_pnp_sv135x135_l110e=1
parameters cjc_pnp_sv135x135_l110e=1
parameters is_pnp_v45x45_l110e=1
parameters bf_pnp_v45x45_l110e=1
parameters nf_pnp_v45x45_l110e=1
parameters re_pnp_v45x45_l110e=1
parameters rc_pnp_v45x45_l110e=1
parameters cje_pnp_v45x45_l110e=1
parameters cjc_pnp_v45x45_l110e=1
parameters is_pnp_v90x90_l110e=1
parameters bf_pnp_v90x90_l110e=1
parameters nf_pnp_v90x90_l110e=1
parameters re_pnp_v90x90_l110e=1
parameters rc_pnp_v90x90_l110e=1
parameters cje_pnp_v90x90_l110e=1
parameters cjc_pnp_v90x90_l110e=1
parameters is_pnp_v135x135_l110e=1
parameters bf_pnp_v135x135_l110e=1
parameters nf_pnp_v135x135_l110e=1
parameters re_pnp_v135x135_l110e=1
parameters rc_pnp_v135x135_l110e=1
parameters cje_pnp_v135x135_l110e=1
parameters cjc_pnp_v135x135_l110e=1
include "./l110ae_bjt_pnp_v041.mdl.scs"
endsection tt_bip

section ff_bip
parameters is_pnp_sv45x45_l110e=0.8
parameters bf_pnp_sv45x45_l110e=1.15
parameters nf_pnp_sv45x45_l110e=0.995
parameters re_pnp_sv45x45_l110e=0.8
parameters rc_pnp_sv45x45_l110e=0.8
parameters cje_pnp_sv45x45_l110e=0.9
parameters cjc_pnp_sv45x45_l110e=0.9
parameters is_pnp_sv90x90_l110e=0.8
parameters bf_pnp_sv90x90_l110e=1.15
parameters nf_pnp_sv90x90_l110e=0.995
parameters re_pnp_sv90x90_l110e=0.8
parameters rc_pnp_sv90x90_l110e=0.8
parameters cje_pnp_sv90x90_l110e=0.9
parameters cjc_pnp_sv90x90_l110e=0.9
parameters is_pnp_sv135x135_l110e=0.8
parameters bf_pnp_sv135x135_l110e=1.15
parameters nf_pnp_sv135x135_l110e=0.995
parameters re_pnp_sv135x135_l110e=0.8
parameters rc_pnp_sv135x135_l110e=0.8
parameters cje_pnp_sv135x135_l110e=0.9
parameters cjc_pnp_sv135x135_l110e=0.9
parameters is_pnp_v45x45_l110e=0.8
parameters bf_pnp_v45x45_l110e=1.15
parameters nf_pnp_v45x45_l110e=0.995
parameters re_pnp_v45x45_l110e=0.8
parameters rc_pnp_v45x45_l110e=0.8
parameters cje_pnp_v45x45_l110e=0.9
parameters cjc_pnp_v45x45_l110e=0.9
parameters is_pnp_v90x90_l110e=0.8
parameters bf_pnp_v90x90_l110e=1.15
parameters nf_pnp_v90x90_l110e=0.995
parameters re_pnp_v90x90_l110e=0.8
parameters rc_pnp_v90x90_l110e=0.8
parameters cje_pnp_v90x90_l110e=0.9
parameters cjc_pnp_v90x90_l110e=0.9
parameters is_pnp_v135x135_l110e=0.8
parameters bf_pnp_v135x135_l110e=1.15
parameters nf_pnp_v135x135_l110e=0.995
parameters re_pnp_v135x135_l110e=0.8
parameters rc_pnp_v135x135_l110e=0.8
parameters cje_pnp_v135x135_l110e=0.9
parameters cjc_pnp_v135x135_l110e=0.9
include "./l110ae_bjt_pnp_v041.mdl.scs"
endsection ff_bip

section ss_bip
parameters is_pnp_sv45x45_l110e=1.2
parameters bf_pnp_sv45x45_l110e=0.85
parameters nf_pnp_sv45x45_l110e=1.005
parameters re_pnp_sv45x45_l110e=1.2
parameters rc_pnp_sv45x45_l110e=1.2
parameters cje_pnp_sv45x45_l110e=1.1
parameters cjc_pnp_sv45x45_l110e=1.1
parameters is_pnp_sv90x90_l110e=1.2
parameters bf_pnp_sv90x90_l110e=0.85
parameters nf_pnp_sv90x90_l110e=1.005
parameters re_pnp_sv90x90_l110e=1.2
parameters rc_pnp_sv90x90_l110e=1.2
parameters cje_pnp_sv90x90_l110e=1.1
parameters cjc_pnp_sv90x90_l110e=1.1
parameters is_pnp_sv135x135_l110e=1.2
parameters bf_pnp_sv135x135_l110e=0.85
parameters nf_pnp_sv135x135_l110e=1.005
parameters re_pnp_sv135x135_l110e=1.2
parameters rc_pnp_sv135x135_l110e=1.2
parameters cje_pnp_sv135x135_l110e=1.1
parameters cjc_pnp_sv135x135_l110e=1.1
parameters is_pnp_v45x45_l110e=1.2
parameters bf_pnp_v45x45_l110e=0.85
parameters nf_pnp_v45x45_l110e=1.005
parameters re_pnp_v45x45_l110e=1.2
parameters rc_pnp_v45x45_l110e=1.2
parameters cje_pnp_v45x45_l110e=1.1
parameters cjc_pnp_v45x45_l110e=1.1
parameters is_pnp_v90x90_l110e=1.2
parameters bf_pnp_v90x90_l110e=0.85
parameters nf_pnp_v90x90_l110e=1.005
parameters re_pnp_v90x90_l110e=1.2
parameters rc_pnp_v90x90_l110e=1.2
parameters cje_pnp_v90x90_l110e=1.1
parameters cjc_pnp_v90x90_l110e=1.1
parameters is_pnp_v135x135_l110e=1.2
parameters bf_pnp_v135x135_l110e=0.85
parameters nf_pnp_v135x135_l110e=1.005
parameters re_pnp_v135x135_l110e=1.2
parameters rc_pnp_v135x135_l110e=1.2
parameters cje_pnp_v135x135_l110e=1.1
parameters cjc_pnp_v135x135_l110e=1.1
include "./l110ae_bjt_pnp_v041.mdl.scs"
endsection ss_bip

endlibrary mylib
