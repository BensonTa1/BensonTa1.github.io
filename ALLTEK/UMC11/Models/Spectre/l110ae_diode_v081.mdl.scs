//********************************************************************************
//* Revision history:
//*
//* <Revision 1>
//* Version : T.0 Phase 1
//* Date    : 2009/12/11
//* Owner   : Ho Cheng Hu
//* Comment : 1. Original release
//*           2. This model card is cpoied from l110e_diode_v011.mdl, and modified
//*              "ik" and "rs" parameters.
//*
//* <Revision 2>
//* Version : 0.1 Phase 1
//* Date    : 2010/03/04
//* Owner   : Ho Cheng Hu
//* Comment : 1. New DSM definition from 2009/11/29.
//*           2. Add Document.
//*
//* <Revision 3>
//* Version : 0.2 Phase 1
//* Date    : 2010/07/20
//* Owner   : Ho Cheng Hu
//* Comment : Version up to 0.2 based on L110AE Si data.
//*
//* <Revision 3>
//* Version : 0.3_p1
//* Date    : 2010/11/30
//* Owner   : Laney Fan
//* Comment : 1.Version up to 0.3 base on HS/IO scalable diode data.
//*           2.Add DNW/Psub and PW/DNW diode models.
//*
//* <Revision 4>
//* Version : 0.4_p1
//* Date    : 2011/09/27
//* Owner   : Laney Fan
//* Comment : 1.Correct the rs equations for HS n+/pw & p+/nw scalable diode model.
//*           2.Add corner parameters for nw/psub diode model
//*
//* <Revision 5>
//* Version : 0.5_p1
//* Date    : 2012/08/09
//* Owner   : Laney Fan
//* Comment : 1.Multiply 0.9 of w and l in the subckt for shrink methodology
//*           2.Add newdio=1 in eldo models.
//*           3.Revise ikp as ikr for spectre models
//*
//* <Revision 6>
//* Version : 0.6_p1
//* Date    : 2012/10/17
//* Owner   : Laney Fan
//* Comment : 1.Correct from multiply 0.9 by w an l to multiply 0.9*0.9 by area
//*
//* <Revision 7>
//* Version : 0.7_p1
//* Date    : 2016/11/23
//* Owner   : Macro Chang
//* Comment : 1.Optimize leakage current and break down voltage.
//*
//* <Revision 8>
//* Version : 0.8_p1
//* Date    : 2017/08/07
//* Owner   : Henry JC Chen
//*           Macro Chang
//* Comment : 1. Fix the format of shrink methodology in diode model.
//*           2. Modify parameters of  NW/Psub leakage current for high temperature.
//********************************************************************************
//* Application Ranges:
//* Geometry range(Before shrinkage):
//*
//* HS1.2V DION
//* 0.5um<=WDES<=14.3um
//* 5um<=LDES<=25um
//*
//* HS1.2V DIOP
//* 0.5um<=WDES<=14.3um
//* 5um<=LDES<=25um
//*
//* IO 3.3V DION
//* 0.5um<=WDES<=14.3um
//* 5um<=LDES<=25um
//*
//* IO 3.3V DIOP
//* 0.5um<=WDES<=14.3um
//* 5um<=LDES<=25um
//*
//* DIONW
//* Area = 1.77E-7 m2
//* Pj = 4.93E-3 m
//*
//* DIODNW
//* Area =3.2E-8 m2
//* 3.2E-4 m <= Pj <=6.4E-3 m
//*
//* DIOPW
//* Area =3.2E-8 m2
//* Pj = 3.2E-4 m
//*
//* Temperature range:-50c ~ 125c ; nominal temperature = 25c.
//********************************Start of Model Card *****************************
//* Device HS n+/pw scalable diode
simulator lang=spectre insensitive=yes
setoption1 options tnom =25
inline subckt dion_l110e ( n1 n3  )
parameters w=0.5e-6 l=20e-6
parameters scale_m      = 0.9
parameters area=(w)*(l)  perim=2*(w+l)

r1 ( n1 n2 ) resistor r=(8.2+2e-12/(area*scale_m**2))*(1+drs_dion_l110e) tc1=6032.8*(area*scale_m**2)+2e-7
dion_l110e ( n2 n3 ) dion  area=area  perim=perim

model dion diode level = 3
+ hcomp=1.0000e+00 imax=1.00e+14
//**************************************************************
//*               GENERAL PARAMETERS
//**************************************************************
+area    = 3.6e-008        perim      = 0.00076         tnom    = 25
//**************************************************************
//*               DC PARAMETERS
//**************************************************************
+is      = 8.81e-008*(1+djs_dion_l110e)            isw     = 9.61e-014*(1+djsw_dion_l110e)             ik      = 1.4945e7          bv      = 13.18
+ibv     = 27.778          ikr     = 2780            n       = 1.008*(1+dn_dion_l110e)                   rs      =0
+jtun    = 4.8e-006        jtunsw  = 5e-014          ntun    = 54.745
//**************************************************************
//*               CAPACITANCE PARAMETERS
//**************************************************************
+cjo      = 0.00072*(1+dcj_dion_l110e)  cjp     = 9.94e-011*(1+dcjp_dion_l110e)  vj      = 0.56            vjsw     = 0.54
+mj      = 0.258           mjsw    = 0.13
//**************************************************************
//*               NOISE PARAMETERS
//**************************************************************
//**************************************************************
//*               TEMPERATURE PARAMETERS
//**************************************************************
+tlev    = 1               tlevc   = 1               trs     =0               tbv1     = -0.00056362
+xti     = 3               cta     = 0.0009555       ctp     = 0.00073248     eg      = 1.16
+pta     = 0.001632        ptp    = 0.00031         xtitun  = 3              keg     = 0.324
//*
ends dion_l110e
//*
//* Device HS p+/nw scalable diode
//*
inline subckt diop_l110e ( n1 n3  )
parameters w=0.5e-6 l=20e-6
parameters scale_m      = 0.9
parameters area=(w)*(l)  perim=2*(w+l)

r1 ( n1 n2 ) resistor r=(4.8+2e-12/(area*scale_m**2))*(1+drs_diop_l110e ) tc1=1e-12
diop_l110e ( n2 n3 ) diop  area=area  perim=perim

model diop diode level = 3
+ hcomp=1.0000e+00 imax=1.00e+14
//**************************************************************
//*               GENERAL PARAMETERS
//**************************************************************
+area    = 3.6e-008        perim      = 0.00076         tnom    = 25
//**************************************************************
//*               DC PARAMETERS
//**************************************************************
+is      = 1.21e-007*(1+djs_diop_l110e)            isw     = 1.08e-013*(1+djsw_diop_l110e)                    ik   = 1.4908e007          bv  = 10.85
+ibv     = 27.778          ikr     = 2780            n       = 1.017*(1+dn_diop_l110e)                          rs   = 0                   nbv = 0.85
+jtun    = 5.04e-007       jtunsw  = 9.045e-012      ntun    = 46.533
//**************************************************************
//*               CAPACITANCE PARAMETERS
//**************************************************************
+cjo      = 9.69e-004*(1+dcj_diop_l110e)  cjp     = 1.18e-010*(1+dcjp_diop_l110e)  vj      = 0.698           vjsw     = 0.75
+mj      = 0.308           mjsw    = 0.1
//**************************************************************
//*               NOISE PARAMETERS
//**************************************************************
//**************************************************************
//*               TEMPERATURE PARAMETERS
//**************************************************************
+tlev    = 1               tlevc   = 1               trs     = 0               tbv1     = -0.00058053
+xti     = 3               cta     = 0.0010049       ctp     = 0.0005243       eg      = 1.16
+pta     = 0.0017088       ptp    = 0.0025864       keg     = 0.524
//*
ends diop_l110e
//*
//* Device IO n+/pw scalable diode
//*
inline subckt dion_33_l110e ( n1 n3  )
parameters w=0.5e-6 l=20e-6
parameters scale_m      = 0.9
parameters area=(w)*(l)  perim=2*(w+l)

r1 ( n1 n2 ) resistor r=(2.6575 + 2.1043e-10/(area*scale_m**2))*(1+drs_dion_33_l110e) tc1=4.34e-4
dion_33_l110e ( n2 n3 ) dion  area=area  perim=perim

model dion diode level = 3
+ hcomp=1.0000e+00 imax=1.00e+14
//**************************************************************
//*               GENERAL PARAMETERS
//**************************************************************
+area    = 5e-008          perim      = 0.002           tnom    = 25
//**************************************************************
//*               DC PARAMETERS
//**************************************************************
+is      = 7.49e-008*(1+djs_dion_33_l110e)         isw     = 1.08e-013*(1+djsw_dion_33_l110e)       ik      = 2.2492e+07          bv      = 12.16
+ibv     = 27.778                                    ikr     = 2780            n       = 1.0161*(1+dn_dion_33_l110e)            rs      = 0                   nbv     = 0.7
+jtun    = 1.9008e-006                               jtunsw  = 9.045e-012      ntun    = 50.814
//**************************************************************
//*               CAPACITANCE PARAMETERS
//**************************************************************
+cjo      = 0.00078*(1+dcj_dion_33_l110e)  cjp     = 1.08e-010*(1+dcjp_dion_33_l110e)  vj      = 0.608           vjsw     = 0.8
+mj      = 0.278           mjsw    = 0.12
//**************************************************************
//*               NOISE PARAMETERS
//**************************************************************
//**************************************************************
//*               TEMPERATURE PARAMETERS
//**************************************************************
+tlev    = 1               tlevc   = 1               trs     = 0               tbv1     = -0.00059534
+xti     = 3               xtitun  = 3               cta     = 0.0009          ctp     = 0.0004
+eg      = 1.16            pta     = 0.001494        ptp    = 0.0006          keg     = 0.4135
//*
ends dion_33_l110e
//*
//* Device IO p+/nw scalable diode
//*
inline subckt diop_33_l110e ( n1 n3  )
parameters w=0.5e-6 l=20e-6
parameters scale_m      = 0.9
parameters area=(w)*(l)  perim=2*(w+l)

r1 ( n1 n2 ) resistor r=(2.1476 + 2.0624e-10/(area*scale_m**2))*(1+drs_diop_33_l110e)  tc1=1.4598e-3
diop_33_l110e ( n2 n3 ) diop  area=area  perim=perim

model diop diode level = 3
+ hcomp=1.0000e+00 imax=1.00e+14
//**************************************************************
//*               GENERAL PARAMETERS
//**************************************************************
+area    = 3.6e-008        perim      = 0.00076         tnom    = 25
//**************************************************************
//*               DC PARAMETERS
//**************************************************************
+is      = 3.06e-007*(1+djs_diop_33_l110e)         isw     = 1.5e-012*(1+djsw_diop_33_l110e)            ik      = 1.0744e+8                                    bv      = 10.64
+ibv     = 27.778                                    ikr     = 2780                                         n       = 1.1204*(1+dn_diop_33_l110e)                rs      = 0
+jtun    = 1.1387e-012                               jtunsw  = 3.383e-012                                   ntun    = 39.942                                       nbv     = 0.7
//**************************************************************
//*               CAPACITANCE PARAMETERS
//**************************************************************
+cjo      = 0.000993*(1+dcj_diop_33_l110e)  cjp     = 1.2e-010*(1+dcjp_diop_33_l110e)  vj      = 0.79            vjsw     = 0.78
+mj      = 0.33            mjsw    = 0.13
//**************************************************************
//*               NOISE PARAMETERS
//**************************************************************
//**************************************************************
//*               TEMPERATURE PARAMETERS
//**************************************************************
+tlev    = 1               tlevc   = 1               trs     = 0               tbv1     = -0.00061298
+xti     = 3               xtitun  = 3               cta     = 0.00072         ctp     = 0.0001
+eg      = 1.16            pta     = 0.0015          ptp    = 0.0005          keg     = 0.439
//*
ends diop_33_l110e
//*
//* Device nw/psub diode
//*
model dionw_l110e diode level = 3
+ hcomp=1.0000e+00 imax=1.00e+14
//**************************************************************
//*               GENERAL PARAMETERS
//**************************************************************
+area    = 1.77e-007       perim      = 0.00493         tnom    = 25
//**************************************************************
//*               DC PARAMETERS
//***************************************************************
+is      = 1.8996e-006*(1+djs_dionw_l110e)          isw      = 1.8425e-009*(1+djsw_dionw_l110e)       ik     = 792          bv      = 9.7886
+ibv     = 5.952           ikr     = 595.2          n       = 1.208*(1+dn_dionw_l110e)            rs     = 1.5232e-005*(1+drs_dionw_l110e)
+jtun    = 5.7634e-006     jtunsw  = 8e-012          ntun    = 36.577                               nbv     = 1.116
//**************************************************************
//*               CAPACITANCE PARAMETERS
//**************************************************************
+cjo      = 8.28e-005*(1+dcj_dionw_l110e)  cjp     = 9.92e-010*(1+dcjp_dionw_l110e)  vj      = 0.588           vjsw     = 0.62
+mj      = 0.474           mjsw    = 0.27
//***************************************************************
//*               NOISE PARAMETERS
//**************************************************************
//**************************************************************
//*               TEMPERATURE PARAMETERS
//**************************************************************
+tlev    = 1               tlevc   = 1               trs     = -0.0038479      tbv1     = -0.000539
+xti     = 3               xtitun  = 3               keg     = 0.37            cta     = 0.00332
+ctp     = 0.001           eg      = 1.16            pta     = 0.0021          ptp    = 0.001
//*
//* Device dnw/psub diode
//*
model diodnw_l110e diode level = 3
+ hcomp=1.0000e+00 imax=1.00e+14
//**************************************************************
//*               GENERAL PARAMETERS
//**************************************************************
+area    = 3.2e-008        perim      = 0.00032         tnom    = 25
//**************************************************************
//*               DC PARAMETERS
//**************************************************************
+is      = 1.3886e-006*(1+djs_diodnw_l110e)        isw     = 7.8545e-011*(1+djsw_diodnw_l110e)     ik      = 6738.8
+bv      = 9.8407                                    ibv     = 5.952                                   ikr     = 595.2
+n       = 1.0073*(1+dn_diodnw_l110e)              rs      = 3.4225e-007*(1+drs_diodnw_l110e)      nbv     = 0.72
+jtun    = 3.4e-008                                  jtunsw  = 1e-014                                  ntun    = 32.6
//**************************************************************
//*               CAPACITANCE PARAMETERS
//**************************************************************
+cjo      = 0.00017814*(1+dcj_diodnw_l110e)        cjp     = 1.9409e-009*(1+dcjp_diodnw_l110e)       vj      = 0.34911
+vjsw     = 0.56633         mj      = 0.2415          mjsw    = 0.30262
//**************************************************************
//*               NOISE PARAMETERS
//**************************************************************
//**************************************************************
//*               TEMPERATURE PARAMETERS
//**************************************************************
+tlev    = 1               tlevc   = 1               trs     = 0.0045789
+tbv1     = -0.000539       xti     = 3               cta     = 0.0027908
+ctp     = 0.0013          eg      = 1.16            pta     = 0.0012245
+ptp    = 0.001           keg     = 0.2442          xtitun  = 3
//* Device pw/dnw diode
//*
model diopw_l110e diode level = 3
+ hcomp=1.0000e+00 imax=1.00e+14
//**************************************************************
//*               GENERAL PARAMETERS
//**************************************************************
+area    = 3.2e-008        perim      = 0.00032         tnom    = 25
//**************************************************************
//*               DC PARAMETERS
//**************************************************************
+is      = 1.2857e-006*(1+djs_diopw_l110e)            isw     = 6.5407e-013*(1+djsw_diopw_l110e)     ik      = 31946
+bv      = 9.35                                         ibv     = 5.952                                  ikr     = 595.2
+n       = 1.0841*(1+dn_diopw_l110e)                  rs      = 8.1728e-007*(1+drs_diopw_l110e)      nbv     = 0.75
+jtun    = 1.8685e-007                                  jtunsw  = 2.208e-012                             ntun    = 35
//**************************************************************
//*               CAPACITANCE PARAMETERS
//**************************************************************
+cjo      = 0.0011667*(1+dcj_diopw_l110e)        cjp     = 5.3568e-010*(1+dcjp_diopw_l110e)            vj      = 0.59388
+vjsw     = 0.62            mj      = 0.3081          mjsw    = 0.27
//**************************************************************
//*               NOISE PARAMETERS
//**************************************************************
//**************************************************************
//*               TEMPERATURE PARAMETERS
//**************************************************************
+tlev    = 1               tlevc   = 1               trs     = 0.006897
+tbv1     = -0.00044198     xti     = 3               cta     = 0.00085358
+ctp     = 0.001           eg      = 1.16            pta     = 0.001312
+ptp    = 0.001           keg     = 0.4477          xtitun  = 3
//*
