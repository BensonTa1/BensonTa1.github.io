//  ******************************************************************************
//
simulator lang=spectre insensitive=yes
//  TT: Typical n-ch MOSFET and Typical p-ch MOSFET
//  FF: Fast n-ch MOSFET and Fast p-ch MOSFET
//  SS: Slow n-ch MOSFET and Slow p-ch MOSFET
//  FNSP: Fast n-ch MOSFET and Slow p-ch MOSFET
//  SNFP: Slow n-ch MOSFET and Fast p-ch MOSFET
//  ******************************************************************************
//

library mylib

section tt
parameters dtox_n_12_sprf=0.0000e+00
parameters dvth0_n_12_sprf=0.0000e+00
parameters dk3_n_12_sprf=0.0000e+00
parameters dnlx_n_12_sprf=0.0000e+00
parameters du0_n_12_sprf=0.0000e+00
parameters dags_n_12_sprf=0.0000e+00
parameters db0_n_12_sprf=0.0000e+00
parameters dvsat_n_12_sprf=0.0000e+00
parameters deta0_n_12_sprf=0.0000e+00
parameters drdsw_n_12_sprf=0.0000e+00
parameters dcgso_n_12_sprf=0.0000e+00
parameters dcgdo_n_12_sprf=0.0000e+00
parameters dxl_n_12_sprf=0.0000e+00
parameters dxw_n_12_sprf=0.0000e+00
parameters dwwl_n_12_sprf=0.0000e+00
parameters dpvth0_n_12_sprf=0.0000e+00
parameters dwk3_n_12_sprf=0.0000e+00
parameters dcj_n_12_sprf=0
parameters dcjsw_n_12_sprf=0
parameters dcjswg_n_12_sprf=0
parameters dlvsat_n_12_sprf=0
parameters dwu0_n_12_sprf=0
parameters drgi_n_12_sprf=0
parameters drch_n_12_sprf=0
parameters drgc_n_12_sprf=0
parameters dcgd_ext_n_12_sprf=0
parameters dcds_ext_n_12_sprf=0
parameters dtox_p_12_sprf=0.0000e+00
parameters dvth0_p_12_sprf=0.0000e+00
parameters dk3_p_12_sprf=0.0000e+00
parameters dnlx_p_12_sprf=0.0000e+00
parameters du0_p_12_sprf=0.0000e+00
parameters dags_p_12_sprf=0.0000e+00
parameters db0_p_12_sprf=0.0000e+00
parameters dvsat_p_12_sprf=0.0000e+00
parameters deta0_p_12_sprf=0.0000e+00
parameters drdsw_p_12_sprf=0.0000e+00
parameters dcgso_p_12_sprf=0.0000e+00
parameters dcgdo_p_12_sprf=0.0000e+00
parameters dxl_p_12_sprf=0.0000e+00
parameters dxw_p_12_sprf=0.0000e+00
parameters dwwl_p_12_sprf=0.0000e+00
parameters dpvth0_p_12_sprf=0.0000e+00
parameters dcj_p_12_sprf=0
parameters dcjswg_p_12_sprf=0
parameters dcjsw_p_12_sprf=0
parameters dcj_nw_p_12_sprf=0
parameters dcjsw_nw_p_12_sprf=0
parameters dlvsat_p_12_sprf=0
parameters dlags_p_12_sprf=0
parameters dcf_p_12_sprf=0
parameters drgi_p_12_sprf=0
parameters drch_p_12_sprf=0
parameters drgc_p_12_sprf=0
parameters dcgd_ext_p_12_sprf=0
parameters dcds_ext_p_12_sprf=0
parameters dcj_nwtw_n_12bpw_sprf=0
parameters dcjsw_nw_n_12bpw_sprf=0
parameters dcjsw_nwtw_n_12bpw_sprf=0
parameters dcj_nw_n_12bpw_sprf=0
//
include "l110ae_sp12_v021_rf.mdl.scs"
endsection tt

section ss
parameters dtox_n_12_sprf=7.89000e-11
parameters dvth0_n_12_sprf=2.02000e-002
parameters dk3_n_12_sprf=12.90000e+000
parameters dnlx_n_12_sprf=1.55000e-008
parameters du0_n_12_sprf=-1.20000e-003
parameters dags_n_12_sprf=0.0000e-001
parameters db0_n_12_sprf=0.0000e+00
parameters dvsat_n_12_sprf=+0.00000e+003
parameters deta0_n_12_sprf=+1.30000e-02
parameters drdsw_n_12_sprf=-3.00000e+000
parameters dcgso_n_12_sprf=-2.6460e-11
parameters dcgdo_n_12_sprf=-2.6460e-11
parameters dxl_n_12_sprf=5.00000e-09
parameters dxw_n_12_sprf=-2.0000000e-008
parameters dwwl_n_12_sprf=-8.00000e-022
parameters dpvth0_n_12_sprf=0.420000e-015
parameters dwk3_n_12_sprf=0.0000e+00
parameters dcj_n_12_sprf=0.1
parameters dcjsw_n_12_sprf=0.1
parameters dcjswg_n_12_sprf=0.1
parameters dlvsat_n_12_sprf=0
parameters dwu0_n_12_sprf=2.000000e-009
parameters drgi_n_12_sprf=0.2
parameters drch_n_12_sprf=0.2
parameters drgc_n_12_sprf=0.2
parameters dcgd_ext_n_12_sprf=0.83
parameters dcds_ext_n_12_sprf=0.3
parameters dtox_p_12_sprf=8.49000e-11
parameters dvth0_p_12_sprf=-02.8300e-002
parameters dk3_p_12_sprf=13.50000e+000
parameters dnlx_p_12_sprf=+1.60000e-009
parameters du0_p_12_sprf=5.600e-004
parameters dags_p_12_sprf=+0.00000e-001
parameters db0_p_12_sprf=0.0000e+00
parameters dvsat_p_12_sprf=-0.0000000e+004
parameters deta0_p_12_sprf=+0.000e-03
parameters drdsw_p_12_sprf=0.00000e+000
parameters dcgso_p_12_sprf=-1.7500e-11
parameters dcgdo_p_12_sprf=-1.7500e-11
parameters dxl_p_12_sprf=5.00000e-09
parameters dxw_p_12_sprf=-2.50000e-008
parameters dwwl_p_12_sprf=+9.00000e-022
parameters dpvth0_p_12_sprf=0.18000e-015
parameters dcj_p_12_sprf=0.1
parameters dcjswg_p_12_sprf=0.1
parameters dcjsw_p_12_sprf=0.1
parameters dcj_nw_p_12_sprf=0.1
parameters dcjsw_nw_p_12_sprf=0.1
parameters dlvsat_p_12_sprf=-0.00000e-3
parameters dlags_p_12_sprf=-0.000e-007
parameters dcf_p_12_sprf=0.75
parameters drgi_p_12_sprf=0.2
parameters drch_p_12_sprf=0.2
parameters drgc_p_12_sprf=0.2
parameters dcgd_ext_p_12_sprf=0.2
parameters dcds_ext_p_12_sprf=2.0
parameters dcj_nwtw_n_12bpw_sprf=0.1
parameters dcjsw_nw_n_12bpw_sprf=0.1
parameters dcjsw_nwtw_n_12bpw_sprf=0.1
parameters dcj_nw_n_12bpw_sprf=0.1

//
include "l110ae_sp12_v021_rf.mdl.scs"
endsection ss

section ff
parameters dtox_n_12_sprf=-7.89000e-11
parameters dvth0_n_12_sprf=-2.2500e-002
parameters dk3_n_12_sprf=-13.000e+000
parameters dnlx_n_12_sprf=-1.2500e-008
parameters du0_n_12_sprf=1.7000e-03
parameters dags_n_12_sprf=-00.0000e-001
parameters db0_n_12_sprf=0.0000e+00
parameters dvsat_n_12_sprf=0.0000000e+003
parameters deta0_n_12_sprf=-17.0000e-03
parameters drdsw_n_12_sprf=+5.5000000e+000
parameters dcgso_n_12_sprf=2.6460e-11
parameters dcgdo_n_12_sprf=2.6460e-11
parameters dxl_n_12_sprf=-5.00000e-09
parameters dxw_n_12_sprf=2.000000e-008
parameters dwwl_n_12_sprf=-00.0000e-022
parameters dpvth0_n_12_sprf=-0.2600e-015
parameters dwk3_n_12_sprf=0.0000e+00
parameters dcj_n_12_sprf=-0.1
parameters dcjsw_n_12_sprf=-0.1
parameters dcjswg_n_12_sprf=-0.1
parameters dlvsat_n_12_sprf=-0.00000e-002
parameters dwu0_n_12_sprf=-3.40000e-09
parameters drgi_n_12_sprf=-0.2
parameters drch_n_12_sprf=-0.2
parameters drgc_n_12_sprf=-0.2
parameters dcgd_ext_n_12_sprf=-0.8
parameters dcds_ext_n_12_sprf=-0.2
parameters dtox_p_12_sprf=-8.49000e-11
parameters dvth0_p_12_sprf=+3.5200e-002
parameters dk3_p_12_sprf=-15.00000e+000
parameters dnlx_p_12_sprf=+4.60000e-009
parameters du0_p_12_sprf=-5.5000e-004
parameters dags_p_12_sprf=0.00000e-001
parameters db0_p_12_sprf=0.0000e+00
parameters dvsat_p_12_sprf=+0.0000000e+004
parameters deta0_p_12_sprf=-18.000e-03
parameters drdsw_p_12_sprf=-0.00000e+000
parameters dcgso_p_12_sprf=1.7500e-11
parameters dcgdo_p_12_sprf=1.7500e-11
parameters dxl_p_12_sprf=-5.00000e-09
parameters dxw_p_12_sprf=2.50000e-008
parameters dwwl_p_12_sprf=32.00000e-022
parameters dpvth0_p_12_sprf=-0.10000e-015
parameters dcj_p_12_sprf=-0.1
parameters dcjswg_p_12_sprf=-0.1
parameters dcjsw_p_12_sprf=-0.1
parameters dcj_nw_p_12_sprf=-0.1
parameters dcjsw_nw_p_12_sprf=-0.1
parameters dlvsat_p_12_sprf=+0.0000e-3
parameters dlags_p_12_sprf=0
parameters dcf_p_12_sprf=-0.57
parameters drgi_p_12_sprf=-0.2
parameters drch_p_12_sprf=-0.2
parameters drgc_p_12_sprf=-0.2
parameters dcgd_ext_p_12_sprf=-0.20
parameters dcds_ext_p_12_sprf=-0.2
parameters dcj_nwtw_n_12bpw_sprf=-0.1
parameters dcjsw_nw_n_12bpw_sprf=-0.1
parameters dcjsw_nwtw_n_12bpw_sprf=-0.1
parameters dcj_nw_n_12bpw_sprf=-0.1
//
include "l110ae_sp12_v021_rf.mdl.scs"
endsection ff

section snfp
parameters dtox_n_12_sprf=0
parameters dvth0_n_12_sprf=2.14000000e-002
parameters dk3_n_12_sprf=-0.5400000e+000
parameters dnlx_n_12_sprf=0.2080000e-008
parameters du0_n_12_sprf=-1.9300000e-003
parameters dags_n_12_sprf=1.1030000e-001
parameters db0_n_12_sprf=0.0000e+00
parameters dvsat_n_12_sprf=+1.8100000e+003
parameters deta0_n_12_sprf=+1.780e-02
parameters drdsw_n_12_sprf=-5.5600000e+000
parameters dcgso_n_12_sprf=0
parameters dcgdo_n_12_sprf=0
parameters dxl_n_12_sprf=5.00000e-09
parameters dxw_n_12_sprf=+6.0000000e-008
parameters dwwl_n_12_sprf=+2.0730000e-022
parameters dpvth0_n_12_sprf=2.000000e-015
parameters dwk3_n_12_sprf=0.0000e+00
parameters dcj_n_12_sprf=0.1
parameters dcjsw_n_12_sprf=0.1
parameters dcjswg_n_12_sprf=0.1
parameters dlvsat_n_12_sprf=0
parameters dwu0_n_12_sprf=0
parameters drgi_n_12_sprf=0.1
parameters drch_n_12_sprf=0.1
parameters drgc_n_12_sprf=0.1
parameters dcgd_ext_n_12_sprf=0.2
parameters dcds_ext_n_12_sprf=0.1
parameters dtox_p_12_sprf=0
parameters dvth0_p_12_sprf=3.82e-02
parameters dk3_p_12_sprf=-7.50e+00
parameters dnlx_p_12_sprf=14.25e-09
parameters du0_p_12_sprf=-2.45e-04
parameters dags_p_12_sprf=+4.0000e-001
parameters db0_p_12_sprf=0.0000e+00
parameters dvsat_p_12_sprf=-0.0000000e+004
parameters deta0_p_12_sprf=-28.00e-03
parameters drdsw_p_12_sprf=0.00000e+000
parameters dcgso_p_12_sprf=0
parameters dcgdo_p_12_sprf=0
parameters dxl_p_12_sprf=-5.00000e-09
parameters dxw_p_12_sprf=-2.50000e-008
parameters dwwl_p_12_sprf=2.0000e-022
parameters dpvth0_p_12_sprf=+11.00e-17
parameters dcj_p_12_sprf=-0.1
parameters dcjswg_p_12_sprf=-0.1
parameters dcjsw_p_12_sprf=-0.1
parameters dcj_nw_p_12_sprf=-0.05
parameters dcjsw_nw_p_12_sprf=-0.05
parameters dlvsat_p_12_sprf=0.00e-04
parameters dlags_p_12_sprf=-1.23e-7
parameters dcf_p_12_sprf=0
parameters drgi_p_12_sprf=-0.1
parameters drch_p_12_sprf=-0.1
parameters drgc_p_12_sprf=-0.1
parameters dcgd_ext_p_12_sprf=-0.2
parameters dcds_ext_p_12_sprf=-0.1
parameters dcj_nwtw_n_12bpw_sprf=0.05
parameters dcjsw_nw_n_12bpw_sprf=0.05
parameters dcjsw_nwtw_n_12bpw_sprf=0.05
parameters dcj_nw_n_12bpw_sprf=0.05
//
include "l110ae_sp12_v021_rf.mdl.scs"
endsection snfp

section fnsp
parameters dtox_n_12_sprf=0
parameters dvth0_n_12_sprf=-1.740e-002
parameters dk3_n_12_sprf=-6.900e+000
parameters dnlx_n_12_sprf=-0.440000e-008
parameters du0_n_12_sprf=1.4000e-03
parameters dags_n_12_sprf=-0.0000e-001
parameters db0_n_12_sprf=0.0000e+00
parameters dvsat_n_12_sprf=0.0000000e+003
parameters deta0_n_12_sprf=-18.7000e-03
parameters drdsw_n_12_sprf=+4.50000e+000
parameters dcgso_n_12_sprf=0
parameters dcgdo_n_12_sprf=0
parameters dxl_n_12_sprf=-5.00000e-09
parameters dxw_n_12_sprf=2.0000000e-008
parameters dwwl_n_12_sprf=-0.0000e-022
parameters dpvth0_n_12_sprf=-0.20000e-015
parameters dwk3_n_12_sprf=0.0000e+00
parameters dcj_n_12_sprf=-0.1
parameters dcjsw_n_12_sprf=-0.1
parameters dcjswg_n_12_sprf=-0.1
parameters dlvsat_n_12_sprf=0
parameters dwu0_n_12_sprf=-2.50000e-09
parameters drgi_n_12_sprf=-0.1
parameters drch_n_12_sprf=-0.1
parameters drgc_n_12_sprf=-0.1
parameters dcgd_ext_n_12_sprf=-0.3
parameters dcds_ext_n_12_sprf=-0.1
parameters dtox_p_12_sprf=0
parameters dvth0_p_12_sprf=-3.041e-02
parameters dk3_p_12_sprf=7.00e+00
parameters dnlx_p_12_sprf=-70.50e-10
parameters du0_p_12_sprf=2.55e-04
parameters dags_p_12_sprf=3.50e-01
parameters db0_p_12_sprf=0.0000e+00
parameters dvsat_p_12_sprf=0.0000000e+004
parameters deta0_p_12_sprf=215.00e-04
parameters drdsw_p_12_sprf=0.000000e+001
parameters dcgso_p_12_sprf=0
parameters dcgdo_p_12_sprf=0
parameters dxl_p_12_sprf=5.00000e-09
parameters dxw_p_12_sprf=+2.5000e-008
parameters dwwl_p_12_sprf=-5.00e-22
parameters dpvth0_p_12_sprf=-23.00e-17
parameters dcj_p_12_sprf=0.1
parameters dcjswg_p_12_sprf=0.1
parameters dcjsw_p_12_sprf=0.1
parameters dcj_nw_p_12_sprf=0.05
parameters dcjsw_nw_p_12_sprf=0.05
parameters dlvsat_p_12_sprf=-1.00e-04
parameters dlags_p_12_sprf=-0.65e-07
parameters dcf_p_12_sprf=0
parameters drgi_p_12_sprf=0.1
parameters drch_p_12_sprf=0.1
parameters drgc_p_12_sprf=0.1
parameters dcgd_ext_p_12_sprf=0.01
parameters dcds_ext_p_12_sprf=0.1
parameters dcj_nwtw_n_12bpw_sprf=-0.05
parameters dcjsw_nw_n_12bpw_sprf=-0.05
parameters dcjsw_nwtw_n_12bpw_sprf=-0.05
parameters dcj_nw_n_12bpw_sprf=-0.05
//
include "l110ae_sp12_v021_rf.mdl.scs"
endsection fnsp
endlibrary mylib
