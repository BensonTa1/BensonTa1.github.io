//  ******************************************************************************
//
simulator lang=spectre insensitive=yes
//  TT: Typical n-ch MOSFET and Typical p-ch MOSFET
//  FF: Fast n-ch MOSFET and Fast p-ch MOSFET
//  SS: Slow n-ch MOSFET and Slow p-ch MOSFET
//  FNSP: Fast n-ch MOSFET and Slow p-ch MOSFET
//  SNFP: Slow n-ch MOSFET and Fast p-ch MOSFET
//  ******************************************************************************
//
library mylib

section tt
parameters dtox_n_12_llrf=0
parameters du0_n_12_llrf=0
parameters dvth0_n_12_llrf=0
parameters dxl_n_12_llrf=0
parameters dxw_n_12_llrf=0
parameters dnlx_n_12_llrf=0
parameters dk3_n_12_llrf=0
parameters dpvth0_n_12_llrf=0
parameters dwwl_n_12_llrf=0
parameters dcj_n_12_llrf=0
parameters dcjsw_n_12_llrf=0
parameters dcjswg_n_12_llrf=0
parameters dcgdo_n_12_llrf=0
parameters dcgso_n_12_llrf=0
parameters dcf_n_12_llrf=0
parameters dcgdl_n_12_llrf=0
parameters dcgsl_n_12_llrf=0
parameters dvsat_n_12_llrf=0
parameters dags_n_12_llrf=0
parameters drdsw_n_12_llrf=0
parameters dwags_n_12_llrf=0
parameters dpvsat_n_12_llrf=0
parameters dpdsub_n_12_llrf=0
parameters drgi_n_12_llrf=0
parameters drch_n_12_llrf=0
parameters drgc_n_12_llrf=0
parameters dcgd_ext_n_12_llrf=0
parameters dcds_ext_n_12_llrf=0
parameters dcj_nwtw_n_12bpw_llrf=0.0000000e+000
parameters dcjp_nwtw_n_12bpw_llrf=0.0000000e+000
parameters dcj_nw_n_12bpw_llrf=0.0000000e+000
parameters dcjp_nw_n_12bpw_llrf=0.0000000e+000
parameters dtox_p_12_llrf=0
parameters dxl_p_12_llrf=0
parameters du0_p_12_llrf=0
parameters dvth0_p_12_llrf=0
parameters drdsw_p_12_llrf=0
parameters dxw_p_12_llrf=0
parameters dnlx_p_12_llrf=0
parameters dk3_p_12_llrf=0
parameters dpvth0_p_12_llrf=0
parameters dwwl_p_12_llrf=0
parameters dcgdo_p_12_llrf=0
parameters dcgso_p_12_llrf=0
parameters dcj_p_12_llrf=0
parameters dcjsw_p_12_llrf=0
parameters dcjswg_p_12_llrf=0
parameters dcgdl_p_12_llrf=0
parameters dcgsl_p_12_llrf=0
parameters dcf_p_12_llrf=0
parameters dags_p_12_llrf=0
parameters dwags_p_12_llrf=0
parameters dwu0_p_12_llrf=0
parameters dpu0_p_12_llrf=0
parameters dlags_p_12_llrf=0
parameters dpags_p_12_llrf=0
parameters drgi_p_12_llrf=0.0000000e+000
parameters drch_p_12_llrf=0.0000000e+000
parameters drgc_p_12_llrf=0.0000000e+000
parameters dcgd_ext_p_12_llrf=0.0000000e+000
parameters dcds_ext_p_12_llrf=0.0000000e+000
parameters dcj_nw_p_12_llrf=0.0000000e+000
parameters cjsw_nw_p_12_llrf=0.0000000e+000
//
include "l110ae_ll12_v021_rf.mdl.scs"
endsection tt
//  *******************************
section ss
parameters dtox_n_12_llrf=8.0000e-11
parameters du0_n_12_llrf=-0.4035e-03
parameters dvth0_n_12_llrf=2.2051e-02
parameters dxl_n_12_llrf=1.0485e-09
parameters dxw_n_12_llrf=-1.6414e-08
parameters dnlx_n_12_llrf=8.5609e-09
parameters dk3_n_12_llrf=2.7518e+00
parameters dpvth0_n_12_llrf=2.5434e-15
parameters dwwl_n_12_llrf=-2.5050e-19
parameters dcj_n_12_llrf=7.2000e-05
parameters dcjsw_n_12_llrf=9.94e-012
parameters dcjswg_n_12_llrf=5e-011
parameters dcgdo_n_12_llrf=-1.86501e-011
parameters dcgso_n_12_llrf=-1.86501e-011
parameters dcf_n_12_llrf=-9.059e-012
parameters dcgdl_n_12_llrf=-3.1552e-012
parameters dcgsl_n_12_llrf=-3.1552e-012
parameters dvsat_n_12_llrf=0.00e+3
parameters dags_n_12_llrf=0.1815
parameters drdsw_n_12_llrf=11.0
parameters dwags_n_12_llrf=1.405e-7
parameters dpvsat_n_12_llrf=-0.6e-10
parameters dpdsub_n_12_llrf=-0.38e-14
parameters drgi_n_12_llrf=0.2
parameters drch_n_12_llrf=0.2
parameters drgc_n_12_llrf=0.2
parameters dcgd_ext_n_12_llrf=0.2
parameters dcds_ext_n_12_llrf=0.2
parameters dcj_nwtw_n_12bpw_llrf=0.1000000e+000
parameters dcjp_nwtw_n_12bpw_llrf=0.1000000e+000
parameters dcj_nw_n_12bpw_llrf=0.1000000e+000
parameters dcjp_nw_n_12bpw_llrf=0.1000000e+000
parameters dtox_p_12_llrf=8.49000e-11
parameters dxl_p_12_llrf=3.00000e-09
parameters du0_p_12_llrf=-5.14430e-04
parameters dvth0_p_12_llrf=-2.01100e-02
parameters drdsw_p_12_llrf=0*1.03470e+02
parameters dxw_p_12_llrf=-1.66090e-09
parameters dnlx_p_12_llrf=6.00120e-09
parameters dk3_p_12_llrf=2.32430e+00
parameters dpvth0_p_12_llrf=-1.77190e-15
parameters dwwl_p_12_llrf=6.84880e-23
parameters dcgdo_p_12_llrf=-1.6275e-11
parameters dcgso_p_12_llrf=-1.6275e-11
parameters dcj_p_12_llrf=9.6900e-05
parameters dcjsw_p_12_llrf=1.18000e-11
parameters dcjswg_p_12_llrf=5.31e-011
parameters dcgdl_p_12_llrf=-8.3591e-012
parameters dcgsl_p_12_llrf=-8.3591e-012
parameters dcf_p_12_llrf=-8.9044e-012
parameters dags_p_12_llrf=0.1675
parameters dwags_p_12_llrf=1.5e-8
parameters dwu0_p_12_llrf=5.25e-11
parameters dpu0_p_12_llrf=-2.26e-17
parameters dlags_p_12_llrf=0.4*3.48e-7
parameters dpags_p_12_llrf=1.05e-13
parameters drgi_p_12_llrf=2.0000000e-001
parameters drch_p_12_llrf=2.0000000e-001
parameters drgc_p_12_llrf=2.0000000e-001
parameters dcgd_ext_p_12_llrf=2.0000000e-001
parameters dcds_ext_p_12_llrf=2.0000000e-001
parameters dcj_nw_p_12_llrf=1.0000000e-001
parameters cjsw_nw_p_12_llrf=1.0000000e-001
//
include "l110ae_ll12_v021_rf.mdl.scs"
endsection ss
//  *******************************
section ff
parameters dtox_n_12_llrf=-8.0000e-11
parameters du0_n_12_llrf=0.2061e-03
parameters dvth0_n_12_llrf=-2.0050e-02
parameters dxl_n_12_llrf=-6.0599e-10
parameters dxw_n_12_llrf=1.1618e-08
parameters dnlx_n_12_llrf=-9.9082e-09
parameters dk3_n_12_llrf=-6.0590e+00
parameters dpvth0_n_12_llrf=-19.1999e-16
parameters dwwl_n_12_llrf=2.8091e-19
parameters dcj_n_12_llrf=-7.2000e-05
parameters dcjsw_n_12_llrf=-9.94e-012
parameters dcjswg_n_12_llrf=-5e-011
parameters dcgdo_n_12_llrf=1.86501e-011
parameters dcgso_n_12_llrf=1.86501e-011
parameters dcf_n_12_llrf=9.059e-012
parameters dcgdl_n_12_llrf=3.1552e-012
parameters dcgsl_n_12_llrf=3.1552e-012
parameters dvsat_n_12_llrf=3.28e+3
parameters dags_n_12_llrf=-0.1705
parameters drdsw_n_12_llrf=-0.7
parameters dwags_n_12_llrf=-42.05e-9
parameters dpvsat_n_12_llrf=-1.0e-10
parameters dpdsub_n_12_llrf=0.1e-15
parameters drgi_n_12_llrf=-0.2
parameters drch_n_12_llrf=-0.2
parameters drgc_n_12_llrf=-0.2
parameters dcgd_ext_n_12_llrf=-0.2
parameters dcds_ext_n_12_llrf=-0.2
parameters dcj_nwtw_n_12bpw_llrf=-0.1000000e+000
parameters dcjp_nwtw_n_12bpw_llrf=-0.1000000e+000
parameters dcj_nw_n_12bpw_llrf=-0.1000000e+000
parameters dcjp_nw_n_12bpw_llrf=-0.1000000e+000
parameters dtox_p_12_llrf=-8.49000e-11
parameters dxl_p_12_llrf=-6.00000e-10
parameters du0_p_12_llrf=3.98880e-04
parameters dvth0_p_12_llrf=2.00890e-02
parameters drdsw_p_12_llrf=0.5*- 8.825720e+01
parameters dxw_p_12_llrf=2.20010e-9
parameters dnlx_p_12_llrf=-5.51230e-09
parameters dk3_p_12_llrf=-2.43320e+00
parameters dpvth0_p_12_llrf=1.83340e-15
parameters dwwl_p_12_llrf=7.04970e-23
parameters dcgdo_p_12_llrf=1.6275e-11
parameters dcgso_p_12_llrf=1.6275e-11
parameters dcj_p_12_llrf=-9.6900e-05
parameters dcjsw_p_12_llrf=-1.18000e-11
parameters dcjswg_p_12_llrf=-5.31e-011
parameters dcgdl_p_12_llrf=8.3591e-012
parameters dcgsl_p_12_llrf=8.3591e-012
parameters dcf_p_12_llrf=8.9044e-012
parameters dags_p_12_llrf=-0.169
parameters dwags_p_12_llrf=-1.05e-8
parameters dwu0_p_12_llrf=-5.8e-11
parameters dpu0_p_12_llrf=1.7e-17
parameters dlags_p_12_llrf=0.4*- 2.19e-7
parameters dpags_p_12_llrf=-1.00e-13
parameters drgi_p_12_llrf=-2.0000000e-001
parameters drch_p_12_llrf=-2.0000000e-001
parameters drgc_p_12_llrf=-2.0000000e-001
parameters dcgd_ext_p_12_llrf=-2.0000000e-001
parameters dcds_ext_p_12_llrf=-2.0000000e-001
parameters dcj_nw_p_12_llrf=-1.0000000e-001
parameters cjsw_nw_p_12_llrf=-1.0000000e-001
//
include "l110ae_ll12_v021_rf.mdl.scs"
endsection ff
//  *******************************
section snfp
parameters dtox_n_12_llrf=0
parameters du0_n_12_llrf=-0.4417e-03
parameters dvth0_n_12_llrf=2.0000e-02
parameters dxl_n_12_llrf=0.2785e-09
parameters dxw_n_12_llrf=-0.7514e-08
parameters dnlx_n_12_llrf=6.5683e-09
parameters dk3_n_12_llrf=2.0034e+00
parameters dpvth0_n_12_llrf=10.4572e-16
parameters dwwl_n_12_llrf=-2.8050e-19
parameters dcj_n_12_llrf=7.2000e-05
parameters dcjsw_n_12_llrf=9.94e-012
parameters dcjswg_n_12_llrf=5e-011
parameters dcgdo_n_12_llrf=0
parameters dcgso_n_12_llrf=0
parameters dcf_n_12_llrf=0
parameters dcgdl_n_12_llrf=0
parameters dcgsl_n_12_llrf=0
parameters dvsat_n_12_llrf=0.00e+3
parameters dags_n_12_llrf=0.0855
parameters drdsw_n_12_llrf=8.6
parameters dwags_n_12_llrf=4.07e-8
parameters dpvsat_n_12_llrf=0.00e-10
parameters dpdsub_n_12_llrf=-0.24e-14
parameters drgi_n_12_llrf=0.1
parameters drch_n_12_llrf=0.1
parameters drgc_n_12_llrf=0.1
parameters dcgd_ext_n_12_llrf=0.1
parameters dcds_ext_n_12_llrf=0.1
parameters dcj_nwtw_n_12bpw_llrf=0.0500000e+000
parameters dcjp_nwtw_n_12bpw_llrf=0.0500000e+000
parameters dcj_nw_n_12bpw_llrf=0.0500000e+000
parameters dcjp_nw_n_12bpw_llrf=0.0500000e+000
parameters dtox_p_12_llrf=0.00000e+00
parameters dxl_p_12_llrf=-3.00000e-10
parameters du0_p_12_llrf=2.56440e-04
parameters dvth0_p_12_llrf=1.96890e-02
parameters drdsw_p_12_llrf=0.8*- 5.212720e+01
parameters dxw_p_12_llrf=1.10010e-9
parameters dnlx_p_12_llrf=-2.95250e-09
parameters dk3_p_12_llrf=-1.09344e+00
parameters dpvth0_p_12_llrf=9.64610e-16
parameters dwwl_p_12_llrf=1.27070e-23
parameters dcgdo_p_12_llrf=0
parameters dcgso_p_12_llrf=0
parameters dcj_p_12_llrf=-9.6900e-05
parameters dcjsw_p_12_llrf=-1.18000e-11
parameters dcjswg_p_12_llrf=-5.31e-011
parameters dcgdl_p_12_llrf=0
parameters dcgsl_p_12_llrf=0
parameters dcf_p_12_llrf=0
parameters dags_p_12_llrf=-0.0782
parameters dwags_p_12_llrf=-0.442e-8
parameters dwu0_p_12_llrf=-3.3e-11
parameters dpu0_p_12_llrf=0.77e-17
parameters dlags_p_12_llrf=1.05*- 1.008e-7
parameters dpags_p_12_llrf=-0.546e-13
parameters drgi_p_12_llrf=-1.0000000e-001
parameters drch_p_12_llrf=-1.0000000e-001
parameters drgc_p_12_llrf=-1.0000000e-001
parameters dcgd_ext_p_12_llrf=-1.0000000e-001
parameters dcds_ext_p_12_llrf=-1.0000000e-001
parameters dcj_nw_p_12_llrf=-5.0000000e-002
parameters cjsw_nw_p_12_llrf=-5.0000000e-002
//
include "l110ae_ll12_v021_rf.mdl.scs"
endsection snfp
//  *******************************
section fnsp
parameters dtox_n_12_llrf=0
parameters du0_n_12_llrf=0.4381e-03
parameters dvth0_n_12_llrf=-1.9000e-02
parameters dxl_n_12_llrf=-1.0061e-10
parameters dxw_n_12_llrf=0.640e-08
parameters dnlx_n_12_llrf=-6.3970e-09
parameters dk3_n_12_llrf=-3.0274e+00
parameters dpvth0_n_12_llrf=-9.7111e-16
parameters dwwl_n_12_llrf=3.9845e-19
parameters dcj_n_12_llrf=-7.2000e-05
parameters dcjsw_n_12_llrf=-9.94e-012
parameters dcjswg_n_12_llrf=-5e-011
parameters dcgdo_n_12_llrf=0
parameters dcgso_n_12_llrf=0
parameters dcf_n_12_llrf=0
parameters dcgdl_n_12_llrf=0
parameters dcgsl_n_12_llrf=0
parameters dvsat_n_12_llrf=3.35e+3
parameters dags_n_12_llrf=-0.0805
parameters drdsw_n_12_llrf=-1.80
parameters dwags_n_12_llrf=-23.025e-9
parameters dpvsat_n_12_llrf=-2.5e-10
parameters dpdsub_n_12_llrf=0.1e-15
parameters drgi_n_12_llrf=-0.1
parameters drch_n_12_llrf=-0.1
parameters drgc_n_12_llrf=-0.1
parameters dcgd_ext_n_12_llrf=-0.1
parameters dcds_ext_n_12_llrf=-0.1
parameters dcj_nwtw_n_12bpw_llrf=-0.0500000e+000
parameters dcjp_nwtw_n_12bpw_llrf=-0.0500000e+000
parameters dcj_nw_n_12bpw_llrf=-0.0500000e+000
parameters dcjp_nw_n_12bpw_llrf=-0.0500000e+000
parameters dtox_p_12_llrf=0.00000e+00
parameters dxl_p_12_llrf=1.50000e-09
parameters du0_p_12_llrf=-2.90230e-04
parameters dvth0_p_12_llrf=-1.93110e-02
parameters drdsw_p_12_llrf=0*0.33770e+02
parameters dxw_p_12_llrf=-0.83090e-09
parameters dnlx_p_12_llrf=3.54220e-09
parameters dk3_p_12_llrf=1.17910e+00
parameters dpvth0_p_12_llrf=-8.49900e-16
parameters dwwl_p_12_llrf=2.50840e-23
parameters dcgdo_p_12_llrf=0
parameters dcgso_p_12_llrf=0
parameters dcj_p_12_llrf=9.6900e-05
parameters dcjsw_p_12_llrf=1.18000e-11
parameters dcjswg_p_12_llrf=5.31e-011
parameters dcgdl_p_12_llrf=0
parameters dcgsl_p_12_llrf=0
parameters dcf_p_12_llrf=0
parameters dags_p_12_llrf=0.0717
parameters dwags_p_12_llrf=0.85e-8
parameters dwu0_p_12_llrf=3.40e-11
parameters dpu0_p_12_llrf=-0.85e-17
parameters dlags_p_12_llrf=0.6*2.09e-7
parameters dpags_p_12_llrf=0.370e-13
parameters drgi_p_12_llrf=1.0000000e-001
parameters drch_p_12_llrf=1.0000000e-001
parameters drgc_p_12_llrf=1.0000000e-001
parameters dcgd_ext_p_12_llrf=1.0000000e-001
parameters dcds_ext_p_12_llrf=1.0000000e-001
parameters dcj_nw_p_12_llrf=5.0000000e-002
parameters cjsw_nw_p_12_llrf=5.0000000e-002
//
include "l110ae_ll12_v021_rf.mdl.scs"
endsection fnsp
//
endlibrary mylib
