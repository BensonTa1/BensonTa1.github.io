//  ********************************************************************
//             Case Definition:
//             TT: Typical case N & P
//             FF: fast N Fast P
//             SS: Slow N Slow P
//             FNSP: fast N slow P
//             SNFP: Slow N Fast P
//  *************************** Start of Model Card *****************************
simulator lang=spectre insensitive=yes

library mylib

section tt
parameters dtox_n_33_l110aerf=0
parameters dxl_n_33_l110aerf=0
parameters du0_n_33_l110aerf=0
parameters dvth0_n_33_l110aerf=0
parameters drdsw_n_33_l110aerf=0
parameters dxw_n_33_l110aerf=0
parameters dlvth0_n_33_l110aerf=0
parameters dk3_n_33_l110aerf=0
parameters dpvth0_n_33_l110aerf=0
parameters dwwl_n_33_l110aerf=0
parameters dcgdo_n_33_l110aerf=0
parameters dcgso_n_33_l110aerf=0
parameters dcj_n_33_l110aerf=0
parameters dcjsw_n_33_l110aerf=0
parameters dcjswg_n_33_l110aerf=0
parameters dcgdl_n_33_l110aerf=0
parameters dcgsl_n_33_l110aerf=0
parameters drshg_n_33_l110aerf=0
parameters drcnt_n_33_l110aerf=0
parameters drvia_n_33_l110aerf=0
parameters dcgd_ext_n_33_l110aerf=0
parameters dcgb_ext_n_33_l110aerf=0
parameters dcds_ext_n_33_l110aerf=0
parameters drch_n_33_l110aerf=0
parameters ddlc_n_33_l110aerf=0
parameters ddwc_n_33_l110aerf=0
parameters dtox_p_33_l110aerf=0
parameters dxl_p_33_l110aerf=0
parameters du0_p_33_l110aerf=0
parameters dvth0_p_33_l110aerf=0
parameters drdsw_p_33_l110aerf=0
parameters dxw_p_33_l110aerf=0
parameters dlvth0_p_33_l110aerf=0
parameters dk3_p_33_l110aerf=0
parameters dpvth0_p_33_l110aerf=0
parameters dwwl_p_33_l110aerf=0
parameters dcgdl_p_33_l110aerf=0
parameters dcgsl_p_33_l110aerf=0
parameters dcgdo_p_33_l110aerf=0
parameters dcgso_p_33_l110aerf=0
parameters dcj_p_33_l110aerf=0
parameters dcjsw_p_33_l110aerf=0
parameters dcjswg_p_33_l110aerf=0
parameters drshg_p_33_l110aerf=0
parameters drcnt_p_33_l110aerf=0
parameters drvia_p_33_l110aerf=0
parameters dcgd_ext_p_33_l110aerf=0
parameters dcgb_ext_p_33_l110aerf=0
parameters dcds_ext_p_33_l110aerf=0
parameters drch_p_33_l110aerf=0
parameters dcj_nw_p_33_l110aerf=0
parameters dcjsw_nw_p_33_l110aerf=0
parameters ddlc_p_33_l110aerf=0
parameters ddwc_p_33_l110aerf=0
parameters dcj_nwtw_n_33bpw_rf=0
parameters dcjsw_nw_n_33bpw_rf=0
parameters dcjsw_nwtw_n_33bpw_rf=0
parameters dcj_nw_n_33bpw_rf=0
//
include "l110ae_33_rf_v051.mdl.scs"
endsection tt
//
section ff
parameters dtox_n_33_l110aerf=-1.50000e-10
parameters dxl_n_33_l110aerf=-1.00000e-08
parameters du0_n_33_l110aerf=3.50e-03
parameters dvth0_n_33_l110aerf=-2.02970e-02
parameters drdsw_n_33_l110aerf=-1.900e+02
parameters dxw_n_33_l110aerf=3.00040e-10
parameters dlvth0_n_33_l110aerf=-9.90e-09
parameters dk3_n_33_l110aerf=-7.54700e-01
parameters dpvth0_n_33_l110aerf=-4.20450e-16
parameters dwwl_n_33_l110aerf=-1.35e-22
parameters dcgdo_n_33_l110aerf=0.1
parameters dcgso_n_33_l110aerf=0.1
parameters dcj_n_33_l110aerf=-0.1
parameters dcjsw_n_33_l110aerf=-0.1
parameters dcjswg_n_33_l110aerf=-0.1
parameters dcgdl_n_33_l110aerf=0.1
parameters dcgsl_n_33_l110aerf=0.1
parameters drshg_n_33_l110aerf=-0.8
parameters drcnt_n_33_l110aerf=-0.7
parameters drvia_n_33_l110aerf=-0.7
parameters dcgd_ext_n_33_l110aerf=-0.2
parameters dcgb_ext_n_33_l110aerf=-0.2
parameters dcds_ext_n_33_l110aerf=-0.2
parameters drch_n_33_l110aerf=-0.1
parameters ddlc_n_33_l110aerf=1.3e-8
parameters ddwc_n_33_l110aerf=5.50e-8
parameters dtox_p_33_l110aerf=-1.50000e-10
parameters dxl_p_33_l110aerf=-5.00000e-09
parameters du0_p_33_l110aerf=4.05900e-04
parameters dvth0_p_33_l110aerf=2.85520e-02
parameters drdsw_p_33_l110aerf=-2.35830e+02
parameters dxw_p_33_l110aerf=1.26200e-08
parameters dlvth0_p_33_l110aerf=6.00e-09
parameters dk3_p_33_l110aerf=-1.19510e-01
parameters dpvth0_p_33_l110aerf=1.65390e-15
parameters dwwl_p_33_l110aerf=1.50e-20
parameters dcgdl_p_33_l110aerf=0.1
parameters dcgsl_p_33_l110aerf=0.1
parameters dcgdo_p_33_l110aerf=0.1
parameters dcgso_p_33_l110aerf=0.1
parameters dcj_p_33_l110aerf=-0.1
parameters dcjsw_p_33_l110aerf=-0.1
parameters dcjswg_p_33_l110aerf=-0.1
parameters drshg_p_33_l110aerf=-0.2
parameters drcnt_p_33_l110aerf=-0.2
parameters drvia_p_33_l110aerf=-0.2
parameters dcgd_ext_p_33_l110aerf=-0.2
parameters dcgb_ext_p_33_l110aerf=-0.2
parameters dcds_ext_p_33_l110aerf=-0.2
parameters drch_p_33_l110aerf=-0.2
parameters dcj_nw_p_33_l110aerf=-0.1
parameters dcjsw_nw_p_33_l110aerf=-0.1
parameters ddlc_p_33_l110aerf=1.4e-8
parameters ddwc_p_33_l110aerf=1.0e-7
parameters dcj_nwtw_n_33bpw_rf=-0.1
parameters dcjsw_nw_n_33bpw_rf=-0.1
parameters dcjsw_nwtw_n_33bpw_rf=-0.1
parameters dcj_nw_n_33bpw_rf=-0.1
//
include "l110ae_33_rf_v051.mdl.scs"
endsection ff
//
section ss
parameters dtox_n_33_l110aerf=1.50000e-10
parameters dxl_n_33_l110aerf=1.00000e-08
parameters du0_n_33_l110aerf=-4.000e-03
parameters dvth0_n_33_l110aerf=1.92990e-02
parameters drdsw_n_33_l110aerf=2.90e+02
parameters dxw_n_33_l110aerf=-3.04050e-09
parameters dlvth0_n_33_l110aerf=1.10e-08
parameters dk3_n_33_l110aerf=6.93660e-01
parameters dpvth0_n_33_l110aerf=6.31730e-16
parameters dwwl_n_33_l110aerf=1.95450e-22
parameters dcgdo_n_33_l110aerf=-0.1
parameters dcgso_n_33_l110aerf=-0.1
parameters dcj_n_33_l110aerf=0.1
parameters dcjsw_n_33_l110aerf=0.1
parameters dcjswg_n_33_l110aerf=0.1
parameters dcgdl_n_33_l110aerf=-0.1
parameters dcgsl_n_33_l110aerf=-0.1
parameters drshg_n_33_l110aerf=0.8
parameters drcnt_n_33_l110aerf=2.0
parameters drvia_n_33_l110aerf=2.3
parameters dcgd_ext_n_33_l110aerf=0.2
parameters dcgb_ext_n_33_l110aerf=0.2
parameters dcds_ext_n_33_l110aerf=0.2
parameters drch_n_33_l110aerf=0.1
parameters ddlc_n_33_l110aerf=-1.3e-8
parameters ddwc_n_33_l110aerf=-1.03e-7
parameters dtox_p_33_l110aerf=1.50000e-10
parameters dxl_p_33_l110aerf=5.00000e-09
parameters du0_p_33_l110aerf=-4.89180e-04
parameters dvth0_p_33_l110aerf=-2.73880e-02
parameters drdsw_p_33_l110aerf=4.20460e+02
parameters dxw_p_33_l110aerf=-2.200e-08
parameters dlvth0_p_33_l110aerf=-6.70e-09
parameters dk3_p_33_l110aerf=9.57600e-02
parameters dpvth0_p_33_l110aerf=-1.28e-15
parameters dwwl_p_33_l110aerf=-1.70e-20
parameters dcgdl_p_33_l110aerf=-0.1
parameters dcgsl_p_33_l110aerf=-0.1
parameters dcgdo_p_33_l110aerf=-0.1
parameters dcgso_p_33_l110aerf=-0.1
parameters dcj_p_33_l110aerf=0.1
parameters dcjsw_p_33_l110aerf=0.1
parameters dcjswg_p_33_l110aerf=0.1
parameters drshg_p_33_l110aerf=0.2
parameters drcnt_p_33_l110aerf=0.2
parameters drvia_p_33_l110aerf=0.2
parameters dcgd_ext_p_33_l110aerf=0.2
parameters dcgb_ext_p_33_l110aerf=0.2
parameters dcds_ext_p_33_l110aerf=0.2
parameters drch_p_33_l110aerf=0.2
parameters dcj_nw_p_33_l110aerf=0.1
parameters dcjsw_nw_p_33_l110aerf=0.1
parameters ddlc_p_33_l110aerf=-1.6e-8
parameters ddwc_p_33_l110aerf=-1.30e-7
parameters dcj_nwtw_n_33bpw_rf=0.1
parameters dcjsw_nw_n_33bpw_rf=0.1
parameters dcjsw_nwtw_n_33bpw_rf=0.1
parameters dcj_nw_n_33bpw_rf=0.1
//
include "l110ae_33_rf_v051.mdl.scs"
endsection ss
//
section fnsp
parameters dtox_n_33_l110aerf=0.00000e+00
parameters dxl_n_33_l110aerf=-1.00000e-08
parameters du0_n_33_l110aerf=2.20e-03
parameters dvth0_n_33_l110aerf=-1.71030e-02
parameters drdsw_n_33_l110aerf=-0.75600e+02
parameters dxw_n_33_l110aerf=5.58200e-10
parameters dlvth0_n_33_l110aerf=-4.20e-09
parameters dk3_n_33_l110aerf=-3.54e-01
parameters dpvth0_n_33_l110aerf=-1.54780e-16
parameters dwwl_n_33_l110aerf=-5.04600e-23
parameters dcgdo_n_33_l110aerf=0
parameters dcgso_n_33_l110aerf=0
parameters dcj_n_33_l110aerf=-0.1
parameters dcjsw_n_33_l110aerf=-0.1
parameters dcjswg_n_33_l110aerf=-0.1
parameters dcgdl_n_33_l110aerf=0
parameters dcgsl_n_33_l110aerf=0
parameters drshg_n_33_l110aerf=-0.4
parameters drcnt_n_33_l110aerf=-0.35
parameters drvia_n_33_l110aerf=-0.35
parameters dcgd_ext_n_33_l110aerf=-0.1
parameters dcgb_ext_n_33_l110aerf=-0.1
parameters dcds_ext_n_33_l110aerf=-0.1
parameters drch_n_33_l110aerf=-0.05
parameters ddlc_n_33_l110aerf=6.5e-9
parameters ddwc_n_33_l110aerf=2.25e-8
parameters dtox_p_33_l110aerf=0.00000e+00
parameters dxl_p_33_l110aerf=5.00000e-09
parameters du0_p_33_l110aerf=-2.92940e-04
parameters dvth0_p_33_l110aerf=-2.23680e-02
parameters drdsw_p_33_l110aerf=1.26e+02
parameters dxw_p_33_l110aerf=-1.00e-08
parameters dlvth0_p_33_l110aerf=-2.50e-09
parameters dk3_p_33_l110aerf=3.16660e-02
parameters dpvth0_p_33_l110aerf=-7.60e-16
parameters dwwl_p_33_l110aerf=1.52e-22
parameters dcgdl_p_33_l110aerf=0
parameters dcgsl_p_33_l110aerf=0
parameters dcgdo_p_33_l110aerf=0
parameters dcgso_p_33_l110aerf=0
parameters dcj_p_33_l110aerf=0.1
parameters dcjsw_p_33_l110aerf=0.1
parameters dcjswg_p_33_l110aerf=0.1
parameters drshg_p_33_l110aerf=0.1
parameters drcnt_p_33_l110aerf=0.1
parameters drvia_p_33_l110aerf=0.1
parameters dcgd_ext_p_33_l110aerf=0.1
parameters dcgb_ext_p_33_l110aerf=0.1
parameters dcds_ext_p_33_l110aerf=0.1
parameters drch_p_33_l110aerf=0.1
parameters dcj_nw_p_33_l110aerf=0.1
parameters dcjsw_nw_p_33_l110aerf=0.1
parameters ddlc_p_33_l110aerf=-8.0e-9
parameters ddwc_p_33_l110aerf=-6.5e-8
parameters dcj_nwtw_n_33bpw_rf=-0.05
parameters dcjsw_nw_n_33bpw_rf=-0.05
parameters dcjsw_nwtw_n_33bpw_rf=-0.05
parameters dcj_nw_n_33bpw_rf=-0.05

//
include "l110ae_33_rf_v051.mdl.scs"
endsection fnsp
//
section snfp
parameters dtox_n_33_l110aerf=0.00000e+00
parameters dxl_n_33_l110aerf=1.00000e-08
parameters du0_n_33_l110aerf=-2.20e-03
parameters dvth0_n_33_l110aerf=1.68060e-02
parameters drdsw_n_33_l110aerf=0.90790e+02
parameters dxw_n_33_l110aerf=-9.85070e-10
parameters dlvth0_n_33_l110aerf=4.40e-09
parameters dk3_n_33_l110aerf=3.58810e-01
parameters dpvth0_n_33_l110aerf=1.67180e-16
parameters dwwl_n_33_l110aerf=7.04700e-23
parameters dcgdo_n_33_l110aerf=0
parameters dcgso_n_33_l110aerf=0
parameters dcj_n_33_l110aerf=0.1
parameters dcjsw_n_33_l110aerf=0.1
parameters dcjswg_n_33_l110aerf=0.1
parameters dcgdl_n_33_l110aerf=0
parameters dcgsl_n_33_l110aerf=0
parameters drshg_n_33_l110aerf=0.4
parameters drcnt_n_33_l110aerf=0.35
parameters drvia_n_33_l110aerf=0.35
parameters dcgd_ext_n_33_l110aerf=0.1
parameters dcgb_ext_n_33_l110aerf=0.1
parameters dcds_ext_n_33_l110aerf=0.1
parameters drch_n_33_l110aerf=0.05
parameters ddlc_n_33_l110aerf=-6.5e-9
parameters ddwc_n_33_l110aerf=-5.0e-8
parameters dtox_p_33_l110aerf=0.00000e+00
parameters dxl_p_33_l110aerf=-5.00000e-09
parameters du0_p_33_l110aerf=2.71930e-04
parameters dvth0_p_33_l110aerf=2.29320e-02
parameters drdsw_p_33_l110aerf=-9.00e+01
parameters dxw_p_33_l110aerf=7.650e-09
parameters dlvth0_p_33_l110aerf=2.30e-09
parameters dk3_p_33_l110aerf=-3.44730e-02
parameters dpvth0_p_33_l110aerf=8.230e-16
parameters dwwl_p_33_l110aerf=-1.1450e-22
parameters dcgdl_p_33_l110aerf=0
parameters dcgsl_p_33_l110aerf=0
parameters dcgdo_p_33_l110aerf=0
parameters dcgso_p_33_l110aerf=0
parameters dcj_p_33_l110aerf=-0.1
parameters dcjsw_p_33_l110aerf=-0.1
parameters dcjswg_p_33_l110aerf=-0.1
parameters drshg_p_33_l110aerf=-0.1
parameters drcnt_p_33_l110aerf=-0.1
parameters drvia_p_33_l110aerf=-0.1
parameters dcgd_ext_p_33_l110aerf=-0.1
parameters dcgb_ext_p_33_l110aerf=-0.1
parameters dcds_ext_p_33_l110aerf=-0.1
parameters drch_p_33_l110aerf=-0.1
parameters dcj_nw_p_33_l110aerf=-0.1
parameters dcjsw_nw_p_33_l110aerf=-0.1
parameters ddlc_p_33_l110aerf=7.0e-9
parameters ddwc_p_33_l110aerf=5.0e-8
parameters dcj_nwtw_n_33bpw_rf=0.05
parameters dcjsw_nw_n_33bpw_rf=0.05
parameters dcjsw_nwtw_n_33bpw_rf=0.05
parameters dcj_nw_n_33bpw_rf=0.05
//
include "l110ae_33_rf_v051.mdl.scs"
endsection snfp
//
//  **************************** End of Model Card *******************************
endlibrary mylib
