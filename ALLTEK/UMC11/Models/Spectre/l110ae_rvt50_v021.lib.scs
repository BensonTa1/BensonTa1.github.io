//******************************************************************************
simulator lang=spectre insensitive=yes
//TT: Typical n-ch MOSFET and Typical p-ch MOSFET
//FF: Fast n-ch MOSFET and Fast p-ch MOSFET
//SS: Slow n-ch MOSFET and Slow p-ch MOSFET
//FNSP: Fast n-ch MOSFET and Slow p-ch MOSFET
//SNFP: Slow n-ch MOSFET and Fast p-ch MOSFET
//******************************************************************************
//
library mylib
section tt
parameters dtox_n_50_rvtl110ae=0.0000000e+000
parameters dxl_n_50_rvtl110ae=0.0000000e+000
parameters dxw_n_50_rvtl110ae=0.0000000e+000
parameters dvth0_n_50_rvtl110ae=0.0000000e+000
parameters dnlx_n_50_rvtl110ae=0.0000000e+000
parameters dk3_n_50_rvtl110ae=0.0000000e+000
parameters dpvth0_n_50_rvtl110ae=0.0000000e+000
parameters du0_n_50_rvtl110ae=0.0000000e+000
parameters dlrdsw_n_50_rvtl110ae=0.0000000e+000
parameters dwwl_n_50_rvtl110ae=0.0000000e+000
parameters dprdsw_n_50_rvtl110ae=0.0000000e+000
parameters dags_n_50_rvtl110ae=0.0000000e+000
parameters dlvsat_n_50_rvtl110ae=0.0000000e+000
parameters dwb0_n_50_rvtl110ae=0.0000000e+000
parameters dpvsat_n_50_rvtl110ae=0.0000000e+000
parameters dleta0_n_50_rvtl110ae=0.0000000e+000
parameters dpeta0_n_50_rvtl110ae=0.0000000e+000
parameters dcj_n_50_rvtl110ae=0.0000000e+000
parameters dcjsw_n_50_rvtl110ae=0.0000000e+000
parameters dcjswg_n_50_rvtl110ae=0.0000000e+000
parameters dcgdo_n_50_rvtl110ae=0.0000000e+000
parameters dcgso_n_50_rvtl110ae=0.0000000e+000
parameters dcgdl_n_50_rvtl110ae=0.0000000e+000
parameters dcgsl_n_50_rvtl110ae=0.0000000e+000
parameters djtsswgd_n_50_rvtl110ae=0.0000000e+000
parameters djtsswgs_n_50_rvtl110ae=0.0000000e+000
parameters dtox_p_50_rvtl110ae=0.0000000e+000
parameters dxl_p_50_rvtl110ae=0.0000000e+000
parameters dxw_p_50_rvtl110ae=0.0000000e+000
parameters dvth0_p_50_rvtl110ae=0.0000000e+000
parameters dlvth0_p_50_rvtl110ae=0.0000000e+000
parameters dk3_p_50_rvtl110ae=0.0000000e+000
parameters dpvth0_p_50_rvtl110ae=0.0000000e+000
parameters du0_p_50_rvtl110ae=0.0000000e+000
parameters drdsw_p_50_rvtl110ae=0.0000000e+000
parameters dpu0_p_50_rvtl110ae=0.0000000e+000
parameters dags_p_50_rvtl110ae=0.0000000e+000
parameters dvsat_p_50_rvtl110ae=0.0000000e+000
parameters dwags_p_50_rvtl110ae=0.0000000e+000
parameters dpvsat_p_50_rvtl110ae=0.0000000e+000
parameters djtsswgd_p_50_rvtl110ae=0.0000000e+000
parameters djtsswgs_p_50_rvtl110ae=0.0000000e+000
parameters dcj_p_50_rvtl110ae=1.0000000e+000
parameters dcjsw_p_50_rvtl110ae=1.0000000e+000
parameters dcjswg_p_50_rvtl110ae=1.0000000e+000
parameters dcgdo_p_50_rvtl110ae=1.0000000e+000
parameters dcgso_p_50_rvtl110ae=1.0000000e+000
parameters dcgdl_p_50_rvtl110ae=1.0000000e+000
parameters dcgsl_p_50_rvtl110ae=1.0000000e+000
parameters dwu0_p_50_rvtl110ae=0.0000000e+000
parameters deta0_p_50_rvtl110ae=0.0000000e+000
+
include "l110ae_rvt50_v021.mdl.scs"
+
endsection tt
//
section ff
parameters dtox_n_50_rvtl110ae=-3.5700000e-010
parameters dxl_n_50_rvtl110ae=-1.5000000e-008
parameters dxw_n_50_rvtl110ae=1.2075535e-008
parameters dvth0_n_50_rvtl110ae=-2.6842729e-002
parameters dnlx_n_50_rvtl110ae=-4.7676272e-008
parameters dk3_n_50_rvtl110ae=-1.2092664e+000
parameters dpvth0_n_50_rvtl110ae=3.3562451e-016
parameters du0_n_50_rvtl110ae=4.2979083e-003
parameters dlrdsw_n_50_rvtl110ae=-2.7964092e-005
parameters dwwl_n_50_rvtl110ae=-4.8103135e-022
parameters dprdsw_n_50_rvtl110ae=0.0000000e+000
parameters dags_n_50_rvtl110ae=-2.1902882e-002
parameters dlvsat_n_50_rvtl110ae=7.7599353e-004
parameters dwb0_n_50_rvtl110ae=4.5248914e-015
parameters dpvsat_n_50_rvtl110ae=2.8709269e-010
parameters dleta0_n_50_rvtl110ae=-1.2456518e-009
parameters dpeta0_n_50_rvtl110ae=3.7805933e-016
parameters dcj_n_50_rvtl110ae=-7.6390000e-005
parameters dcjsw_n_50_rvtl110ae=-9.6400000e-012
parameters dcjswg_n_50_rvtl110ae=-1.7580000e-011
parameters dcgdo_n_50_rvtl110ae=4.3000000e-012
parameters dcgso_n_50_rvtl110ae=4.3000000e-012
parameters dcgdl_n_50_rvtl110ae=1.0000000e-011
parameters dcgsl_n_50_rvtl110ae=1.0000000e-011
parameters djtsswgd_n_50_rvtl110ae=3.1243791e-007
parameters djtsswgs_n_50_rvtl110ae=3.1243791e-007
parameters dtox_p_50_rvtl110ae=-3.7200000e-010
parameters dxl_p_50_rvtl110ae=-2.0000000e-008
parameters dxw_p_50_rvtl110ae=5.3260494e-010
parameters dvth0_p_50_rvtl110ae=4.1942043e-002
parameters dlvth0_p_50_rvtl110ae=1.2675350e-008
parameters dk3_p_50_rvtl110ae=-3.9817363e-001
parameters dpvth0_p_50_rvtl110ae=2.3587909e-015
parameters du0_p_50_rvtl110ae=7.6801386e-004
parameters drdsw_p_50_rvtl110ae=-2.4314345e+002
parameters dpu0_p_50_rvtl110ae=1.7524756e-016
parameters dags_p_50_rvtl110ae=-6.1242244e-003
parameters dvsat_p_50_rvtl110ae=1.4376535e+003
parameters dwags_p_50_rvtl110ae=-3.2844223e-010
parameters dpvsat_p_50_rvtl110ae=6.1549188e-010
parameters djtsswgd_p_50_rvtl110ae=7.3500000e-006
parameters djtsswgs_p_50_rvtl110ae=7.3500000e-006
parameters dcj_p_50_rvtl110ae=9.0000000e-001
parameters dcjsw_p_50_rvtl110ae=9.0000000e-001
parameters dcjswg_p_50_rvtl110ae=9.0000000e-001
parameters dcgdo_p_50_rvtl110ae=1.1000000e+000
parameters dcgso_p_50_rvtl110ae=1.1000000e+000
parameters dcgdl_p_50_rvtl110ae=1.1000000e+000
parameters dcgsl_p_50_rvtl110ae=1.1000000e+000
parameters dwu0_p_50_rvtl110ae=1.7182799e-010
parameters deta0_p_50_rvtl110ae=0.0000000e+000
+
include "l110ae_rvt50_v021.mdl.scs"
+
endsection ff
//
section ss
parameters dtox_n_50_rvtl110ae=3.5700000e-010
parameters dxl_n_50_rvtl110ae=1.5000000e-008
parameters dxw_n_50_rvtl110ae=-1.9763985e-008
parameters dvth0_n_50_rvtl110ae=2.4647433e-002
parameters dnlx_n_50_rvtl110ae=5.4390993e-008
parameters dk3_n_50_rvtl110ae=1.0535771e+000
parameters dpvth0_n_50_rvtl110ae=-6.2304914e-016
parameters du0_n_50_rvtl110ae=-4.5054698e-003
parameters dlrdsw_n_50_rvtl110ae=5.8681692e-005
parameters dwwl_n_50_rvtl110ae=-2.7800355e-022
parameters dprdsw_n_50_rvtl110ae=0.0000000e+000
parameters dags_n_50_rvtl110ae=2.5851519e-002
parameters dlvsat_n_50_rvtl110ae=-8.2785509e-004
parameters dwb0_n_50_rvtl110ae=-5.4206114e-015
parameters dpvsat_n_50_rvtl110ae=-5.5085661e-010
parameters dleta0_n_50_rvtl110ae=1.1771743e-009
parameters dpeta0_n_50_rvtl110ae=-5.7337097e-016
parameters dcj_n_50_rvtl110ae=7.6390000e-005
parameters dcjsw_n_50_rvtl110ae=9.6400000e-012
parameters dcjswg_n_50_rvtl110ae=1.7580000e-011
parameters dcgdo_n_50_rvtl110ae=-4.3000000e-012
parameters dcgso_n_50_rvtl110ae=-4.3000000e-012
parameters dcgdl_n_50_rvtl110ae=-1.0000000e-011
parameters dcgsl_n_50_rvtl110ae=-1.0000000e-011
parameters djtsswgd_n_50_rvtl110ae=-6.0462725e-008
parameters djtsswgs_n_50_rvtl110ae=-6.0462725e-008
parameters dtox_p_50_rvtl110ae=3.7200000e-010
parameters dxl_p_50_rvtl110ae=2.0000000e-008
parameters dxw_p_50_rvtl110ae=-7.8506032e-010
parameters dvth0_p_50_rvtl110ae=-4.1103043e-002
parameters dlvth0_p_50_rvtl110ae=-1.4046511e-008
parameters dk3_p_50_rvtl110ae=2.7853679e-001
parameters dpvth0_p_50_rvtl110ae=-1.1871962e-015
parameters du0_p_50_rvtl110ae=-8.1971489e-004
parameters drdsw_p_50_rvtl110ae=4.7862610e+002
parameters dpu0_p_50_rvtl110ae=-2.0395794e-016
parameters dags_p_50_rvtl110ae=6.0340951e-003
parameters dvsat_p_50_rvtl110ae=-3.5323245e+003
parameters dwags_p_50_rvtl110ae=2.2447818e-010
parameters dpvsat_p_50_rvtl110ae=-8.1619173e-010
parameters djtsswgd_p_50_rvtl110ae=-4.9000000e-007
parameters djtsswgs_p_50_rvtl110ae=-4.9000000e-007
parameters dcj_p_50_rvtl110ae=1.1000000e+000
parameters dcjsw_p_50_rvtl110ae=1.1000000e+000
parameters dcjswg_p_50_rvtl110ae=1.1000000e+000
parameters dcgdo_p_50_rvtl110ae=9.0000000e-001
parameters dcgso_p_50_rvtl110ae=9.0000000e-001
parameters dcgdl_p_50_rvtl110ae=9.0000000e-001
parameters dcgsl_p_50_rvtl110ae=9.0000000e-001
parameters dwu0_p_50_rvtl110ae=-1.8516205e-010
parameters deta0_p_50_rvtl110ae=1.4647065e-005
+
include "l110ae_rvt50_v021.mdl.scs"
+
endsection ss
//
section fnsp
parameters dtox_n_50_rvtl110ae=0.0000000e+000
parameters dxl_n_50_rvtl110ae=-8.0000000e-009
parameters dxw_n_50_rvtl110ae=6.6066851e-009
parameters dvth0_n_50_rvtl110ae=-1.3585607e-002
parameters dnlx_n_50_rvtl110ae=-2.2627915e-008
parameters dk3_n_50_rvtl110ae=-5.7883985e-001
parameters dpvth0_n_50_rvtl110ae=5.8806650e-016
parameters du0_n_50_rvtl110ae=2.3921332e-003
parameters dlrdsw_n_50_rvtl110ae=-1.4696652e-005
parameters dwwl_n_50_rvtl110ae=-5.4257004e-022
parameters dprdsw_n_50_rvtl110ae=0.0000000e+000
parameters dags_n_50_rvtl110ae=-1.1188299e-002
parameters dlvsat_n_50_rvtl110ae=7.6816772e-004
parameters dwb0_n_50_rvtl110ae=2.3533815e-015
parameters dpvsat_n_50_rvtl110ae=6.5286202e-011
parameters dleta0_n_50_rvtl110ae=-1.1910884e-009
parameters dpeta0_n_50_rvtl110ae=2.3761858e-016
parameters dcj_n_50_rvtl110ae=-7.6390000e-005
parameters dcjsw_n_50_rvtl110ae=-9.6400000e-012
parameters dcjswg_n_50_rvtl110ae=-1.7580000e-011
parameters dcgdo_n_50_rvtl110ae=0.0000000e+000
parameters dcgso_n_50_rvtl110ae=0.0000000e+000
parameters dcgdl_n_50_rvtl110ae=0.0000000e+000
parameters dcgsl_n_50_rvtl110ae=0.0000000e+000
parameters djtsswgd_n_50_rvtl110ae=3.0867217e-007
parameters djtsswgs_n_50_rvtl110ae=3.0867217e-007
parameters dtox_p_50_rvtl110ae=0.0000000e+000
parameters dxl_p_50_rvtl110ae=1.0000000e-008
parameters dxw_p_50_rvtl110ae=-4.2736701e-010
parameters dvth0_p_50_rvtl110ae=-2.0751264e-002
parameters dlvth0_p_50_rvtl110ae=-6.8099275e-009
parameters dk3_p_50_rvtl110ae=1.9274196e-001
parameters dpvth0_p_50_rvtl110ae=-8.5206582e-016
parameters du0_p_50_rvtl110ae=-4.7969810e-004
parameters drdsw_p_50_rvtl110ae=1.9935066e+002
parameters dpu0_p_50_rvtl110ae=-9.4282635e-017
parameters dags_p_50_rvtl110ae=3.0768523e-003
parameters dvsat_p_50_rvtl110ae=-2.3191059e+003
parameters dwags_p_50_rvtl110ae=1.3421509e-010
parameters dpvsat_p_50_rvtl110ae=-3.4171323e-010
parameters djtsswgd_p_50_rvtl110ae=-4.9000000e-007
parameters djtsswgs_p_50_rvtl110ae=-4.9000000e-007
parameters dcj_p_50_rvtl110ae=1.1000000e+000
parameters dcjsw_p_50_rvtl110ae=1.1000000e+000
parameters dcjswg_p_50_rvtl110ae=1.1000000e+000
parameters dcgdo_p_50_rvtl110ae=1.0000000e+000
parameters dcgso_p_50_rvtl110ae=1.0000000e+000
parameters dcgdl_p_50_rvtl110ae=1.0000000e+000
parameters dcgsl_p_50_rvtl110ae=1.0000000e+000
parameters dwu0_p_50_rvtl110ae=-8.9587731e-011
parameters deta0_p_50_rvtl110ae=3.0439196e-004
+
include "l110ae_rvt50_v021.mdl.scs"
+
endsection fnsp
//
section snfp
parameters dtox_n_50_rvtl110ae=0.0000000e+000
parameters dxl_n_50_rvtl110ae=8.0000000e-009
parameters dxw_n_50_rvtl110ae=-8.3567873e-009
parameters dvth0_n_50_rvtl110ae=1.3069722e-002
parameters dnlx_n_50_rvtl110ae=2.4389116e-008
parameters dk3_n_50_rvtl110ae=5.5668489e-001
parameters dpvth0_n_50_rvtl110ae=-6.6210583e-016
parameters du0_n_50_rvtl110ae=-2.4201766e-003
parameters dlrdsw_n_50_rvtl110ae=2.1423524e-005
parameters dwwl_n_50_rvtl110ae=4.2348199e-022
parameters dprdsw_n_50_rvtl110ae=0.0000000e+000
parameters dags_n_50_rvtl110ae=1.2228380e-002
parameters dlvsat_n_50_rvtl110ae=-7.4903384e-004
parameters dwb0_n_50_rvtl110ae=-2.5852783e-015
parameters dpvsat_n_50_rvtl110ae=-1.3349569e-010
parameters dleta0_n_50_rvtl110ae=5.9453399e-013
parameters dpeta0_n_50_rvtl110ae=1.1554241e-016
parameters dcj_n_50_rvtl110ae=7.6390000e-005
parameters dcjsw_n_50_rvtl110ae=9.6400000e-012
parameters dcjswg_n_50_rvtl110ae=1.7580000e-011
parameters dcgdo_n_50_rvtl110ae=0.0000000e+000
parameters dcgso_n_50_rvtl110ae=0.0000000e+000
parameters dcgdl_n_50_rvtl110ae=0.0000000e+000
parameters dcgsl_n_50_rvtl110ae=0.0000000e+000
parameters djtsswgd_n_50_rvtl110ae=-5.3146184e-008
parameters djtsswgs_n_50_rvtl110ae=-5.3146184e-008
parameters dtox_p_50_rvtl110ae=0.0000000e+000
parameters dxl_p_50_rvtl110ae=-1.0000000e-008
parameters dxw_p_50_rvtl110ae=2.2460146e-010
parameters dvth0_p_50_rvtl110ae=2.1218937e-002
parameters dlvth0_p_50_rvtl110ae=6.3242397e-009
parameters dk3_p_50_rvtl110ae=-1.9892162e-001
parameters dpvth0_p_50_rvtl110ae=1.1036536e-015
parameters du0_p_50_rvtl110ae=4.7206960e-004
parameters drdsw_p_50_rvtl110ae=-1.4408270e+002
parameters dpu0_p_50_rvtl110ae=8.8642676e-017
parameters dags_p_50_rvtl110ae=-3.1475411e-003
parameters dvsat_p_50_rvtl110ae=1.8160994e+003
parameters dwags_p_50_rvtl110ae=-1.4394251e-010
parameters dpvsat_p_50_rvtl110ae=3.0717356e-010
parameters djtsswgd_p_50_rvtl110ae=7.3500000e-006
parameters djtsswgs_p_50_rvtl110ae=7.3500000e-006
parameters dcj_p_50_rvtl110ae=9.0000000e-001
parameters dcjsw_p_50_rvtl110ae=9.0000000e-001
parameters dcjswg_p_50_rvtl110ae=9.0000000e-001
parameters dcgdo_p_50_rvtl110ae=1.0000000e+000
parameters dcgso_p_50_rvtl110ae=1.0000000e+000
parameters dcgdl_p_50_rvtl110ae=1.0000000e+000
parameters dcgsl_p_50_rvtl110ae=1.0000000e+000
parameters dwu0_p_50_rvtl110ae=8.8746215e-011
parameters deta0_p_50_rvtl110ae=0.0000000e+000
+
include "l110ae_rvt50_v021.mdl.scs"
+
endsection snfp
//
endlibrary mylib
