.SUBCKT MOMCAPS_SY_MML110AE PLUS MINUS B
.ENDS

.SUBCKT MOMCAPS_AS_MML110AE PLUS MINUS B
.ENDS

.SUBCKT MOMCAPS_STRIPE_MML110AE PLUS MINUS B
.ENDS

.SUBCKT MOMCAPS_SYMESH_MML110AE PLUS1 MINUS1 PLUS2 MINUS2 B
.ENDS

.SUBCKT MOMCAPS_ASMESH_MML110AE PLUS1 MINUS1 PLUS2 MINUS2 B
.ENDS

.SUBCKT MOMCAPS_STRIPEMESH_MML110AE PLUS1 MINUS1 PLUS2 MINUS2 B
.ENDS

.SUBCKT MIMCAPS_1F_PSUB_RFKF PLUS MINUS PSUB
.ENDS

.SUBCKT MIMCAPS_1F_NWELL_RFKF PLUS MINUS NW PSUB
.ENDS

.SUBCKT MIMCAPS_1P5F_PSUB_RFKF PLUS MINUS PSUB
.ENDS

.SUBCKT MIMCAPS_1P5F_NWELL_RFKF PLUS MINUS NW PSUB
.ENDS

.SUBCKT MIMCAPS_2F_PSUB_RFKF PLUS MINUS PSUB
.ENDS

.SUBCKT MIMCAPS_2F_NWELL_RFKF PLUS MINUS NW PSUB
.ENDS

.SUBCKT N_12BPW_HSRF D G S B NW PSUB
.ENDS

.SUBCKT N_12_HSRF D G S B
.ENDS

.SUBCKT N_33BPW_RF D G S B NW PSUB
.ENDS

.SUBCKT N_33_RF D G S B
.ENDS

.SUBCKT N_33_HGRF D G S B
.ENDS

.SUBCKT N_33BPW_HGRF D G S B NW PSUB
.ENDS

.SUBCKT P_12_HSRF D G S B PSUB
.ENDS

.SUBCKT P_33_RF D G S B PSUB
.ENDS

.SUBCKT P_33_HGRF D G S B PSUB
.ENDS

.SUBCKT N_12BPW_SPRF D G S B NW PSUB
.ENDS

.SUBCKT N_12_SPRF D G S B
.ENDS

.SUBCKT P_12_SPRF D G S B PSUB
.ENDS

.SUBCKT N_12BPW_LLRF D G S B NW PSUB
.ENDS

.SUBCKT N_12_LLRF D G S B
.ENDS

.SUBCKT P_12_LLRF D G S B PSUB
.ENDS

.SUBCKT PAD_RF PLUS PSUB
.ENDS

.SUBCKT RNNPO_RF PLUS MINUS NW PSUB
.ENDS

.SUBCKT RNPPO_RF PLUS MINUS NW PSUB
.ENDS

.SUBCKT RNHR1000_RF PLUS MINUS NW PSUB
.ENDS

.SUBCKT VARMIS_12_RF PLUS MINUS PSUB
.ENDS

.SUBCKT VARMIS_33_RF PLUS MINUS PSUB
.ENDS

.SUBCKT VARDIOP_RF PLUS MINUS PSUB
.ENDS

.SUBCKT MOMCAPS_ARRAY_VP3_RF PLUS MINUS NW PSUB
.ENDS

.SUBCKT MOMCAPS_ARRAY_VP4_RF PLUS MINUS NW PSUB
.ENDS

.SUBCKT MOMCAPS_ARRAY_VP5_RFVCL PLUS MINUS SH
.ENDS

.SUBCKT L_CR40K_RFVIL PLUS MINUS PSUB
.ENDS

.SUBCKT LNW_CR40K_RFVIL PLUS MINUS NW PSUB
.ENDS

.SUBCKT L_SQSK_RFVIL PLUS MINUS PSUB
.ENDS

.SUBCKT L_SQSKNW_RFVIL PLUS MINUS NW PSUB
.ENDS

.SUBCKT L_SY40K_RFVIL PLUS MINUS PSUB
.ENDS

.SUBCKT LNW_SY40K_RFVIL PLUS MINUS NW PSUB
.ENDS

.SUBCKT L_SY40KCT_RFVIL PLUS MINUS CT PSUB
.ENDS

.SUBCKT LNW_SY40KCT_RFVIL PLUS MINUS CT NW PSUB
.ENDS

.SUBCKT L_OCCTOUT_TRANS_RFVIL P1 P2 S1 S2 CTS PSUB
.ENDS

.SUBCKT L_SQ_TRANS_RFVIL P1 P2 S1 S2 PSUB
.ENDS

.SUBCKT L_SQCTIN_TRANS_RFVIL P1 P2 S1 S2 CTP PSUB
.ENDS

.SUBCKT L_SQCTOUT_TRANS_RFVIL P1 P2 S1 S2 CTS PSUB
.ENDS

.SUBCKT L_CR40K_RFVIL_1P6M0T1U PLUS MINUS PSUB
.ENDS

.SUBCKT LNW_CR40K_RFVIL_1P6M0T1U PLUS MINUS NW PSUB
.ENDS

.SUBCKT L_SQSK_RFVIL_1P6M0T1U PLUS MINUS PSUB
.ENDS

.SUBCKT LNW_SQSK_RFVIL_1P6M0T1U PLUS MINUS NW PSUB
.ENDS

.SUBCKT L_SY40K_RFVIL_1P6M0T1U PLUS MINUS PSUB
.ENDS

.SUBCKT LNW_SY40K_RFVIL_1P6M0T1U PLUS MINUS NW PSUB
.ENDS

.SUBCKT L_SY40KCT_RFVIL_1P6M0T1U PLUS MINUS CT PSUB
.ENDS

.SUBCKT LNW_SY40KCT_RFVIL_1P6M0T1U PLUS MINUS CT NW PSUB
.ENDS

.SUBCKT L_CR8K_RFVIL_1P6M0T1F PLUS MINUS PSUB
.ENDS

.SUBCKT LNW_CR8K_RFVIL_1P6M0T1F PLUS MINUS NW PSUB
.ENDS

.SUBCKT L_CR8K_RFVIL_1P5M1T PLUS MINUS PSUB
.ENDS

.SUBCKT L_SQSK_RFVIL_1P6M0T1F PLUS MINUS PSUB
.ENDS

.SUBCKT LNW_SQSK_RFVIL_1P6M0T1F PLUS MINUS NW PSUB
.ENDS

.SUBCKT L_SQSK_RFVIL_1P5M1T PLUS MINUS PSUB
.ENDS

.SUBCKT L_SY8K_RFVIL_1P6M0T1F PLUS MINUS PSUB
.ENDS

.SUBCKT LNW_SY8K_RFVIL_1P6M0T1F PLUS MINUS NW PSUB
.ENDS

.SUBCKT L_SY8K_RFVIL_1P5M1T PLUS MINUS PSUB
.ENDS

.SUBCKT L_SY8KCT_RFVIL_1P6M0T1F PLUS MINUS CT PSUB
.ENDS

.SUBCKT LNW_SY8KCT_RFVIL_1P6M0T1F PLUS MINUS CT NW PSUB
.ENDS

.SUBCKT L_SY8KCT_RFVIL_1P5M1T PLUS MINUS CT PSUB
.ENDS

.SUBCKT L_CR20K_RFVIL_1P7M0T1F1U PLUS MINUS PSUB
.ENDS

.SUBCKT L_SQSK_RFVIL_1P7M0T1F1U PLUS MINUS PSUB
.ENDS

.SUBCKT L_SY20K_RFVIL_1P7M0T1F1U PLUS MINUS PSUB
.ENDS

.SUBCKT L_SY20KCT_RFVIL_1P7M0T1F1U PLUS MINUS CT PSUB
.ENDS

.SUBCKT L_CR12K_RFVIL_1P8M0T1F1U PLUS MINUS PSUB
.ENDS

.SUBCKT L_SQSK_RFVIL_1P8M0T1F1U PLUS MINUS PSUB
.ENDS

.SUBCKT L_SY12K_RFVIL_1P8M0T1F1U PLUS MINUS PSUB
.ENDS

.SUBCKT L_SY12KCT_RFVIL_1P8M0T1F1U PLUS MINUS CT PSUB
.ENDS

.SUBCKT L_CR40K_RFVIL_1P6M2T40K PLUS MINUS PSUB
.ENDS

.SUBCKT L_SQSK_RFVIL_1P6M2T40K PLUS MINUS PSUB
.ENDS

.SUBCKT L_SY40K_RFVIL_1P6M2T40K PLUS MINUS PSUB
.ENDS

.SUBCKT L_SY40KCT_RFVIL_1P6M2T40K PLUS MINUS CT PSUB
.ENDS
