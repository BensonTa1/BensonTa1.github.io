ADE simulation setup
Run mode: Single Run, Sweeps and Corners
Tests:
  TEST_TSMC13_ALLTEK_PLL:CP:1: TEST_TSMC13_ALLTEK_PLL/CP/schematic, simulator spectre
Global variables:
  D0 = 1.2
  D1 = 0
  VS = {Exclusion List}1.2{Exclusion List}{Center/Span%}Auto:1.2:3:20{Center/Span%}
  temperature = {Exclusion List}30{Exclusion List}{From/To}Auto:-25:5:100{From/To}
  VOUT = {Exclusion List}600m{Exclusion List}{From/To}Auto:300m:4:0.9{From/To}
  CP_IB = 10u
Corners (nominal off):
  model folders: /home/IC/Desktop/virtuoso/Process/TSMC13/TSMC13/models/spectre
  C0: cr013g_2d5_v1d4.scs[tt ss ff sf fs, tt_res ss_res ff_res]
Specs:
  TEST_TSMC13_ALLTEK_PLL:CP:1 / Phase Margin: > 60
