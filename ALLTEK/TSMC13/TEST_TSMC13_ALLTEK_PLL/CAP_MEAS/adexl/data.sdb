ADE simulation setup
Run mode: Monte Carlo Sampling
Tests:
  TEST_TSMC13_ALLTEK_PLL:CAP_MEAS:1: TEST_TSMC13_ALLTEK_PLL/CAP_MEAS/schematic, simulator spectre
Corners (nominal off):
  model folders: /home/IC/Desktop/virtuoso/Process/TSMC13/TSMC13/models/spectre
  C0: tsmc13rf.scs
Monte Carlo Sampling options: mcmethod=mismatch, mcnumpoints=200
