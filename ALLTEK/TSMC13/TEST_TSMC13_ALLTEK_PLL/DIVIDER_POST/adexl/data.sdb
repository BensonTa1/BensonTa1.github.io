ADE simulation setup
Run mode: Single Run, Sweeps and Corners
Tests:
  TEST_TSMC13_ALLTEK_PLL:DIVIDER_POST:1: TEST_TSMC13_ALLTEK_PLL/DIVIDER_POST/config, simulator spectre
    Outputs: (cross(vtime('tran "/FOUT2") 0.6 3 "rising" nil nil nil) - cross(vtime('tran "/FOUT2") 0.6 2 "rising" nil nil nil))
Global variables:
  POST_SEL = {Exclusion List}0{Exclusion List}{From/To}Auto:0:2:1.2{From/To}
  FS = 3.5G
  VS = {Exclusion List}1.2{Exclusion List}{Center/Span%}Auto:1.2:3:20{Center/Span%}
  temperature = {Exclusion List}30{Exclusion List}{From/To}Auto:-25:5:125{From/To}
Corners (nominal off):
  model folders: /home/IC/Desktop/virtuoso/Process/TSMC13/TSMC13/models/spectre
  C0: cr013g_2d5_v1d4.scs[tt ff ss sf fs]
