ADE simulation setup
Run mode: Single Run, Sweeps and Corners
Tests:
  TEST_TSMC13_ALLTEK_PLL:VCO_RING:1: TEST_TSMC13_ALLTEK_PLL/VCO_RING/schematic, simulator spectre
Global variables:
  VS = {Exclusion List}1.2{Exclusion List}{Center/Span%}Auto:1.2:3:20{Center/Span%}
  temperature = {Exclusion List}30{Exclusion List}{From/To}Auto:-25:5:125{From/To}
  VD1 = 0 (off)
  VD0 = 0 (off)
  VD2 = 0 (off)
  VCTRL = {Exclusion List}0.6{Exclusion List}{From/To}Auto:0:3:1.2{From/To}
  VDA = 0
Corners (nominal off):
  model folders: /home/IC/Desktop/virtuoso/Process/TSMC13/TSMC13/models/spectre
  C0: cr013g_2d5_v1d4.scs[tt ff ss sf fs, tt_res ff_res ss_res]
