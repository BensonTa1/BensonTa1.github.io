ADE simulation setup
Run mode: Single Run, Sweeps and Corners
Tests:
  TEST_TSMC13_ALLTEK_PLL:VCO_RING:1: TEST_TSMC13_ALLTEK_PLL/VCO_RING1/config, simulator spectre
Global variables:
  VS = {Exclusion List}1.2{Exclusion List}{Center/Span%}Auto:1.2:3:20{Center/Span%} (off)
  temperature = {Exclusion List}30{Exclusion List}{From/To}Auto:-25:5:125{From/To} (off)
  VCTRL = {Exclusion List}0.6{Exclusion List}{From/To}Auto:0:3:1.2{From/To} (off)
  D0 = 1.2
  CAP_D0 = 0
  CAP_D1 = 1.2
  CAP_DALL = 1.2
Corners (nominal off):
  model folders: /home/IC/Desktop/virtuoso/Process/TSMC13/TSMC13/models/spectre
  C0: cr013g_2d5_v1d4.scs[tt ff ss sf fs, tt_res ff_res ss_res, tt_mim], ResModel.scs[tt_disres]
  C1 (off): cr013g_2d5_v1d4.scs[tt, tt_res ff_res ss_res]
