ADE simulation setup
Run mode: Single Run, Sweeps and Corners
Tests:
  TEST_TSMC13_ALLTEK_PLL:DIVIDER_CMOS_D2_D3:1: TEST_TSMC13_ALLTEK_PLL/DIVIDER_CMOS_D2_D3/schematic, simulator spectre
Global variables:
  FS = 2.5G
  VS = 1.2
  temperature = {Exclusion List}30{Exclusion List}{From/To}Auto:-50:6:150{From/To}
Corners (nominal off):
  model folders: /home/IC/Desktop/virtuoso/Process/TSMC13/TSMC13/models/spectre
  C0: cr013g_2d5_v1d4.scs[tt ff ss sf fs]
