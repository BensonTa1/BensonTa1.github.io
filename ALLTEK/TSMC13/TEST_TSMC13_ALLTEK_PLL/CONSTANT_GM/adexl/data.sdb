ADE simulation setup
Run mode: Single Run, Sweeps and Corners
Tests:
  TEST_TSMC13_ALLTEK_PLL:CONSTANT_GM:1: TEST_TSMC13_ALLTEK_PLL/CONSTANT_GM/schematic, simulator spectre
Global variables:
  VS = {Exclusion List}1.2{Exclusion List}{Center/Span%}Auto:1.2:3:20{Center/Span%}
  temperature = {Exclusion List}30{Exclusion List}{From/To}Auto:-25:5:125{From/To}
Corners (nominal off):
  model folders: /home/IC/Desktop/virtuoso/Process/TSMC13/TSMC13/models/spectre
  C0: cr013g_2d5_v1d4.scs[tt_res ss_res ff_res, tt ff ss fs sf]
  C1 (off): cr013g_2d5_v1d4.scs[tt, stat]
