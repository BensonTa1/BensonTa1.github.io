ADE simulation setup
Run mode: Single Run, Sweeps and Corners
Tests:
  TEST_TSMC13_ALLTEK_PLL:PFD:1: TEST_TSMC13_ALLTEK_PLL/PFD/schematic, simulator spectre
Global variables:
  TS = 1/(19.2E6)
  TS1 = 1/(18E6)
  VS = {Exclusion List}1.2{Exclusion List}{Center/Span%}Auto:1.2:3:20{Center/Span%}
  temperature = {Exclusion List}30{Exclusion List}{From/To}Auto:-25:5:125{From/To}
Corners:
  model folders: /home/IC/Desktop/virtuoso/Process/TSMC13/TSMC13/models/spectre
  C0: cr013g_2d5_v1d4.scs[tt ss ff fs sf]
