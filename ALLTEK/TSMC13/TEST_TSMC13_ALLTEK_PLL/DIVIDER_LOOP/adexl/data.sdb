ADE simulation setup
Run mode: Monte Carlo Sampling
Tests:
  TEST_TSMC13_ALLTEK_PLL:DIVIDER_LOOP:1: TEST_TSMC13_ALLTEK_PLL/DIVIDER_LOOP/config, simulator spectre
Global variables:
  P0 = {Exclusion List}0{Exclusion List}{From/To}Auto:0:2:1.2{From/To} (off)
  P1 = {Exclusion List}1.2{Exclusion List}{From/To}Auto:0:2:1.2{From/To} (off)
  FS = 4G
  VS = {Exclusion List}1.2{Exclusion List}{Center/Span%}Auto:1.2:3:20{Center/Span%} (off)
  temperature = {Exclusion List}30{Exclusion List}{From/To}Auto:-25:5:125{From/To} (off)
  D4 = {Exclusion List}0{Exclusion List}{From/To}Auto:0:2:1.2{From/To} (off)
  D3 = {Exclusion List}0{Exclusion List}{From/To}Auto:0:2:1.2{From/To} (off)
  D2 = {Exclusion List}0{Exclusion List}{From/To}Auto:0:2:1.2{From/To} (off)
  D1 = {Exclusion List}0{Exclusion List}{From/To}Auto:0:2:1.2{From/To} (off)
  D0 = {Exclusion List}0{Exclusion List}{From/To}Auto:0:2:1.2{From/To} (off)
Corners:
  model folders: /home/IC/Desktop/virtuoso/Process/TSMC13/TSMC13/models/spectre
  C1: cr013g_2d5_v1d4.scs[tt, stat]
