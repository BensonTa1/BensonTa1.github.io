ADE simulation setup
Run mode: Single Run, Sweeps and Corners
Tests:
  TEST_TSMC13_ALLTEK_PLL:DIVIDER_ETSPC_D3_D4:1: TEST_TSMC13_ALLTEK_PLL/DIVIDER_ETSPC_D3_D4/schematic, simulator spectre
Global variables:
  FS = 4G
  VS = {Exclusion List}1.2{Exclusion List}{Center/Span%}Auto:1.2:3:10{Center/Span%}
  temperature = {Exclusion List}30{Exclusion List}{From/To}Auto:-25:6:125{From/To}
  MC = 0
Corners (nominal off):
  model folders: /home/IC/Desktop/virtuoso/Process/TSMC13/TSMC13/models/spectre
  C0: cr013g_2d5_v1d4.scs[tt ff ss sf fs]
