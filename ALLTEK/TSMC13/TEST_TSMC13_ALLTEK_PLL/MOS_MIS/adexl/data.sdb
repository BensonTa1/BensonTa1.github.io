ADE simulation setup
Run mode: Monte Carlo Sampling
Tests:
  TEST_TSMC13_ALLTEK_PLL:MOS_MIS:1: TEST_TSMC13_ALLTEK_PLL/MOS_MIS/schematic, simulator spectre
Corners (nominal off):
  model folders: /home/IC/Desktop/virtuoso/Process/TSMC13/TSMC13/models/spectre
  C0: cr013g_2d5_v1d4.scs[tt ff ss, stat]
