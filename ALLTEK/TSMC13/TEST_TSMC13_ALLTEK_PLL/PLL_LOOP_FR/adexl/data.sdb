ADE simulation setup
Run mode: Single Run, Sweeps and Corners
Tests:
  TEST_TSMC13_ALLTEK_PLL:PLL_LOOP_FR:1: TEST_TSMC13_ALLTEK_PLL/PLL_LOOP_FR/schematic, simulator spectre
Global variables:
  temperature = {Inclusion List}30{Inclusion List}{From/To}Auto:-25:5:125{From/To}
  VDC = {Inclusion List}1{Inclusion List}{From/To}Auto:0:13:1.2{From/To}
Corners:
  model folders: /home/IC/Desktop/virtuoso/Process/TSMC13/TSMC13/models/spectre
  C0: cr013g_2d5_v1d4.scs[tt ff ss sf fs]
