ADE simulation setup
Run mode: Single Run, Sweeps and Corners
Tests:
  TEST_TSMC13_Standard_Cell:DFF_D2:1: TEST_TSMC13_Standard_Cell/DFF_D2/schematic, simulator spectre
Global variables:
  TS = 0.25n
  temperature = {Exclusion List}30{Exclusion List}{From/To}Auto:-25:5:125{From/To}
  VS = {Exclusion List}1.2{Exclusion List}{Center/Span%}Auto:1.2:3:10{Center/Span%}
  W = 5u
Corners (nominal off):
  model folders: /home/IC/Desktop/virtuoso/Process/TSMC13/TSMC13/models/spectre
  C0: cor_std_mos.scs[ff fs sf ss tt]
