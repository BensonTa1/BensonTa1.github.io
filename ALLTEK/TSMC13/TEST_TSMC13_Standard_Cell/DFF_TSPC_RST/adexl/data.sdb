ADE simulation setup
Run mode: Single Run, Sweeps and Corners
Tests:
  TEST_TSMC13_Standard_Cell:DFF_TSPC_RST:1: TEST_TSMC13_Standard_Cell/DFF_TSPC_RST/schematic, simulator spectre
Global variables:
  FS = 6G
  VS = 1.2
  temperature = {Exclusion List}30{Exclusion List}{From/To}Auto:-25:6:125{From/To}
Corners (nominal off):
  model folders: /home/IC/Desktop/virtuoso/Process/TSMC13/TSMC13/models/spectre
  C0: cr013g_2d5_v1d4.scs[tt ff ss sf fs]
