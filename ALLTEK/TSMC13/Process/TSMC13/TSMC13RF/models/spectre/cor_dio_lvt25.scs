library dio_lvt25_cor

section ff_dio_lvt25
include "cr013g_2d5_v1d4.scs" section = ff_dio_lvt25
endsection ff_dio_lvt25

section ss_dio_lvt25
include "cr013g_2d5_v1d4.scs" section = ss_dio_lvt25
endsection ss_dio_lvt25

section tt_dio_lvt25
include "cr013g_2d5_v1d4.scs" section = tt_dio_lvt25
endsection tt_dio_lvt25

endlibrary dio_lvt25_cor
