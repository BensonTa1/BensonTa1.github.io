library mim_cor

section ff_mim
include "cr013g_2d5_v1d4.scs" section = ff_mim
endsection ff_mim

section ss_mim
include "cr013g_2d5_v1d4.scs" section = ss_mim
endsection ss_mim

section tt_mim
include "cr013g_2d5_v1d4.scs" section = tt_mim
endsection tt_mim

endlibrary mim_cor
