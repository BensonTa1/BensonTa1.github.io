library dio_uhvt_cor

section ff_dio_uhvt
include "cr013g_2d5_v1d4.scs" section = ff_dio_uhvt
endsection ff_dio_uhvt

section ss_dio_uhvt
include "cr013g_2d5_v1d4.scs" section = ss_dio_uhvt
endsection ss_dio_uhvt

section tt_dio_uhvt
include "cr013g_2d5_v1d4.scs" section = tt_dio_uhvt
endsection tt_dio_uhvt

endlibrary dio_uhvt_cor
