library bip_cor

section ff_bip
include "cr013g_2d5_v1d4.scs" section = ff_bip
endsection ff_bip

section ss_bip
include "cr013g_2d5_v1d4.scs" section = ss_bip
endsection ss_bip

section tt_bip
include "cr013g_2d5_v1d4.scs" section = tt_bip
endsection tt_bip

endlibrary bip_cor
