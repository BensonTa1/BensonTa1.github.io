//
simulator lang=spectre insensitive=yes
library tsmclib

section res_t
parameters rnw=409.0
parameters rnl=6.65
parameters rns=6.65
parameters rnwo=72.75
parameters rpl=7.25
parameters rps=7.25
parameters rpwo=145.87
include "ResModel.scs" section=res_macro
endsection res_t

//  ************ Library of best corner *********************************

section res_b
parameters rnw=334.0
parameters rnl=5.05
parameters rns=4.95
parameters rnwo=59.42
parameters rpl=5.37
parameters rps=4.66
parameters rpwo=116.7
include "ResModel.scs" section=res_macro
endsection res_b

//  ************ Library of worst corner ********************************

section res_w
parameters rnw=484.0
parameters rnl=8.25
parameters rns=8.35
parameters rnwo=86.08
parameters rpl=9.13
parameters rps=9.84
parameters rpwo=175.04
include "ResModel.scs" section=res_macro
endsection res_w

//  *********************************************************************

section res_macro
subckt rnwod_m ( n2 n1 body )
parameters l=1u w=1u rsh=rnw dw=0.224u ptc1=2.33e-3 ptc2=8.76e-6 pvc1=1.45e-2 pvc2=-6.27e-4
+ pt=temp tfac=1.0 + ptc1 * (pt - 25.0) + ptc2 * (pt - 25.0) * (pt - 25.0)

r1 ( n2 nm ) bsource r=rsh * l / (4.0 * (w - dw)) * (1 + pvc1 * abs(v(n2,n1))
+ + pvc2 * v(n2,n1) * v(n2,n1)) * tfac
r2 ( nm nn ) bsource r=rsh * l / (4.0 * (w - dw)) * (1 + pvc1 * abs(v(n2,n1))
+ + pvc2 * v(n2,n1) * v(n2,n1)) * tfac
r3 ( nn nx ) bsource r=rsh * l / (4.0 * (w - dw)) * (1 + pvc1 * abs(v(n2,n1))
+ + pvc2 * v(n2,n1) * v(n2,n1)) * tfac
r4 ( nx n1 ) bsource r=rsh * l / (4.0 * (w - dw)) * (1 + pvc1 * abs(v(n2,n1))
+ + pvc2 * v(n2,n1) * v(n2,n1)) * tfac
d1 ( body n2 ) nwdio area=(w - dw) * l / 5.0 pj=(w - dw) + 2.0 * l / 5.0
d2 ( body nm ) nwdio area=(w - dw) * l / 5.0 pj=2.0 * l / 5.0
d3 ( body nn ) nwdio area=(w - dw) * l / 5.0 pj=2.0 * l / 5.0
d4 ( body nx ) nwdio area=(w - dw) * l / 5.0 pj=2.0 * l / 5.0
d5 ( body n1 ) nwdio area=(w - dw) * l / 5.0 pj=(w - dw) + 2.0 * l / 5.0

ends rnwod_m

subckt rnodl_m ( n2 n1 body )
parameters l=1u w=1u rsh=rnl dw=-0.057u ptc1=2.97e-3 ptc2=2.89e-7 pvc1=-9.44e-5
+ pvc2=1.42e-3 pt=temp tfac=1.0 + ptc1 * (pt - 25.0) + ptc2 * (pt - 25.0) * (pt
+ - 25)

r1 ( n2 nm ) bsource r=rsh * l / (4.0 * (w - dw)) * (1 + pvc1 * abs(v(n2,n1))
+ + pvc2 * v(n2,n1) * v(n2,n1)) * tfac
r2 ( nm nn ) bsource r=rsh * l / (4.0 * (w - dw)) * (1 + pvc1 * abs(v(n2,n1))
+ + pvc2 * v(n2,n1) * v(n2,n1)) * tfac
r3 ( nn nx ) bsource r=rsh * l / (4.0 * (w - dw)) * (1 + pvc1 * abs(v(n2,n1))
+ + pvc2 * v(n2,n1) * v(n2,n1)) * tfac
r4 ( nx n1 ) bsource r=rsh * l / (4.0 * (w - dw)) * (1 + pvc1 * abs(v(n2,n1))
+ + pvc2 * v(n2,n1) * v(n2,n1)) * tfac
d1 ( body n2 ) ndio area=(w - dw) * l / 5.0 pj=(w - dw) + 2.0 * l / 5.0
d2 ( body nm ) ndio area=(w - dw) * l / 5.0 pj=2.0 * l / 5.0
d3 ( body nn ) ndio area=(w - dw) * l / 5.0 pj=2.0 * l / 5.0
d4 ( body nx ) ndio area=(w - dw) * l / 5.0 pj=2.0 * l / 5.0
d5 ( body n1 ) ndio area=(w - dw) * l / 5.0 pj=(w - dw) + 2.0 * l / 5.0

ends rnodl_m

subckt rnods_m ( n2 n1 body )
parameters l=1u w=1u rsh=rns dw=-0.057u ptc1=3.34e-3 ptc2=3.79e-7 pvc1=-1.67e-4
+ pvc2=6.88e-4 pt=temp tfac=1.0 + ptc1 * (pt - 25.0) + ptc2 * (pt - 25.0) * (pt
+ - 25)

r1 ( n2 nm ) bsource r=rsh * l / (4.0 * (w - dw)) * (1 + pvc1 * abs(v(n2,n1))
+ + pvc2 * v(n2,n1) * v(n2,n1)) * tfac
r2 ( nm nn ) bsource r=rsh * l / (4.0 * (w - dw)) * (1 + pvc1 * abs(v(n2,n1))
+ + pvc2 * v(n2,n1) * v(n2,n1)) * tfac
r3 ( nn nx ) bsource r=rsh * l / (4.0 * (w - dw)) * (1 + pvc1 * abs(v(n2,n1))
+ + pvc2 * v(n2,n1) * v(n2,n1)) * tfac
r4 ( nx n1 ) bsource r=rsh * l / (4.0 * (w - dw)) * (1 + pvc1 * abs(v(n2,n1))
+ + pvc2 * v(n2,n1) * v(n2,n1)) * tfac
d1 ( body n2 ) ndio area=(w - dw) * l / 5.0 pj=(w - dw) + 2.0 * l / 5.0
d2 ( body nm ) ndio area=(w - dw) * l / 5.0 pj=2.0 * l / 5.0
d3 ( body nn ) ndio area=(w - dw) * l / 5.0 pj=2.0 * l / 5.0
d4 ( body nx ) ndio area=(w - dw) * l / 5.0 pj=2.0 * l / 5.0
d5 ( body n1 ) ndio area=(w - dw) * l / 5.0 pj=(w - dw) + 2.0 * l / 5.0

ends rnods_m

subckt rnodwo_m ( n2 n1 body )
parameters l=1u w=1u rsh=rnwo dw=0.011u ptc1=1.32e-3 ptc2=5.53e-7 pvc1=2.99e-4 pvc2=5.56e-5
+ pt=temp tfac=1.0 + ptc1 * (pt - 25.0) + ptc2 * (pt - 25.0) * (pt - 25)

r1 ( n2 nm ) bsource r=rsh * l / (4.0 * (w - dw)) * (1 + pvc1 * abs(v(n2,n1))
+ + pvc2 * v(n2,n1) * v(n2,n1)) * tfac
r2 ( nm nn ) bsource r=rsh * l / (4.0 * (w - dw)) * (1 + pvc1 * abs(v(n2,n1))
+ + pvc2 * v(n2,n1) * v(n2,n1)) * tfac
r3 ( nn nx ) bsource r=rsh * l / (4.0 * (w - dw)) * (1 + pvc1 * abs(v(n2,n1))
+ + pvc2 * v(n2,n1) * v(n2,n1)) * tfac
r4 ( nx n1 ) bsource r=rsh * l / (4.0 * (w - dw)) * (1 + pvc1 * abs(v(n2,n1))
+ + pvc2 * v(n2,n1) * v(n2,n1)) * tfac
d1 ( body n2 ) ndio area=(w - dw) * l / 5.0 pj=(w - dw) + 2.0 * l / 5.0
d2 ( body nm ) ndio area=(w - dw) * l / 5.0 pj=2.0 * l / 5.0
d3 ( body nn ) ndio area=(w - dw) * l / 5.0 pj=2.0 * l / 5.0
d4 ( body nx ) ndio area=(w - dw) * l / 5.0 pj=2.0 * l / 5.0
d5 ( body n1 ) ndio area=(w - dw) * l / 5.0 pj=(w - dw) + 2.0 * l / 5.0

ends rnodwo_m

subckt rpodl_m ( n2 n1 body )
parameters l=1u w=1u rsh=rpl dw=-0.07u ptc1=2.89e-3 ptc2=1.03e-6 pvc1=-1.94e-4 pvc2=1.2e-3
+ pt=temp tfac=1.0 + ptc1 * (pt - 25.0) + ptc2 * (pt - 25.0) * (pt - 25)

r1 ( n2 nm ) bsource r=rsh * l / (4.0 * (w - dw)) * (1 + pvc1 * abs(v(n2,n1))
+ + pvc2 * v(n2,n1) * v(n2,n1)) * tfac
r2 ( nm nn ) bsource r=rsh * l / (4.0 * (w - dw)) * (1 + pvc1 * abs(v(n2,n1))
+ + pvc2 * v(n2,n1) * v(n2,n1)) * tfac
r3 ( nn nx ) bsource r=rsh * l / (4.0 * (w - dw)) * (1 + pvc1 * abs(v(n2,n1))
+ + pvc2 * v(n2,n1) * v(n2,n1)) * tfac
r4 ( nx n1 ) bsource r=rsh * l / (4.0 * (w - dw)) * (1 + pvc1 * abs(v(n2,n1))
+ + pvc2 * v(n2,n1) * v(n2,n1)) * tfac
d1 ( n2 body ) pdio area=(w - dw) * l / 5.0 pj=(w - dw) + 2.0 * l / 5.0
d2 ( nm body ) pdio area=(w - dw) * l / 5.0 pj=2.0 * l / 5.0
d3 ( nn body ) pdio area=(w - dw) * l / 5.0 pj=2.0 * l / 5.0
d4 ( nx body ) pdio area=(w - dw) * l / 5.0 pj=2.0 * l / 5.0
d5 ( n1 body ) pdio area=(w - dw) * l / 5.0 pj=(w - dw) + 2.0 * l / 5.0

ends rpodl_m

subckt rpods_m ( n2 n1 body )
parameters l=1u w=1u rsh=rps dw=-0.07u ptc1=3.45e-3 ptc2=4.16e-7 pvc1=-1.57e-4 pvc2=5.77e-4
+ pt=temp tfac=1.0 + ptc1 * (pt - 25.0) + ptc2 * (pt - 25.0) * (pt - 25)

r1 ( n2 nm ) bsource r=rsh * l / (4.0 * (w - dw)) * (1 + pvc1 * abs(v(n2,n1))
+ + pvc2 * v(n2,n1) * v(n2,n1)) * tfac
r2 ( nm nn ) bsource r=rsh * l / (4.0 * (w - dw)) * (1 + pvc1 * abs(v(n2,n1))
+ + pvc2 * v(n2,n1) * v(n2,n1)) * tfac
r3 ( nn nx ) bsource r=rsh * l / (4.0 * (w - dw)) * (1 + pvc1 * abs(v(n2,n1))
+ + pvc2 * v(n2,n1) * v(n2,n1)) * tfac
r4 ( nx n1 ) bsource r=rsh * l / (4.0 * (w - dw)) * (1 + pvc1 * abs(v(n2,n1))
+ + pvc2 * v(n2,n1) * v(n2,n1)) * tfac
d1 ( n2 body ) pdio area=(w - dw) * l / 5.0 pj=(w - dw) + 2.0 * l / 5.0
d2 ( nm body ) pdio area=(w - dw) * l / 5.0 pj=2.0 * l / 5.0
d3 ( nn body ) pdio area=(w - dw) * l / 5.0 pj=2.0 * l / 5.0
d4 ( nx body ) pdio area=(w - dw) * l / 5.0 pj=2.0 * l / 5.0
d5 ( n1 body ) pdio area=(w - dw) * l / 5.0 pj=(w - dw) + 2.0 * l / 5.0

ends rpods_m

subckt rpodwo_m ( n2 n1 body )
parameters l=1u w=1u rsh=rpwo dw=0.068u ptc1=1.28e-3 ptc2=9.43e-7 pvc1=3.68e-5 pvc2=2.45e-4
+ pt=temp tfac=1.0 + ptc1 * (pt - 25.0) + ptc2 * (pt - 25.0) * (pt - 25)

r1 ( n2 nm ) bsource r=rsh * l / (4.0 * (w - dw)) * (1 + pvc1 * abs(v(n2,n1))
+ + pvc2 * v(n2,n1) * v(n2,n1)) * tfac
r2 ( nm nn ) bsource r=rsh * l / (4.0 * (w - dw)) * (1 + pvc1 * abs(v(n2,n1))
+ + pvc2 * v(n2,n1) * v(n2,n1)) * tfac
r3 ( nn nx ) bsource r=rsh * l / (4.0 * (w - dw)) * (1 + pvc1 * abs(v(n2,n1))
+ + pvc2 * v(n2,n1) * v(n2,n1)) * tfac
r4 ( nx n1 ) bsource r=rsh * l / (4.0 * (w - dw)) * (1 + pvc1 * abs(v(n2,n1))
+ + pvc2 * v(n2,n1) * v(n2,n1)) * tfac
d1 ( n2 body ) pdio area=(w - dw) * l / 5.0 pj=(w - dw) + 2.0 * l / 5.0
d2 ( nm body ) pdio area=(w - dw) * l / 5.0 pj=2.0 * l / 5.0
d3 ( nn body ) pdio area=(w - dw) * l / 5.0 pj=2.0 * l / 5.0
d4 ( nx body ) pdio area=(w - dw) * l / 5.0 pj=2.0 * l / 5.0
d5 ( n1 body ) pdio area=(w - dw) * l / 5.0 pj=(w - dw) + 2.0 * l / 5.0

ends rpodwo_m

endsection res_macro

//*******************************************************************************
//                                                                              *
//      1. Distributed Resistor corner model                                    *
//                                                                              *
//          a.LIB TT_DISRES:Typical model                                       *
//                                                                              *
//          b.LIB FF_DISRES:Fast corner model                                   *
//                                                                              *
//          c.LIB SS_DISRES:Slow corner model                                   *
//                                                                              *
//*******************************************************************************

section stat_disres
statistics {
    mismatch {
        vary par_disres dist=gauss std=1/1
        }
    }
endsection stat_disres

section tt_disres
parameters
+ par_disres=0
+ disr_rppolyl=7.67
+ disr_rppolys=7.67
+ disr_rnpolyl=7.31
+ disr_rnpolys=7.31
+ disr_rnpolywo=260.09
+ disr_rppolywo=319.55
+ disr_rppolyhri=950
include "ResModel.scs" section=dis_res
endsection tt_disres

section ss_disres
parameters
+ par_disres=0
+ disr_rppolyl=7.67 + 1.92
+ disr_rppolys=7.67 + 2.32
+ disr_rnpolyl=7.31 + 1.90
+ disr_rnpolys=7.31 + 2.36
+ disr_rnpolywo=260.09 + 43.52
+ disr_rppolywo=319.55 + 63.91
+ disr_rppolyhri=950 + 190
include "ResModel.scs" section=dis_res
endsection ss_disres

section ff_disres
parameters
+ par_disres=0
+ disr_rppolyl=7.67 - 1.92
+ disr_rppolys=7.67 - 2.32
+ disr_rnpolyl=7.31 - 1.90
+ disr_rnpolys=7.31 - 2.36
+ disr_rnpolywo=260.09 - 43.52
+ disr_rppolywo=319.55 - 63.91
+ disr_rppolyhri=950 - 190
include "ResModel.scs" section=dis_res
endsection ff_disres

//  *************************************************************************************
// 	DISTRIBUTED RESISTOR MODEL                                                      *
//                                                                                      *
//               Model name      structure                                              *
//               -----------------------------------------                              *
//               rppolyl_dis    Distributed P+ Poly w/i Silicide w>=2um                 *
//               rppolys_dis    Distributed P+ Poly w/i Silicide 0.13um<=w<2um          *
//               rnpolyl_dis    Distributed N+ Poly w/i Silicide w>=2um                 *
//               rnpolys_dis    Distributed N+ Poly w/i Silicide 0.13um<=w<2um          *
//               rppolywo_dis   Distributed P+ Poly w/o Silicide w>1um,sqr>2            *
//               rnpolywo_dis   Distributed N+ Poly w/o Silicide w>1um,sqr>2            *
//               rppolyhri_dis  Distributed P- Poly w/o Silicide w>1um,sqr>2            *
//               rppolyl_dis_mis    Distributed P+ Poly w/i Silicide w>=2um
//               rppolys_dis_mis    Distributed P+ Poly w/i Silicide 0.13um<=w<2um
//               rnpolyl_dis_mis    Distributed N+ Poly w/i Silicide w>=2um
//               rnpolys_dis_mis    Distributed N+ Poly w/i Silicide 0.13um<=w<2um
//               rppolywo_dis_mis   Distributed P+ Poly w/o Silicide w>1um,sqr>2        *
//               rnpolywo_dis_mis   Distributed N+ Poly w/o Silicide w>1um,sqr>2        *
//               rppolyhri_dis_mis  Distributed P- Poly w/o Silicide w>1um,sqr>2        *
//  *************************************************************************************

section dis_res
subckt rppolyl_dis ( n1 n2 gnode )
parameters l=1u w=1u mf=1 rsh=disr_rppolyl dw=-0.035u ptc1=2.64e-03 ptc2=1.92e-06
+ pvc1=3.14e-03 pvc2=6.18e-03 pt=temp tfac=1.0 + ptc1 * (pt - 25.0) + ptc2 * (pt
+ - 25.0) * (pt - 25.0)
r1 ( n1 n2 ) bsource r=rsh / mf * l / (w - dw) * (1 + pvc1 * abs(v(n2,n1)) + pvc2
+ * v(n2,n1) * v(n2,n1)) * tfac
cox1 ( n1 gnode ) capacitor c=1 / 2 * (0.09677 * w * (l + 0.9u) * 1e+12 + 0.05582
+ * 2 * (w + l + 0.9u) * 1e+6 + 0.1) * 1e-15 * mf
cox2 ( n2 gnode ) capacitor c=1 / 2 * (0.09677 * w * (l + 0.9u) * 1e+12 + 0.05582
+ * 2 * (w + l + 0.9u) * 1e+6 + 0.1) * 1e-15 * mf

ends rppolyl_dis

subckt rppolys_dis ( n1 n2 gnode )
parameters l=1u w=1u mf=1 rsh=disr_rppolys dw=-0.035u ptc1=2.88e-03 ptc2=4.47e-07
+ pvc1=1.93e-04 pvc2=1.99e-03 pt=temp tfac=1.0 + ptc1 * (pt - 25.0) + ptc2 * (pt
+ - 25.0) * (pt - 25.0)
r1 ( n1 n2 ) bsource r=rsh / mf * l / (w - dw) * (1 + pvc1 * abs(v(n2,n1)) + pvc2
+ * v(n2,n1) * v(n2,n1)) * tfac
cox1 ( n1 gnode ) capacitor c=1 / 2 * (0.09677 * w * (l + 0.9u) * 1e+12 + 0.05582
+ * 2 * (w + l + 0.9u) * 1e+6 + 0.1) * 1e-15 * mf
cox2 ( n2 gnode ) capacitor c=1 / 2 * (0.09677 * w * (l + 0.9u) * 1e+12 + 0.05582
+ * 2 * (w + l + 0.9u) * 1e+6 + 0.1) * 1e-15 * mf
ends rppolys_dis

subckt rnpolyl_dis ( n1 n2 gnode )
parameters l=1u w=1u mf=1 rsh=disr_rnpolyl dw=-0.055u ptc1=2.77e-03 ptc2=1.51e-06
+ pvc1=3.37e-03 pvc2=6.34e-03 pt=temp tfac=1.0 + ptc1 * (pt - 25.0) + ptc2 * (pt
+ - 25.0) * (pt - 25.0)
r1 ( n1 n2 ) bsource r=rsh / mf * l / (w - dw) * (1 + pvc1 * abs(v(n2,n1)) + pvc2
+ * v(n2,n1) * v(n2,n1)) * tfac
cox1 ( n1 gnode ) capacitor c=1 / 2 * (0.09677 * w * (l + 0.9u) * 1e+12 + 0.05582
+ * 2 * (w + l + 0.9u) * 1e+6 + 0.1) * 1e-15 * mf
cox2 ( n2 gnode ) capacitor c=1 / 2 * (0.09677 * w * (l + 0.9u) * 1e+12 + 0.05582
+ * 2 * (w + l + 0.9u) * 1e+6 + 0.1) * 1e-15 * mf

ends rnpolyl_dis

subckt rnpolys_dis ( n1 n2 gnode )
parameters l=1u w=1u mf=1 rsh=disr_rnpolys dw=-0.055u ptc1=3.29e-03 ptc2=1.67e-07
+ pvc1=3.56e-04 pvc2=2.66e-03 pt=temp tfac=1.0 + ptc1 * (pt - 25.0) + ptc2 * (pt
+ - 25.0) * (pt - 25.0)
r1 ( n1 n2 ) bsource r=rsh / mf * l / (w - dw) * (1 + pvc1 * abs(v(n2,n1)) + pvc2
+ * v(n2,n1) * v(n2,n1)) * tfac
cox1 ( n1 gnode ) capacitor c=1 / 2 * (0.09677 * w * (l + 0.9u) * 1e+12 + 0.05582
+ * 2 * (w + l + 0.9u) * 1e+6 + 0.1) * 1e-15 * mf
cox2 ( n2 gnode ) capacitor c=1 / 2 * (0.09677 * w * (l + 0.9u) * 1e+12 + 0.05582
+ * 2 * (w + l + 0.9u) * 1e+6 + 0.1) * 1e-15 * mf
ends rnpolys_dis

subckt rnpolywo_dis ( n1 n2 gnode )
parameters l=1u w=1u mf=1 rend0=3.91e-05 rsh=disr_rnpolywo dl=0.02051u dw=0.07157u
+ pt=temp pvce1=9.19e-01 pvce2=1.86e+01 pvce3=-1.64e+00 ptce1=2.75e-04 ptce2=-4.10e-06
+ pvcp1=-2.73e-02 pvcp2=1.23e-05 pvcp3=-1.70e+00 ptcp1=-1.11e-03 ptcp2=1.51e-06
+ tface=1.0 + ptce1 * (pt - 25.0) + ptce2 * (pt - 25.0) * (pt - 25.0) tfacp=1.0
+ + ptcp1 * (pt - 25.0) + ptcp2 * (pt - 25.0) * (pt - 25.0)
rend1 ( n1 3 ) bsource r=rend0 / mf / (w - dw) * tface * (1 + pvce1 * (tanh(pvce2
+ * abs(v(n1,3)) + pvce3) - tanh(pvce3)))
rpure ( 3 4 ) bsource r=rsh / mf * (l - dl) / (w - dw) * tfacp * (1 + pvcp1 * (tanh(pvcp2
+ * abs(v(3,4) / (l - dl)) + pvcp3) - tanh(pvcp3)))
rend2 ( 4 n2 ) bsource r=rend0 / mf / (w - dw) * tface * (1 + pvce1 * (tanh(pvce2
+ * abs(v(4,n2)) + pvce3) - tanh(pvce3)))
cox1 ( 3 gnode ) capacitor c=1 / 2 * (0.09677 * w * (l + 0.9u) * 1e+12 + 0.05582
+ * 2 * (w + l + 0.9u) * 1e+6 + 0.1) * 1e-15 * mf
cox2 ( 4 gnode ) capacitor c=1 / 2 * (0.09677 * w * (l + 0.9u) * 1e+12 + 0.05582
+ * 2 * (w + l + 0.9u) * 1e+6 + 0.1) * 1e-15 * mf
ends rnpolywo_dis

subckt rppolywo_dis ( n1 n2 gnode )
parameters l=1u w=1u mf=1 rend0=1.01e-04 rsh=disr_rppolywo dl=0.04698u dw=0.07953u
+ pt=temp pvce1=-9.40e-02 pvce2=6.39e+01 pvce3=-2.71e+00 ptce1=-1.71e-03 ptce2=1.06e-06
+ pvcp1=-1.99e-01 pvcp2=6.05e-06 pvcp3=-3.23e+00 ptcp1=-1.19e-04 ptcp2=6.54e-07
+ tface=1.0 + ptce1 * (pt - 25.0) + ptce2 * (pt - 25.0) * (pt - 25.0) tfacp=1.0
+ + ptcp1 * (pt - 25.0) + ptcp2 * (pt - 25.0) * (pt - 25.0)
rend1 ( n1 3 ) bsource r=rend0 / mf / (w - dw) * tface * (1 + pvce1 * (tanh(pvce2
+ * abs(v(n1,3)) + pvce3) - tanh(pvce3)))
rpure ( 3 4 ) bsource r=rsh / mf * (l - dl) / (w - dw) * tfacp * (1 + pvcp1 * (tanh(pvcp2
+ * abs(v(3,4) / (l - dl)) + pvcp3) - tanh(pvcp3)))
rend2 ( 4 n2 ) bsource r=rend0 / mf / (w - dw) * tface * (1 + pvce1 * (tanh(pvce2
+ * abs(v(4,n2)) + pvce3) - tanh(pvce3)))
cox1 ( 3 gnode ) capacitor c=1 / 2 * (0.09677 * w * (l + 0.9u) * 1e+12 + 0.05582
+ * 2 * (w + l + 0.9u) * 1e+6 + 0.1) * 1e-15 * mf
cox2 ( 4 gnode ) capacitor c=1 / 2 * (0.09677 * w * (l + 0.9u) * 1e+12 + 0.05582
+ * 2 * (w + l + 0.9u) * 1e+6 + 0.1) * 1e-15 * mf
ends rppolywo_dis

subckt rppolyhri_dis ( n1 n2 gnode )
parameters l=1u w=1u mf=1 rend0=5.320e-05 rsh=disr_rppolyhri dl=0u dw=0.093u
+ pt=temp pvce1=0.5 pvce2=1.25 pvce3=-1.25 ptce1=-6.5e-04 ptce2=3.5e-08 pvcp1=-0.095
+ pvcp2=1.205e-06 pvcp3=-0.873 ptcp1=-7.670e-04 ptcp2=7.594e-07 tface=1.0 + ptce1
+ * (pt - 25.0) + ptce2 * (pt - 25.0) * (pt - 25.0) tfacp=1.0 + ptcp1 * (pt - 25.0)
+ + ptcp2 * (pt - 25.0) * (pt - 25.0)
rend1 ( n1 3 ) bsource r=rend0 / mf / (w - dw) * tface * (1 + pvce1 * (tanh(pvce2
+ * abs(v(n1,3)) + pvce3) - tanh(pvce3)))
rpure ( 3 4 ) bsource r=rsh / mf * (l - dl) / (w - dw) * tfacp * (1 + pvcp1 * (tanh(pvcp2
+ * abs(v(3,4) / (l - dl)) + pvcp3) - tanh(pvcp3)))
rend2 ( 4 n2 ) bsource r=rend0 / mf / (w - dw) * tface * (1 + pvce1 * (tanh(pvce2
+ * abs(v(4,n2)) + pvce3) - tanh(pvce3)))
cox1 ( 3 gnode ) capacitor c=1 / 2 * (0.09677 * w * (l + 0.9u) * 1e+12 + 0.05582
+ * 2 * (w + l + 0.9u) * 1e+6 + 0.1) * 1e-15 * mf
cox2 ( 4 gnode ) capacitor c=1 / 2 * (0.09677 * w * (l + 0.9u) * 1e+12 + 0.05582
+ * 2 * (w + l + 0.9u) * 1e+6 + 0.1) * 1e-15 * mf

ends rppolyhri_dis

//  ********************************
//        Mismatch   model         *
//  ********************************
subckt rppolyl_dis_mis ( n1 n2 gnode )
parameters l=1u w=1u mf=1 geo_fac=1 / sqrt(mf * l * w * 1e12) factmis=0.00871085
+ * geo_fac * par_disres rsh=disr_rppolyl * (1 + factmis) dw=-0.035u ptc1=2.64e-03
+ ptc2=1.92e-06 pvc1=3.14e-03 pvc2=6.18e-03 pt=temp tfac=1.0 + ptc1 * (pt - 25.0)
+ + ptc2 * (pt - 25.0) * (pt - 25.0)
r1 ( n1 n2 ) bsource r=rsh / mf * l / (w - dw) * (1 + pvc1 * abs(v(n2,n1)) + pvc2
+ * v(n2,n1) * v(n2,n1)) * tfac
cox1 ( n1 gnode ) capacitor c=1 / 2 * (0.09677 * w * (l + 0.9u) * 1e+12 + 0.05582
+ * 2 * (w + l + 0.9u) * 1e+6 + 0.1) * 1e-15 * mf
cox2 ( n2 gnode ) capacitor c=1 / 2 * (0.09677 * w * (l + 0.9u) * 1e+12 + 0.05582
+ * 2 * (w + l + 0.9u) * 1e+6 + 0.1) * 1e-15 * mf
ends rppolyl_dis_mis

subckt rppolys_dis_mis ( n1 n2 gnode )
parameters l=1u w=1u mf=1 geo_fac=1 / sqrt(mf * l * w * 1e12) factmis=0.00871085
+ * geo_fac * par_disres rsh=disr_rppolys * (1 + factmis) dw=-0.035u ptc1=2.88e-03
+ ptc2=4.47e-07 pvc1=1.93e-04 pvc2=1.99e-03 pt=temp tfac=1.0 + ptc1 * (pt - 25.0)
+ + ptc2 * (pt - 25.0) * (pt - 25.0)
r1 ( n1 n2 ) bsource r=rsh / mf * l / (w - dw) * (1 + pvc1 * abs(v(n2,n1)) + pvc2
+ * v(n2,n1) * v(n2,n1)) * tfac
cox1 ( n1 gnode ) capacitor c=1 / 2 * (0.09677 * w * (l + 0.9u) * 1e+12 + 0.05582
+ * 2 * (w + l + 0.9u) * 1e+6 + 0.1) * 1e-15 * mf
cox2 ( n2 gnode ) capacitor c=1 / 2 * (0.09677 * w * (l + 0.9u) * 1e+12 + 0.05582
+ * 2 * (w + l + 0.9u) * 1e+6 + 0.1) * 1e-15 * mf
ends rppolys_dis_mis

subckt rnpolyl_dis_mis ( n1 n2 gnode )
parameters l=1u w=1u mf=1 geo_fac=1 / sqrt(mf * l * w * 1e12) factmis=0.00919451 *
+ geo_fac * par_disres rsh=disr_rnpolyl * (1 + factmis) dw=-0.055u ptc1=2.77e-03
+ ptc2=1.51e-06 pvc1=3.37e-03 pvc2=6.34e-03 pt=temp tfac=1.0 + ptc1 * (pt - 25.0)
+ + ptc2 * (pt - 25.0) * (pt - 25.0)
r1 ( n1 n2 ) bsource r=rsh / mf * l / (w - dw) * (1 + pvc1 * abs(v(n2,n1)) + pvc2
+ * v(n2,n1) * v(n2,n1)) * tfac
cox1 ( n1 gnode ) capacitor c=1 / 2 * (0.09677 * w * (l + 0.9u) * 1e+12 + 0.05582
+ * 2 * (w + l + 0.9u) * 1e+6 + 0.1) * 1e-15 * mf
cox2 ( n2 gnode ) capacitor c=1 / 2 * (0.09677 * w * (l + 0.9u) * 1e+12 + 0.05582
+ * 2 * (w + l + 0.9u) * 1e+6 + 0.1) * 1e-15 * mf
ends rnpolyl_dis_mis

subckt rnpolys_dis_mis ( n1 n2 gnode )
parameters l=1u w=1u mf=1 geo_fac=1 / sqrt(mf * l * w * 1e12) factmis=0.00919451 *
+ geo_fac * par_disres rsh=disr_rnpolys * (1 + factmis) dw=-0.055u ptc1=3.29e-03
+ ptc2=1.67e-07 pvc1=3.56e-04 pvc2=2.66e-03 pt=temp tfac=1.0 + ptc1 * (pt - 25.0)
+ + ptc2 * (pt - 25.0) * (pt - 25.0)
r1 ( n1 n2 ) bsource r=rsh / mf * l / (w - dw) * (1 + pvc1 * abs(v(n2,n1)) + pvc2
+ * v(n2,n1) * v(n2,n1)) * tfac
cox1 ( n1 gnode ) capacitor c=1 / 2 * (0.09677 * w * (l + 0.9u) * 1e+12 + 0.05582
+ * 2 * (w + l + 0.9u) * 1e+6 + 0.1) * 1e-15 * mf
cox2 ( n2 gnode ) capacitor c=1 / 2 * (0.09677 * w * (l + 0.9u) * 1e+12 + 0.05582
+ * 2 * (w + l + 0.9u) * 1e+6 + 0.1) * 1e-15 * mf
ends rnpolys_dis_mis

subckt rnpolywo_dis_mis ( n1 n2 gnode )
parameters l=1u w=1u mf=1 geo_fac=1 / sqrt(mf * l * w * 1e12) factmis=0.02897 * geo_fac * par_disres
+ rend0=3.91e-05 * (1 + factmis) rsh=disr_rnpolywo * (1 + factmis) dl=0.02051u dw=0.07157u
+ pt=temp pvce1=9.19e-01 pvce2=1.86e+01 pvce3=-1.64e+00 ptce1=2.75e-04 ptce2=-4.10e-06
+ pvcp1=-2.73e-02 pvcp2=1.23e-05 pvcp3=-1.70e+00 ptcp1=-1.11e-03 ptcp2=1.51e-06
+ tface=1.0 + ptce1 * (pt - 25.0) + ptce2 * (pt - 25.0) * (pt - 25.0) tfacp=1.0
+ + ptcp1 * (pt - 25.0) + ptcp2 * (pt - 25.0) * (pt - 25.0)
rend1 ( n1 3 ) bsource r=rend0 / mf / (w - dw) * tface * (1 + pvce1 * (tanh(pvce2
+ * abs(v(n1,3)) + pvce3) - tanh(pvce3)))
rpure ( 3 4 ) bsource r=rsh / mf * (l - dl) / (w - dw) * tfacp * (1 + pvcp1 * (tanh(pvcp2
+ * abs(v(3,4) / (l - dl)) + pvcp3) - tanh(pvcp3)))
rend2 ( 4 n2 ) bsource r=rend0 / mf / (w - dw) * tface * (1 + pvce1 * (tanh(pvce2
+ * abs(v(4,n2)) + pvce3) - tanh(pvce3)))
cox1 ( 3 gnode ) capacitor c=1 / 2 * (0.09677 * w * (l + 0.9u) * 1e+12 + 0.05582
+ * 2 * (w + l + 0.9u) * 1e+6 + 0.1) * 1e-15 * mf
cox2 ( 4 gnode ) capacitor c=1 / 2 * (0.09677 * w * (l + 0.9u) * 1e+12 + 0.05582
+ * 2 * (w + l + 0.9u) * 1e+6 + 0.1) * 1e-15 * mf
ends rnpolywo_dis_mis

subckt rppolywo_dis_mis ( n1 n2 gnode )
parameters l=1u w=1u mf=1 geo_fac = 1 / sqrt(mf * l * w * 1e12) factmis=0.01456 * geo_fac * par_disres
+ rend0=1.01e-04 * (1 + factmis) rsh=disr_rppolywo * (1 + factmis) dl=0.04698u dw=0.07953u
+ pt=temp pvce1=-9.40e-02 pvce2=6.39e+01 pvce3=-2.71e+00 ptce1=-1.71e-03 ptce2=1.06e-06
+ pvcp1=-1.99e-01 pvcp2=6.05e-06 pvcp3=-3.23e+00 ptcp1=-1.19e-04 ptcp2=6.54e-07
+ tface=1.0 + ptce1 * (pt - 25.0) + ptce2 * (pt - 25.0) * (pt - 25.0) tfacp=1.0
+ + ptcp1 * (pt - 25.0) + ptcp2 * (pt - 25.0) * (pt - 25.0)
rend1 ( n1 3 ) bsource r=rend0 / mf / (w - dw) * tface * (1 + pvce1 * (tanh(pvce2
+ * abs(v(n1,3)) + pvce3) - tanh(pvce3)))
rpure ( 3 4 ) bsource r=rsh / mf * (l - dl) / (w - dw) * tfacp * (1 + pvcp1 * (tanh(pvcp2
+ * abs(v(3,4) / (l - dl)) + pvcp3) - tanh(pvcp3)))
rend2 ( 4 n2 ) bsource r=rend0 / mf / (w - dw) * tface * (1 + pvce1 * (tanh(pvce2
+ * abs(v(4,n2)) + pvce3) - tanh(pvce3)))
cox1 ( 3 gnode ) capacitor c=1 / 2 * (0.09677 * w * (l + 0.9u) * 1e+12 + 0.05582
+ * 2 * (w + l + 0.9u) * 1e+6 + 0.1) * 1e-15 * mf
cox2 ( 4 gnode ) capacitor c=1 / 2 * (0.09677 * w * (l + 0.9u) * 1e+12 + 0.05582
+ * 2 * (w + l + 0.9u) * 1e+6 + 0.1) * 1e-15 * mf
ends rppolywo_dis_mis

subckt rppolyhri_dis_mis ( n1 n2 gnode )
parameters l=1u w=1u mf=1 geo_fac =1 / sqrt(mf * l * w * 1e12) factmis=0.011823 * geo_fac * par_disres
+ rend0=5.320e-05 * (1 + factmis) rsh=disr_rppolyhri * (1 + factmis) dl=0u dw=0.093u
+ pt=temp pvce1=0.5 pvce2=1.25 pvce3=-1.25 ptce1=-6.5e-04 ptce2=3.5e-08 pvcp1=-0.095
+ pvcp2=1.205e-06 pvcp3=-0.873 ptcp1=-7.670e-04 ptcp2=7.594e-07 tface=1.0 + ptce1
+ * (pt - 25.0) + ptce2 * (pt - 25.0) * (pt - 25.0) tfacp=1.0 + ptcp1 * (pt - 25.0)
+ + ptcp2 * (pt - 25.0) * (pt - 25.0)
rend1 ( n1 3 ) bsource r=rend0 / mf / (w - dw) * tface * (1 + pvce1 * (tanh(pvce2
+ * abs(v(n1,3)) + pvce3) - tanh(pvce3)))
rpure ( 3 4 ) bsource r=rsh / mf * (l - dl) / (w - dw) * tfacp * (1 + pvcp1 * (tanh(pvcp2
+ * abs(v(3,4) / (l - dl)) + pvcp3) - tanh(pvcp3)))
rend2 ( 4 n2 ) bsource r=rend0 / mf / (w - dw) * tface * (1 + pvce1 * (tanh(pvce2
+ * abs(v(4,n2)) + pvce3) - tanh(pvce3)))
cox1 ( 3 gnode ) capacitor c=1 / 2 * (0.09677 * w * (l + 0.9u) * 1e+12 + 0.05582
+ * 2 * (w + l + 0.9u) * 1e+6 + 0.1) * 1e-15 * mf
cox2 ( 4 gnode ) capacitor c=1 / 2 * (0.09677 * w * (l + 0.9u) * 1e+12 + 0.05582
+ * 2 * (w + l + 0.9u) * 1e+6 + 0.1) * 1e-15 * mf

ends rppolyhri_dis_mis

endsection dis_res
endlibrary tsmclib
