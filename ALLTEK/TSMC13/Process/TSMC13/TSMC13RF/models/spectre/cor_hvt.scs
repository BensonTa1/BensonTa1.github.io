library hvt_cor

section ff_hvt
include "cr013g_2d5_v1d4.scs" section = ff_hvt
endsection ff_hvt

section fs_hvt
include "cr013g_2d5_v1d4.scs" section = fs_hvt
endsection fs_hvt

section sf_hvt
include "cr013g_2d5_v1d4.scs" section = sf_hvt
endsection sf_hvt

section ss_hvt
include "cr013g_2d5_v1d4.scs" section = ss_hvt
endsection ss_hvt

section tt_hvt
include "cr013g_2d5_v1d4.scs" section = tt_hvt
endsection tt_hvt

endlibrary hvt_cor
