library dio_hvt_cor

section ff_dio_hvt
include "cr013g_2d5_v1d4.scs" section = ff_dio_hvt
endsection ff_dio_hvt

section ss_dio_hvt
include "cr013g_2d5_v1d4.scs" section = ss_dio_hvt
endsection ss_dio_hvt

section tt_dio_hvt
include "cr013g_2d5_v1d4.scs" section = tt_dio_hvt
endsection tt_dio_hvt

endlibrary dio_hvt_cor
