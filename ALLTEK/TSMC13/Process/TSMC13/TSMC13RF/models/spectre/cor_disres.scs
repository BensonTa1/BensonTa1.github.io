library disres_cor

section ff_disres
include "ResModel.scs" section = ff_disres
endsection ff_disres

section ss_disres
include "ResModel.scs" section = ss_disres
endsection ss_disres

section tt_disres
include "ResModel.scs" section = tt_disres
endsection tt_disres

endlibrary disres_cor
