library hvt_g_cor

section ff_hvt_g
include "cr013g_2d5_v1d4.scs" section = ff_hvt_g
endsection ff_hvt_g

section fs_hvt_g
include "cr013g_2d5_v1d4.scs" section = fs_hvt_g
endsection fs_hvt_g

section sf_hvt_g
include "cr013g_2d5_v1d4.scs" section = sf_hvt_g
endsection sf_hvt_g

section ss_hvt_g
include "cr013g_2d5_v1d4.scs" section = ss_hvt_g
endsection ss_hvt_g

section tt_hvt_g
include "cr013g_2d5_v1d4.scs" section = tt_hvt_g
endsection tt_hvt_g

endlibrary hvt_g_cor
