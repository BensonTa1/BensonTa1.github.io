library uhvt_g_cor

section ff_uhvt_g
include "cr013g_2d5_v1d4.scs" section = ff_uhvt_g
endsection ff_uhvt_g

section fs_uhvt_g
include "cr013g_2d5_v1d4.scs" section = fs_uhvt_g
endsection fs_uhvt_g

section sf_uhvt_g
include "cr013g_2d5_v1d4.scs" section = sf_uhvt_g
endsection sf_uhvt_g

section ss_uhvt_g
include "cr013g_2d5_v1d4.scs" section = ss_uhvt_g
endsection ss_uhvt_g

section tt_uhvt_g
include "cr013g_2d5_v1d4.scs" section = tt_uhvt_g
endsection tt_uhvt_g

endlibrary uhvt_g_cor
