library dio_na_cor

section ff_dio_na
include "cr013g_2d5_v1d4.scs" section = ff_dio_na
endsection ff_dio_na

section ss_dio_na
include "cr013g_2d5_v1d4.scs" section = ss_dio_na
endsection ss_dio_na

section tt_dio_na
include "cr013g_2d5_v1d4.scs" section = tt_dio_na
endsection tt_dio_na

endlibrary dio_na_cor
