library 25_cor

section ff_25
include "cr013g_2d5_v1d4.scs" section = ff_25
endsection ff_25

section fs_25
include "cr013g_2d5_v1d4.scs" section = fs_25
endsection fs_25

section sf_25
include "cr013g_2d5_v1d4.scs" section = sf_25
endsection sf_25

section ss_25
include "cr013g_2d5_v1d4.scs" section = ss_25
endsection ss_25

section tt_25
include "cr013g_2d5_v1d4.scs" section = tt_25
endsection tt_25

endlibrary 25_cor
