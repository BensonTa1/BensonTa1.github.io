library rfmvar_25_cor

section ff_rfmvar_25
include "cr013g_2d5_v1d4.scs" section = ff_rfmvar_25
endsection ff_rfmvar_25

section ss_rfmvar_25
include "cr013g_2d5_v1d4.scs" section = ss_rfmvar_25
endsection ss_rfmvar_25

section tt_rfmvar_25
include "cr013g_2d5_v1d4.scs" section = tt_rfmvar_25
endsection tt_rfmvar_25

endlibrary rfmvar_25_cor
