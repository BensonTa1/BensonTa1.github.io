library dio_na25_cor

section ff_dio_na25
include "cr013g_2d5_v1d4.scs" section = ff_dio_na25
endsection ff_dio_na25

section ss_dio_na25
include "cr013g_2d5_v1d4.scs" section = ss_dio_na25
endsection ss_dio_na25

section tt_dio_na25
include "cr013g_2d5_v1d4.scs" section = tt_dio_na25
endsection tt_dio_na25

endlibrary dio_na25_cor
