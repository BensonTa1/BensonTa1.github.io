library dio_25_cor

section ff_dio_25
include "cr013g_2d5_v1d4.scs" section = ff_dio_25
endsection ff_dio_25

section ss_dio_25
include "cr013g_2d5_v1d4.scs" section = ss_dio_25
endsection ss_dio_25

section tt_dio_25
include "cr013g_2d5_v1d4.scs" section = tt_dio_25
endsection tt_dio_25

endlibrary dio_25_cor
