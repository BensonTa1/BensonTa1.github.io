library mos_cap_25_cor

section ff_mos_cap_25
include "cr013g_2d5_v1d4.scs" section = ff_mos_cap_25
endsection ff_mos_cap_25

section ss_mos_cap_25
include "cr013g_2d5_v1d4.scs" section = ss_mos_cap_25
endsection ss_mos_cap_25

section tt_mos_cap_25
include "cr013g_2d5_v1d4.scs" section = tt_mos_cap_25
endsection tt_mos_cap_25

endlibrary mos_cap_25_cor
