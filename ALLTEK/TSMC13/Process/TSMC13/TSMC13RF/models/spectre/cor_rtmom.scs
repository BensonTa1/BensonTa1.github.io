library rtmom_cor

section ff_rtmom
include "cr013g_2d5_v1d4.scs" section = ff_rtmom
endsection ff_rtmom

section ss_rtmom
include "cr013g_2d5_v1d4.scs" section = ss_rtmom
endsection ss_rtmom

section tt_rtmom
include "cr013g_2d5_v1d4.scs" section = tt_rtmom
endsection tt_rtmom

endlibrary rtmom_cor
