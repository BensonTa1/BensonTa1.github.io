//
//  **********************************************
simulator lang=spectre insensitive=yes
library tsmclib

// **********************************************
//             TSMC RF SPICE MODEL            *
// **********************************************
// This model has been modified for RF purpose.
//
//    PROCESS :  0.13um Mixed-Signal SALICIDE(1P8M, 1.2V/2.5V)
//    MODEL   :  BSIM3 ( V3.24 )
//    DOC. NO.:  T-013-MM-SP-001
//    VERSION :  1.4
//    DATE    :  April. 30, 2009
//    SPECTRE VERSION : 6.2.1.170
//
//*********************************************************************************************
//   UPDATE HISTORY :
//
//      V0.1Z: Created 1.2V/2.5V NMOS and MOS varactor models.
//
//      V0.1p2:
//           1. Created MIM capacitor models.
//           2. Created spiral inductor models.
//           3. Model for Mentor Graphic Eldo v5.4_1.1 and/or later version is added.
//
//      V0.1:   The same version as V0.1p2.
//
//      V0.2p1: Created 1.2V PMOS models.
//
//      V0.2p2:
//           1. Created 2.5V PMOS models.
//           2. Created 2.5V MOS varactor model.
//           3. Updated 1.2V MOS varactor model.
//           4. Created P+/Nwell junction varactor model.
//           5. Added ADS V1.5 model.
//           6. Added interconnect model.
//
//      V0.2:
//           1. Correct typo in the document:
//              a. Correct the number of branches(B) of 1.2V/2.5V MOS varactor form B=15 to B=30.
//              b. Correct Fig. 6.1 and Fig. 6.5 from schematic layout to real layout.
//              c. Correct Fig. 8.20 to Fig 8.27 for the updated MOS varactor.
//           2. Modified node names in the model card for consistancy with the layout:
//              a. Changed node names of "nd ng ns nb" to "D G S B" respectively in the subcuit 1.2V/2.5V N/P MOS.
//              b. Changed node names of "n1 n2" to "Gate Bulk" respectively in the subcircuit MOS varactor.
//              c. Changed node names of "p1 p2" to "Top Bottom" respectively in the subcircuit MIM and spiral inductors.
//              d. Changed node names of "p1 p2" to "Anode Cathode" respectively in the subcircuit junction varactor.
//           3. Simplified the model cards by including the library RF_MACRO in TT_RFMOS.
//           4. Added VCR and TCR of M8T in the interconnect resistor table.
//
//      V0.3:
//           a. Revised MIMCAP model.
//           b. Revised Inductor model.
//           c. Revised Interconnect model.
//
//      V1.0:
//           a. Updated MOS model
//           b. Updated MIM capacitor model.
//           c. Updated inductor model.
//           d. Updated MOS varactor model.
//           e. Updated Junction varactor model.
//           f. Add resistor model.
//           g. Updated interconnect model.
//
//      V1.1:
//           a. Updated spectre model card of MIM for convergency issue.
//              Updated MIM target and tightened corner.
//           b. Updated leakage current of 1.2V MOS Varactor
//           c. Updated corner model of 1.2V and 2.5V MOS Varactor.
//           d. Updated distributed resistor model
//           e. Added HRI resistor rf model
//
//      V1.2:
//	    a. Added 1.2 CMOS statistical model
//	    b. Revised 1.2 CMOS corner model
//	    c. Added 1.2 CMOS mismatch model
//	    d. Added Resistor mismatch model
//	    e. Added 1.2/2.5V PMOS model without DNW
// 	    f. Added 1.0fF MiM_Cap without underground metal and 1.5fF MiM_Cap wi/wo underground metal
//	    g. Added Center-tapped inductor
//	    h. Added Xj varactor without DNW
//	    i. Updated 1.2/2.5V MOS Varactor W/L/G/B 4D scalable model
//	    j. Added 1.2/2.5V MOS Varactor without DNW
//	    k. Updated interconnect model
//          l. Revised the MOS model format from subckt to inline subckt in SPECTRE
//          m. Rename the parameter "scale" to "scale1" to avoid using ".option nokwscale" in netlist in ELDO
//          n. Add ResModel.eldo in ELDO
//
//      V1.3:
//           a. Added 1.2V hvt, 1.2V lvt, 2.5V svt and 2.5V lvt CMOS mismatch model
//           b. Added RTMOM Baseband capacitor model
//           c. Added mismatch model of 1.0fF/um^2 and 1.5fF/um^2 MIM
//           d. updated 1.2V svt mismatch model from 3 wafer data to 3 lot data
//
//      V1.4p1: Correct the SPECTRE model card by adding the missed "stat_res" section for mismatch simuation of resistors
//
//      V1.4: (April. 30, 2009)
//           a. Update rmu corner values
//           b. Update BB based on cm013g_fsg v2.4 (Apr-03-08)
//           c. Update RFCMOS Lod equation about 'sax' and diodes 'AREA' and 'PJ' equations
//           d. Add schottky barrier diode model
//           e. Corner tighten of RF model (nmos_rf & nmos_rf25)
//           f. Modified the inductor equation in rf_jvar to avoid the negative inductance issue.
//           g. Adding flicker noise model for n+ & p+ poly w/o silicide and HRI resistor.
//           h. Updated the BJT model, aligning with current Design Rule to better reflect silicon.
//           i. Adding flicker noise model for 1.2 and 2.5V native devices
//           j. Gate current equation in Spectre format
//	     k. Remove guess statistical model(BB & RF)(wait for Si data validation)
//           l. Remove ADS model card version
//           m. Rename model card name rf013(1.2/2.5V 0.13um RF model card) as cr013g_2d5_v1d4
//
//*******************************************************************************************
//  THIS MODEL LIB CONTAINS RF MODEL                                                          *
//   A. RF model contains:                                                                  *
//                                                                                          *
//       1. 1.2V nominal Vt N/PMOS corner                                                   *
//                                                                                          *
//          a.LIB TT_RFMOS:Typical RF model                                                 *
//                                                                                          *
//          b.LIB FF_RFMOS:Fast N Fast P corner RF model                                    *
//                                                                                          *
//          c.LIB SS_RFMOS:Slow N Slow P corner RF model                                    *
//                                                                                          *
//          d.LIB SF_RFMOS:Slow N Fast P corner RF model                                    *
//                                                                                          *
//          e.LIB FS_RFMOS:Fast N Slow P corner RF model                                    *
//                                                                                          *
//       2. 2.5V nominal Vt N/PMOS corner                                                   *
//                                                                                          *
//          a.LIB TT_RFMOS25:Typical RF model                                               *
//                                                                                          *
//          b.LIB FF_RFMOS25:Fast N Fast P corner RF model                                  *
//                                                                                          *
//          c.LIB SS_RFMOS25:Slow N Slow P corner RF model                                  *
//                                                                                          *
//          d.LIB SF_RFMOS25:Slow N Fast P corner RF model                                  *
//                                                                                          *
//          e.LIB FS_RFMOS25:Fast N Slow P corner RF model                                  *
//                                                                                          *
//       3. MIM capacitor corner model                                                      *
//                                                                                          *
//          a.LIB TT_RFMIM:Typical model                                                    *
//                                                                                          *
//          b.LIB FF_RFMIM:Fast corner model                                                *
//                                                                                          *
//          c.LIB SS_RFMIM:Slow corner model                                                *
//                                                                                          *
//                                                                                          *
//       4. Inductor corner model                                                           *
//                                                                                          *
//          a.LIB TT_RFIND:Typical model                                                    *
//                                                                                          *
//          b.LIB FF_RFIND:Fast corner model                                                *
//                                                                                          *
//          c.LIB SS_RFIND:Slow corner model                                                *
//                                                                                          *
//                                                                                          *
//       5. 1.2V MOS varactor corner model                                                  *
//                                                                                          *
//          a.LIB TT_RFMVAR:Typical model                                                   *
//                                                                                          *
//          b.LIB FF_RFMVAR:Fast corner model                                               *
//                                                                                          *
//          c.LIB SS_RFMVAR:Slow corner model                                               *
//                                                                                          *
//                                                                                          *
//       6. 2.5V MOS varactor corner model                                                  *
//                                                                                          *
//          a.LIB TT_RFMVAR_25:Typical model                                                *
//                                                                                          *
//          b.LIB FF_RFMVAR_25:Fast corner model                                            *
//                                                                                          *
//          c.LIB SS_RFMVAR_25:Slow corner model                                            *
//                                                                                          *
//                                                                                          *
//       7. P+/NW Junction varactor corner model                                            *
//                                                                                          *
//          a.LIB TT_RFJVAR:Typical model                                                   *
//                                                                                          *
//          b.LIB FF_RFJVAR:Fast corner model                                               *
//                                                                                          *
//          c.LIB SS_RFJVAR:Slow corner model                                               *
//                                                                                          *
//                                                                                          *
//       8. Resistor corner model                                                           *
//                                                                                          *
//          i). Salicided poly resistor                                                     *
//                                                                                          *
//             (a).LIB TT_RFRES_SA:Typical model                                            *
//                                                                                          *
//             (b).LIB FF_RFRES_SA:Fast corner model                                        *
//                                                                                          *
//             (c).LIB SS_RFRES_SA:Slow corner model                                        *
//                                                                                          *
//          ii). Non-salicided P+ poly resistor                                             *
//                                                                                          *
//             (a).LIB TT_RFRES_RPO:Typical model                                           *
//                                                                                          *
//             (b).LIB FF_RFRES_RPO:Fast corner model                                       *
//                                                                                          *
//             (c).LIB SS_RFRES_RPO:Slow corner model                                       *
//                                                                                          *
//          iii). Non-salicided P- poly resistor                                            *
//                                                                                          *
//             (a).LIB TT_RFRES_HRI:Typical model                                           *
//                                                                                          *
//             (b).LIB FF_RFRES_HRI:Fast corner model                                       *
//                                                                                          *
//             (c).LIB SS_RFRES_HRI:Slow corner model                                       *
//                                                                                          *
//                                                                                          *
//      9. Distributed Resistor corner model                                                *
//                                                                                          *
//          a.LIB TT_DISRES:Typical model                                                   *
//                                                                                          *
//          b.LIB FF_DISRES:Fast corner model                                               *
//                                                                                          *
//          c.LIB SS_DISRES:Slow corner model                                               *
//                                                                                          *
//      10. Schottky barrier diode corner model                                             *
//                                                                                          *
//          a.LIB tt_rfsbd:Typical model                                                    *
//                                                                                          *
//          b.LIB ff_rfsbd:Fast corner model                                                *
//                                                                                          *
//          c.LIB ss_rfsbd:Slow corner model                                                *
//                                                                                          *
//          d.LIB mc_rfsbd:Monte-Carlo RF statistical model                                 *
//                                                                                          *
//*******************************************************************************************
//   **********************************************
//   *             TSMC SPICE MODEL               *
//   **********************************************
//
//     PROCESS :  0.13um MIXED SIGNAL SALICIDE FSG IMD (1P8M,1.2V/2.5V) (CM013G)
//     MODEL   :  BSIM3 ( V3.24 )
//     DOC. NO.:  T-013-CM-SP-005
//     VERSION :  2.4
//     DATE    :  April 3, 2008
//     SPECTRE VERSION : 6.2.1.170
//     (The most updated SPECTRE version is suggested for circuit simulation.)
//  ****************************************************************************
//
//        SPICE model release notes for HSPICE A-2008.03:
//
//
//  (1) 1.2V Standard Vt, 1.2V Low Vt, 1.2V High Vt, 1.2V Ultra High Vt and 2.5V devices
//      include Noise and LOD effect.
//
//  (2) Native devices are without LOD effect.
//
//  (3) For BSIM3 model, CALCACM is used in HSPICE A-2008.03.  For CALCACM >0,  the
//      default calculation of AS/AD and PS/PD will be calculated using HDIF.
//      When CALCACM=0, the default is zero for AS/AD and PS/PD.
//
//  ****************************************************************************
//                                                                             *
//        IN THIS MODEL LIB CONTAINS :                                         *
//                                                                             *
//        1.LIB TT                                                             *
//              SS                                                             *
//              FF                                                             *
//              SF                                                             *
//              FS                                                             *
//    ( 1.2V Standard devices with different geometric and corner models)      *
//                                                                             *
//        2.LIB TT_g                                                           *
//              SS_g                                                           *
//              FF_g                                                           *
//              SF_g                                                           *
//              FS_g                                                           *
//    ( 1.2V Standard Vt devices with gate current models)                     *
//                                                                             *
//        3.LIB TT_25                                                          *
//              SS_25                                                          *
//              FF_25                                                          *
//              SF_25                                                          *
//              FS_25                                                          *
//    ( 2.5V Standard devices with different geometric and corner models)      *
//                                                                             *
//        4.LIB TT_na                                                          *
//              SS_na                                                          *
//              FF_na                                                          *
//    ( 1.2V Native devices with different geometric and corner models)        *
//                                                                             *
//        5.LIB TT_na_g                                                        *
//              SS_na_g                                                        *
//              FF_na_g                                                        *
//    ( 1.2V Native devices with gate current models)                          *
//                                                                             *
//        6.LIB TT_lvt                                                         *
//              SS_lvt                                                         *
//              FF_lvt                                                         *
//              SF_lvt                                                         *
//              FS_lvt                                                         *
//    ( 1.2V Low Vt devices with different geometric and corner models)        *
//                                                                             *
//        7.LIB TT_lvt_g                                                       *
//              SS_lvt_g                                                       *
//              FF_lvt_g                                                       *
//              SF_lvt_g                                                       *
//              FS_lvt_g                                                       *
//    ( 1.2V Low Vt devices with gate current models)                          *
//                                                                             *
//        8.LIB TT_lvt25                                                       *
//              SS_lvt25                                                       *
//              FF_lvt25                                                       *
//              SF_lvt25                                                       *
//              FS_lvt25                                                       *
//    ( 2.5V Low Vt devices with different geometric and corner models)        *
//                                                                             *
//        9.LIB TT_hvt                                                         *
//              SS_hvt                                                         *
//              FF_hvt                                                         *
//              SF_hvt                                                         *
//              FS_hvt                                                         *
//    ( 1.2V High Vt devices with different geometric and corner models)       *
//                                                                             *
//       10.LIB TT_hvt_g                                                       *
//              SS_hvt_g                                                       *
//              FF_hvt_g                                                       *
//              SF_hvt_g                                                       *
//              FS_hvt_g                                                       *
//    ( 1.2V High Vt devices with gate current models)                         *
//                                                                             *
//       11.LIB TT_uhvt                                                        *
//              SS_uhvt                                                        *
//              FF_uhvt                                                        *
//              SF_uhvt                                                        *
//              FS_uhvt                                                        *
//    ( 1.2V Ultra High Vt devices with different geometric and corner models) *
//                                                                             *
//       12.LIB TT_uhvt_g                                                      *
//              SS_uhvt_g                                                      *
//              FF_uhvt_g                                                      *
//              SF_uhvt_g                                                      *
//              FS_uhvt_g                                                      *
//    ( 1.2V ULtra High Vt devices with gate current models)                   *
//                                                                             *
//       13.LIB TT_na25                                                        *
//              SS_na25                                                        *
//              FF_na25                                                        *
//                                                                             *
//         ( 2.5V Native nMOS devices )                                        *
//                                                                             *
//       14.LIB TT_BIP                                                         *
//              SS_BIP                                                         *
//              FF_BIP                                                         *
//         ( P+/NW/PSUB 10x10,5x5 and 2x2 vertical PNP bipolar )               *
//                                                                             *
//       15.LIB TT_BIP_NPN                                                     *
//              SS_BIP_NPN                                                     *
//              FF_BIP_NPN                                                     *
//         ( N+/PW/PSUB 10x10,5x5 and 2x2 vertical NPN bipolar )               *
//                                                                             *
//       16.LIB TT_DIO                                                         *
//          LIB SS_DIO                                                         *
//          LIB FF_DIO                                                         *
//         ( 1.2V P+/NW ,N+/PW & NW/PSUB diode )                               *
//                                                                             *
//       17.LIB TT_DIO_DNW                                                     *
//          LIB SS_DIO_DNW                                                     *
//          LIB FF_DIO_DNW                                                     *
//          ( DNWPSUB & PWDNW diode )                                          *
//                                                                             *
//       18.LIB TT_DIO_hvt                                                     *
//          LIB SS_DIO_hvt                                                     *
//          LIB FF_DIO_hvt                                                     *
//         ( 1.2V High Vt P+/NW, N+/PW, and NW/PSUB diode )                    *
//                                                                             *
//       19.LIB TT_DIO_uhvt                                                    *
//          LIB SS_DIO_uhvt                                                    *
//          LIB FF_DIO_uhvt                                                    *
//         ( 1.2V Ultra High Vt P+/NW, N+/PW, and NW/PSUB diode )              *
//                                                                             *
//       20.LIB TT_DIO_na                                                      *
//          LIB SS_DIO_na                                                      *
//          LIB FF_DIO_na                                                      *
//         ( 1.2V Native N+/PW diode )                                         *
//                                                                             *
//       21.LIB TT_DIO_25                                                      *
//          LIB SS_DIO_25                                                      *
//          LIB FF_DIO_25                                                      *
//         ( 2.5V P+/NW, and N+/PW diode )                                     *
//                                                                             *
//       22.LIB TT_DIO_lvt                                                     *
//          LIB SS_DIO_lvt                                                     *
//          LIB FF_DIO_lvt                                                     *
//           ( 1.2V Low Vt P+/NW, N+/PW diode )                                *
//                                                                             *
//       23.LIB TT_DIO_lvt25                                                   *
//          LIB SS_DIO_lvt25                                                   *
//          LIB FF_DIO_lvt25                                                   *
//         ( 2.5V LVT P+/NW, and N+/PW diode )                                 *
//                                                                             *
//       24.LIB TT_DIO_na25                                                    *
//          LIB SS_DIO_na25                                                    *
//          LIB FF_DIO_na25                                                    *
//          ( 2.5V Native N+/PW diode )                                        *
//                                                                             *
//       25.LIB TT_RES                                                         *
//              SS_RES                                                         *
//              FF_RES                                                         *
//         (resist model)                                                      *
//                                                                             *
//       26.LIB TT_MOS_CAP                                                     *
//              SS_MOS_CAP                                                     *
//              FF_MOS_CAP                                                     *
//                                                                             *
//       27.LIB TT_MOS_CAP_25                                                  *
//              SS_MOS_CAP_25                                                  *
//              FF_MOS_CAP_25                                                  *
//                                                                             *
//       28.LIB TT_MIM                                                         *
//              SS_MIM                                                         *
//              FF_MIM                                                         *
//         ( MIM CAPACITOR model)                                              *
//                                                                             *
//       29.LIB TT_RTMOM                                                       *
//             SS_RTMOM                                                        *
//             FF_RTMOM                                                        *
//        (RTMOM capacitor model)                                              *
//                                                                             *
//  ****************************************************************************
//  ****************************************************************************
//                                                                             *
//  1)To use these models directly by programming in this style:               *
//                                                                             *
//      .lib 'lib_path/lib_name' model_name                                    *
//                                                                             *
//                                                                             *
//     EX: .lib '/home/user/tsmc/LOGIC/cm013g_fsg.scs' TT                      *
//         for typical 1.2V N,PMOS                                             *
//         .lib '/home/user/tsmc/LOGIC/cm013g_fsg.scs' TT_25                   *
//         for typical 2.5V N,PMOS                                             *
//         .lib '/home/user/tsmc/LOGIC/cm013g_fsg.scs' TT_hvt                  *
//         for typical 1.2V high Vt N,PMOS                                     *
//         .lib '/home/user/tsmc/LOGIC/cm013g_fsg.scs' TT_hvt_g                *
//         for typical 1.2V high Vt N,PMOS with gate current model             *
//         .lib '/home/user/tsmc/LOGIC/cm013g_fsg.scs' TT_uhvt                 *
//         for typical 1.2V ultra high Vt N,PMOS                               *
//         .lib '/home/user/tsmc/LOGIC/cm013g_fsg.scs' TT_uhvt_g               *
//         for typical 1.2V ultra high Vt N,PMOS with gate current model       *
//                                                                             *
//   note:                                                                     *
//       corner_name                                                           *
//        TT : typical model for 1.2V devices                                  *
//        SS : Slow NMOS Slow PMOS model for 1.2V devices                      *
//        FF : Fast NMOS Fast PMOS model for 1.2V devices                      *
//        SF : Slow NMOS Fast PMOS model for 1.2V devices                      *
//        FS : Fast NMOS Slow PMOS model for 1.2V devices                      *
//                                                                             *
//       corner_name                                                           *
//        TT_g : typical MOS with gate current for 1.2V devices                *
//        SS_g : Slow NMOS Slow PMOS model with gate current for 1.2V devices  *
//        FF_g : Fast NMOS Fast PMOS model with gate current for 1.2V devices  *
//        SF_g : Slow NMOS Fast PMOS model with gate current for 1.2V devices  *
//        FS_g : Fast NMOS Slow PMOS model with gate current for 1.2V devices  *
//                                                                             *
//       corner_name                                                           *
//        TT_25 : typical model for 2.5V devices                               *
//        SS_25 : Slow NMOS Slow PMOS model for 2.5V devices                   *
//        FF_25 : Fast NMOS Fast PMOS model for 2.5V devices                   *
//        SF_25 : Slow NMOS Fast PMOS model for 2.5V devices                   *
//        FS_25 : Fast NMOS Slow PMOS model for 2.5V devices                   *
//                                                                             *
//       corner_name                                                           *
//        TT_na : typical model for 1.2V  native nmos devices                  *
//        SS_na : Slow NMOS Slow PMOS model for 1.2V native nmos devices       *
//        FF_na : Fast NMOS Fast PMOS model for 1.2V native nmos devices       *
//                                                                             *
//       corner_name                                                           *
//        TT_lvt : typical model for 1.2V low Vt devices                       *
//        SS_lvt : Slow NMOS Slow PMOS model for 1.2V low Vt devices           *
//        FF_lvt : Fast NMOS Fast PMOS model for 1.2V low Vt devices           *
//        SF_lvt : Slow NMOS Fast PMOS model for 1.2V low Vt devices           *
//        FS_lvt : Fast NMOS Slow PMOS model for 1.2V low Vt devices           *
//                                                                             *
//       corner_name                                                           *
//        TT_lvt_g : typical MOS with gate current for 1.2V low Vt devices     *
//        SS_lvt_g : Slow NMOS Slow PMOS model with gate current for 1.2V low Vt devices
//        FF_lvt_g : Fast NMOS Fast PMOS model with gate current for 1.2V low Vt devices
//        SF_lvt_g : Slow NMOS Fast PMOS model with gate current for 1.2V low Vt devices
//        FS_lvt_g : Fast NMOS Slow PMOS model with gate current for 1.2V low Vt devices
//                                                                             *
//       corner_name                                                           *
//        TT_lvt25 : typical model for 2.5V LVT devices                        *
//        SS_lvt25 : Slow NMOS Slow PMOS model for 2.5V LVT devices            *
//        FF_lvt25 : Fast NMOS Fast PMOS model for 2.5V LVT devices            *
//        SF_lvt25 : Slow NMOS Fast PMOS model for 2.5V LVT devices            *
//        FS_lvt25 : Fast NMOS Slow PMOS model for 2.5V LVT devices            *
//                                                                             *
//       corner_name                                                           *
//        TT_hvt : typical model for 1.2V high Vt devices                      *
//        SS_hvt : Slow NMOS Slow PMOS model for 1.2V high Vt devices          *
//        FF_hvt : Fast NMOS Fast PMOS model for 1.2V high Vt devices          *
//        SF_hvt : Slow NMOS Fast PMOS model for 1.2V high Vt devices          *
//        FS_hvt : Fast NMOS Slow PMOS model for 1.2V high Vt devices          *
//                                                                             *
//       corner_name                                                           *
//        TT_hvt_g : typical MOS with gate current for 1.2V high Vt devices    *
//        SS_hvt_g : Slow NMOS Slow PMOS model with gate current for 1.2V high Vt devices
//        FF_hvt_g : Fast NMOS Fast PMOS model with gate current for 1.2V high Vt devices
//        SF_hvt_g : Slow NMOS Fast PMOS model with gate current for 1.2V high Vt devices
//        FS_hvt_g : Fast NMOS Slow PMOS model with gate current for 1.2V high Vt devices
//                                                                             *
//       corner_name                                                           *
//        TT_uhvt : typical model for 1.2V ultra high Vt devices               *
//        SS_uhvt : Slow NMOS Slow PMOS model for 1.2V ultra high Vt devices   *
//        FF_uhvt : Fast NMOS Fast PMOS model for 1.2V ultra high Vt devices   *
//        SF_uhvt : Slow NMOS Fast PMOS model for 1.2V ultra high Vt devices   *
//        FS_uhvt : Fast NMOS Slow PMOS model for 1.2V ultra high Vt devices   *
//                                                                             *
//       corner_name                                                           *
//        TT_uhvt_g : typical MOS with gate current for 1.2V ultra high Vt devices
//        SS_uhvt_g : Slow NMOS Slow PMOS model with gate current for 1.2V ultra high Vt devices
//        FF_uhvt_g : Fast NMOS Fast PMOS model with gate current for 1.2V ultra high Vt devices
//        SF_uhvt_g : Slow NMOS Fast PMOS model with gate current for 1.2V ultra high Vt devices
//        FS_uhvt_g : Fast NMOS Slow PMOS model with gate current for 1.2V ultra high Vt devices
//                                                                             *
//       corner_name                                                           *
//        TT_na25 : typical model for 2.5V  native nmos devices                *
//        SS_na25 : Slow NMOS Slow PMOS model for 2.5V native nmos devices     *
//        FF_na25 : Fast NMOS Fast PMOS model for 2.5V native nmos devices     *
//                                                                             *
//  2)HDIF depends on your layout poly spacer to contact center distance.      *
//    The value listed here is TSMC minimum-rule value. You can change it      *
//    according to your layout.                                                *
//                                                                             *
//  3)To use the gate current model, please follow the convention given below: *
//    xmn1 D G S B nch_g W=x L=x AD=x AS=x PD=x PS=x NRD=x NRS=x M=x SCALE=x   *
//    xmp1 D G S B pch_g W=x L=x AD=x AS=x PD=x PS=x NRD=x NRS=x M=x SCALE=x   *
//  note:                                                                      *
//    (a) The usage of this macro model is the same as a regular MOS model.    *
//    (b) Please make sure the value of 'SCALE' is given properly (default=1). *
//        The value must be consistent with the value defined in .option SCALE.*
//    (c) The S/D sharing selector is not available in the gate current model. *
// 4)XPART Guideline :							          *
//   a.In TSMC BSIM models, XPART is set to 1 (0/100 partition) in logic          *
//     models to avoid non-convergence issue when simulating logic circuits       *
//     which tend to be of large size; and XPART is set to 0 (40/60 partition)    *
//     in RF modelsto preserve analog accuracy.				          *
//   b.In BSIM capacitance models, paramter XPART describes how channel charge    *
//     is partitioned between the source and the drain such that the associated   *
//     capacitance models can be derived accordingly. The best agreement was      *
//     obtained with a partition of 60% of the inversion charge to the source     *
//     and 40% to the drain (XPART=0 (40/60)). But unfortunately, sometimes this  *
//     setting can cause numerical difficulty during a SPICE simulation.          *
//   c.Generally speaking, digital circuits benefit from XPART = 1 (0/100) more   *
//     and analog circuits benefit from XPART = 0 (40/60) more. Both of them      *
//     only have some differences on ring speed for L>1.2um devices (< 2.5%).     *
//     CV simulation curve won't be effect by XPART.		  	          *
//  note:                                                                         *
//     For RF regime, XPART = 0 (40/60) is better for working freq < Device fT    *
//     and XPART = 1 (0/100) is better for working freq > Device fT               *
//*********************************************************************************
//

section stat_rfmos
statistics {
    mismatch {
        vary parnrf1 dist=gauss std=1/1
        vary parnrf2 dist=gauss std=1/1
        vary parprf1 dist=gauss std=1/1
        vary parprf2 dist=gauss std=1/1
        }
    }
endsection stat_rfmos

section stat_rfmos25
statistics {
    mismatch {
        vary parnrf1_25 dist=gauss std=1/1
        vary parnrf2_25 dist=gauss std=1/1
        vary parprf1_25 dist=gauss std=1/1
        vary parprf2_25 dist=gauss std=1/1
        }
    }
endsection stat_rfmos25

section stat_rfmim
statistics {
    mismatch {
        vary par_rfmim dist=gauss std=1/1
        }
    }
endsection stat_rfmim

section stat_rfres_sa
statistics {
    mismatch {
        vary par_sarf dist=gauss std=1/1
        }
    }
endsection stat_rfres_sa

section stat_rfres_rpo
statistics {
    mismatch {
        vary par_rporf dist=gauss std=1/1
        }
    }
endsection stat_rfres_rpo

section stat_rfres_hri
statistics {
    mismatch {
        vary par_hrirf dist=gauss std=1/1
        }
    }
endsection stat_rfres_hri

section stat_mim
statistics {
    mismatch {
        vary par_mim dist=gauss std=1/1
        }
    }
endsection stat_mim

section stat_res
statistics {
    mismatch {
        vary par_res dist=gauss std=1/1
        }
    }
endsection stat_res

section stat
statistics {
    mismatch {
        vary parn1 dist=gauss std=1/1
        vary parn2 dist=gauss std=1/1
        vary parp1 dist=gauss std=1/1
        vary parp2 dist=gauss std=1/1
        }
 }

endsection stat

section stat_hvt
statistics {
    mismatch {
        vary parn1_hvt dist=gauss std=1/1
        vary parn2_hvt dist=gauss std=1/1
        vary parp1_hvt dist=gauss std=1/1
        vary parp2_hvt dist=gauss std=1/1
        }
    }
endsection stat_hvt

section stat_lvt
statistics {
    mismatch {
        vary parn1_lvt dist=gauss std=1/1
        vary parn2_lvt dist=gauss std=1/1
        vary parp1_lvt dist=gauss std=1/1
        vary parp2_lvt dist=gauss std=1/1
        }
 }
endsection stat_lvt

section stat_25
statistics {
    mismatch {
        vary parn1_25 dist=gauss std=1/1
        vary parn2_25 dist=gauss std=1/1
        vary parp1_25 dist=gauss std=1/1
        vary parp2_25 dist=gauss std=1/1
        }
 }
endsection stat_25

//********************************************************
//*********    1.2V N/PMOS Corner Parameters   ***********
//********************************************************

section tt_rfmos
parameters parnrf1=0
parameters parnrf2=0
parameters parprf1=0
parameters parprf2=0
parameters toxnrf=2.810e-09
parameters dxlrf=0
parameters dxwrf=0
parameters cjnrf=1.3360e-03
parameters cjswnrf=3.2800e-11
parameters cjswgnrf=3.8350e-10
parameters cgonrf=2.6000e-10
parameters rshnrf=6.6
parameters hdifnrf=1.35e-07
parameters cglnrf=8.0e-11
parameters dvthnrf=0
parameters dwvthnrf=0
parameters dlvthnrf=0
parameters dpvthnrf=0
parameters dlvsatnrf=0
parameters dpvsatnrf=0
parameters dppclmnrf=0
parameters dk2nrf=0
parameters dlk2nrf=0
parameters toxprf=2.850e-09
parameters cjprf=1.3210e-03
parameters cjswprf=4.7750e-11
parameters cjswgprf=4.0780e-10
parameters cgoprf=1.2700e-10
parameters rshprf=7.2
parameters hdifprf=1.35e-07
parameters cglprf=3.1000e-10
parameters dvthprf=0
parameters dlvthprf=0
parameters dwvthprf=0
parameters dpvthprf=0
parameters dlvsatprf=0
parameters dpvsatprf=0
parameters dk2prf=0
parameters dlk2prf=0
include "cr013g_2d5_v1d4.scs" section=rf_mos
endsection tt_rfmos

section ss_rfmos
parameters parnrf1=0
parameters parnrf2=0
parameters parprf1=0
parameters parprf2=0
parameters toxnrf=2.829e-09
parameters dxlrf=3.14e-09
parameters dxwrf=-1.00e-08
parameters cjnrf=1.4028e-03
parameters cjswnrf=3.6080e-11
parameters cjswgnrf=4.2185e-10
parameters cgonrf=2.4629e-10
parameters rshnrf=6.6
parameters hdifnrf=1.35e-07
parameters cglnrf=7.5782e-11
parameters dvthnrf=2.10e-02
parameters dwvthnrf=3.65e-09
parameters dlvthnrf=2.42e-09
parameters dpvthnrf=2.18e-16
parameters dlvsatnrf=-1.00e-04
parameters dpvsatnrf=-9.00e-11
parameters dppclmnrf=0
parameters dk2nrf=0.005
parameters dlk2nrf=2.0e-9
parameters toxprf=2.869e-09
parameters cjprf=1.3870e-03
parameters cjswprf=5.2525e-11
parameters cjswgprf=4.4858e-10
parameters cgoprf=1.1995e-10
parameters rshprf=7.2
parameters hdifprf=1.35e-07
parameters cglprf=2.9279e-10
parameters dvthprf=-2.06e-02
parameters dlvthprf=-2.50e-09
parameters dwvthprf=-4.10e-09
parameters dpvthprf=-1.70e-16
parameters dlvsatprf=-2.0e-04
parameters dpvsatprf=9.00e-11
parameters dk2prf=0.01
parameters dlk2prf=1.0e-9
include "cr013g_2d5_v1d4.scs" section=rf_mos
endsection ss_rfmos

section ff_rfmos
parameters parnrf1=0
parameters parnrf2=0
parameters parprf1=0
parameters parprf2=0
parameters toxnrf=2.791e-09
parameters dxlrf=-3.14e-09
parameters dxwrf=5.09e-09
parameters cjnrf=1.2692e-03
parameters cjswnrf=2.9520e-11
parameters cjswgnrf=3.4515e-10
parameters cgonrf=2.7371e-10
parameters rshnrf=6.6
parameters hdifnrf=1.35e-07
parameters cglnrf=8.4218e-11
parameters dvthnrf=-2.16e-02
parameters dwvthnrf=-3.75e-09
parameters dlvthnrf=-2.30e-09
parameters dpvthnrf=-2.20e-16
parameters dlvsatnrf=0.00e+00
parameters dpvsatnrf=9.00e-11
parameters dppclmnrf=0
parameters dk2nrf=-0.005
parameters dlk2nrf=-2.0e-9
parameters toxprf=2.831e-09
parameters cjprf=1.2550e-03
parameters cjswprf=4.2975e-11
parameters cjswgprf=3.6702e-10
parameters cgoprf=1.3399e-10
parameters rshprf=7.2
parameters hdifprf=1.35e-07
parameters cglprf=3.2707e-10
parameters dvthprf=2.11e-02
parameters dlvthprf=2.35e-09
parameters dwvthprf=4.43e-09
parameters dpvthprf=1.78e-16
parameters dlvsatprf=-1.50e-04
parameters dpvsatprf=-2.0e-11
parameters dk2prf=-0.01
parameters dlk2prf=-1.0e-9
include "cr013g_2d5_v1d4.scs" section=rf_mos
endsection ff_rfmos

section sf_rfmos
parameters parnrf1=0
parameters parnrf2=0
parameters parprf1=0
parameters parprf2=0
parameters toxnrf=2.810e-09
parameters dxlrf=0
parameters dxwrf=0
parameters cjnrf=1.4028e-03
parameters cjswnrf=3.6080e-11
parameters cjswgnrf=4.2185e-10
parameters cgonrf=2.6000e-10
parameters rshnrf=6.6
parameters hdifnrf=1.35e-07
parameters cglnrf=8.0e-11
parameters dvthnrf=2.15e-02
parameters dwvthnrf=3.31e-09
parameters dlvthnrf=2.27e-09
parameters dpvthnrf=2.34e-16
parameters dlvsatnrf=0
parameters dpvsatnrf=0
parameters dppclmnrf=0
parameters dk2nrf=0.005
parameters dlk2nrf=2.0e-9
parameters toxprf=2.850e-09
parameters cjprf=1.2550e-03
parameters cjswprf=4.2975e-11
parameters cjswgprf=3.6702e-10
parameters cgoprf=1.2700e-10
parameters rshprf=7.2
parameters hdifprf=1.35e-07
parameters cglprf=3.1000e-10
parameters dvthprf=2.18e-02
parameters dlvthprf=2.20e-09
parameters dwvthprf=4.19e-09
parameters dpvthprf=1.90e-16
parameters dlvsatprf=0
parameters dpvsatprf=0
parameters dk2prf=-0.01
parameters dlk2prf=-1.0e-9
include "cr013g_2d5_v1d4.scs" section=rf_mos
endsection sf_rfmos

section fs_rfmos
parameters parnrf1=0
parameters parnrf2=0
parameters parprf1=0
parameters parprf2=0
parameters toxnrf=2.810e-09
parameters dxlrf=0
parameters dxwrf=0
parameters cjnrf=1.2692e-03
parameters cjswnrf=2.9520e-11
parameters cjswgnrf=3.4515e-10
parameters cgonrf=2.6000e-10
parameters rshnrf=6.6
parameters hdifnrf=1.35e-07
parameters cglnrf=8.0e-11
parameters dvthnrf=-2.20e-02
parameters dwvthnrf=-3.31e-09
parameters dlvthnrf=-2.27e-09
parameters dpvthnrf=-2.35e-16
parameters dlvsatnrf=0
parameters dpvsatnrf=0
parameters dppclmnrf=0
parameters dk2nrf=-0.005
parameters dlk2nrf=-2.0e-9
parameters toxprf=2.850e-09
parameters cjprf=1.3870e-03
parameters cjswprf=5.2525e-11
parameters cjswgprf=4.4858e-10
parameters cgoprf=1.2700e-10
parameters rshprf=7.2
parameters hdifprf=1.35e-07
parameters cglprf=3.1000e-10
parameters dvthprf=-2.15e-02
parameters dlvthprf=-2.20e-09
parameters dwvthprf=-4.19e-09
parameters dpvthprf=-1.91e-16
parameters dlvsatprf=0
parameters dpvsatprf=0
parameters dk2prf=0.01
parameters dlk2prf=1.0e-9
include "cr013g_2d5_v1d4.scs" section=rf_mos
endsection fs_rfmos

// *****************************    LIBRARY OF TYPICAL CASE    ******************************

section tt_rfmos25
parameters parnrf1_25=0
parameters parnrf2_25=0
parameters parprf1_25=0
parameters parprf2_25=0
parameters toxnrf_25=5.83e-09
parameters dxlrf_25=0
parameters dxwrf_25=0
parameters dvthnrf_25=0
parameters dlvthnrf_25=0
parameters dwvthnrf_25=0
parameters dpvthnrf_25=0
parameters dlvsatnrf_25=0
parameters cjnrf_25=9.680e-04
parameters cjswnrf_25=2.4500e-11
parameters cjswgnrf_25=1.704e-10
parameters cgonrf_25=1.99e-10
parameters hdifnrf_25=1.35e-07
parameters cglnrf_25=1.42e-10
parameters dk2nrf_25=0
parameters dlk2nrf_25=0
parameters toxprf_25=5.87e-09
parameters dvthprf_25=0
parameters dlvthprf_25=0
parameters dwvthprf_25=0
parameters dpvthprf_25=0
parameters dlvsatprf_25=0
parameters cjprf_25=1.184e-03
parameters cjswprf_25=3.0610e-11
parameters cjswgprf_25=2.0210e-10
parameters cgoprf_25=1.050e-10
parameters hdifprf_25=1.35e-07
parameters cglprf_25=2.0e-10
parameters dk2prf_25=0
parameters dlk2prf_25=0
include "cr013g_2d5_v1d4.scs" section=rf_mos25

endsection tt_rfmos25

// *****************************  LIBRARY OF SNSP CORNER CASE  ******************************

section ss_rfmos25
parameters parnrf1_25=0
parameters parnrf2_25=0
parameters parprf1_25=0
parameters parprf2_25=0
parameters toxnrf_25=5.98e-09
parameters dxlrf_25=7.000e-09
parameters dxwrf_25=-7.000e-09
parameters dvthnrf_25=2.82e-02
parameters dlvthnrf_25=7.13e-09
parameters dwvthnrf_25=1.51e-09
parameters dpvthnrf_25=1.50e-16
parameters dlvsatnrf_25=0
parameters cjnrf_25=1.016e-03
parameters cjswnrf_25=2.5725e-11
parameters cjswgnrf_25=1.7895e-10
parameters cgonrf_25=1.8908e-10
parameters hdifnrf_25=1.35e-07
parameters cglnrf_25=1.3492e-10
parameters dk2nrf_25=0.005
parameters dlk2nrf_25=2.0e-9
parameters toxprf_25=6.02e-09
parameters dvthprf_25=-2.82e-02
parameters dlvthprf_25=-3.50e-10
parameters dwvthprf_25=-1.57e-09
parameters dpvthprf_25=-2.73e-16
parameters dlvsatprf_25=-3.39e-03
parameters cjprf_25=1.2436e-03
parameters cjswprf_25=3.2141e-11
parameters cjswgprf_25=2.1227e-10
parameters cgoprf_25=9.975e-11
parameters hdifprf_25=1.35e-07
parameters cglprf_25=1.9e-10
parameters dk2prf_25=0.01
parameters dlk2prf_25=1.0e-9
include "cr013g_2d5_v1d4.scs" section=rf_mos25

endsection ss_rfmos25

// *****************************  LIBRARY OF FNFP CORNER CASE  ******************************

section ff_rfmos25
parameters parnrf1_25=0
parameters parnrf2_25=0
parameters parprf1_25=0
parameters parprf2_25=0
parameters toxnrf_25=5.68e-09
parameters dxlrf_25=-7.000e-09
parameters dxwrf_25=7.000e-09
parameters dvthnrf_25=-2.88e-02
parameters dlvthnrf_25=-6.44e-09
parameters dwvthnrf_25=-1.59e-09
parameters dpvthnrf_25=-1.66e-16
parameters dlvsatnrf_25=0
parameters cjnrf_25=9.196e-04
parameters cjswnrf_25=2.3275e-11
parameters cjswgnrf_25=1.6185e-10
parameters cgonrf_25=2.0898e-10
parameters hdifnrf_25=1.35e-07
parameters cglnrf_25=1.4912e-10
parameters dk2nrf_25=-0.005
parameters dlk2nrf_25=-2.0e-9
parameters toxprf_25=5.72e-09
parameters dvthprf_25=2.85e-02
parameters dlvthprf_25=2.40e-10
parameters dwvthprf_25=1.68e-09
parameters dpvthprf_25=2.78e-16
parameters dlvsatprf_25=3.32e-03
parameters cjprf_25=1.1258e-03
parameters cjswprf_25=2.908e-11
parameters cjswgprf_25=1.9206e-10
parameters cgoprf_25=1.1025e-10
parameters hdifprf_25=1.35e-07
parameters cglprf_25=2.1e-10
parameters dk2prf_25=-0.01
parameters dlk2prf_25=-1.0e-9
include "cr013g_2d5_v1d4.scs" section=rf_mos25

endsection ff_rfmos25

// *****************************  LIBRARY OF SNFP CORNER CASE  ******************************

section sf_rfmos25
parameters parnrf1_25=0
parameters parnrf2_25=0
parameters parprf1_25=0
parameters parprf2_25=0
parameters toxnrf_25=5.83e-09
parameters dxlrf_25=0
parameters dxwrf_25=0
parameters dvthnrf_25=2.87e-02
parameters dlvthnrf_25=8.21e-09
parameters dwvthnrf_25=1.25e-09
parameters dpvthnrf_25=5.27e-18
parameters dlvsatnrf_25=0
parameters cjnrf_25=1.016e-03
parameters cjswnrf_25=2.5725e-11
parameters cjswgnrf_25=1.7895e-10
parameters cgonrf_25=1.99e-10
parameters hdifnrf_25=1.35e-07
parameters cglnrf_25=1.42e-10
parameters dk2nrf_25=0.005
parameters dlk2nrf_25=2.0e-9
parameters toxprf_25=5.87e-09
parameters dvthprf_25=2.93e-02
parameters dlvthprf_25=1.56e-09
parameters dwvthprf_25=1.50e-09
parameters dpvthprf_25=2.16e-16
parameters dlvsatprf_25=0
parameters cjprf_25=1.1258e-03
parameters cjswprf_25=2.908e-11
parameters cjswgprf_25=1.9206e-10
parameters cgoprf_25=1.05e-10
parameters hdifprf_25=1.35e-07
parameters cglprf_25=2.0e-10
parameters dk2prf_25=-0.01
parameters dlk2prf_25=-1.0e-9
include "cr013g_2d5_v1d4.scs" section=rf_mos25

endsection sf_rfmos25

// *****************************  LIBRARY OF FNSP CORNER CASE  ******************************

section fs_rfmos25
parameters parnrf1_25=0
parameters parnrf2_25=0
parameters parprf1_25=0
parameters parprf2_25=0
parameters toxnrf_25=5.83e-09
parameters dxlrf_25=0
parameters dxwrf_25=0
parameters dvthnrf_25=-2.93e-02
parameters dlvthnrf_25=-8.18e-09
parameters dwvthnrf_25=-1.20e-09
parameters dpvthnrf_25=-1.67e-17
parameters dlvsatnrf_25=0
parameters cjnrf_25=9.196e-04
parameters cjswnrf_25=2.3275e-11
parameters cjswgnrf_25=1.6185e-10
parameters cgonrf_25=1.99e-10
parameters hdifnrf_25=1.35e-07
parameters cglnrf_25=1.42e-10
parameters dk2nrf_25=-0.005
parameters dlk2nrf_25=-2.0e-9
parameters toxprf_25=5.87e-09
parameters dvthprf_25=-2.89e-02
parameters dlvthprf_25=-1.56e-09
parameters dwvthprf_25=-1.51e-09
parameters dpvthprf_25=-2.15e-16
parameters dlvsatprf_25=0
parameters cjprf_25=1.2436e-03
parameters cjswprf_25=3.2141e-11
parameters cjswgprf_25=2.1227e-10
parameters cgoprf_25=1.05e-10
parameters hdifprf_25=1.35e-07
parameters cglprf_25=2.0e-10
parameters dk2prf_25=0.01
parameters dlk2prf_25=1.0e-9
include "cr013g_2d5_v1d4.scs" section=rf_mos25

endsection fs_rfmos25

//********************************************************
//**************** MIM Corner Parameters *****************
//********************************************************
section tt_rfmim
parameters par_rfmim=0
parameters l_mimfac=1.0
+ cmim_mimfac=1.0
+ cm6_mimfac=1.0
+ rctm_mimfac=1.0
+ cm5_mimfac=1.0
+ rsub_mimfac=1.0
+ csub_mimfac=1.0
include "cr013g_2d5_v1d4.scs" section=rf_mim
endsection tt_rfmim

section ff_rfmim
parameters par_rfmim=0
parameters l_mimfac=0.9762
+ cmim_mimfac=0.9
+ cm6_mimfac=0.929
+ rctm_mimfac=0.9
+ cm5_mimfac=0.931
+ rsub_mimfac=0.8
+ csub_mimfac=1.25
include "cr013g_2d5_v1d4.scs" section=rf_mim
endsection ff_rfmim

section ss_rfmim
parameters par_rfmim=0
parameters l_mimfac=1.0235
+ cmim_mimfac=1.1
+ cm6_mimfac=1.084
+ rctm_mimfac=1.1
+ cm5_mimfac=1.074
+ rsub_mimfac=1.2
+ csub_mimfac=0.833
include "cr013g_2d5_v1d4.scs" section=rf_mim
endsection ss_rfmim

//********************************************************
//************* Inductor Corner Parameters ***************
//********************************************************
section tt_rfind
parameters c12_indfac=1.0
+ rm8_indfac=1.0
+ l_indfac=1.0
+ cm8_indfac=1.0
+ csub_indfac=1.0
+ rsub_indfac=1.0
include "cr013g_2d5_v1d4.scs" section=rf_ind
endsection tt_rfind

section ff_rfind
parameters c12_indfac=0.898
+ rm8_indfac=0.9
+ l_indfac=0.9762
+ cm8_indfac=0.939
+ csub_indfac=1.25
+ rsub_indfac=0.8
include "cr013g_2d5_v1d4.scs" section=rf_ind
endsection ff_rfind

section ss_rfind
parameters c12_indfac=1.124
+ rm8_indfac=1.1
+ l_indfac=1.0235
+ cm8_indfac=1.065
+ csub_indfac=0.8333
+ rsub_indfac=1.2
include "cr013g_2d5_v1d4.scs" section=rf_ind
endsection ss_rfind

//********************************************************
//************* 1.2V MOS Varactor Corner Parameters ******
//********************************************************
section tt_rfmvar
parameters
+ l_mvfacrf=1
+ rm_mvfacrf=1
+ rsub_mvfacrf=1
+ csub_mvfacrf=1
+ dlcrf=0.032e-6
+ dwcrf=0
+ cmin_arf=2.1e-3
+ cmin_lrf=2.5e-10
+ cmin_wrf=4.1e-10
+ dcgarf=5e-3
+ dcgwrf=0
+ fac_varrf=1
include "cr013g_2d5_v1d4.scs" section=rf_mvar
endsection tt_rfmvar

section ff_rfmvar
parameters
+ l_mvfacrf=1.0235
+ rm_mvfacrf=1.1
+ rsub_mvfacrf=0.8
+ csub_mvfacrf=1.25
+ dlcrf=0.037E-6
+ dwcrf=-0.0075e-6
+ cmin_arf=2.268e-3
+ cmin_lrf=2.7e-10
+ cmin_wrf=4.428e-10
+ dcgarf=5.187e-3
+ dcgwrf=0
+ fac_varrf=2.45
include "cr013g_2d5_v1d4.scs" section=rf_mvar
endsection ff_rfmvar

section ss_rfmvar
parameters
+ l_mvfacrf=0.9762
+ rm_mvfacrf=0.9
+ rsub_mvfacrf=1.2
+ csub_mvfacrf=0.833
+ dlcrf=0.027E-6
+ dwcrf=0.0075e-6
+ cmin_arf=1.932e-3
+ cmin_lrf=2.3e-10
+ cmin_wrf=3.772e-10
+ dcgarf=4.813e-3
+ dcgwrf=0
+ fac_varrf=0.4082
include "cr013g_2d5_v1d4.scs" section=rf_mvar
endsection ss_rfmvar

//********************************************************
//************* 2.5V MOS Varactor Corner Parameters ***********
//********************************************************
section tt_rfmvar_25
parameters
+ l_mvfacrf25=1
+ rm_mvfacrf25=1
+ rsub_mvfacrf25=1
+ csub_mvfacrf25=1
+ dlcrf25=0.06e-6
+ dwcrf25=0.02e-6
+ cmin_arf25=1.25e-3
+ cmin_lrf25=2.5e-10
+ cmin_wrf25=4.0e-10
+ dcgarf25=2.25e-3
+ dcgwrf25=4.0e-11
include "cr013g_2d5_v1d4.scs" section=rf_mvar25
endsection tt_rfmvar_25

section ff_rfmvar_25
parameters
+ l_mvfacrf25=1.0235
+ rm_mvfacrf25=1.1
+ rsub_mvfacrf25=0.8
+ csub_mvfacrf25=1.25
+ dlcrf25=0.0666E-6
+ dwcrf25=0.0125e-6
+ cmin_arf25=1.35e-3
+ cmin_lrf25=2.7e-10
+ cmin_wrf25=4.32e-10
+ dcgarf25=2.3542e-3
+ dcgwrf25=4.19e-11
include "cr013g_2d5_v1d4.scs" section=rf_mvar25
endsection ff_rfmvar_25

section ss_rfmvar_25
parameters
+ l_mvfacrf25=0.9762
+ rm_mvfacrf25=0.9
+ rsub_mvfacrf25=1.2
+ csub_mvfacrf25=0.833
+ dlcrf25=0.0534E-6
+ dwcrf25=0.0275e-6
+ cmin_arf25=1.15e-3
+ cmin_lrf25=2.3e-10
+ cmin_wrf25=3.68e-10
+ dcgarf25=2.1458e-3
+ dcgwrf25=3.81e-11
include "cr013g_2d5_v1d4.scs" section=rf_mvar25
endsection ss_rfmvar_25

//********************************************************
//************* Xj Varactor Corner Parameters ************
//********************************************************
section tt_rfjvar
parameters cj_fac=1
+ cjsw_fac=1
+ l_fac=1
+ rm_fac=1
+ rsub_fac=1
+ csub_fac=1
+ rwell_fac=1
+ csti_fac=1
include "cr013g_2d5_v1d4.scs" section=rf_jvar
endsection tt_rfjvar

section ff_rfjvar
parameters cj_fac=0.95
+ cjsw_fac=0.95
+ l_fac=0.9762
+ rm_fac=0.9
+ rsub_fac=1.2
+ csub_fac=0.83333
+ rwell_fac=0.85
+ csti_fac=0.95
include "cr013g_2d5_v1d4.scs" section=rf_jvar
endsection ff_rfjvar

section ss_rfjvar
parameters cj_fac=1.05
+ cjsw_fac=1.05
+ l_fac=1.0235
+ rm_fac=1.1
+ rsub_fac=0.8
+ csub_fac=1.25
+ rwell_fac=1.15
+ csti_fac=1.05
include "cr013g_2d5_v1d4.scs" section=rf_jvar
endsection ss_rfjvar

section tt_rfres_sa
parameters
+ par_sarf=0
+ rppolyl=7.67
+ rppolys=7.67
+ sal_fac=1
+ sacox_fac=1
+ sarsub_fac=1
+ sacsub_fac=1
include "cr013g_2d5_v1d4.scs" section=rf_res_sa
endsection tt_rfres_sa

section ff_rfres_sa
parameters
+ par_sarf=0
+ rppolyl=7.67 - 1.92
+ rppolys=7.67 - 2.32
+ sal_fac=0.9762
+ sacox_fac=0.8964
+ sarsub_fac=1.2
+ sacsub_fac=0.833
include "cr013g_2d5_v1d4.scs" section=rf_res_sa
endsection ff_rfres_sa

section ss_rfres_sa
parameters
+ par_sarf=0
+ rppolyl=7.67 + 1.92
+ rppolys=7.67 + 2.32
+ sal_fac=1.0235
+ sacox_fac=1.1235
+ sarsub_fac=0.8
+ sacsub_fac=1.25
include "cr013g_2d5_v1d4.scs" section=rf_res_sa
endsection ss_rfres_sa

section tt_rfres_rpo
parameters
+ par_rporf=0
+ rppolywo=319.55
+ rpol_fac=1
+ rpocox_fac=1
+ rporsub_fac=1
+ rpocsub_fac=1
include "cr013g_2d5_v1d4.scs" section=rf_res_rpo
endsection tt_rfres_rpo

section ff_rfres_rpo
parameters
+ par_rporf=0
+ rppolywo=319.55 - 63.91
+ rpol_fac=0.9762
+ rpocox_fac=0.8964
+ rporsub_fac=1.2
+ rpocsub_fac=0.833
include "cr013g_2d5_v1d4.scs" section=rf_res_rpo
endsection ff_rfres_rpo

section ss_rfres_rpo
parameters
+ par_rporf=0
+ rppolywo=319.55 + 63.91
+ rpol_fac=1.0235
+ rpocox_fac=1.124
+ rporsub_fac=0.8
+ rpocsub_fac=1.25
include "cr013g_2d5_v1d4.scs" section=rf_res_rpo
endsection ss_rfres_rpo

section tt_rfres_hri
parameters
+ par_hrirf=0
+ rppolyhri=950
+ hricox_fac=1
+ hrirsub_fac=1
+ hricsub_fac=1
include "cr013g_2d5_v1d4.scs" section=rf_res_hri
endsection tt_rfres_hri

section ff_rfres_hri
parameters
+ par_hrirf=0
+ rppolyhri=950 - 190
+ hricox_fac=0.8964
+ hrirsub_fac=1.2
+ hricsub_fac=0.833
include "cr013g_2d5_v1d4.scs" section=rf_res_hri
endsection ff_rfres_hri

section ss_rfres_hri
parameters
+ par_hrirf=0
+ rppolyhri=950 + 190
+ hricox_fac=1.124
+ hrirsub_fac=0.8
+ hricsub_fac=1.25
include "cr013g_2d5_v1d4.scs" section=rf_res_hri
endsection ss_rfres_hri

// ************************************************************************
// ************ Schottky Barrier Diode Model Corner Parameters ************
// ************************************************************************

section tt_rfsbd
parameters factor_isf_wi=1
parameters factor_re_wi=1
parameters factor_isr_wi=1
parameters factor_cjf_wi=1
parameters factor_isf_wo=1
parameters factor_re_wo=1
parameters factor_isr_wo=1
parameters factor_cjf_wo=1
parameters factor_l=1
parameters factor_rm=1
parameters factor_rsub=1
parameters factor_csub=1
parameters factor_rnwell=1
parameters factor_csti=1
parameters factor_is_d=1
parameters factor_jsw_d=1
parameters factor_n_d=1
parameters factor_rs_d=1
parameters factor_cj_d=1
parameters factor_cjsw_d=1
include "cr013g_2d5_v1d4.scs" section=rf_sbd

endsection tt_rfsbd

section ss_rfsbd
parameters factor_isf_wi=0.1
parameters factor_re_wi=1.3
parameters factor_isr_wi=1 / 25
parameters factor_cjf_wi=1.25
parameters factor_isf_wo=0.05
parameters factor_re_wo=1.3
parameters factor_isr_wo=1 / 15
parameters factor_cjf_wo=1.25
parameters factor_l=1.0235
parameters factor_rm=1.1
parameters factor_rsub=0.8
parameters factor_csub=1.25
parameters factor_rnwell=1.15
parameters factor_csti=1.05
parameters factor_is_d=0.7
parameters factor_jsw_d=0.5
parameters factor_n_d=1.0025
parameters factor_rs_d=1.2
parameters factor_cj_d=1.05
parameters factor_cjsw_d=1.1
include "cr013g_2d5_v1d4.scs" section=rf_sbd

endsection ss_rfsbd

section ff_rfsbd
parameters factor_isf_wi=1.9
parameters factor_re_wi=0.7
parameters factor_isr_wi=25
parameters factor_cjf_wi=0.75
parameters factor_isf_wo=1.95
parameters factor_re_wo=0.7
parameters factor_isr_wo=15
parameters factor_cjf_wo=0.75
parameters factor_l=0.9762
parameters factor_rm=0.9
parameters factor_rsub=1.2
parameters factor_csub=0.75
parameters factor_rnwell=0.85
parameters factor_csti=0.95
parameters factor_is_d=1.3
parameters factor_jsw_d=2
parameters factor_n_d=0.9975
parameters factor_rs_d=0.8
parameters factor_cj_d=0.95
parameters factor_cjsw_d=0.9
include "cr013g_2d5_v1d4.scs" section=rf_sbd

endsection ff_rfsbd

// ************************************************************************
// ************ Schottky Barrier Diode Model Statistical Model ************
// ************************************************************************

section mc_rfsbd
parameters par1_rfsbd=0
parameters a1_rfsbd=par1_rfsbd * 4.2387e+000 * 3 / 3
parameters factor_isf_wi=1.0000e+000 + ( - 2.1232e-001) * a1_rfsbd
parameters factor_re_wi=1.0000e+000 + (7.0773e-002) * a1_rfsbd
parameters factor_isr_wi=10 ** (par1_rfsbd * ( - 1) * (log(25) / 3))
parameters factor_cjf_wi=1.0000e+000 + (5.8978e-002) * a1_rfsbd
parameters factor_isf_wo=1.0000e+000 + ( - 2.2411e-001) * a1_rfsbd
parameters factor_re_wo=1.0000e+000 + (7.0773e-002) * a1_rfsbd
parameters factor_isr_wo=10 ** (par1_rfsbd * ( - 1) * (log(15) / 3))
parameters factor_cjf_wo=1.0000e+000 + (5.8978e-002) * a1_rfsbd
parameters factor_l=1.0000e+000 + (5.5795e-003) * a1_rfsbd
parameters factor_rm=1.0000e+000 + (2.3591e-002) * a1_rfsbd
parameters factor_rsub=1.0000e+000 + ( - 4.7182e-002) * a1_rfsbd
parameters factor_csub=1.0000e+000 + (5.8978e-002) * a1_rfsbd
parameters factor_rnwell=1.0000e+000 + (3.5387e-002) * a1_rfsbd
parameters factor_csti=1.0000e+000 + (1.1796e-002) * a1_rfsbd
parameters factor_is_d=1.0000e+000 + ( - 7.0773e-002) * a1_rfsbd
parameters factor_jsw_d=10 ** (par1_rfsbd * ( - 1) * (log(2) / 3))
parameters factor_n_d=1.0000e+000 + (5.8978e-004) * a1_rfsbd
parameters factor_rs_d=1.0000e+000 + (4.7182e-002) * a1_rfsbd
parameters factor_cj_d=1.0000e+000 + (1.1796e-002) * a1_rfsbd
parameters factor_cjsw_d=1.0000e+000 + (2.3591e-002) * a1_rfsbd

statistics {
    process {
        vary par1_rfsbd dist=gauss std=1/3
        }
    }

include "cr013g_2d5_v1d4.scs" section=rf_sbd

endsection mc_rfsbd

//**************************************************************************************************
//
// 1.2V MOS MODEL :
//
//
//              .lib RF_MOS : Typical
//
//              Model name       nr               lr (um)           wr (um)
//                            low   high        low     high     low    high
//            -----------------------------------------------------------------
//              nmos_rf        1     64         0.13    0.24     1.2     10
//            -----------------------------------------------------------------
//              pmos_rf        1     64         0.13    0.24     1.2     10
//            -----------------------------------------------------------------
//              pmos_rf_nw     1     64         0.13    0.24     1.2     10
//            -----------------------------------------------------------------
//              nmos_rf_mis    1     64         0.13    0.24     1.2     10
//            -----------------------------------------------------------------
//              pmos_rf_mis    1     64         0.13    0.24     1.2     10
//            -----------------------------------------------------------------
//              pmos_rf_nw_mis 1     64         0.13    0.24     1.2     10
//            -----------------------------------------------------------------
//            End Model
//            **nr: Finger number
//            **wr: Width per finger
//
//**************************************************************************************************
section rf_mos

inline subckt nmos_rf ( d g s b )
parameters lr=13.e-08 nr=1 wr=2.5e-6 lspace=0.42u ledge=2.0u ledgeeff=0.73u lsti=1.0u
+ wsti=2.0u rod=2015 rsti=3364 ns=int(nr / 2 + 1) nd=int((nr + 1) / 2)
+ nodd=(nr - int(nr / 2) * 2) dummyflag=1 sleff=ledge
+ + dummyflag * (ledgeeff - ledge) sreff=ledge + dummyflag * (ledgeeff - ledge)
+ ldios=(ns - 2) * lspace + sleff + sreff + nodd * (lspace - sleff) ldiod=(ns -
+ 1) * lspace + nodd * sleff lod=nr * (lr + lspace) + 2 * ledge - lspace sdiofa=wr
+ * ldios sdiofp=2 * ldios + (2 - nodd) * wr * (1 - dummyflag) ddiofa=wr * ldiod
+ ddiofp=2 * ldiod + nodd * wr * (1 - dummyflag) sdiogp=wr * nr + (2 - nodd) * wr
+ * dummyflag ddiogp=wr * nr + nodd * wr * dummyflag sax=1 / (log((ledge + lr /
+ 2 + nr * (lr + lspace)) * (ledge + lr / 2 + (nr - 1) * (lr + lspace)) / (ledge
+ + lspace + 3 * lr / 2) / (ledge + lr / 2)) / (2 * nr * (lr + lspace)) + 1 / (nr
+ * (ledge + lr / 2))) - lr / 2 rsx=(0.0158
+ * (lr * 1e6 + 0.42) * (2 * ns + 1 / ns - 3) + 0.771 / ns + 0.232) / (wr * 1e6)
+ rdx=0.0053 * (lr * 1e6 + 0.42) * (nd + 2 / nd) + 0.138 * (wr * 1e6 + 2.16) / nd
+ + 0.0867 / (1.2 + (nd - 1) * (lr * 1e6 + 0.42)) rgx=((0.625 * (wr * 1e6 + 0.96)
+ / (lr * 1e6 - 0.02) + 6.46) / nr + nr * (0.000286 * wr * 1e6 + 0.0139) + 0.0138
+ * wr * 1e6 + 0.718 * lr * 1e6 + 733 * lr / nr / wr + 5.189)
+ rbx=(rod * lod / 12 + rsti * lsti / 2) * (rod * wr / 12 +
+ rsti * wsti / 2) / (lod * (rod * lod / 12 + rsti * lsti / 2) + wr * (rod * wr
+ / 12 + rsti * wsti / 2)) rdbx=rod * lr / (wr * nr * 2) cgsx=(1.3 * nr * (lr *
+ 1e6 + 0.42) / (0.1 * wr * 1e6 + 2.9) + 0.2 * wr * 1e6 + 0.67) * 1e-15 cgdx=(0.19
+ * nr * lr * 1e6 + 0.07 * nr + 0.282) * 1e-15 cdsx=(0.1 + 0.062 * nr * wr * 1e6
+ / (lr * 1e6 + 0.6) + 1.8 * nr * (lr * 1e6 + 0.42) / (wr * 1e6 + 9.8)) * 1e-15
+ w1=(wr + 0.015e-6 + dxwrf) * nr l1=lr - 0.02e-6
+ + dxlrf tcc=1 + 1.7e-3 * (temp - 25) area=w1 * 2.5e-9 * 1e4 * tcc tox=(toxnrf
+ - 8.3e-10) * 1e2 jf=2.704e-08 ef=2.623e+07 varaf= - 0.18955 * log(l1) + 0.99251
+ varbf=0.54 * ef * tox jr=5.065e-7 er=7.43e6 varar= - 0.072266 * log(l1) + 16.394
+ varbr=0.52 * er * tox forward_eff=area * jf * exp( - ef * tox * varaf) / pow(tox,2.5)
+ reverse_eff=area * jr * exp( - er * tox * varar) / pow(tox,2.5) tmp1=varbf + 2.0
+ tmp2=varbr + 2.0
rg ( g gi ) resistor r=rgx
rs ( s si ) resistor r=rsx
rd ( d di ) resistor r=rdx
//  ********************
cgs_m ( gi si ) capacitor c=cgsx
cgd_m ( gi di ) capacitor c=cgdx
cds_m ( si di ) capacitor c=cdsx
//  *** Diodes  ****************
dss ( sb si ) ndio_rf_f area=sdiofa pj=sdiofp
ddd ( db di ) ndio_rf_f area=ddiofa pj=ddiofp
dsg ( sb si ) ndio_rf_g area=1e-15 pj=sdiogp
ddg ( db di ) ndio_rf_g area=1e-15 pj=ddiogp
//  ***************************************************************************
rb ( b bi ) resistor r=rbx tc1=0.0037 tc2=9.64e-6
cb ( b bi ) capacitor c=162f / rbx
rdb ( db bi ) resistor r=rdbx tc1=0.0037 tc2=9.64e-6
cdb ( db bi ) capacitor c=162f / rdbx
rsb ( sb bi ) resistor r=rdbx tc1=0.0037 tc2=9.64e-6
csb ( sb bi ) capacitor c=162f / rdbx
nmos_rf ( di gi si bi ) nch_rf l=lr w=wr m=nr ad=0 as=0 pd=0 ps=0 sa=sax sb=sax
gdf1 ( gi di ) bsource i =forward_eff * pow((abs(v(gi,di)) + v(gi,di)) / 2,tmp1)
+ - reverse_eff * pow((abs(v(gi,di)) - v(gi,di)) / 2,tmp2) + 1e-18 * v(gi,di)
gdf2 ( gi si ) bsource i =forward_eff * pow((abs(v(gi,si)) + v(gi,si)) / 2,tmp1)
+ - reverse_eff * pow((abs(v(gi,si)) - v(gi,si)) / 2,tmp2) + 1e-18 * v(gi,si)
ends nmos_rf

inline subckt pmos_rf ( d g s b )
parameters lr=13.e-08 nr=1 wr=2.5e-6 lspace=0.42u ledge=2.0u ledgeeff=0.73u lsti=1.0u
+ wsti=2.0u rod=342 rsti=913 ns=int(nr / 2 + 1) nd=int((nr + 1) / 2)
+ nodd=(nr - int(nr / 2) * 2) dummyflag=1 sleff=ledge
+ + dummyflag * (ledgeeff - ledge) sreff=ledge + dummyflag * (ledgeeff - ledge)
+ ldios=(ns - 2) * lspace + sleff + sreff + nodd * (lspace - sleff) ldiod=(ns -
+ 1) * lspace + nodd * sleff lod=nr * (lr + lspace) + 2 * ledge - lspace sdiofa=wr
+ * ldios sdiofp=2 * ldios + (2 - nodd) * wr * (1 - dummyflag) ddiofa=wr * ldiod
+ ddiofp=2 * ldiod + nodd * wr * (1 - dummyflag) sdiogp=wr * nr + (2 - nodd) * wr
+ * dummyflag ddiogp=wr * nr + nodd * wr * dummyflag sax=1 / (log((ledge + lr /
+ 2 + nr * (lr + lspace)) * (ledge + lr / 2 + (nr - 1) * (lr + lspace)) / (ledge
+ + lspace + 3 * lr / 2) / (ledge + lr / 2)) / (2 * nr * (lr + lspace)) + 1 / (nr
+ * (ledge + lr / 2))) - lr / 2 rsx=(0.0158
+ * (lr * 1e6 + 0.42) * (2 * ns + 1 / ns - 3) + 0.771 / ns + 0.232) / (wr * 1e6)
+ rdx=0.0053 * (lr * 1e6 + 0.42) * (nd + 2 / nd) + 0.138 * (wr * 1e6 + 2.16) / nd
+ + 0.0867 / (1.2 + (nd - 1) * (lr * 1e6 + 0.42)) rgx=((0.625 * (wr * 1e6 + 0.96)
+ / (lr * 1e6 - 0.02) + 6.46) / nr + nr * (0.000286 * wr * 1e6 + 0.0139) + 0.0138
+ * wr * 1e6 + 0.718 * lr * 1e6 + 1223 * lr / nr / wr + 4.689)
+ rbx=(rod * lod / 12 + rsti * lsti / 2) * (rod * wr / 12 +
+ rsti * wsti / 2) / (lod * (rod * lod / 12 + rsti * lsti / 2) + wr * (rod * wr
+ / 12 + rsti * wsti / 2)) rdbx=rod * lr / (wr * nr * 2) cgsx=(1.3 * nr * (lr *
+ 1e6 + 0.42) / (0.1 * wr * 1e6 + 2.9) + 0.2 * wr * 1e6 + 0.67) * 1e-15 cgdx=(0.19
+ * nr * lr * 1e6 + 0.07 * nr + 0.282) * 1e-15 cdsx=(0.1 + 0.062 * nr * wr * 1e6
+ / (lr * 1e6 + 0.6) + 1.8 * nr * (lr * 1e6 + 0.42) / (wr * 1e6 + 9.8)) * 1e-15
+ jf=1.1575e-07 ef=7.127e+06 jr=2.8e-8 er=4.373e6
+ w1=(wr + 0.015e-6 + dxwrf) * nr l1=lr + dxlrf - 0.02e-6 tox=(toxprf - 8e-10) *
+ 1e2 tcc=1 + 1.4e-3 * (temp - 25) area=w1 * 6.1e-9 * 1e4 * tcc varaf= - 0.70902
+ * log(l1) + 5.9821 varbf=1.2 * ef * tox varbr=0.52 * er * tox varar= - 0.31121
+ * log(l1) + 24.530 forward_eff=area * jf * exp( - ef * tox * varaf) / pow(tox,2.5)
+ reverse_eff=area * jr * exp( - er * tox * varar) / pow(tox,2.5) tmp1=varbf + 2.0
+ tmp2=varbr + 2.0

//  ********************
rg ( g gi ) resistor r=rgx
rs ( s si ) resistor r=rsx
rd ( d di ) resistor r=rdx
//  ********************
cgs_m ( gi si ) capacitor c=cgsx
cgd_m ( gi di ) capacitor c=cgdx
cds_m ( si di ) capacitor c=cdsx
//  *** Diodes  ****************
dss ( si sb ) pdio_rf_f area=sdiofa pj=sdiofp
ddd ( di db ) pdio_rf_f area=ddiofa pj=ddiofp
dsg ( si sb ) pdio_rf_g area=1e-15 pj=sdiogp
ddg ( di db ) pdio_rf_g area=1e-15 pj=ddiogp
//  ***************************************************************************
rb ( b bi ) resistor r=rbx tc1=0.00374 tc2=9.10e-6
cb ( b bi ) capacitor c=169f / rbx
rdb ( db bi ) resistor r=rdbx tc1=0.00374 tc2=9.10e-6
cdb ( db bi ) capacitor c=169f / rdbx
rsb ( sb bi ) resistor r=rdbx tc1=0.00374 tc2=9.10e-6
csb ( sb bi ) capacitor c=169f / rdbx
pmos_rf ( di gi si bi ) pch_rf l=lr w=wr m=nr ad=0 as=0 pd=0 ps=0 sa=sax sb=sax
gdf1 ( di gi ) bsource i =forward_eff * pow((abs(v(di,gi)) + v(di,gi)) / 2,tmp1)
+ - reverse_eff * pow((abs(v(di,gi)) - v(di,gi)) / 2,tmp2) + 1e-18 * v(di,gi)
gdf2 ( si gi ) bsource i =forward_eff * pow((abs(v(si,gi)) + v(si,gi)) / 2,tmp1)
+ - reverse_eff * pow((abs(v(si,gi)) - v(si,gi)) / 2,tmp2) + 1e-18 * v(si,gi)
ends pmos_rf

inline subckt pmos_rf_nw ( d g s b )
parameters lr=13.e-08 nr=1 wr=2.5e-6 lspace=0.42u ledge=2.0u ledgeeff=0.73u lsti=1.0u
+ wsti=2.0u rod=805 rsti=2148 ns=int(nr / 2 + 1) nd=int((nr + 1) / 2)
+nodd=(nr - int(nr / 2) * 2) dummyflag=1 sleff=ledge
+ + dummyflag * (ledgeeff - ledge) sreff=ledge + dummyflag * (ledgeeff - ledge)
+ ldios=(ns - 2) * lspace + sleff + sreff + nodd * (lspace - sleff) ldiod=(ns -
+ 1) * lspace + nodd * sleff lod=nr * (lr + lspace) + 2 * ledge - lspace sdiofa=wr
+ * ldios sdiofp=2 * ldios + (2 - nodd) * wr * (1 - dummyflag) ddiofa=wr * ldiod
+ ddiofp=2 * ldiod + nodd * wr * (1 - dummyflag) sdiogp=wr * nr + (2 - nodd) * wr
+ * dummyflag ddiogp=wr * nr + nodd * wr * dummyflag sax=1 / (log((ledge + lr /
+ 2 + nr * (lr + lspace)) * (ledge + lr / 2 + (nr - 1) * (lr + lspace)) / (ledge
+ + lspace + 3 * lr / 2) / (ledge + lr / 2)) / (2 * nr * (lr + lspace)) + 1 / (nr
+ * (ledge + lr / 2))) - lr / 2 rsx=(0.0158
+ * (lr * 1e6 + 0.42) * (2 * ns + 1 / ns - 3) + 0.771 / ns + 0.232) / (wr * 1e6)
+ rdx=0.0053 * (lr * 1e6 + 0.42) * (nd + 2 / nd) + 0.138 * (wr * 1e6 + 2.16) / nd
+ + 0.0867 / (1.2 + (nd - 1) * (lr * 1e6 + 0.42)) rgx=((0.625 * (wr * 1e6 + 0.96)
+ / (lr * 1e6 - 0.02) + 6.46) / nr + nr * (0.000286 * wr * 1e6 + 0.0139) + 0.0138
+ * wr * 1e6 + 0.718 * lr * 1e6 + 1223 * lr / nr / wr + 4.689)
+ rbx=(rod * lod / 12 + rsti * lsti / 2) * (rod * wr / 12 +
+ rsti * wsti / 2) / (lod * (rod * lod / 12 + rsti * lsti / 2) + wr * (rod * wr
+ / 12 + rsti * wsti / 2)) rdbx=rod * lr / (wr * nr * 2) cgsx=(1.3 * nr * (lr *
+ 1e6 + 0.42) / (0.1 * wr * 1e6 + 2.9) + 0.2 * wr * 1e6 + 0.67) * 1e-15 cgdx=(0.19
+ * nr * lr * 1e6 + 0.07 * nr + 0.282) * 1e-15 cdsx=(0.1 + 0.062 * nr * wr * 1e6
+ / (lr * 1e6 + 0.6) + 1.8 * nr * (lr * 1e6 + 0.42) / (wr * 1e6 + 9.8)) * 1e-15
+ jf=1.1575e-07 ef=7.127e+06 jr=2.8e-8 er=4.373e6
+ w1=(wr + 0.015e-6 + dxwrf) * nr l1=lr + dxlrf - 0.02e-6 tox=(toxprf - 8e-10) *
+ 1e2 tcc=1 + 1.4e-3 * (temp - 25) area=w1 * 6.1e-9 * 1e4 * tcc varaf= - 0.70902
+ * log(l1) + 5.9821 varbf=1.2 * ef * tox varbr=0.52 * er * tox varar= - 0.31121
+ * log(l1) + 24.530 forward_eff=area * jf * exp( - ef * tox * varaf) / pow(tox,2.5)
+ reverse_eff=area * jr * exp( - er * tox * varar) / pow(tox,2.5) tmp1=varbf + 2.0
+ tmp2=varbr + 2.0

rg ( g gi ) resistor r=rgx
rs ( s si ) resistor r=rsx
rd ( d di ) resistor r=rdx
//  ********************
cgs_m ( gi si ) capacitor c=cgsx
cgd_m ( gi di ) capacitor c=cgdx
cds_m ( si di ) capacitor c=cdsx
//  *** Diodes  ****************
dss ( si sb ) pdio_rf_f area=sdiofa pj=sdiofp
ddd ( di db ) pdio_rf_f area=ddiofa pj=ddiofp
dsg ( si sb ) pdio_rf_g area=1e-15 pj=sdiogp
ddg ( di db ) pdio_rf_g area=1e-15 pj=ddiogp
//  ***************************************************************************
rb ( b bi ) resistor r=rbx tc1=0.00374 tc2=9.10e-6
cb ( b bi ) capacitor c=169f / rbx
rdb ( db bi ) resistor r=rdbx tc1=0.00374 tc2=9.10e-6
cdb ( db bi ) capacitor c=169f / rdbx
rsb ( sb bi ) resistor r=rdbx tc1=0.00374 tc2=9.10e-6
csb ( sb bi ) capacitor c=169f / rdbx
pmos_rf_nw ( di gi si bi ) pch_rf l=lr w=wr m=nr ad=0 as=0 pd=0 ps=0 sa=sax sb=sax
gdf1 ( di gi ) bsource i =forward_eff * pow((abs(v(di,gi)) + v(di,gi)) / 2,tmp1)
+ - reverse_eff * pow((abs(v(di,gi)) - v(di,gi)) / 2,tmp2) + 1e-18 * v(di,gi)
gdf2 ( si gi ) bsource i =forward_eff * pow((abs(v(si,gi)) + v(si,gi)) / 2,tmp1)
+ - reverse_eff * pow((abs(v(si,gi)) - v(si,gi)) / 2,tmp2) + 1e-18 * v(si,gi)
ends pmos_rf_nw
model nch_rf bsim3v3  {
     1: type=n
+ lmin=1.30e-07             lmax=3.5001e-07           wmin=1.20e-06
+ wmax=1.0005e-05           tnom=25                   version=3.24
+ tox=toxnrf                toxm=toxnrf               xj=1.9e-07
+ nch=6.14815e+17           lln=1                     lwn=1
+ wln=1                     wwn=-1                    lint=0
+ ll=0                      lw=0                      lwl=0
+ wint=1.25e-08             wl=0                      ww=0
+ wwl=0                     mobmod=1                  binunit=2
+ xl=-2.0e-08+dxlrf         xw=1.5e-08+dxwrf          dwg=0
+ dwb=0                     vth0=0.3731874+dvthnrf    lvth0=7.422214e-09+dlvthnrf
+ wvth0=-1.186831e-08+dwvthnrf                        pvth0=1.677027e-15+dpvthnrf
+ k1=0.4624763              lk1=-8.17183e-10          wk1=2.367341e-10
+ pk1=-7.812222e-17         k2=-0.01+dk2nrf           lk2=0+dlk2nrf
+ k3=0
+ dvt0=0                    dvt1=0                    dvt2=0
+ dvt0w=0                   dvt1w=0                   dvt2w=0
+ nlx=0                     w0=0                      k3b=0
+ vfb=-0.905175             vsat=92367.39             lvsat=-0.0001660512+dlvsatnrf
+ wvsat=0.001075562         pvsat=9.296548e-11+dpvsatnrf        ua=5.390622e-10
+ lua=-8.717873e-19         wua=2.09273e-16           pua=-2.426999e-23
+ ub=2.801752e-18           lub=2.109314e-26          wub=-1.01701e-24
+ pub=-2.108259e-31         uc=2.99737e-10            luc=2.053834e-17
+ wuc=-4.73468e-17          puc=-4.036318e-23         rdsw=102.9
+ prwb=0                    prwg=0                    wr=1
+ u0=0.06172818             lu0=2.412345e-09          wu0=-1.226186e-08
+ pu0=-2.672088e-15         a0=1.2                    keta=-0.001
+ a1=0                      a2=0.99                   ags=0.9478924
+ lags=5.99237e-09          wags=5.208151e-07         pags=-5.989373e-14
+ b0=0                      b1=0                      voff=-0.1260906
+ lvoff=2.091559e-10        wvoff=2.089575e-08        pvoff=-8.687199e-15
+ nfactor=1.041947          lnfactor=8.291686e-08     wnfactor=8.048968e-08
+ pnfactor=-4.166534e-15    cit=-5.5653970e-04        lcit=1.8365813e-10
+ wcit=6.6506490e-10        pcit=-2.1947146e-16       cdsc=0
+ cdscb=0                   cdscd=0                   eta0=0.0003695728
+ leta0=8.926878e-10        weta0=1.303616e-09
+ peta0=-6.765388e-16       etab=-0.003397638         letab=-4.08592e-10
+ wetab=1.475642e-09        petab=-3.906104e-17       dsub=0
+ pclm=0.2353426            lpclm=1.03837e-07         wpclm=-1.033738e-07
+ ppclm=3.411337e-14+dppclmnrf                        pdiblc1=0
+ pdiblc2=0.001378058       lpdiblc2=3.702408e-10     wpdiblc2=-1.279943e-09
+ ppdiblc2=4.223811e-16     pdiblcb=0                 drout=0
+ pscbe1=1.8e+08            pscbe2=5e-08              pvag=0
+ delta=0.01                kt1=-0.1794609            lkt1=-2.728266e-09
+ wkt1=-2.53779e-08         pkt1=7.478905e-15         kt2=-0.02
+ at=35000                  ute=-1.44321              lute=-1.874063e-08
+ wute=-6.786381e-08        pute=2.239505e-14         ua1=3.56853e-09
+ lua1=-1.56246e-16         wua1=-6.849511e-16        pua1=-8.74969e-23
+ ub1=-4.90324e-18          lub1=1.819599e-25         wub1=7.820111e-25
+ pub1=7.786192e-32         uc1=-3.769706e-10         luc1=6.973365e-18
+ wuc1=1.969626e-17         puc1=1.275997e-23         kt1l=0
+ prt=0                     alpha0=0                  alpha1=0.009179
+ beta0=6.415               cj=0                      mj=0.4528
+ pb=0.7956                 cjsw=0                    mjsw=0.2323
+ pbsw=0.7956               cjswg=0                   mjswg=0.4087
+ pbswg=0.7956              tcj=0.0009067             tcjsw=0.0002781
+ tcjswg=0.0002781          tpb=0.001427              tpbsw=0.001427
+ tpbswg=0.001427           js=8.00e-7                jsw=1.55e-12
+ cgdo=cgonrf               cgso=cgonrf               cgbo=0
+ capmod=3                  nqsmod=0                  xpart=0
+ cf=0                      tlev=1                    tlevc=1
+ xti=3                     n=1                       hdif=hdifnrf
+ ldif=8e-08                rsh=rshnrf                rs=0
+ rd=0                      dlc=2.69e-8               cgdl=cglnrf
+ cgsl=cglnrf               wwc=-6.5e-2               dwc=0
+ noia=7.0e+18              noib=2.5e+4               noic=1.0e-13
+ em=4.1e+7                 ef=1.009                  noimod=2
+ noff=1.515                voffcv=-0.03              clc=0
+ sa0=0.35e-6               sb0=0.35e-6               kvsat=0.4
+ wlod=0.5e-6               tku0=0.03                 ku0=-0.62e-7
+ llodku0=1                 wlodku0=1                 lku0=2.0e-7
+ wku0=0.7e-6               pku0=-0.5e-13             kvth0=5.2e-9
+ stk2=2.5e-9               steta0=-1.1e-10           lkvth0=-1.0e-8
+ wkvth0=2.2e-6             pkvth0=-5e-14             llodvth=1.0
+ wlodvth=1                 lodk2=1                   lodeta0=2
+ minr=1e-3                 imax=0.01                 imelt=0.01
//

     }
model pch_rf bsim3v3  {
     1: type=p
+ lmin=1.30e-07             lmax=3.501e-07            wmin=1.20e-06
+ wmax=1.0005e-05           tnom=25                   version=3.24
+ tox=toxprf                toxm=toxprf               xj=2.1e-07
+ nch=7.3e+17               lln=1                     lwn=1
+ wln=1                     wwn=-1                    lint=4e-09
+ ll=0                      lw=0                      lwl=0
+ wint=-6.5e-09             wl=0                      ww=0
+ wwl=0                     mobmod=1                  binunit=2
+ xl=-2.0e-08+dxlrf         xw=1.5e-08+dxwrf          dwg=0
+ dwb=0                     vth0=-0.3007786+dvthprf   lvth0=-1.2452491e-08+dlvthprf
+ wvth0=1.2451168e-08+dwvthprf                        pvth0=-3.8804420e-16+dpvthprf
+ k1=0.4343991              lk1=5.106258e-09          wk1=1.955284e-08
+ pk1=-6.296016e-15         k2=-0.001+dk2prf          lk2=0+dlk2prf
+ k3=0
+ dvt0=0                    dvt1=0                    dvt2=0
+ dvt0w=0                   dvt1w=0                   dvt2w=0
+ nlx=0                     w0=0                      k3b=0
+ vfb=-0.9415483            vsat=7.5100910e+04        lvsat=1.5775075e-03+dlvsatprf
+ wvsat=5.4269470e-03       pvsat=-1.7474771e-09+dpvsatprf      ua=1.97713e-09
+ lua=-3.3012e-17           wua=2.219549e-16          pua=-2.6204e-23
+ ub=-6.506528e-19          lub=-4.222554e-26         wub=-6.450149e-26
+ pub=5.245532e-32          uc=-1.75756e-10           rdsw=445
+ prwb=0                    prwg=0                    wr=1
+ u0=0.01419055             lu0=-1.703087e-11         wu0=-2.498718e-09
+ pu0=1.708708e-16          a0=1                      keta=-0.001
+ a1=0                      a2=0.99                   ags=0.4
+ b0=0                      b1=0                      voff=-0.1158204
+ lvoff=-3.966937e-09       wvoff=3.397306e-09        pvoff=-6.412771e-16
+ nfactor=0.8082265         lnfactor=2.955105e-08     wnfactor=-9.569868e-09
+ pnfactor=3.081497e-15     cit=-4.0173460e-04        lcit=1.2935854e-10
+ wcit=4.9533890e-10        pcit=-1.5949910e-16       cdsc=0
+ cdscb=0                   cdscd=0                   eta0=1.5685277e-04
+ leta0=7.5449350e-10       weta0=2.5048039e-10
+ peta0=-8.0654780e-17      etab=0.001460148          letab=-5.023678e-10
+ wetab=1.626878e-10        petab=-5.238544e-17       dsub=0
+ pclm=0.6714336            lpclm=3.173837e-08        wpclm=-8.096643e-08
+ ppclm=2.607119e-14        pdiblc1=0                 pdiblc2=-0.0003129804
+ lpdiblc2=1.329797e-10     wpdiblc2=-4.306437e-11    ppdiblc2=1.386674e-17
+ pdiblcb=0                 drout=0                   pscbe1=4.24e+08
+ pscbe2=1e-07              pvag=0                    delta=0.005
+ kt1=-0.1887242            lkt1=-3.179637e-09        wkt1=-2.00967e-08
+ pkt1=1.944595e-15         kt2=0.01                  at=37800.74
+ lat=-0.002511839          wat=0.0008134381          pat=-2.619272e-10
+ ute=-0.8                  ua1=1.691787e-09          lua1=3.740971e-17
+ wua1=6.570216e-16         pua1=-7.576462e-23        ub1=-1.550013e-18
+ lub1=-8.562571e-26        wub1=-9.995162e-25        pub1=5.025138e-32
+ uc1=-4.330339e-10         luc1=1.053065e-17         wuc1=2.178463e-16
+ puc1=-3.031291e-23        kt1l=0                    prt=0
+ alpha0=0                  alpha1=0.001435           beta0=9.351
+ cj=0                      mj=0.4234                 pb=0.9
+ cjsw=0                    mjsw=0.1716               pbsw=0.9
+ cjswg=0                   mjswg=0.4413              pbswg=0.9
+ tcj=0.000887              tcjsw=0.000298            tcjswg=0.000298
+ tpb=0.001643              tpbsw=0.001643            tpbswg=0.001643
+ js=1.80e-7                jsw=8.055e-13             cgdo=cgoprf
+ cgso=cgoprf               cgbo=0                    capmod=3
+ nqsmod=0                  xpart=0                   cf=0
+ tlev=1                    tlevc=1                   xti=3
+ n=1                       hdif=hdifprf              ldif=8e-08
+ rsh=rshprf                rs=0                      rd=0
+ dlc=3.30e-8               cgdl=cglprf               cgsl=cglprf
+ wwc=-5.5e-2               dwc=0                     noia=1.0e+19
+ noib=1.0e+3               noic=1.0e-11              em=1.0e+8
+ ef=1.107                  noimod=2                  noff=1.83
+ voffcv=-0.026             clc=0                     sa0=0.35e-6
+ sb0=0.35e-6               kvsat=-0.6                wlod=0.3e-6
+ tku0=0.50                 ku0=1.14e-7               llodku0=1
+ wlodku0=1                 lku0=6e-8                 wku0=3.0e-7
+ pku0=1e-14                kvth0=-2.3e-9             stk2=0e-9
+ steta0=0                  lkvth0=1e-8               wkvth0=2.5e-7
+ pkvth0=4e-14              llodvth=1                 wlodvth=1
+ lodk2=1                   lodeta0=1                 minr=1e-3
+ imax=0.01                 imelt=0.01
     }

model ndio_rf_f diode
+ level=1                   is=8.00e-07
+ n=1.0                     bv=10.6                   ibv=0.05
+ isw=1.55e-12              cj=cjnrf                  vj=0.7956
+ mj=0.4528                 cjsw=cjswnrf              vjsw=0.7956
+ mjsw=0.2323               tlev=1                    eg=1.17
+ xti=3                     tbv1=-1*-0.000888
+ tlevc=1                   cta=0.0009067             ctp=0.0002781
+ pta=0.001427              ptp=0.001427              tnom=25
+ fc=0                      area=3.92e-08             pj=0.00084
+ ns=1.0                    nz=1.0                    imax=1e40
+ minr=1e-10                allow_scaling=1

model ndio_rf_g diode
+ level=1                   is=8.00e-07
+ n=1.0                     bv=10.6                   ibv=0.05
+ isw=1.55e-12              cj=cjnrf                  vj=0.7956
+ mj=0.4528                 cjsw=cjswgnrf             vjsw=0.7956
+ mjsw=0.4087               tlev=1                    eg=1.17
+ xti=3                     tbv1=-1*-0.000888
+ tlevc=1                   cta=0.0009067             ctp=0.0002781
+ pta=0.001427              ptp=0.001427              tnom=25
+ fc=0                      area=3.92e-08             pj=0.00084
+ ns=1.0                    nz=1.0                    imax=1e40
+ minr=1e-10                allow_scaling=1

model pdio_rf_f diode
+ level=1                   is=1.800e-07
+ n=1.0                     bv=8.4                    ibv=0.02
+ isw=8.06e-13              cj=cjprf                  vj=0.9
+ mj=0.4234                 cjsw=cjswprf              vjsw=0.9
+ mjsw=0.114                tlev=1                    eg=1.17
+ xti=3                     tbv1=-1*-0.000845
+ tlevc=1                   cta=0.000887              ctp=0.000298
+ pta=0.001643              ptp=0.001643              tnom=25
+ fc=0                      area=3.92e-08             pj=0.00084
+ ns=1.0                    nz=1.0                    imax=1e40
+ minr=1e-10                allow_scaling=1

model pdio_rf_g diode
+ level=1                   is=1.800e-07
+ n=1.0                     bv=8.4                    ibv=0.02
+ isw=8.06e-13              cj=cjprf                  vj=0.9
+ mj=0.4234                 cjsw=cjswgprf             vjsw=0.9
+ mjsw=0.485                tlev=1                    eg=1.17
+ xti=3                     tbv1=-1*-0.000845
+ tlevc=1                   cta=0.000887              ctp=0.000298
+ pta=0.001643              ptp=0.001643              tnom=25
+ fc=0                      area=3.92e-08             pj=0.00084
+ ns=1.0                    nz=1.0                    imax=1e40
+ minr=1e-10                allow_scaling=1

inline subckt nmos_rf_mis ( d g s b )
parameters lr=13.e-08 nr=1 wr=2.5e-6 lspace=0.42u ledge=2.0u ledgeeff=0.73u lsti=1.0u
+ wsti=2.0u rod=2015 rsti=3364 ns=int(nr / 2 + 1) nd=int((nr + 1) / 2)
+ nodd=(nr - int(nr / 2) * 2) dummyflag=1 sleff=ledge
+ + dummyflag * (ledgeeff - ledge) sreff=ledge + dummyflag * (ledgeeff - ledge)
+ ldios=(ns - 2) * lspace + sleff + sreff + nodd * (lspace - sleff) ldiod=(ns -
+ 1) * lspace + nodd * sleff lod=nr * (lr + lspace) + 2 * ledge - lspace sdiofa=wr
+ * ldios sdiofp=2 * ldios + (2 - nodd) * wr * (1 - dummyflag) ddiofa=wr * ldiod
+ ddiofp=2 * ldiod + nodd * wr * (1 - dummyflag) sdiogp=wr * nr + (2 - nodd) * wr
+ * dummyflag ddiogp=wr * nr + nodd * wr * dummyflag sax=1 / (log((ledge + lr /
+ 2 + nr * (lr + lspace)) * (ledge + lr / 2 + (nr - 1) * (lr + lspace)) / (ledge
+ + lspace + 3 * lr / 2) / (ledge + lr / 2)) / (2 * nr * (lr + lspace)) + 1 / (nr
+ * (ledge + lr / 2))) - lr / 2 rsx=(0.0158
+ * (lr * 1e6 + 0.42) * (2 * ns + 1 / ns - 3) + 0.771 / ns + 0.232) / (wr * 1e6)
+ rdx=0.0053 * (lr * 1e6 + 0.42) * (nd + 2 / nd) + 0.138 * (wr * 1e6 + 2.16) / nd
+ + 0.0867 / (1.2 + (nd - 1) * (lr * 1e6 + 0.42)) rgx=((0.625 * (wr * 1e6 + 0.96)
+ / (lr * 1e6 - 0.02) + 6.46) / nr + nr * (0.000286 * wr * 1e6 + 0.0139) + 0.0138
+ * wr * 1e6 + 0.718 * lr * 1e6 + 733 * lr / nr / wr + 5.189)
+ rbx=(rod * lod / 12 + rsti * lsti / 2) * (rod * wr / 12 +
+ rsti * wsti / 2) / (lod * (rod * lod / 12 + rsti * lsti / 2) + wr * (rod * wr
+ / 12 + rsti * wsti / 2)) rdbx=rod * lr / (wr * nr * 2) cgsx=(1.3 * nr * (lr *
+ 1e6 + 0.42) / (0.1 * wr * 1e6 + 2.9) + 0.2 * wr * 1e6 + 0.67) * 1e-15 cgdx=(0.19
+ * nr * lr * 1e6 + 0.07 * nr + 0.282) * 1e-15 cdsx=(0.1 + 0.062 * nr * wr * 1e6
+ / (lr * 1e6 + 0.6) + 1.8 * nr * (lr * 1e6 + 0.42) / (wr * 1e6 + 9.8)) * 1e-15
+ w1=(wr + 0.015e-6 + dxwrf) * nr l1=lr - 0.02e-6
+ + dxlrf tcc=1 + 1.7e-3 * (temp - 25) area=w1 * 2.5e-9 * 1e4 * tcc tox=(toxnrf
+ - 8.3e-10) * 1e2 jf=2.704e-08 ef=2.623e+07 varaf= - 0.18955 * log(l1) + 0.99251
+ varbf=0.54 * ef * tox jr=5.065e-7 er=7.43e6 varar= - 0.072266 * log(l1) + 16.394
+ varbr=0.52 * er * tox forward_eff=area * jf * exp( - ef * tox * varaf) / pow(tox,2.5)
+ reverse_eff=area * jr * exp( - er * tox * varar) / pow(tox,2.5) tmp1=varbf + 2.0
+ tmp2=varbr + 2.0  temp1=parnrf1 temp2=parnrf2 fac1=0.630
+ * temp1 + 0.776 * temp2 fac2=0.630 * temp1 - 0.776 * temp2 lef=lr - 2.0e-8 wef=wr
+ + 1.5e-8 geo_fac=1 / sqrt(nr * lef * wef * 1e12) vthmis=0.002536 * geo_fac
+ * fac1 dlmis=0.002159 * geo_fac * lef * fac2 dwmis= - 0.002159 * geo_fac * wef
+ * fac2 toxmis=0.002159 * geo_fac * toxnrf * fac2
rg ( g gi ) resistor r=rgx
rs ( s si ) resistor r=rsx
rd ( d di ) resistor r=rdx
//  ********************
cgs_m ( gi si ) capacitor c=cgsx
cgd_m ( gi di ) capacitor c=cgdx
cds_m ( si di ) capacitor c=cdsx
//  *** Diodes  ****************
dss ( sb si ) ndio_rf_f area=sdiofa pj=sdiofp
ddd ( db di ) ndio_rf_f area=ddiofa pj=ddiofp
dsg ( sb si ) ndio_rf_g area=1e-15 pj=sdiogp
ddg ( db di ) ndio_rf_g area=1e-15 pj=ddiogp
//  ***************************************************************************
rb ( b bi ) resistor r=rbx tc1=0.0037 tc2=9.64e-6
cb ( b bi ) capacitor c=162f / rbx
rdb ( db bi ) resistor r=rdbx tc1=0.0037 tc2=9.64e-6
cdb ( db bi ) capacitor c=162f / rdbx
rsb ( sb bi ) resistor r=rdbx tc1=0.0037 tc2=9.64e-6
csb ( sb bi ) capacitor c=162f / rdbx
nmos_rf_mis ( di gi si bi ) nch_rf l=lr w=wr m=nr ad=0 as=0 pd=0 ps=0 sa=sax sb=sax
gdf1 ( gi di ) bsource i =forward_eff * pow((abs(v(gi,di)) + v(gi,di)) / 2,tmp1)
+ - reverse_eff * pow((abs(v(gi,di)) - v(gi,di)) / 2,tmp2) + 1e-18 * v(gi,di)
gdf2 ( gi si ) bsource i =forward_eff * pow((abs(v(gi,si)) + v(gi,si)) / 2,tmp1)
+ - reverse_eff * pow((abs(v(gi,si)) - v(gi,si)) / 2,tmp2) + 1e-18 * v(gi,si)

model nch_rf bsim3v3  {
     1: type=n
+ lmin=1.30e-07             lmax=3.5001e-07           wmin=1.20e-06
+ wmax=1.0005e-05           tnom=25                   version=3.24
+ tox=toxnrf+toxmis                toxm=toxnrf+toxmis               xj=1.9e-07
+ nch=6.14815e+17           lln=1                     lwn=1
+ wln=1                     wwn=-1                    lint=0
+ ll=0                      lw=0                      lwl=0
+ wint=1.25e-08             wl=0                      ww=0
+ wwl=0                     mobmod=1                  binunit=2
+ xl=-2.0e-08+dxlrf+dlmis         xw=1.5e-08+dxwrf+dwmis          dwg=0
+ dwb=0                     vth0=0.3731874+dvthnrf+vthmis    lvth0=7.422214e-09+dlvthnrf
+ wvth0=-1.186831e-08+dwvthnrf                        pvth0=1.677027e-15+dpvthnrf
+ k1=0.4624763              lk1=-8.17183e-10          wk1=2.367341e-10
+ pk1=-7.812222e-17         k2=-0.01+dk2nrf           lk2=0+dlk2nrf
+ k3=0
+ dvt0=0                    dvt1=0                    dvt2=0
+ dvt0w=0                   dvt1w=0                   dvt2w=0
+ nlx=0                     w0=0                      k3b=0
+ vfb=-0.905175             vsat=92367.39             lvsat=-0.0001660512+dlvsatnrf
+ wvsat=0.001075562         pvsat=9.296548e-11+dpvsatnrf        ua=5.390622e-10
+ lua=-8.717873e-19         wua=2.09273e-16           pua=-2.426999e-23
+ ub=2.801752e-18           lub=2.109314e-26          wub=-1.01701e-24
+ pub=-2.108259e-31         uc=2.99737e-10            luc=2.053834e-17
+ wuc=-4.73468e-17          puc=-4.036318e-23         rdsw=102.9
+ prwb=0                    prwg=0                    wr=1
+ u0=0.06172818             lu0=2.412345e-09          wu0=-1.226186e-08
+ pu0=-2.672088e-15         a0=1.2                    keta=-0.001
+ a1=0                      a2=0.99                   ags=0.9478924
+ lags=5.99237e-09          wags=5.208151e-07         pags=-5.989373e-14
+ b0=0                      b1=0                      voff=-0.1260906
+ lvoff=2.091559e-10        wvoff=2.089575e-08        pvoff=-8.687199e-15
+ nfactor=1.041947          lnfactor=8.291686e-08     wnfactor=8.048968e-08
+ pnfactor=-4.166534e-15    cit=-5.5653970e-04        lcit=1.8365813e-10
+ wcit=6.6506490e-10        pcit=-2.1947146e-16       cdsc=0
+ cdscb=0                   cdscd=0                   eta0=0.0003695728
+ leta0=8.926878e-10        weta0=1.303616e-09
+ peta0=-6.765388e-16       etab=-0.003397638         letab=-4.08592e-10
+ wetab=1.475642e-09        petab=-3.906104e-17       dsub=0
+ pclm=0.2353426            lpclm=1.03837e-07         wpclm=-1.033738e-07
+ ppclm=3.411337e-14+dppclmnrf                        pdiblc1=0
+ pdiblc2=0.001378058       lpdiblc2=3.702408e-10     wpdiblc2=-1.279943e-09
+ ppdiblc2=4.223811e-16     pdiblcb=0                 drout=0
+ pscbe1=1.8e+08            pscbe2=5e-08              pvag=0
+ delta=0.01                kt1=-0.1794609            lkt1=-2.728266e-09
+ wkt1=-2.53779e-08         pkt1=7.478905e-15         kt2=-0.02
+ at=35000                  ute=-1.44321              lute=-1.874063e-08
+ wute=-6.786381e-08        pute=2.239505e-14         ua1=3.56853e-09
+ lua1=-1.56246e-16         wua1=-6.849511e-16        pua1=-8.74969e-23
+ ub1=-4.90324e-18          lub1=1.819599e-25         wub1=7.820111e-25
+ pub1=7.786192e-32         uc1=-3.769706e-10         luc1=6.973365e-18
+ wuc1=1.969626e-17         puc1=1.275997e-23         kt1l=0
+ prt=0                     alpha0=0                  alpha1=0.009179
+ beta0=6.415               cj=0                      mj=0.4528
+ pb=0.7956                 cjsw=0                    mjsw=0.2323
+ pbsw=0.7956               cjswg=0                   mjswg=0.4087
+ pbswg=0.7956              tcj=0.0009067             tcjsw=0.0002781
+ tcjswg=0.0002781          tpb=0.001427              tpbsw=0.001427
+ tpbswg=0.001427           js=8.00e-7                jsw=1.55e-12
+ cgdo=cgonrf               cgso=cgonrf               cgbo=0
+ capmod=3                  nqsmod=0                  xpart=0
+ cf=0                      tlev=1                    tlevc=1
+ xti=3                     n=1                       hdif=hdifnrf
+ ldif=8e-08                rsh=rshnrf                rs=0
+ rd=0                      dlc=2.69e-8               cgdl=cglnrf
+ cgsl=cglnrf               wwc=-6.5e-2               dwc=0
+ noia=7.0e+18              noib=2.5e+4               noic=1.0e-13
+ em=4.1e+7                 ef=1.009                  noimod=2
+ noff=1.515                voffcv=-0.03              clc=0
+ sa0=0.35e-6               sb0=0.35e-6               kvsat=0.4
+ wlod=0.5e-6               tku0=0.03                 ku0=-0.62e-7
+ llodku0=1                 wlodku0=1                 lku0=2.0e-7
+ wku0=0.7e-6               pku0=-0.5e-13             kvth0=5.2e-9
+ stk2=2.5e-9               steta0=-1.1e-10           lkvth0=-1.0e-8
+ wkvth0=2.2e-6             pkvth0=-5e-14             llodvth=1.0
+ wlodvth=1                 lodk2=1                   lodeta0=2
+ minr=1e-3                 imax=0.01                 imelt=0.01
//

     }

model ndio_rf_f diode
+ level=1                   is=8.00e-07
+ n=1.0                     bv=10.6                   ibv=0.05
+ isw=1.55e-12              cj=cjnrf                  vj=0.7956
+ mj=0.4528                 cjsw=cjswnrf              vjsw=0.7956
+ mjsw=0.2323               tlev=1                    eg=1.17
+ xti=3                     tbv1=-1*-0.000888
+ tlevc=1                   cta=0.0009067             ctp=0.0002781
+ pta=0.001427              ptp=0.001427              tnom=25
+ fc=0                      area=3.92e-08             pj=0.00084
+ ns=1.0                    nz=1.0                    imax=1e40
+ minr=1e-10                allow_scaling=1

model ndio_rf_g diode
+ level=1                   is=8.00e-07
+ n=1.0                     bv=10.6                   ibv=0.05
+ isw=1.55e-12              cj=cjnrf                  vj=0.7956
+ mj=0.4528                 cjsw=cjswgnrf             vjsw=0.7956
+ mjsw=0.4087               tlev=1                    eg=1.17
+ xti=3                     tbv1=-1*-0.000888
+ tlevc=1                   cta=0.0009067             ctp=0.0002781
+ pta=0.001427              ptp=0.001427              tnom=25
+ fc=0                      area=3.92e-08             pj=0.00084
+ ns=1.0                    nz=1.0                    imax=1e40
+ minr=1e-10                allow_scaling=1

ends nmos_rf_mis

inline subckt pmos_rf_mis ( d g s b )
parameters lr=13.e-08 nr=1 wr=2.5e-6 lspace=0.42u ledge=2.0u ledgeeff=0.73u lsti=1.0u
+ wsti=2.0u rod=342 rsti=913 ns=int(nr / 2 + 1) nd=int((nr + 1) / 2)
+ nodd=(nr - int(nr / 2) * 2) dummyflag=1 sleff=ledge
+ + dummyflag * (ledgeeff - ledge) sreff=ledge + dummyflag * (ledgeeff - ledge)
+ ldios=(ns - 2) * lspace + sleff + sreff + nodd * (lspace - sleff) ldiod=(ns -
+ 1) * lspace + nodd * sleff lod=nr * (lr + lspace) + 2 * ledge - lspace sdiofa=wr
+ * ldios sdiofp=2 * ldios + (2 - nodd) * wr * (1 - dummyflag) ddiofa=wr * ldiod
+ ddiofp=2 * ldiod + nodd * wr * (1 - dummyflag) sdiogp=wr * nr + (2 - nodd) * wr
+ * dummyflag ddiogp=wr * nr + nodd * wr * dummyflag sax=1 / (log((ledge + lr /
+ 2 + nr * (lr + lspace)) * (ledge + lr / 2 + (nr - 1) * (lr + lspace)) / (ledge
+ + lspace + 3 * lr / 2) / (ledge + lr / 2)) / (2 * nr * (lr + lspace)) + 1 / (nr
+ * (ledge + lr / 2))) - lr / 2 rsx=(0.0158
+ * (lr * 1e6 + 0.42) * (2 * ns + 1 / ns - 3) + 0.771 / ns + 0.232) / (wr * 1e6)
+ rdx=0.0053 * (lr * 1e6 + 0.42) * (nd + 2 / nd) + 0.138 * (wr * 1e6 + 2.16) / nd
+ + 0.0867 / (1.2 + (nd - 1) * (lr * 1e6 + 0.42)) rgx=((0.625 * (wr * 1e6 + 0.96)
+ / (lr * 1e6 - 0.02) + 6.46) / nr + nr * (0.000286 * wr * 1e6 + 0.0139) + 0.0138
+ * wr * 1e6 + 0.718 * lr * 1e6 + 1223 * lr / nr / wr + 4.689)
+ rbx=(rod * lod / 12 + rsti * lsti / 2) * (rod * wr / 12 +
+ rsti * wsti / 2) / (lod * (rod * lod / 12 + rsti * lsti / 2) + wr * (rod * wr
+ / 12 + rsti * wsti / 2)) rdbx=rod * lr / (wr * nr * 2) cgsx=(1.3 * nr * (lr *
+ 1e6 + 0.42) / (0.1 * wr * 1e6 + 2.9) + 0.2 * wr * 1e6 + 0.67) * 1e-15 cgdx=(0.19
+ * nr * lr * 1e6 + 0.07 * nr + 0.282) * 1e-15 cdsx=(0.1 + 0.062 * nr * wr * 1e6
+ / (lr * 1e6 + 0.6) + 1.8 * nr * (lr * 1e6 + 0.42) / (wr * 1e6 + 9.8)) * 1e-15
+ jf=1.1575e-07 ef=7.127e+06 jr=2.8e-8 er=4.373e6
+ w1=(wr + 0.015e-6 + dxwrf) * nr l1=lr + dxlrf - 0.02e-6 tox=(toxprf - 8e-10) *
+ 1e2 tcc=1 + 1.4e-3 * (temp - 25) area=w1 * 6.1e-9 * 1e4 * tcc varaf= - 0.70902
+ * log(l1) + 5.9821 varbf=1.2 * ef * tox varbr=0.52 * er * tox varar= - 0.31121
+ * log(l1) + 24.530 forward_eff=area * jf * exp( - ef * tox * varaf) / pow(tox,2.5)
+ reverse_eff=area * jr * exp( - er * tox * varar) / pow(tox,2.5) tmp1=varbf + 2.0
+ tmp2=varbr + 2.0 temp1=parprf1 temp2=parprf2 fac1=0.778
+ * temp1 + 0.629 * temp2 fac2=0.778 * temp1 - 0.629 * temp2 lef=lr - 2.0e-8 wef=wr
+ + 1.5e-8 geo_fac=1 / sqrt(nr * lef * wef * 1e12) vthmis=0.002585 * geo_fac
+ * fac1 dlmis=0.001932 * geo_fac * lef * fac2 dwmis= - 0.001932 * geo_fac * wef
+ * fac2 toxmis=0.001932 * geo_fac * toxprf * fac2

rg ( g gi ) resistor r=rgx
rs ( s si ) resistor r=rsx
rd ( d di ) resistor r=rdx
//  ********************
cgs_m ( gi si ) capacitor c=cgsx
cgd_m ( gi di ) capacitor c=cgdx
cds_m ( si di ) capacitor c=cdsx
//  *** Diodes  ****************
dss ( si sb ) pdio_rf_f area=sdiofa pj=sdiofp
ddd ( di db ) pdio_rf_f area=ddiofa pj=ddiofp
dsg ( si sb ) pdio_rf_g area=1e-15 pj=sdiogp
ddg ( di db ) pdio_rf_g area=1e-15 pj=ddiogp
//  ***************************************************************************
rb ( b bi ) resistor r=rbx tc1=0.00374 tc2=9.10e-6
cb ( b bi ) capacitor c=169f / rbx
rdb ( db bi ) resistor r=rdbx tc1=0.00374 tc2=9.10e-6
cdb ( db bi ) capacitor c=169f / rdbx
rsb ( sb bi ) resistor r=rdbx tc1=0.00374 tc2=9.10e-6
csb ( sb bi ) capacitor c=169f / rdbx
pmos_rf_mis ( di gi si bi ) pch_rf l=lr w=wr m=nr ad=0 as=0 pd=0 ps=0 sa=sax sb=sax
gdf1 ( di gi ) bsource i =forward_eff * pow((abs(v(di,gi)) + v(di,gi)) / 2,tmp1)
+ - reverse_eff * pow((abs(v(di,gi)) - v(di,gi)) / 2,tmp2) + 1e-18 * v(di,gi)
gdf2 ( si gi ) bsource i =forward_eff * pow((abs(v(si,gi)) + v(si,gi)) / 2,tmp1)
+ - reverse_eff * pow((abs(v(si,gi)) - v(si,gi)) / 2,tmp2) + 1e-18 * v(si,gi)

model pch_rf bsim3v3  {
     1: type=p
+ lmin=1.30e-07             lmax=3.501e-07            wmin=1.20e-06
+ wmax=1.0005e-05           tnom=25                   version=3.24
+ tox=toxprf+toxmis                toxm=toxprf+toxmis               xj=2.1e-07
+ nch=7.3e+17               lln=1                     lwn=1
+ wln=1                     wwn=-1                    lint=4e-09
+ ll=0                      lw=0                      lwl=0
+ wint=-6.5e-09             wl=0                      ww=0
+ wwl=0                     mobmod=1                  binunit=2
+ xl=-2.0e-08+dxlrf+dlmis         xw=1.5e-08+dxwrf+dwmis          dwg=0
+ dwb=0                     vth0=-0.3007786+dvthprf+vthmis   lvth0=-1.2452491e-08+dlvthprf
+ wvth0=1.2451168e-08+dwvthprf                        pvth0=-3.8804420e-16+dpvthprf
+ k1=0.4343991              lk1=5.106258e-09          wk1=1.955284e-08
+ pk1=-6.296016e-15         k2=-0.001+dk2prf          lk2=0+dlk2prf
+ k3=0
+ dvt0=0                    dvt1=0                    dvt2=0
+ dvt0w=0                   dvt1w=0                   dvt2w=0
+ nlx=0                     w0=0                      k3b=0
+ vfb=-0.9415483            vsat=7.5100910e+04        lvsat=1.5775075e-03+dlvsatprf
+ wvsat=5.4269470e-03       pvsat=-1.7474771e-09+dpvsatprf      ua=1.97713e-09
+ lua=-3.3012e-17           wua=2.219549e-16          pua=-2.6204e-23
+ ub=-6.506528e-19          lub=-4.222554e-26         wub=-6.450149e-26
+ pub=5.245532e-32          uc=-1.75756e-10           rdsw=445
+ prwb=0                    prwg=0                    wr=1
+ u0=0.01419055             lu0=-1.703087e-11         wu0=-2.498718e-09
+ pu0=1.708708e-16          a0=1                      keta=-0.001
+ a1=0                      a2=0.99                   ags=0.4
+ b0=0                      b1=0                      voff=-0.1158204
+ lvoff=-3.966937e-09       wvoff=3.397306e-09        pvoff=-6.412771e-16
+ nfactor=0.8082265         lnfactor=2.955105e-08     wnfactor=-9.569868e-09
+ pnfactor=3.081497e-15     cit=-4.0173460e-04        lcit=1.2935854e-10
+ wcit=4.9533890e-10        pcit=-1.5949910e-16       cdsc=0
+ cdscb=0                   cdscd=0                   eta0=1.5685277e-04
+ leta0=7.5449350e-10       weta0=2.5048039e-10
+ peta0=-8.0654780e-17      etab=0.001460148          letab=-5.023678e-10
+ wetab=1.626878e-10        petab=-5.238544e-17       dsub=0
+ pclm=0.6714336            lpclm=3.173837e-08        wpclm=-8.096643e-08
+ ppclm=2.607119e-14        pdiblc1=0                 pdiblc2=-0.0003129804
+ lpdiblc2=1.329797e-10     wpdiblc2=-4.306437e-11    ppdiblc2=1.386674e-17
+ pdiblcb=0                 drout=0                   pscbe1=4.24e+08
+ pscbe2=1e-07              pvag=0                    delta=0.005
+ kt1=-0.1887242            lkt1=-3.179637e-09        wkt1=-2.00967e-08
+ pkt1=1.944595e-15         kt2=0.01                  at=37800.74
+ lat=-0.002511839          wat=0.0008134381          pat=-2.619272e-10
+ ute=-0.8                  ua1=1.691787e-09          lua1=3.740971e-17
+ wua1=6.570216e-16         pua1=-7.576462e-23        ub1=-1.550013e-18
+ lub1=-8.562571e-26        wub1=-9.995162e-25        pub1=5.025138e-32
+ uc1=-4.330339e-10         luc1=1.053065e-17         wuc1=2.178463e-16
+ puc1=-3.031291e-23        kt1l=0                    prt=0
+ alpha0=0                  alpha1=0.001435           beta0=9.351
+ cj=0                      mj=0.4234                 pb=0.9
+ cjsw=0                    mjsw=0.1716               pbsw=0.9
+ cjswg=0                   mjswg=0.4413              pbswg=0.9
+ tcj=0.000887              tcjsw=0.000298            tcjswg=0.000298
+ tpb=0.001643              tpbsw=0.001643            tpbswg=0.001643
+ js=1.80e-7                jsw=8.055e-13             cgdo=cgoprf
+ cgso=cgoprf               cgbo=0                    capmod=3
+ nqsmod=0                  xpart=0                   cf=0
+ tlev=1                    tlevc=1                   xti=3
+ n=1                       hdif=hdifprf              ldif=8e-08
+ rsh=rshprf                rs=0                      rd=0
+ dlc=3.30e-8               cgdl=cglprf               cgsl=cglprf
+ wwc=-5.5e-2               dwc=0                     noia=1.0e+19
+ noib=1.0e+3               noic=1.0e-11              em=1.0e+8
+ ef=1.107                  noimod=2                  noff=1.83
+ voffcv=-0.026             clc=0                     sa0=0.35e-6
+ sb0=0.35e-6               kvsat=-0.6                wlod=0.3e-6
+ tku0=0.50                 ku0=1.14e-7               llodku0=1
+ wlodku0=1                 lku0=6e-8                 wku0=3.0e-7
+ pku0=1e-14                kvth0=-2.3e-9             stk2=0e-9
+ steta0=0                  lkvth0=1e-8               wkvth0=2.5e-7
+ pkvth0=4e-14              llodvth=1                 wlodvth=1
+ lodk2=1                   lodeta0=1                 minr=1e-3
+ imax=0.01                 imelt=0.01
     }

model pdio_rf_f diode
+ level=1                   is=1.800e-07
+ n=1.0                     bv=8.4                    ibv=0.02
+ isw=8.06e-13              cj=cjprf                  vj=0.9
+ mj=0.4234                 cjsw=cjswprf              vjsw=0.9
+ mjsw=0.114                tlev=1                    eg=1.17
+ xti=3                     tbv1=-1*-0.000845
+ tlevc=1                   cta=0.000887              ctp=0.000298
+ pta=0.001643              ptp=0.001643              tnom=25
+ fc=0                      area=3.92e-08             pj=0.00084
+ ns=1.0                    nz=1.0                    imax=1e40
+ minr=1e-10                allow_scaling=1

model pdio_rf_g diode
+ level=1                   is=1.800e-07
+ n=1.0                     bv=8.4                    ibv=0.02
+ isw=8.06e-13              cj=cjprf                  vj=0.9
+ mj=0.4234                 cjsw=cjswgprf             vjsw=0.9
+ mjsw=0.485                tlev=1                    eg=1.17
+ xti=3                     tbv1=-1*-0.000845
+ tlevc=1                   cta=0.000887              ctp=0.000298
+ pta=0.001643              ptp=0.001643              tnom=25
+ fc=0                      area=3.92e-08             pj=0.00084
+ ns=1.0                    nz=1.0                    imax=1e40
+ minr=1e-10                allow_scaling=1

ends pmos_rf_mis

inline subckt pmos_rf_nw_mis ( d g s b )
parameters lr=13.e-08 nr=1 wr=2.5e-6 lspace=0.42u ledge=2.0u ledgeeff=0.73u lsti=1.0u
+ wsti=2.0u rod=805 rsti=2148 ns=int(nr / 2 + 1) nd=int((nr + 1) / 2)
+ nodd=(nr - int(nr / 2) * 2) dummyflag=1 sleff=ledge
+ + dummyflag * (ledgeeff - ledge) sreff=ledge + dummyflag * (ledgeeff - ledge)
+ ldios=(ns - 2) * lspace + sleff + sreff + nodd * (lspace - sleff) ldiod=(ns -
+ 1) * lspace + nodd * sleff lod=nr * (lr + lspace) + 2 * ledge - lspace sdiofa=wr
+ * ldios sdiofp=2 * ldios + (2 - nodd) * wr * (1 - dummyflag) ddiofa=wr * ldiod
+ ddiofp=2 * ldiod + nodd * wr * (1 - dummyflag) sdiogp=wr * nr + (2 - nodd) * wr
+ * dummyflag ddiogp=wr * nr + nodd * wr * dummyflag sax=1 / (log((ledge + lr /
+ 2 + nr * (lr + lspace)) * (ledge + lr / 2 + (nr - 1) * (lr + lspace)) / (ledge
+ + lspace + 3 * lr / 2) / (ledge + lr / 2)) / (2 * nr * (lr + lspace)) + 1 / (nr
+ * (ledge + lr / 2))) - lr / 2 rsx=(0.0158
+ * (lr * 1e6 + 0.42) * (2 * ns + 1 / ns - 3) + 0.771 / ns + 0.232) / (wr * 1e6)
+ rdx=0.0053 * (lr * 1e6 + 0.42) * (nd + 2 / nd) + 0.138 * (wr * 1e6 + 2.16) / nd
+ + 0.0867 / (1.2 + (nd - 1) * (lr * 1e6 + 0.42)) rgx=((0.625 * (wr * 1e6 + 0.96)
+ / (lr * 1e6 - 0.02) + 6.46) / nr + nr * (0.000286 * wr * 1e6 + 0.0139) + 0.0138
+ * wr * 1e6 + 0.718 * lr * 1e6 + 1223 * lr / nr / wr + 4.689)
+ rbx=(rod * lod / 12 + rsti * lsti / 2) * (rod * wr / 12 +
+ rsti * wsti / 2) / (lod * (rod * lod / 12 + rsti * lsti / 2) + wr * (rod * wr
+ / 12 + rsti * wsti / 2)) rdbx=rod * lr / (wr * nr * 2) cgsx=(1.3 * nr * (lr *
+ 1e6 + 0.42) / (0.1 * wr * 1e6 + 2.9) + 0.2 * wr * 1e6 + 0.67) * 1e-15 cgdx=(0.19
+ * nr * lr * 1e6 + 0.07 * nr + 0.282) * 1e-15 cdsx=(0.1 + 0.062 * nr * wr * 1e6
+ / (lr * 1e6 + 0.6) + 1.8 * nr * (lr * 1e6 + 0.42) / (wr * 1e6 + 9.8)) * 1e-15
+ jf=1.1575e-07 ef=7.127e+06 jr=2.8e-8 er=4.373e6
+ w1=(wr + 0.015e-6 + dxwrf) * nr l1=lr + dxlrf - 0.02e-6 tox=(toxprf - 8e-10) *
+ 1e2 tcc=1 + 1.4e-3 * (temp - 25) area=w1 * 6.1e-9 * 1e4 * tcc varaf= - 0.70902
+ * log(l1) + 5.9821 varbf=1.2 * ef * tox varbr=0.52 * er * tox varar= - 0.31121
+ * log(l1) + 24.530 forward_eff=area * jf * exp( - ef * tox * varaf) / pow(tox,2.5)
+ reverse_eff=area * jr * exp( - er * tox * varar) / pow(tox,2.5) tmp1=varbf + 2.0
+ tmp2=varbr + 2.0 temp1=parprf1 temp2=parprf2 fac1=0.778
+ * temp1 + 0.629 * temp2 fac2=0.778 * temp1 - 0.629 * temp2 lef=lr - 2.0e-8 wef=wr
+ + 1.5e-8 geo_fac=1 / sqrt(nr * lef * wef * 1e12) vthmis=0.002585 * geo_fac
+ * fac1 dlmis=0.001932 * geo_fac * lef * fac2 dwmis= - 0.001932 * geo_fac * wef
+ * fac2 toxmis=0.001932 * geo_fac * toxprf * fac2

rg ( g gi ) resistor r=rgx
rs ( s si ) resistor r=rsx
rd ( d di ) resistor r=rdx
//  ********************
cgs_m ( gi si ) capacitor c=cgsx
cgd_m ( gi di ) capacitor c=cgdx
cds_m ( si di ) capacitor c=cdsx
//  *** Diodes  ****************
dss ( si sb ) pdio_rf_f area=sdiofa pj=sdiofp
ddd ( di db ) pdio_rf_f area=ddiofa pj=ddiofp
dsg ( si sb ) pdio_rf_g area=1e-15 pj=sdiogp
ddg ( di db ) pdio_rf_g area=1e-15 pj=ddiogp
//  ***************************************************************************
rb ( b bi ) resistor r=rbx tc1=0.00374 tc2=9.10e-6
cb ( b bi ) capacitor c=169f / rbx
rdb ( db bi ) resistor r=rdbx tc1=0.00374 tc2=9.10e-6
cdb ( db bi ) capacitor c=169f / rdbx
rsb ( sb bi ) resistor r=rdbx tc1=0.00374 tc2=9.10e-6
csb ( sb bi ) capacitor c=169f / rdbx
pmos_rf_nw_mis ( di gi si bi ) pch_rf l=lr w=wr m=nr ad=0 as=0 pd=0 ps=0 sa=sax sb=sax
gdf1 ( di gi ) bsource i =forward_eff * pow((abs(v(di,gi)) + v(di,gi)) / 2,tmp1)
+ - reverse_eff * pow((abs(v(di,gi)) - v(di,gi)) / 2,tmp2) + 1e-18 * v(di,gi)
gdf2 ( si gi ) bsource i =forward_eff * pow((abs(v(si,gi)) + v(si,gi)) / 2,tmp1)
+ - reverse_eff * pow((abs(v(si,gi)) - v(si,gi)) / 2,tmp2) + 1e-18 * v(si,gi)
 model pch_rf bsim3v3  {
     1: type=p
+ lmin=1.30e-07             lmax=3.501e-07            wmin=1.20e-06
+ wmax=1.0005e-05           tnom=25                   version=3.24
+ tox=toxprf+toxmis                toxm=toxprf+toxmis               xj=2.1e-07
+ nch=7.3e+17               lln=1                     lwn=1
+ wln=1                     wwn=-1                    lint=4e-09
+ ll=0                      lw=0                      lwl=0
+ wint=-6.5e-09             wl=0                      ww=0
+ wwl=0                     mobmod=1                  binunit=2
+ xl=-2.0e-08+dxlrf+dlmis         xw=1.5e-08+dxwrf+dwmis          dwg=0
+ dwb=0                     vth0=-0.3007786+dvthprf+vthmis   lvth0=-1.2452491e-08+dlvthprf
+ wvth0=1.2451168e-08+dwvthprf                        pvth0=-3.8804420e-16+dpvthprf
+ k1=0.4343991              lk1=5.106258e-09          wk1=1.955284e-08
+ pk1=-6.296016e-15         k2=-0.001+dk2prf          lk2=0+dlk2prf
+ k3=0
+ dvt0=0                    dvt1=0                    dvt2=0
+ dvt0w=0                   dvt1w=0                   dvt2w=0
+ nlx=0                     w0=0                      k3b=0
+ vfb=-0.9415483            vsat=7.5100910e+04        lvsat=1.5775075e-03+dlvsatprf
+ wvsat=5.4269470e-03       pvsat=-1.7474771e-09+dpvsatprf      ua=1.97713e-09
+ lua=-3.3012e-17           wua=2.219549e-16          pua=-2.6204e-23
+ ub=-6.506528e-19          lub=-4.222554e-26         wub=-6.450149e-26
+ pub=5.245532e-32          uc=-1.75756e-10           rdsw=445
+ prwb=0                    prwg=0                    wr=1
+ u0=0.01419055             lu0=-1.703087e-11         wu0=-2.498718e-09
+ pu0=1.708708e-16          a0=1                      keta=-0.001
+ a1=0                      a2=0.99                   ags=0.4
+ b0=0                      b1=0                      voff=-0.1158204
+ lvoff=-3.966937e-09       wvoff=3.397306e-09        pvoff=-6.412771e-16
+ nfactor=0.8082265         lnfactor=2.955105e-08     wnfactor=-9.569868e-09
+ pnfactor=3.081497e-15     cit=-4.0173460e-04        lcit=1.2935854e-10
+ wcit=4.9533890e-10        pcit=-1.5949910e-16       cdsc=0
+ cdscb=0                   cdscd=0                   eta0=1.5685277e-04
+ leta0=7.5449350e-10       weta0=2.5048039e-10
+ peta0=-8.0654780e-17      etab=0.001460148          letab=-5.023678e-10
+ wetab=1.626878e-10        petab=-5.238544e-17       dsub=0
+ pclm=0.6714336            lpclm=3.173837e-08        wpclm=-8.096643e-08
+ ppclm=2.607119e-14        pdiblc1=0                 pdiblc2=-0.0003129804
+ lpdiblc2=1.329797e-10     wpdiblc2=-4.306437e-11    ppdiblc2=1.386674e-17
+ pdiblcb=0                 drout=0                   pscbe1=4.24e+08
+ pscbe2=1e-07              pvag=0                    delta=0.005
+ kt1=-0.1887242            lkt1=-3.179637e-09        wkt1=-2.00967e-08
+ pkt1=1.944595e-15         kt2=0.01                  at=37800.74
+ lat=-0.002511839          wat=0.0008134381          pat=-2.619272e-10
+ ute=-0.8                  ua1=1.691787e-09          lua1=3.740971e-17
+ wua1=6.570216e-16         pua1=-7.576462e-23        ub1=-1.550013e-18
+ lub1=-8.562571e-26        wub1=-9.995162e-25        pub1=5.025138e-32
+ uc1=-4.330339e-10         luc1=1.053065e-17         wuc1=2.178463e-16
+ puc1=-3.031291e-23        kt1l=0                    prt=0
+ alpha0=0                  alpha1=0.001435           beta0=9.351
+ cj=0                      mj=0.4234                 pb=0.9
+ cjsw=0                    mjsw=0.1716               pbsw=0.9
+ cjswg=0                   mjswg=0.4413              pbswg=0.9
+ tcj=0.000887              tcjsw=0.000298            tcjswg=0.000298
+ tpb=0.001643              tpbsw=0.001643            tpbswg=0.001643
+ js=1.80e-7                jsw=8.055e-13             cgdo=cgoprf
+ cgso=cgoprf               cgbo=0                    capmod=3
+ nqsmod=0                  xpart=0                   cf=0
+ tlev=1                    tlevc=1                   xti=3
+ n=1                       hdif=hdifprf              ldif=8e-08
+ rsh=rshprf                rs=0                      rd=0
+ dlc=3.30e-8               cgdl=cglprf               cgsl=cglprf
+ wwc=-5.5e-2               dwc=0                     noia=1.0e+19
+ noib=1.0e+3               noic=1.0e-11              em=1.0e+8
+ ef=1.107                  noimod=2                  noff=1.83
+ voffcv=-0.026             clc=0                     sa0=0.35e-6
+ sb0=0.35e-6               kvsat=-0.6                wlod=0.3e-6
+ tku0=0.50                 ku0=1.14e-7               llodku0=1
+ wlodku0=1                 lku0=6e-8                 wku0=3.0e-7
+ pku0=1e-14                kvth0=-2.3e-9             stk2=0e-9
+ steta0=0                  lkvth0=1e-8               wkvth0=2.5e-7
+ pkvth0=4e-14              llodvth=1                 wlodvth=1
+ lodk2=1                   lodeta0=1                 minr=1e-3
+ imax=0.01                 imelt=0.01
     }

model pdio_rf_f diode
+ level=1                   is=1.800e-07
+ n=1.0                     bv=8.4                    ibv=0.02
+ isw=8.06e-13              cj=cjprf                  vj=0.9
+ mj=0.4234                 cjsw=cjswprf              vjsw=0.9
+ mjsw=0.114                tlev=1                    eg=1.17
+ xti=3                     tbv1=-1*-0.000845
+ tlevc=1                   cta=0.000887              ctp=0.000298
+ pta=0.001643              ptp=0.001643              tnom=25
+ fc=0                      area=3.92e-08             pj=0.00084
+ ns=1.0                    nz=1.0                    imax=1e40
+ minr=1e-10                allow_scaling=1

model pdio_rf_g diode
+ level=1                   is=1.800e-07
+ n=1.0                     bv=8.4                    ibv=0.02
+ isw=8.06e-13              cj=cjprf                  vj=0.9
+ mj=0.4234                 cjsw=cjswgprf             vjsw=0.9
+ mjsw=0.485                tlev=1                    eg=1.17
+ xti=3                     tbv1=-1*-0.000845
+ tlevc=1                   cta=0.000887              ctp=0.000298
+ pta=0.001643              ptp=0.001643              tnom=25
+ fc=0                      area=3.92e-08             pj=0.00084
+ ns=1.0                    nz=1.0                    imax=1e40
+ minr=1e-10                allow_scaling=1

ends pmos_rf_nw_mis

endsection rf_mos

// *************************************************************************************************
//
//  2.5V MOS MODEL :
//
//
//              .lib RF_MOS25  : Typical model
//
//              Model name         nr               lr (um)           wr (um)
//                              low   high        low    high      low    high
//            -----------------------------------------------------------------
//              nmos_rf25        1     64         0.28   0.5      1.2    10
//            -----------------------------------------------------------------
//              pmos_rf25        1     64         0.28   0.5      1.2    10
//            -----------------------------------------------------------------
//              pmos_rf25_nw     1     64         0.28   0.5      1.2    10
//            -----------------------------------------------------------------
//              nmos_rf25_mis    1     64         0.28   0.5      1.2    10
//            -----------------------------------------------------------------
//              pmos_rf25_mis    1     64         0.28   0.5      1.2    10
//            -----------------------------------------------------------------
//              pmos_rf25_nw_mis 1     64         0.28   0.5      1.2    10
//            -----------------------------------------------------------------
//            End Model
//            **nr: Finger number
//            **wr: Width per finger
//
//
// *************************************************************************************************

section rf_mos25

inline subckt nmos_rf25 ( d g s b )
parameters lr=35.0e-08 nr=1 wr=2.5e-6 lspace=0.42u ledge=2.0u ledgeeff=0.73u lsti=1.0u
+ wsti=2.0u rod=2015 rsti=3364 ns=int(nr / 2 + 1) nd=int((nr + 1) / 2) nodd=(nr
+ - int(nr / 2) * 2) dummyflag=1 sleff=ledge + dummyflag * (ledgeeff - ledge) sreff=ledge
+ + dummyflag * (ledgeeff - ledge) ldios=(ns - 2) * lspace + sleff + sreff + nodd
+ * (lspace - sleff) ldiod=(ns - 1) * lspace + nodd * sleff sdiofa=wr * ldios sdiofp=2
+ * ldios + (2 - nodd) * wr * (1 - dummyflag) ddiofa=wr * ldiod ddiofp=2 * ldiod
+ + nodd * wr * (1 - dummyflag) sdiogp=wr * nr + (2 - nodd) * wr * dummyflag ddiogp=wr
+ * nr + nodd * wr * dummyflag rsx=(0.0158 * (lr * 1e6 + 0.42) * (2 * ns + 1 / ns
+ - 3) + 0.771 / ns + 0.232) / (wr * 1e6) rdx=0.0053 * (lr * 1e6 + 0.42) * (nd +
+ 2 / nd) + 0.138 * (wr * 1e6 + 2.16) / nd + 0.0867 / (1.2 + (nd - 1) * (lr * 1e6
+ + 0.42)) rgx=((0.625 * (wr * 1e6 + 0.96) / (lr * 1e6 - 0.02) + 6.46) / nr + nr
+ * (0.000286 * wr * 1e6 + 0.0139) + 0.0138 * wr * 1e6 + 0.718 * lr * 1e6 + 349
+ * lr / nr / wr + 2.389) lod=nr * (lr + lspace) + 2 * ledge - lspace rbx=(rod *
+ lod / 12 + rsti * lsti / 2) * (rod * wr / 12 + rsti * wsti / 2) / (lod * (rod
+ * lod / 12 + rsti * lsti / 2) + wr * (rod * wr / 12 + rsti * wsti / 2)) rdbx=rod
+ * lr / (wr * nr * 2) cgsx=(1.3 * nr * (lr * 1e6 + 0.42) / (0.1 * wr * 1e6 + 2.9)
+ + 0.2 * wr * 1e6 + 0.67) * 1e-15 cgdx=(0.19 * nr * lr * 1e6 + 0.07 * nr + 0.282)
+ * 1e-15 cdsx=(0.1 + 0.062 * nr * wr * 1e6 / (lr * 1e6 + 0.6) + 1.8 * nr * (lr
+ * 1e6 + 0.42) / (wr * 1e6 + 9.8)) * 1e-15 sax=1 / (log((ledge + lr / 2 + nr *
+ (lr + lspace)) * (ledge + lr / 2 + (nr - 1) * (lr + lspace)) / (ledge + lspace
+ + 3 * lr / 2) / (ledge + lr / 2)) / (2 * nr * (lr + lspace)) + 1 / (nr * (ledge
+ + lr / 2))) - lr / 2
// ********************
rg ( g gi ) resistor r=rgx
rs ( s si ) resistor r=rsx
rd ( d di ) resistor r=rdx
// ********************
cgs_m ( gi si ) capacitor c=cgsx
cgd_m ( gi di ) capacitor c=cgdx
cds_m ( si di ) capacitor c=cdsx
// **** Diodes  ****************
dss ( sb si ) ndio_rf25_f area=sdiofa pj=sdiofp
ddd ( db di ) ndio_rf25_f area=ddiofa pj=ddiofp
dsg ( sb si ) ndio_rf25_g area=1e-15 pj=sdiogp
ddg ( db di ) ndio_rf25_g area=1e-15 pj=ddiogp
// ****************************************************************************
rb ( b bi ) resistor r=rbx tc1=0.0037 tc2=9.64e-6
cb ( b bi ) capacitor c=162f / rbx
rdb ( db bi ) resistor r=rdbx tc1=0.0037 tc2=9.64e-6
cdb ( db bi ) capacitor c=162f / rdbx
rsb ( sb bi ) resistor r=rdbx tc1=0.0037 tc2=9.64e-6
csb ( sb bi ) capacitor c=162f / rdbx
// ****** MOSFET *******
nmos_rf25 ( di gi si bi ) nch_rf25 l=lr w=wr m=nr ad=0 as=0 pd=0 ps=0 sa=sax sb=sax
ends nmos_rf25
//

inline subckt pmos_rf25 ( d g s b )
parameters lr=30.0e-08 nr=1 wr=2.5e-6 lspace=0.42u ledge=2.0u ledgeeff=0.73u lsti=1.0u
+ wsti=2.0u rod=342 rsti=913 ns=int(nr / 2 + 1) nd=int((nr + 1) / 2) nodd=(nr -
+ int(nr / 2) * 2) dummyflag=1 sleff=ledge + dummyflag * (ledgeeff - ledge) sreff=ledge
+ + dummyflag * (ledgeeff - ledge) ldios=(ns - 2) * lspace + sleff + sreff + nodd
+ * (lspace - sleff) ldiod=(ns - 1) * lspace + nodd * sleff sdiofa=wr * ldios sdiofp=2
+ * ldios + (2 - nodd) * wr * (1 - dummyflag) ddiofa=wr * ldiod ddiofp=2 * ldiod
+ + nodd * wr * (1 - dummyflag) sdiogp=wr * nr + (2 - nodd) * wr * dummyflag ddiogp=wr
+ * nr + nodd * wr * dummyflag rsx=(0.0158 * (lr * 1e6 + 0.42) * (2 * ns + 1 / ns
+ - 3) + 0.771 / ns + 0.232) / (wr * 1e6) rdx=0.0053 * (lr * 1e6 + 0.42) * (nd +
+ 2 / nd) + 0.138 * (wr * 1e6 + 2.16) / nd + 0.0867 / (1.2 + (nd - 1) * (lr * 1e6
+ + 0.42)) rgx=((0.625 * (wr * 1e6 + 0.96) / (lr * 1e6 - 0.02) + 6.46) / nr + nr
+ * (0.000286 * wr * 1e6 + 0.0139) + 0.0138 * wr * 1e6 + 0.718 * lr * 1e6 + 808
+ * lr / nr / wr + 1.589) lod=nr * (lr + lspace) + 2 * ledge - lspace rbx=(rod *
+ lod / 12 + rsti * lsti / 2) * (rod * wr / 12 + rsti * wsti / 2) / (lod * (rod
+ * lod / 12 + rsti * lsti / 2) + wr * (rod * wr / 12 + rsti * wsti / 2)) rdbx=rod
+ * lr / (wr * nr * 2) cgsx=(1.3 * nr * (lr * 1e6 + 0.42) / (0.1 * wr * 1e6 + 2.9)
+ + 0.2 * wr * 1e6 + 0.67) * 1e-15 cgdx=(0.19 * nr * lr * 1e6 + 0.07 * nr + 0.282)
+ * 1e-15 cdsx=(0.1 + 0.062 * nr * wr * 1e6 / (lr * 1e6 + 0.6) + 1.8 * nr * (lr
+ * 1e6 + 0.42) / (wr * 1e6 + 9.8)) * 1e-15 sax=1 / (log((ledge + lr / 2 + nr *
+ (lr + lspace)) * (ledge + lr / 2 + (nr - 1) * (lr + lspace)) / (ledge + lspace
+ + 3 * lr / 2) / (ledge + lr / 2)) / (2 * nr * (lr + lspace)) + 1 / (nr * (ledge
+ + lr / 2))) - lr / 2

// ********************
rg ( g gi ) resistor r=rgx
rs ( s si ) resistor r=rsx
rd ( d di ) resistor r=rdx
// ********************
cgs_m ( gi si ) capacitor c=cgsx
cgd_m ( gi di ) capacitor c=cgdx
cds_m ( si di ) capacitor c=cdsx
// **** Diodes  ****************
dss ( si sb ) pdio_rf25_f area=sdiofa pj=sdiofp
ddd ( di db ) pdio_rf25_f area=ddiofa pj=ddiofp
dsg ( si sb ) pdio_rf25_g area=1e-15 pj=sdiogp
ddg ( di db ) pdio_rf25_g area=1e-15 pj=ddiogp
// ****************************************************************************
rb ( b bi ) resistor r=rbx tc1=0.00374 tc2=9.10e-6
cb ( b bi ) capacitor c=169f / rbx
rdb ( db bi ) resistor r=rdbx tc1=0.00374 tc2=9.10e-6
cdb ( db bi ) capacitor c=169f / rdbx
rsb ( sb bi ) resistor r=rdbx tc1=0.00374 tc2=9.10e-6
csb ( sb bi ) capacitor c=169f / rdbx
// ****** MOSFET *******
pmos_rf25 ( di gi si bi ) pch_rf25 l=lr w=wr m=nr ad=0 as=0 pd=0 ps=0 sa=sax sb=sax
ends pmos_rf25
//

inline subckt pmos_rf25_nw ( d g s b )
parameters lr=30.0e-08 nr=1 wr=2.5e-6 lspace=0.42u ledge=2.0u ledgeeff=0.73u lsti=1.0u
+ wsti=2.0u rod=805 rsti=2148 ns=int(nr / 2 + 1) nd=int((nr + 1) / 2) nodd=(nr -
+ int(nr / 2) * 2) dummyflag=1 sleff=ledge + dummyflag * (ledgeeff - ledge) sreff=ledge
+ + dummyflag * (ledgeeff - ledge) ldios=(ns - 2) * lspace + sleff + sreff + nodd
+ * (lspace - sleff) ldiod=(ns - 1) * lspace + nodd * sleff sdiofa=wr * ldios sdiofp=2
+ * ldios + (2 - nodd) * wr * (1 - dummyflag) ddiofa=wr * ldiod ddiofp=2 * ldiod
+ + nodd * wr * (1 - dummyflag) sdiogp=wr * nr + (2 - nodd) * wr * dummyflag ddiogp=wr
+ * nr + nodd * wr * dummyflag rsx=(0.0158 * (lr * 1e6 + 0.42) * (2 * ns + 1 / ns
+ - 3) + 0.771 / ns + 0.232) / (wr * 1e6) rdx=0.0053 * (lr * 1e6 + 0.42) * (nd +
+ 2 / nd) + 0.138 * (wr * 1e6 + 2.16) / nd + 0.0867 / (1.2 + (nd - 1) * (lr * 1e6
+ + 0.42)) rgx=((0.625 * (wr * 1e6 + 0.96) / (lr * 1e6 - 0.02) + 6.46) / nr + nr
+ * (0.000286 * wr * 1e6 + 0.0139) + 0.0138 * wr * 1e6 + 0.718 * lr * 1e6 + 808
+ * lr / nr / wr + 1.589) lod=nr * (lr + lspace) + 2 * ledge - lspace rbx=(rod *
+ lod / 12 + rsti * lsti / 2) * (rod * wr / 12 + rsti * wsti / 2) / (lod * (rod
+ * lod / 12 + rsti * lsti / 2) + wr * (rod * wr / 12 + rsti * wsti / 2)) rdbx=rod
+ * lr / (wr * nr * 2) cgsx=(1.3 * nr * (lr * 1e6 + 0.42) / (0.1 * wr * 1e6 + 2.9)
+ + 0.2 * wr * 1e6 + 0.67) * 1e-15 cgdx=(0.19 * nr * lr * 1e6 + 0.07 * nr + 0.282)
+ * 1e-15 cdsx=(0.1 + 0.062 * nr * wr * 1e6 / (lr * 1e6 + 0.6) + 1.8 * nr * (lr
+ * 1e6 + 0.42) / (wr * 1e6 + 9.8)) * 1e-15 sax=1 / (log((ledge + lr / 2 + nr *
+ (lr + lspace)) * (ledge + lr / 2 + (nr - 1) * (lr + lspace)) / (ledge + lspace
+ + 3 * lr / 2) / (ledge + lr / 2)) / (2 * nr * (lr + lspace)) + 1 / (nr * (ledge
+ + lr / 2))) - lr / 2

// ********************
rg ( g gi ) resistor r=rgx
rs ( s si ) resistor r=rsx
rd ( d di ) resistor r=rdx
// ********************
cgs_m ( gi si ) capacitor c=cgsx
cgd_m ( gi di ) capacitor c=cgdx
cds_m ( si di ) capacitor c=cdsx
// **** Diodes  ****************
dss ( si sb ) pdio_rf25_f area=sdiofa pj=sdiofp
ddd ( di db ) pdio_rf25_f area=ddiofa pj=ddiofp
dsg ( si sb ) pdio_rf25_g area=1e-15 pj=sdiogp
ddg ( di db ) pdio_rf25_g area=1e-15 pj=ddiogp
// ****************************************************************************
rb ( b bi ) resistor r=rbx tc1=0.00374 tc2=9.10e-6
cb ( b bi ) capacitor c=169f / rbx
rdb ( db bi ) resistor r=rdbx tc1=0.00374 tc2=9.10e-6
cdb ( db bi ) capacitor c=169f / rdbx
rsb ( sb bi ) resistor r=rdbx tc1=0.00374 tc2=9.10e-6
csb ( sb bi ) capacitor c=169f / rdbx
// ****** MOSFET *******
pmos_rf25_nw ( di gi si bi ) pch_rf25 l=lr w=wr m=nr ad=0 as=0 pd=0 ps=0 sa=sax sb=sax
ends pmos_rf25_nw
//   //
// **************************************************************
//                                                              *
//              2.5V NMOS DEVICES MODEL                         *
//                                                              *
// **************************************************************
model nch_rf25 bsim3v3  {
     1: type=n
+ lmin=2.8e-007             lmax=5.01e-007            wmin=1.2e-006
+ wmax=10.01e-006           tnom=25                   version=3.24
+ tox=toxnrf_25             toxm=toxnrf_25            xj=1.9e-07
+ nch=3.28e+17              lln=1                     lwn=1
+ wln=1                     wwn=-1                    lint=3.1e-08
+ wint=1.95e-08             mobmod=1                  binunit=2
+ xl=-4e-08+dxlrf_25        xw=1e-8+dxwrf_25          dwg=0
+ dwb=0                     ldif=8e-08                hdif=hdifnrf_25
+ rsh=6.6                   rd=0                      rs=0
+ vth0=0.6844962+dvthnrf_25 lvth0=-2.467325e-08+dlvthnrf_25
+ wvth0=-4.611279e-08+dwvthnrf_25                     pvth0=1.436083e-14+dpvthnrf_25
+ k1=0.8531682              lk1=-8.657477e-08         wk1=-2.425473e-07
+ pk1=7.057792e-14          k2=-0.05141579+dk2nrf_25  lk2=-1.554543e-09+dlk2nrf_25
+ wk2=5.928379e-08          pk2=-1.755766e-14         k3=0
+ dvt0=0                    dvt1=0                    dvt2=0
+ dvt0w=0                   dvt1w=0                   dvt2w=0
+ nlx=0                     w0=0                      k3b=0
+ vfb=-0.7652686            vsat=8.6448090e+04        lvsat=-5.7633940e-04+dlvsatnrf_25
+ wvsat=-1.7101926e-03      pvsat=6.8065680e-10       ua=-7.156305e-10
+ lua=7.263201e-18          wua=7.741344e-17          pua=-1.48899e-24
+ ub=2.17854e-18            lub=-1.327395e-25         wub=-7.808022e-25
+ pub=9.218037e-32          uc=1.243654e-10           luc=-2.194589e-17
+ wuc=-7.08698e-17          puc=1.290974e-23          rdsw=325.9
+ prwb=0                    prwg=0                    wr=1
+ u0=0.03633325             lu0=-3.323704e-10         wu0=-8.728519e-09
+ pu0=2.04032e-16           a0=0.2551618              la0=1.203947e-07
+ wa0=4.091018e-07          pa0=-2.363322e-13         keta=-0.06037572
+ lketa=1.582387e-08        wketa=1.872172e-08        pketa=-8.606989e-15
+ a1=0                      a2=0.99                   ags=-0.02971154
+ lags=1.728653e-09         wags=9.693079e-08         pags=-1.725368e-14
+ b0=0                      b1=0                      voff=-0.09485205
+ lvoff=-6.399188e-09       wvoff=-8.496678e-08       pvoff=1.415763e-14
+ nfactor=1                 cit=1.87189e-05           lcit=7.270839e-11
+ wcit=1.032899e-09         pcit=-1.772961e-16        cdsc=0
+ cdscb=0                   cdscd=0                   eta0=-4.4818090e-04
+ leta0=5.7637610e-10       weta0=-2.1118445e-09      peta0=8.4051400e-16
+ etab=-0.0001431909        letab=-3.410101e-10       wetab=-5.635467e-11
+ petab=2.242921e-17        dsub=0                    pclm=0.7395863
+ lpclm=4.393965e-08        wpclm=7.346791e-09        ppclm=-2.87391e-15
+ pdiblc1=1e-06             pdiblc2=-0.03464225       lpdiblc2=1.577762e-08
+ wpdiblc2=1.337371e-08     ppdiblc2=-5.322741e-15    pdiblcb=0.01
+ drout=0                   pscbe1=3.5e+08            pscbe2=1e-06
+ pvag=0                    delta=0.01                alpha0=0
+ alpha1=0.7997             beta0=14.401              kt1=-0.3076753
+ lkt1=1.479193e-08         wkt1=-1.008979e-08        pkt1=-2.732598e-15
+ kt2=-0.03407931           lkt2=3.146365e-09         wkt2=-2.645907e-09
+ pkt2=1.527902e-16         at=1431.908               lat=0.0034101
+ wat=0.0005635483          pat=-2.242926e-10         ute=-1.371134
+ lute=-5.164809e-09        wute=3.060447e-07         pute=-1.120987e-14
+ ua1=1.833928e-09          lua1=-3.618919e-17        wua1=1.018181e-16
+ pua1=-4.052361e-23        ub1=-2.309933e-18         lub1=2.244739e-25
+ wub1=4.74888e-25          pub1=-6.789896e-32        uc1=-7.1775e-12
+ luc1=4.941405e-18         wuc1=-2.410485e-18        puc1=-1.280585e-24
+ kt1l=0                    prt=0                     cj=0
+ mj=0.3193271              pb=0.7249372              cjsw=0
+ mjsw=0.01                 pbsw=0.7249372            cjswg=0
+ mjswg=0.01                pbswg=0.7249372           tpb=0.001816363
+ tpbsw=0.001816363         tpbswg=0.001816363        tcj=0.001010853
+ tcjsw=9.297595e-05        tcjswg=9.297595e-05       js=4.03e-7
+ jsw=1.8e-12               n=1                       xti=3
+ cgdo=cgonrf_25            cgso=cgonrf_25            capmod=3
+ nqsmod=0                  xpart=0                   cf=0
+ tlev=1                    tlevc=1                   dlc=4.6e-08
+ cgbo=0                    cgdl=cglnrf_25            cgsl=cglnrf_25
+ wwc=-1.22e-2              dwc=0                     noia=8.0e+19
+ noib=2.5e+4               noic=1.0e-13              em=1.1e+7
+ ef=0.872                  noimod=2                  sa0=0.35e-6
+ sb0=0.35e-6               kvsat=0.35                wlod=0.3e-6
+ tku0=0.03                 ku0=-5.95e-8              llodku0=1
+ wlodku0=1                 lku0=1.493e-7             wku0=3.5e-7
+ pku0=0                    kvth0=7.2e-9              stk2=0
+ steta0=-1.1e-10           lkvth0=-5e-8              wkvth0=5e-6
+ pkvth0=0                  llodvth=1.0               wlodvth=1
+ lodk2=1                   lodeta0=2                 clc=0
+ minr=1e-3                 imax=0.01                 imelt=0.01
+ noff=1.865                voffcv=-0.03
//
  }
model ndio_rf25_f diode
+ level=1                   is=4.03e-7                n=1
+ bv=13.1                   ibv=0.03                  isw=1.8e-12
+ cj=cjnrf_25               pj=8.4e-4                 mj=0.3193271
+ fc=0                      cjsw=cjswnrf_25           area=3.92e-8
+ mjsw=0.01                 tlevc=1                   cta=0.001010853
+ ctp=9.297595e-05          tbv1=-1*-9.0e-4           tlev=1
+ xti=3                     eg=1.17                   vjsw=0.7249372
+ vj=0.7249372              pta=0.001816363           tnom=25
+ ptp=0.001816363           ns=1                      nz=1
+ imax=1e40                 minr=1e-10                allow_scaling=1

//
model ndio_rf25_g diode
+ level=1                   is=4.03e-7                n=1
+ bv=13.1                   ibv=0.03                  isw=1.8e-12
+ cj=cjnrf_25               pj=8.4e-4                 mj=0.3193271
+ fc=0                      cjsw=cjswgnrf_25          area=3.92e-8
+ mjsw=0.01                 tlevc=1                   cta=0.001010853
+ ctp=9.297595e-05          tbv1=-1*-9.0e-4           tlev=1
+ xti=3                     eg=1.17                   vjsw=0.7249372
+ vj=0.7249372              pta=0.001816363           tnom=25
+ ptp=0.001816363           ns=1                      nz=1
+ imax=1e40                 minr=1e-10                allow_scaling=1

model pch_rf25 bsim3v3  {
     1: type=p
+ lmin=2.8e-007             lmax=5.01e-007            wmin=1.2e-006
+ wmax=10.01e-006           tnom=25                   version=3.24
+ tox=toxprf_25             toxm=toxprf_25            xj=2.1e-07
+ nch=7.22e+17              lln=1                     lwn=1
+ wln=1                     wwn=-1                    lint=4.4e-08
+ wint=5e-09                mobmod=1                  binunit=2
+ xl=-4e-08+dxlrf_25        xw=1e-8+dxwrf_25          dwg=0
+ dwb=0                     ldif=8e-08                hdif=hdifprf_25
+ rsh=7.2                   rd=0                      rs=0
+ vth0=-0.64129175+dvthprf_25                         lvth0=2.3027418e-08+dlvthprf_25
+ wvth0=1.9674751e-08+dwvthprf_25                     pvth0=-5.2895013e-15+dpvthprf_25
+ k1=0.7562134              lk1=5.515479e-08          wk1=6.032497e-08
+ pk1=-2.646622e-14         k2=0.0499368+dk2prf_25    lk2=-3.829295e-08+dlk2prf_25
+ wk2=-6.148596e-08         pk2=1.521488e-14          k3=0
+ dvt0=0                    dvt1=0                    dvt2=0
+ dvt0w=0                   dvt1w=0                   dvt2w=0
+ nlx=0                     w0=0                      k3b=0
+ vfb=-1.400653             vsat=98625.01             wvsat=0.01376373
+ ua=3.604407e-10           lvsat=0+dlvsatprf_25      lua=-4.535359e-17
+ wua=6.245323e-17          pua=-9.8606e-24           ub=1.114336e-18
+ lub=5.417961e-26          wub=1.556058e-25          pub=3.849286e-32
+ uc=4.846232e-11           luc=-3.747956e-18         wuc=-5.543386e-17
+ puc=1.225494e-23          rdsw=784.6                prwb=0
+ prwg=0                    wr=1                      u0=0.01144613
+ lu0=-3.090805e-10         wu0=-1.206365e-09         pu0=-1.379744e-16
+ a0=0.5519273              la0=5.56803e-08           wa0=-1.519973e-07
+ pa0=-2.843797e-14         keta=-0.04863737          lketa=6.936704e-09
+ wketa=2.068658e-09        pketa=-3.491148e-15       a1=0
+ a2=0.99                   ags=0.02                  b0=0
+ b1=0                      voff=-0.0989763           lvoff=2.506003e-09
+ wvoff=-1.448955e-08       pvoff=-1.99603e-15        nfactor=1
+ cit=7.246053e-05          lcit=-2.243561e-11        wcit=-6.972834e-11
+ pcit=2.681678e-17         cdsc=0                    cdscb=0
+ cdscd=0                   eta0=6.2043840e-04        leta0=-1.1920305e-10
+ weta0=-1.8089307e-09      peta0=6.7292220e-16       etab=0.001636668
+ letab=-7.204406e-10       wetab=-5.041685e-10       petab=1.875508e-16
+ dsub=0                    pclm=0.6178901            lpclm=5.124457e-08
+ wpclm=1.495026e-09        ppclm=-3.482891e-16       pdiblc1=1e-06
+ pdiblc2=-0.005677225      lpdiblc2=2.483928e-09     wpdiblc2=3.899443e-09
+ ppdiblc2=-1.450593e-15    pdiblcb=0.01              drout=0
+ pscbe1=3.5e+08            pscbe2=5e-07              pvag=0
+ delta=0.01                alpha0=0                  alpha1=1.0857
+ beta0=23.74               kt1=-0.2076636            lkt1=-2.431654e-08
+ wkt1=-7.121064e-08        pkt1=3.001055e-14         kt2=-0.01723043
+ lkt2=-2.900122e-09        wkt2=-1.394708e-08        pkt2=3.491342e-15
+ at=-50000                 ute=-0.763168             lute=-3.338875e-08
+ wute=-5.426509e-09        pute=3.63037e-14          ua1=1.752e-09
+ ub1=-2.122632e-18         lub1=2.081626e-26         wub1=-5.678085e-26
+ pub1=-5.863848e-32        uc1=-4.384848e-11         luc1=9.295796e-18
+ wuc1=8.56422e-17          puc1=-1.721515e-23        kt1l=0
+ prt=0                     cj=0                      mj=0.3952264
+ pb=0.854899               cjsw=0                    mjsw=0.0450429
+ pbsw=0.854899             cjswg=0                   mjswg=0.0450429
+ pbswg=0.854899            tpb=0.001603538           tpbsw=0.001603538
+ tpbswg=0.001603538        tcj=0.0009016089          tcjsw=0.0001793034
+ tcjswg=0.0001793034       js=2.0e-7                 jsw=1.36e-12
+ n=1                       xti=3                     cgdo=cgoprf_25
+ cgso=cgoprf_25            capmod=3                  nqsmod=0
+ xpart=0                   cf=0                      tlev=1
+ tlevc=1                   dlc=3.68e-8               cgbo=0
+ cgdl=cglprf_25            cgsl=cglprf_25            wwc=-1.20e-2
+ dwc=0                     noia=5.0e+19              noib=4.0e+3
+ noic=8.0e-12              em=4.1e+7                 ef=1.152
+ noimod=2                  sa0=0.35e-6               sb0=0.35e-6
+ kvsat=-1                  wlod=0.3e-6               tku0=0.03
+ ku0=8.5e-08               llodku0=1                 wlodku0=1
+ lku0=8.0e-09              wku0=6.0e-07              pku0=0
+ kvth0=1.0e-09             stk2=0                    steta0=-3e-10
+ lkvth0=-1.0e-10           wkvth0=0                  pkvth0=0
+ llodvth=1                 wlodvth=1                 lodk2=1
+ lodeta0=1                 clc=0                     minr=1e-3
+ imax=0.01                 imelt=0.01
+ noff=1.865                voffcv=-0.02
//
  }
model pdio_rf25_f diode
+ level=1                   is=2.0e-7                 n=1
+ bv=9.8                    ibv=0.03                  isw=1.36e-12
+ cj=cjprf_25               pj=8.4e-4                 mj=0.3952264
+ fc=0                      cjsw=cjswprf_25           area=3.92e-8
+ mjsw=0.0450429            tlevc=1                   cta=0.0009016089
+ ctp=0.0001793034          tbv1=-1*-8.1e-4           tlev=1
+ xti=3                     eg=1.17                   vjsw=0.854899
+ vj=0.854899               pta=0.001603538           tnom=25
+ ptp=0.001603538           ns=1                      nz=1
+ imax=1e40                 minr=1e-10                allow_scaling=1

//
model pdio_rf25_g diode
+ level=1                   is=2.0e-7                 n=1
+ bv=9.8                    ibv=0.03                  isw=1.36e-12
+ cj=cjprf_25               pj=8.4e-4                 mj=0.3952264
+ fc=0                      cjsw=cjswgprf_25          area=3.92e-8
+ mjsw=0.0450429            tlevc=1                   cta=0.0009016089
+ ctp=0.0001793034          tbv1=-1*-8.1e-4           tlev=1
+ xti=3                     eg=1.17                   vjsw=0.854899
+ vj=0.854899               pta=0.001603538           tnom=25
+ ptp=0.001603538           ns=1                      nz=1
+ imax=1e40                 minr=1e-10                allow_scaling=1

inline subckt nmos_rf25_mis ( d g s b )
parameters lr=35.0e-08 nr=1 wr=2.5e-6 temp1=parnrf1_25 temp2=parnrf2_25 fac1=0.427
+ * temp1 + 0.904 * temp2 fac2=0.427 * temp1 - 0.904 * temp2 lef=lr - 4.0e-8 wef=wr
+ + 1.0e-8 geo_fac=1 / sqrt(nr * lef * wef * 1e12) vthmis=0.006243 * geo_fac * fac1
+ dlmis=0.002279 * geo_fac * lef * fac2 dwmis= - 0.002279 * geo_fac * wef * fac2
+ toxmis=0.002279 * geo_fac * toxnrf_25 * fac2 lspace=0.42u ledge=2.0u ledgeeff=0.73u
+ lsti=1.0u wsti=2.0u rod=2015 rsti=3364 ns=int(nr / 2 + 1) nd=int((nr + 1) / 2)
+ nodd=(nr - int(nr / 2) * 2) dummyflag=1 sleff=ledge + dummyflag * (ledgeeff -
+ ledge) sreff=ledge + dummyflag * (ledgeeff - ledge) ldios=(ns - 2) * lspace +
+ sleff + sreff + nodd * (lspace - sleff) ldiod=(ns - 1) * lspace + nodd * sleff
+ sdiofa=wr * ldios sdiofp=2 * ldios + (2 - nodd) * wr * (1 - dummyflag) ddiofa=wr
+ * ldiod ddiofp=2 * ldiod + nodd * wr * (1 - dummyflag) sdiogp=wr * nr + (2 - nodd)
+ * wr * dummyflag ddiogp=wr * nr + nodd * wr * dummyflag rsx=(0.0158 * (lr * 1e6
+ + 0.42) * (2 * ns + 1 / ns - 3) + 0.771 / ns + 0.232) / (wr * 1e6) rdx=0.0053
+ * (lr * 1e6 + 0.42) * (nd + 2 / nd) + 0.138 * (wr * 1e6 + 2.16) / nd + 0.0867
+ / (1.2 + (nd - 1) * (lr * 1e6 + 0.42)) rgx=((0.625 * (wr * 1e6 + 0.96) / (lr *
+ 1e6 - 0.02) + 6.46) / nr + nr * (0.000286 * wr * 1e6 + 0.0139) + 0.0138 * wr *
+ 1e6 + 0.718 * lr * 1e6 + 349 * lr / nr / wr + 2.389) lod=nr * (lr + lspace) +
+ 2 * ledge - lspace rbx=(rod * lod / 12 + rsti * lsti / 2) * (rod * wr / 12 + rsti
+ * wsti / 2) / (lod * (rod * lod / 12 + rsti * lsti / 2) + wr * (rod * wr / 12
+ + rsti * wsti / 2)) rdbx=rod * lr / (wr * nr * 2) cgsx=(1.3 * nr * (lr * 1e6 +
+ 0.42) / (0.1 * wr * 1e6 + 2.9) + 0.2 * wr * 1e6 + 0.67) * 1e-15 cgdx=(0.19 * nr
+ * lr * 1e6 + 0.07 * nr + 0.282) * 1e-15 cdsx=(0.1 + 0.062 * nr * wr * 1e6 / (lr
+ * 1e6 + 0.6) + 1.8 * nr * (lr * 1e6 + 0.42) / (wr * 1e6 + 9.8)) * 1e-15 sax=1
+ / (log((ledge + lr / 2 + nr * (lr + lspace)) * (ledge + lr / 2 + (nr - 1) * (lr
+ + lspace)) / (ledge + lspace + 3 * lr / 2) / (ledge + lr / 2)) / (2 * nr * (lr
+ + lspace)) + 1 / (nr * (ledge + lr / 2))) - lr / 2
// ********************
rg ( g gi ) resistor r=rgx
rs ( s si ) resistor r=rsx
rd ( d di ) resistor r=rdx
// ********************
cgs_m ( gi si ) capacitor c=cgsx
cgd_m ( gi di ) capacitor c=cgdx
cds_m ( si di ) capacitor c=cdsx
// **** Diodes  ****************
dss ( sb si ) ndio_rf25_f area=sdiofa pj=sdiofp
ddd ( db di ) ndio_rf25_f area=ddiofa pj=ddiofp
dsg ( sb si ) ndio_rf25_g area=1e-15 pj=sdiogp
ddg ( db di ) ndio_rf25_g area=1e-15 pj=ddiogp
// ****************************************************************************
rb ( b bi ) resistor r=rbx tc1=0.0037 tc2=9.64e-6
cb ( b bi ) capacitor c=162f / rbx
rdb ( db bi ) resistor r=rdbx tc1=0.0037 tc2=9.64e-6
cdb ( db bi ) capacitor c=162f / rdbx
rsb ( sb bi ) resistor r=rdbx tc1=0.0037 tc2=9.64e-6
csb ( sb bi ) capacitor c=162f / rdbx
// ****** MOSFET *******
nmos_rf25_mis ( di gi si bi ) nch_rf25 l=lr w=wr m=nr ad=0 as=0 pd=0 ps=0 sa=sax sb=sax
model nch_rf25 bsim3v3  {
     1: type=n
+ lmin=2.8e-007             lmax=5.01e-007            wmin=1.2e-006
+ wmax=10.01e-006           tnom=25                   version=3.24
+ tox=(toxnrf_25+toxmis)    toxm=(toxnrf_25+toxmis)   xj=1.9e-07
+ nch=3.28e+17              lln=1                     lwn=1
+ wln=1                     wwn=-1                    lint=3.1e-08
+ wint=1.95e-08             mobmod=1                  binunit=2
+ xl=-4e-08+(dxlrf_25+dlmis)                          xw=1e-8+(dxwrf_25+dwmis)
+ dwg=0                     dwb=0                     ldif=8e-08
+ hdif=hdifnrf_25           rsh=6.6                   rd=0
+ rs=0                      vth0=0.6844962+(dvthnrf_25+vthmis)
+ lvth0=-2.467325e-08+dlvthnrf_25                     wvth0=-4.611279e-08+dwvthnrf_25
+ pvth0=1.436083e-14+dpvthnrf_25                      k1=0.8531682
+ lk1=-8.657477e-08         wk1=-2.425473e-07         pk1=7.057792e-14
+ k2=-0.05141579+dk2nrf_25  lk2=-1.554543e-09+dlk2nrf_25
+ wk2=5.928379e-08          pk2=-1.755766e-14         k3=0
+ dvt0=0                    dvt1=0                    dvt2=0
+ dvt0w=0                   dvt1w=0                   dvt2w=0
+ nlx=0                     w0=0                      k3b=0
+ vfb=-0.7652686            vsat=8.6448090e+04        lvsat=-5.7633940e-04+dlvsatnrf_25
+ wvsat=-1.7101926e-03      pvsat=6.8065680e-10       ua=-7.156305e-10
+ lua=7.263201e-18          wua=7.741344e-17          pua=-1.48899e-24
+ ub=2.17854e-18            lub=-1.327395e-25         wub=-7.808022e-25
+ pub=9.218037e-32          uc=1.243654e-10           luc=-2.194589e-17
+ wuc=-7.08698e-17          puc=1.290974e-23          rdsw=325.9
+ prwb=0                    prwg=0                    wr=1
+ u0=0.03633325             lu0=-3.323704e-10         wu0=-8.728519e-09
+ pu0=2.04032e-16           a0=0.2551618              la0=1.203947e-07
+ wa0=4.091018e-07          pa0=-2.363322e-13         keta=-0.06037572
+ lketa=1.582387e-08        wketa=1.872172e-08        pketa=-8.606989e-15
+ a1=0                      a2=0.99                   ags=-0.02971154
+ lags=1.728653e-09         wags=9.693079e-08         pags=-1.725368e-14
+ b0=0                      b1=0                      voff=-0.09485205
+ lvoff=-6.399188e-09       wvoff=-8.496678e-08       pvoff=1.415763e-14
+ nfactor=1                 cit=1.87189e-05           lcit=7.270839e-11
+ wcit=1.032899e-09         pcit=-1.772961e-16        cdsc=0
+ cdscb=0                   cdscd=0                   eta0=-4.4818090e-04
+ leta0=5.7637610e-10       weta0=-2.1118445e-09      peta0=8.4051400e-16
+ etab=-0.0001431909        letab=-3.410101e-10       wetab=-5.635467e-11
+ petab=2.242921e-17        dsub=0                    pclm=0.7395863
+ lpclm=4.393965e-08        wpclm=7.346791e-09        ppclm=-2.87391e-15
+ pdiblc1=1e-06             pdiblc2=-0.03464225       lpdiblc2=1.577762e-08
+ wpdiblc2=1.337371e-08     ppdiblc2=-5.322741e-15    pdiblcb=0.01
+ drout=0                   pscbe1=3.5e+08            pscbe2=1e-06
+ pvag=0                    delta=0.01                alpha0=0
+ alpha1=0.7997             beta0=14.401              kt1=-0.3076753
+ lkt1=1.479193e-08         wkt1=-1.008979e-08        pkt1=-2.732598e-15
+ kt2=-0.03407931           lkt2=3.146365e-09         wkt2=-2.645907e-09
+ pkt2=1.527902e-16         at=1431.908               lat=0.0034101
+ wat=0.0005635483          pat=-2.242926e-10         ute=-1.371134
+ lute=-5.164809e-09        wute=3.060447e-07         pute=-1.120987e-14
+ ua1=1.833928e-09          lua1=-3.618919e-17        wua1=1.018181e-16
+ pua1=-4.052361e-23        ub1=-2.309933e-18         lub1=2.244739e-25
+ wub1=4.74888e-25          pub1=-6.789896e-32        uc1=-7.1775e-12
+ luc1=4.941405e-18         wuc1=-2.410485e-18        puc1=-1.280585e-24
+ kt1l=0                    prt=0                     cj=0
+ mj=0.3193271              pb=0.7249372              cjsw=0
+ mjsw=0.01                 pbsw=0.7249372            cjswg=0
+ mjswg=0.01                pbswg=0.7249372           tpb=0.001816363
+ tpbsw=0.001816363         tpbswg=0.001816363        tcj=0.001010853
+ tcjsw=9.297595e-05        tcjswg=9.297595e-05       js=4.03e-7
+ jsw=1.8e-12               n=1                       xti=3
+ cgdo=cgonrf_25            cgso=cgonrf_25            capmod=3
+ nqsmod=0                  xpart=0                   cf=0
+ tlev=1                    tlevc=1                   dlc=4.6e-08
+ cgbo=0                    cgdl=cglnrf_25            cgsl=cglnrf_25
+ wwc=-1.22e-2              dwc=0                     noia=8.0e+19
+ noib=2.5e+4               noic=1.0e-13              em=1.1e+7
+ ef=0.872                  noimod=2                  sa0=0.35e-6
+ sb0=0.35e-6               kvsat=0.35                wlod=0.3e-6
+ tku0=0.03                 ku0=-5.95e-8              llodku0=1
+ wlodku0=1                 lku0=1.493e-7             wku0=3.5e-7
+ pku0=0                    kvth0=7.2e-9              stk2=0
+ steta0=-1.1e-10           lkvth0=-5e-8              wkvth0=5e-6
+ pkvth0=0                  llodvth=1.0               wlodvth=1
+ lodk2=1                   lodeta0=2                 clc=0
+ minr=1e-3                 imax=0.01                 imelt=0.01
+ noff=1.865                voffcv=-0.03
//
  }
model ndio_rf25_f diode
+ level=1                   is=4.03e-7                n=1
+ bv=13.1                   ibv=0.03                  isw=1.8e-12
+ cj=cjnrf_25               pj=8.4e-4                 mj=0.3193271
+ fc=0                      cjsw=cjswnrf_25           area=3.92e-8
+ mjsw=0.01                 tlevc=1                   cta=0.001010853
+ ctp=9.297595e-05          tbv1=-1*-9.0e-4           tlev=1
+ xti=3                     eg=1.17                   vjsw=0.7249372
+ vj=0.7249372              pta=0.001816363           tnom=25
+ ptp=0.001816363           ns=1                      nz=1
+ imax=1e40                 minr=1e-10                allow_scaling=1

//
model ndio_rf25_g diode
+ level=1                   is=4.03e-7                n=1
+ bv=13.1                   ibv=0.03                  isw=1.8e-12
+ cj=cjnrf_25               pj=8.4e-4                 mj=0.3193271
+ fc=0                      cjsw=cjswgnrf_25          area=3.92e-8
+ mjsw=0.01                 tlevc=1                   cta=0.001010853
+ ctp=9.297595e-05          tbv1=-1*-9.0e-4           tlev=1
+ xti=3                     eg=1.17                   vjsw=0.7249372
+ vj=0.7249372              pta=0.001816363           tnom=25
+ ptp=0.001816363           ns=1                      nz=1
+ imax=1e40                 minr=1e-10                allow_scaling=1

ends nmos_rf25_mis
//

inline subckt pmos_rf25_mis ( d g s b )
parameters lr=30.0e-08 nr=1 wr=2.5e-6 temp1=parprf1_25 temp2=parprf2_25 fac1=0.887
+ * temp1 + 0.461 * temp2 fac2=0.887 * temp1 - 0.461 * temp2 lef=lr - 4.0e-8 wef=wr
+ + 1.0e-8 geo_fac=1 / sqrt(nr * lef * wef * 1e12) vthmis=0.003463 * geo_fac * fac1
+ dlmis=0.002070 * geo_fac * lef * fac2 dwmis= - 0.002070 * geo_fac * wef * fac2
+ toxmis=0.002070 * geo_fac * toxprf_25 * fac2 lspace=0.42u ledge=2.0u ledgeeff=0.73u
+ lsti=1.0u wsti=2.0u rod=342 rsti=913 ns=int(nr / 2 + 1) nd=int((nr + 1) / 2) nodd=(nr
+ - int(nr / 2) * 2) dummyflag=1 sleff=ledge + dummyflag * (ledgeeff - ledge) sreff=ledge
+ + dummyflag * (ledgeeff - ledge) ldios=(ns - 2) * lspace + sleff + sreff + nodd
+ * (lspace - sleff) ldiod=(ns - 1) * lspace + nodd * sleff sdiofa=wr * ldios sdiofp=2
+ * ldios + (2 - nodd) * wr * (1 - dummyflag) ddiofa=wr * ldiod ddiofp=2 * ldiod
+ + nodd * wr * (1 - dummyflag) sdiogp=wr * nr + (2 - nodd) * wr * dummyflag ddiogp=wr
+ * nr + nodd * wr * dummyflag rsx=(0.0158 * (lr * 1e6 + 0.42) * (2 * ns + 1 / ns
+ - 3) + 0.771 / ns + 0.232) / (wr * 1e6) rdx=0.0053 * (lr * 1e6 + 0.42) * (nd +
+ 2 / nd) + 0.138 * (wr * 1e6 + 2.16) / nd + 0.0867 / (1.2 + (nd - 1) * (lr * 1e6
+ + 0.42)) rgx=((0.625 * (wr * 1e6 + 0.96) / (lr * 1e6 - 0.02) + 6.46) / nr + nr
+ * (0.000286 * wr * 1e6 + 0.0139) + 0.0138 * wr * 1e6 + 0.718 * lr * 1e6 + 808
+ * lr / nr / wr + 1.589) lod=nr * (lr + lspace) + 2 * ledge - lspace rbx=(rod *
+ lod / 12 + rsti * lsti / 2) * (rod * wr / 12 + rsti * wsti / 2) / (lod * (rod
+ * lod / 12 + rsti * lsti / 2) + wr * (rod * wr / 12 + rsti * wsti / 2)) rdbx=rod
+ * lr / (wr * nr * 2) cgsx=(1.3 * nr * (lr * 1e6 + 0.42) / (0.1 * wr * 1e6 + 2.9)
+ + 0.2 * wr * 1e6 + 0.67) * 1e-15 cgdx=(0.19 * nr * lr * 1e6 + 0.07 * nr + 0.282)
+ * 1e-15 cdsx=(0.1 + 0.062 * nr * wr * 1e6 / (lr * 1e6 + 0.6) + 1.8 * nr * (lr
+ * 1e6 + 0.42) / (wr * 1e6 + 9.8)) * 1e-15 sax=1 / (log((ledge + lr / 2 + nr *
+ (lr + lspace)) * (ledge + lr / 2 + (nr - 1) * (lr + lspace)) / (ledge + lspace
+ + 3 * lr / 2) / (ledge + lr / 2)) / (2 * nr * (lr + lspace)) + 1 / (nr * (ledge
+ + lr / 2))) - lr / 2

// ********************
rg ( g gi ) resistor r=rgx
rs ( s si ) resistor r=rsx
rd ( d di ) resistor r=rdx
// ********************
cgs_m ( gi si ) capacitor c=cgsx
cgd_m ( gi di ) capacitor c=cgdx
cds_m ( si di ) capacitor c=cdsx
// **** Diodes  ****************
dss ( si sb ) pdio_rf25_f area=sdiofa pj=sdiofp
ddd ( di db ) pdio_rf25_f area=ddiofa pj=ddiofp
dsg ( si sb ) pdio_rf25_g area=1e-15 pj=sdiogp
ddg ( di db ) pdio_rf25_g area=1e-15 pj=ddiogp
// ****************************************************************************
rb ( b bi ) resistor r=rbx tc1=0.00374 tc2=9.10e-6
cb ( b bi ) capacitor c=169f / rbx
rdb ( db bi ) resistor r=rdbx tc1=0.00374 tc2=9.10e-6
cdb ( db bi ) capacitor c=169f / rdbx
rsb ( sb bi ) resistor r=rdbx tc1=0.00374 tc2=9.10e-6
csb ( sb bi ) capacitor c=169f / rdbx
// ****** MOSFET *******
pmos_rf25_mis ( di gi si bi ) pch_rf25 l=lr w=wr m=nr ad=0 as=0 pd=0 ps=0 sa=sax sb=sax
model pch_rf25 bsim3v3  {
     1: type=p
+ lmin=2.8e-007             lmax=5.01e-007            wmin=1.2e-006
+ wmax=10.01e-006           tnom=25                   version=3.24
+ tox=(toxprf_25+toxmis)    toxm=(toxprf_25+toxmis)   xj=2.1e-07
+ nch=7.22e+17              lln=1                     lwn=1
+ wln=1                     wwn=-1                    lint=4.4e-08
+ wint=5e-09                mobmod=1                  binunit=2
+ xl=-4e-08+(dxlrf_25+dlmis)                          xw=1e-8+(dxwrf_25+dwmis)
+ dwg=0                     dwb=0                     ldif=8e-08
+ hdif=hdifprf_25           rsh=7.2                   rd=0
+ rs=0                      vth0=-0.64129175+(dvthprf_25+vthmis)
+ lvth0=2.3027418e-08+dlvthprf_25                     wvth0=1.9674751e-08+dwvthprf_25
+ pvth0=-5.2895013e-15+dpvthprf_25                    k1=0.7562134
+ lk1=5.515479e-08          wk1=6.032497e-08          pk1=-2.646622e-14
+ k2=0.0499368+dk2prf_25    lk2=-3.829295e-08+dlk2prf_25
+ wk2=-6.148596e-08         pk2=1.521488e-14          k3=0
+ dvt0=0                    dvt1=0                    dvt2=0
+ dvt0w=0                   dvt1w=0                   dvt2w=0
+ nlx=0                     w0=0                      k3b=0
+ vfb=-1.400653             vsat=98625.01             wvsat=0.01376373
+ ua=3.604407e-10           lvsat=0+dlvsatprf_25      lua=-4.535359e-17
+ wua=6.245323e-17          pua=-9.8606e-24           ub=1.114336e-18
+ lub=5.417961e-26          wub=1.556058e-25          pub=3.849286e-32
+ uc=4.846232e-11           luc=-3.747956e-18         wuc=-5.543386e-17
+ puc=1.225494e-23          rdsw=784.6                prwb=0
+ prwg=0                    wr=1                      u0=0.01144613
+ lu0=-3.090805e-10         wu0=-1.206365e-09         pu0=-1.379744e-16
+ a0=0.5519273              la0=5.56803e-08           wa0=-1.519973e-07
+ pa0=-2.843797e-14         keta=-0.04863737          lketa=6.936704e-09
+ wketa=2.068658e-09        pketa=-3.491148e-15       a1=0
+ a2=0.99                   ags=0.02                  b0=0
+ b1=0                      voff=-0.0989763           lvoff=2.506003e-09
+ wvoff=-1.448955e-08       pvoff=-1.99603e-15        nfactor=1
+ cit=7.246053e-05          lcit=-2.243561e-11        wcit=-6.972834e-11
+ pcit=2.681678e-17         cdsc=0                    cdscb=0
+ cdscd=0                   eta0=6.2043840e-04        leta0=-1.1920305e-10
+ weta0=-1.8089307e-09      peta0=6.7292220e-16       etab=0.001636668
+ letab=-7.204406e-10       wetab=-5.041685e-10       petab=1.875508e-16
+ dsub=0                    pclm=0.6178901            lpclm=5.124457e-08
+ wpclm=1.495026e-09        ppclm=-3.482891e-16       pdiblc1=1e-06
+ pdiblc2=-0.005677225      lpdiblc2=2.483928e-09     wpdiblc2=3.899443e-09
+ ppdiblc2=-1.450593e-15    pdiblcb=0.01              drout=0
+ pscbe1=3.5e+08            pscbe2=5e-07              pvag=0
+ delta=0.01                alpha0=0                  alpha1=1.0857
+ beta0=23.74               kt1=-0.2076636            lkt1=-2.431654e-08
+ wkt1=-7.121064e-08        pkt1=3.001055e-14         kt2=-0.01723043
+ lkt2=-2.900122e-09        wkt2=-1.394708e-08        pkt2=3.491342e-15
+ at=-50000                 ute=-0.763168             lute=-3.338875e-08
+ wute=-5.426509e-09        pute=3.63037e-14          ua1=1.752e-09
+ ub1=-2.122632e-18         lub1=2.081626e-26         wub1=-5.678085e-26
+ pub1=-5.863848e-32        uc1=-4.384848e-11         luc1=9.295796e-18
+ wuc1=8.56422e-17          puc1=-1.721515e-23        kt1l=0
+ prt=0                     cj=0                      mj=0.3952264
+ pb=0.854899               cjsw=0                    mjsw=0.0450429
+ pbsw=0.854899             cjswg=0                   mjswg=0.0450429
+ pbswg=0.854899            tpb=0.001603538           tpbsw=0.001603538
+ tpbswg=0.001603538        tcj=0.0009016089          tcjsw=0.0001793034
+ tcjswg=0.0001793034       js=2.0e-7                 jsw=1.36e-12
+ n=1                       xti=3                     cgdo=cgoprf_25
+ cgso=cgoprf_25            capmod=3                  nqsmod=0
+ xpart=0                   cf=0                      tlev=1
+ tlevc=1                   dlc=3.68e-8               cgbo=0
+ cgdl=cglprf_25            cgsl=cglprf_25            wwc=-1.20e-2
+ dwc=0                     noia=5.0e+19              noib=4.0e+3
+ noic=8.0e-12              em=4.1e+7                 ef=1.152
+ noimod=2                  sa0=0.35e-6               sb0=0.35e-6
+ kvsat=-1                  wlod=0.3e-6               tku0=0.03
+ ku0=8.5e-08               llodku0=1                 wlodku0=1
+ lku0=8.0e-09              wku0=6.0e-07              pku0=0
+ kvth0=1.0e-09             stk2=0                    steta0=-3e-10
+ lkvth0=-1.0e-10           wkvth0=0                  pkvth0=0
+ llodvth=1                 wlodvth=1                 lodk2=1
+ lodeta0=1                 clc=0                     minr=1e-3
+ imax=0.01                 imelt=0.01
+ noff=1.865                voffcv=-0.02
//
  }
model pdio_rf25_f diode
+ level=1                   is=2.0e-7                 n=1
+ bv=9.8                    ibv=0.03                  isw=1.36e-12
+ cj=cjprf_25               pj=8.4e-4                 mj=0.3952264
+ fc=0                      cjsw=cjswprf_25           area=3.92e-8
+ mjsw=0.0450429            tlevc=1                   cta=0.0009016089
+ ctp=0.0001793034          tbv1=-1*-8.1e-4           tlev=1
+ xti=3                     eg=1.17                   vjsw=0.854899
+ vj=0.854899               pta=0.001603538           tnom=25
+ ptp=0.001603538           ns=1                      nz=1
+ imax=1e40                 minr=1e-10                allow_scaling=1

//
model pdio_rf25_g diode
+ level=1                   is=2.0e-7                 n=1
+ bv=9.8                    ibv=0.03                  isw=1.36e-12
+ cj=cjprf_25               pj=8.4e-4                 mj=0.3952264
+ fc=0                      cjsw=cjswgprf_25          area=3.92e-8
+ mjsw=0.0450429            tlevc=1                   cta=0.0009016089
+ ctp=0.0001793034          tbv1=-1*-8.1e-4           tlev=1
+ xti=3                     eg=1.17                   vjsw=0.854899
+ vj=0.854899               pta=0.001603538           tnom=25
+ ptp=0.001603538           ns=1                      nz=1
+ imax=1e40                 minr=1e-10                allow_scaling=1

ends pmos_rf25_mis
//

inline subckt pmos_rf25_nw_mis ( d g s b )
parameters lr=30.0e-08 nr=1 wr=2.5e-6 temp1=parprf1_25 temp2=parprf2_25 fac1=0.887
+ * temp1 + 0.461 * temp2 fac2=0.887 * temp1 - 0.461 * temp2 lef=lr - 4.0e-8 wef=wr
+ + 1.0e-8 geo_fac=1 / sqrt(nr * lef * wef * 1e12) vthmis=0.003463 * geo_fac * fac1
+ dlmis=0.002070 * geo_fac * lef * fac2 dwmis= - 0.002070 * geo_fac * wef * fac2
+ toxmis=0.002070 * geo_fac * toxprf_25 * fac2 lspace=0.42u ledge=2.0u ledgeeff=0.73u
+ lsti=1.0u wsti=2.0u rod=805 rsti=2148 ns=int(nr / 2 + 1) nd=int((nr + 1) / 2)
+ nodd=(nr - int(nr / 2) * 2) dummyflag=1 sleff=ledge + dummyflag * (ledgeeff -
+ ledge) sreff=ledge + dummyflag * (ledgeeff - ledge) ldios=(ns - 2) * lspace +
+ sleff + sreff + nodd * (lspace - sleff) ldiod=(ns - 1) * lspace + nodd * sleff
+ sdiofa=wr * ldios sdiofp=2 * ldios + (2 - nodd) * wr * (1 - dummyflag) ddiofa=wr
+ * ldiod ddiofp=2 * ldiod + nodd * wr * (1 - dummyflag) sdiogp=wr * nr + (2 - nodd)
+ * wr * dummyflag ddiogp=wr * nr + nodd * wr * dummyflag rsx=(0.0158 * (lr * 1e6
+ + 0.42) * (2 * ns + 1 / ns - 3) + 0.771 / ns + 0.232) / (wr * 1e6) rdx=0.0053
+ * (lr * 1e6 + 0.42) * (nd + 2 / nd) + 0.138 * (wr * 1e6 + 2.16) / nd + 0.0867
+ / (1.2 + (nd - 1) * (lr * 1e6 + 0.42)) rgx=((0.625 * (wr * 1e6 + 0.96) / (lr *
+ 1e6 - 0.02) + 6.46) / nr + nr * (0.000286 * wr * 1e6 + 0.0139) + 0.0138 * wr *
+ 1e6 + 0.718 * lr * 1e6 + 808 * lr / nr / wr + 1.589) lod=nr * (lr + lspace) +
+ 2 * ledge - lspace rbx=(rod * lod / 12 + rsti * lsti / 2) * (rod * wr / 12 + rsti
+ * wsti / 2) / (lod * (rod * lod / 12 + rsti * lsti / 2) + wr * (rod * wr / 12
+ + rsti * wsti / 2)) rdbx=rod * lr / (wr * nr * 2) cgsx=(1.3 * nr * (lr * 1e6 +
+ 0.42) / (0.1 * wr * 1e6 + 2.9) + 0.2 * wr * 1e6 + 0.67) * 1e-15 cgdx=(0.19 * nr
+ * lr * 1e6 + 0.07 * nr + 0.282) * 1e-15 cdsx=(0.1 + 0.062 * nr * wr * 1e6 / (lr
+ * 1e6 + 0.6) + 1.8 * nr * (lr * 1e6 + 0.42) / (wr * 1e6 + 9.8)) * 1e-15 sax=1
+ / (log((ledge + lr / 2 + nr * (lr + lspace)) * (ledge + lr / 2 + (nr - 1) * (lr
+ + lspace)) / (ledge + lspace + 3 * lr / 2) / (ledge + lr / 2)) / (2 * nr * (lr
+ + lspace)) + 1 / (nr * (ledge + lr / 2))) - lr / 2

// ********************
rg ( g gi ) resistor r=rgx
rs ( s si ) resistor r=rsx
rd ( d di ) resistor r=rdx
// ********************
cgs_m ( gi si ) capacitor c=cgsx
cgd_m ( gi di ) capacitor c=cgdx
cds_m ( si di ) capacitor c=cdsx
// **** Diodes  ****************
dss ( si sb ) pdio_rf25_f area=sdiofa pj=sdiofp
ddd ( di db ) pdio_rf25_f area=ddiofa pj=ddiofp
dsg ( si sb ) pdio_rf25_g area=1e-15 pj=sdiogp
ddg ( di db ) pdio_rf25_g area=1e-15 pj=ddiogp
// ****************************************************************************
rb ( b bi ) resistor r=rbx tc1=0.00374 tc2=9.10e-6
cb ( b bi ) capacitor c=169f / rbx
rdb ( db bi ) resistor r=rdbx tc1=0.00374 tc2=9.10e-6
cdb ( db bi ) capacitor c=169f / rdbx
rsb ( sb bi ) resistor r=rdbx tc1=0.00374 tc2=9.10e-6
csb ( sb bi ) capacitor c=169f / rdbx
// ****** MOSFET *******
pmos_rf25_nw_mis ( di gi si bi ) pch_rf25 l=lr w=wr m=nr ad=0 as=0 pd=0 ps=0 sa=sax sb=sax
model pch_rf25 bsim3v3  {
     1: type=p
+ lmin=2.8e-007             lmax=5.01e-007            wmin=1.2e-006
+ wmax=10.01e-006           tnom=25                   version=3.24
+ tox=(toxprf_25+toxmis)    toxm=(toxprf_25+toxmis)   xj=2.1e-07
+ nch=7.22e+17              lln=1                     lwn=1
+ wln=1                     wwn=-1                    lint=4.4e-08
+ wint=5e-09                mobmod=1                  binunit=2
+ xl=-4e-08+(dxlrf_25+dlmis)                          xw=1e-8+(dxwrf_25+dwmis)
+ dwg=0                     dwb=0                     ldif=8e-08
+ hdif=hdifprf_25           rsh=7.2                   rd=0
+ rs=0                      vth0=-0.64129175+(dvthprf_25+vthmis)
+ lvth0=2.3027418e-08+dlvthprf_25                     wvth0=1.9674751e-08+dwvthprf_25
+ pvth0=-5.2895013e-15+dpvthprf_25                    k1=0.7562134
+ lk1=5.515479e-08          wk1=6.032497e-08          pk1=-2.646622e-14
+ k2=0.0499368+dk2prf_25    lk2=-3.829295e-08+dlk2prf_25
+ wk2=-6.148596e-08         pk2=1.521488e-14          k3=0
+ dvt0=0                    dvt1=0                    dvt2=0
+ dvt0w=0                   dvt1w=0                   dvt2w=0
+ nlx=0                     w0=0                      k3b=0
+ vfb=-1.400653             vsat=98625.01             wvsat=0.01376373
+ ua=3.604407e-10           lvsat=0+dlvsatprf_25      lua=-4.535359e-17
+ wua=6.245323e-17          pua=-9.8606e-24           ub=1.114336e-18
+ lub=5.417961e-26          wub=1.556058e-25          pub=3.849286e-32
+ uc=4.846232e-11           luc=-3.747956e-18         wuc=-5.543386e-17
+ puc=1.225494e-23          rdsw=784.6                prwb=0
+ prwg=0                    wr=1                      u0=0.01144613
+ lu0=-3.090805e-10         wu0=-1.206365e-09         pu0=-1.379744e-16
+ a0=0.5519273              la0=5.56803e-08           wa0=-1.519973e-07
+ pa0=-2.843797e-14         keta=-0.04863737          lketa=6.936704e-09
+ wketa=2.068658e-09        pketa=-3.491148e-15       a1=0
+ a2=0.99                   ags=0.02                  b0=0
+ b1=0                      voff=-0.0989763           lvoff=2.506003e-09
+ wvoff=-1.448955e-08       pvoff=-1.99603e-15        nfactor=1
+ cit=7.246053e-05          lcit=-2.243561e-11        wcit=-6.972834e-11
+ pcit=2.681678e-17         cdsc=0                    cdscb=0
+ cdscd=0                   eta0=6.2043840e-04        leta0=-1.1920305e-10
+ weta0=-1.8089307e-09      peta0=6.7292220e-16       etab=0.001636668
+ letab=-7.204406e-10       wetab=-5.041685e-10       petab=1.875508e-16
+ dsub=0                    pclm=0.6178901            lpclm=5.124457e-08
+ wpclm=1.495026e-09        ppclm=-3.482891e-16       pdiblc1=1e-06
+ pdiblc2=-0.005677225      lpdiblc2=2.483928e-09     wpdiblc2=3.899443e-09
+ ppdiblc2=-1.450593e-15    pdiblcb=0.01              drout=0
+ pscbe1=3.5e+08            pscbe2=5e-07              pvag=0
+ delta=0.01                alpha0=0                  alpha1=1.0857
+ beta0=23.74               kt1=-0.2076636            lkt1=-2.431654e-08
+ wkt1=-7.121064e-08        pkt1=3.001055e-14         kt2=-0.01723043
+ lkt2=-2.900122e-09        wkt2=-1.394708e-08        pkt2=3.491342e-15
+ at=-50000                 ute=-0.763168             lute=-3.338875e-08
+ wute=-5.426509e-09        pute=3.63037e-14          ua1=1.752e-09
+ ub1=-2.122632e-18         lub1=2.081626e-26         wub1=-5.678085e-26
+ pub1=-5.863848e-32        uc1=-4.384848e-11         luc1=9.295796e-18
+ wuc1=8.56422e-17          puc1=-1.721515e-23        kt1l=0
+ prt=0                     cj=0                      mj=0.3952264
+ pb=0.854899               cjsw=0                    mjsw=0.0450429
+ pbsw=0.854899             cjswg=0                   mjswg=0.0450429
+ pbswg=0.854899            tpb=0.001603538           tpbsw=0.001603538
+ tpbswg=0.001603538        tcj=0.0009016089          tcjsw=0.0001793034
+ tcjswg=0.0001793034       js=2.0e-7                 jsw=1.36e-12
+ n=1                       xti=3                     cgdo=cgoprf_25
+ cgso=cgoprf_25            capmod=3                  nqsmod=0
+ xpart=0                   cf=0                      tlev=1
+ tlevc=1                   dlc=3.68e-8               cgbo=0
+ cgdl=cglprf_25            cgsl=cglprf_25            wwc=-1.20e-2
+ dwc=0                     noia=5.0e+19              noib=4.0e+3
+ noic=8.0e-12              em=4.1e+7                 ef=1.152
+ noimod=2                  sa0=0.35e-6               sb0=0.35e-6
+ kvsat=-1                  wlod=0.3e-6               tku0=0.03
+ ku0=8.5e-08               llodku0=1                 wlodku0=1
+ lku0=8.0e-09              wku0=6.0e-07              pku0=0
+ kvth0=1.0e-09             stk2=0                    steta0=-3e-10
+ lkvth0=-1.0e-10           wkvth0=0                  pkvth0=0
+ llodvth=1                 wlodvth=1                 lodk2=1
+ lodeta0=1                 clc=0                     minr=1e-3
+ imax=0.01                 imelt=0.01
+ noff=1.865                voffcv=-0.02
//
  }
model pdio_rf25_f diode
+ level=1                   is=2.0e-7                 n=1
+ bv=9.8                    ibv=0.03                  isw=1.36e-12
+ cj=cjprf_25               pj=8.4e-4                 mj=0.3952264
+ fc=0                      cjsw=cjswprf_25           area=3.92e-8
+ mjsw=0.0450429            tlevc=1                   cta=0.0009016089
+ ctp=0.0001793034          tbv1=-1*-8.1e-4           tlev=1
+ xti=3                     eg=1.17                   vjsw=0.854899
+ vj=0.854899               pta=0.001603538           tnom=25
+ ptp=0.001603538           ns=1                      nz=1
+ imax=1e40                 minr=1e-10                allow_scaling=1

//
model pdio_rf25_g diode
+ level=1                   is=2.0e-7                 n=1
+ bv=9.8                    ibv=0.03                  isw=1.36e-12
+ cj=cjprf_25               pj=8.4e-4                 mj=0.3952264
+ fc=0                      cjsw=cjswgprf_25          area=3.92e-8
+ mjsw=0.0450429            tlevc=1                   cta=0.0009016089
+ ctp=0.0001793034          tbv1=-1*-8.1e-4           tlev=1
+ xti=3                     eg=1.17                   vjsw=0.854899
+ vj=0.854899               pta=0.001603538           tnom=25
+ ptp=0.001603538           ns=1                      nz=1
+ imax=1e40                 minr=1e-10                allow_scaling=1

ends pmos_rf25_nw_mis
//

endsection rf_mos25

//*************************************************************************************************
// MIM CAPACITOR MODEL :
//
//     HF model:
//          1.0fF MiM_Cap w/i underground metal for 1PXM 4<=X<=8
//          1.0fF MiM_Cap w/o underground metal for 1PXM 4<=X<=8
//          1.5fF MiM_Cap w/i underground metal for 1PXM 4<=X<=8
//          1.5fF MiM_Cap w/o underground metal for 1PXM 4<=X<=8
//
//     ## library files:
//
//     1. The 1.0fF MIM capacitors with underground metal are modeled with sub-circuit 'mimcap_um_1p0_sin_rf'
//     2. The 1.0fF MIM capacitors without underground metal are modeled with sub-circuit 'mimcap_woum_1p0_sin_rf'
//     3. The 1.5fF MIM capacitors with underground metal are modeled with sub-circuit 'mimcap_um_1p5_sin_rf'
//     4. The 1.5fF MIM capacitors without underground metal are modeled with sub-circuit 'mimcap_woum_1p5_sin_rf'
//
//            Model name           lt(um)            wt(um)            lay
//                              low    high       low    high       low    high
//     -------------------------------------------------------------------------
//     mimcap_um_1p0_sin_rf      4     100         4     100
//     mimcap_woum_1p0_sin_rf    4     100         4     100         4       8
//     mimcap_um_1p5_sin_rf      4     100         4     100
//     mimcap_woum_1p5_sin_rf    4     100         4     100         4       8
//     -------------------------------------------------------------------------
//            End Model
//            **lt: length dimension of top metal
//            **wt: width dimension of top metal
//            **lt >= wt
//            **lay: Metal layer option (4,5,6,7,8)
//
//*************************************************************************************************
section rf_mim
subckt mimcap_um_1p0_sin_rf ( top bottom um )
parameters lt=10u wt=10u ltop_para=((0.14 * (wt * 1e6) * (log((wt * 1e6) / (lt *
+ 1e6 + 0.05)) + 1.19 + 0.022 * (lt * 1e6 + 0.05) / (wt * 1e6)) / 1 + 1.5) / 3 +
+ 1.78) * 1e-12 lbot_cbm=((0.14 * (wt * 1e6 + 4.04) * (log((wt * 1e6 + 4.04) / ((lt
+ * 1e6 + 4.04) + 0.2)) + 1.19 + 0.022 * ((lt * 1e6 + 4.04) + 0.2) / (wt * 1e6 +
+ 4.04)) / 1 + 1.5) / 3) * 1e-12 lbot_lead=((0.606 + 0.14 * ((lt * 1e6 + 4.04) /
+ 2) * (log(((lt * 1e6 + 4.04) / 2) / (1 + 0.9)) + 1.19 + 0.022 * (1 + 0.9) / ((lt
+ * 1e6 + 4.04) / 2)) / 1 + 1.5) / 2) * 1e-12 lbot_para=(lbot_cbm + lbot_lead) via_v=int((lt
+ * 1e6 / 2 - 1.46) / (1.19) + 1) res_v=(via_v - 1) * (2 * via_v - 1) / (6 * via_v)
+ * 0.0083 + 20.15 / via_v via_h=int((wt * 1e6 - 3.64) / (2.925) + 1) rtop_para=(0.040508475
+ + (via_h - 1) * (2 * via_h - 1) / (6 * via_h) * 0.010169492 + res_v / 2 / via_h
+ + 0.15) r1=(lt * 1e6 + 0.2) / 2 / (wt * 1e6 + 0.2) * 0.293 / 3 r3=(wt * 1e6 +
+ 0.2) / 2 / (lt * 1e6 + 0.2) * 0.293 / 3 rcbm=(1 / (2 / r1 + 2 / r3)) via_left=int((((wt
+ * 1e6 + 4.04) - 0.96 + ((lt * 1e6 + 4.04) / 2 - 3.06)) - 0.76) / (1.21) + 1) res_left=0.002083333
+ + (via_left - 1) * (2 * via_left - 1) / (6 * via_left) * 0.008854167 + 0.54 /
+ via_left via_vert=int((((lt * 1e6 + 4.04) / 2 - 3.06) - 0.76) / (1.21) + 1) res_vert=0.002083333
+ + (via_vert - 1) * (2 * via_vert - 1) / (6 * via_vert) * 0.008854167 + 0.54 /
+ via_vert res_cbm=1 / (1 / res_left + 1 / res_vert) res_lead=(2 / 1.92 + (lt *
+ 1e6 + 4.04) / 2 / 1) * 0.02 res_upper=res_cbm + res_lead rbot_para=(res_upper
+ / 2 + rcbm + 0.15) cmim_para=(((wt - 0.108e-6) * (lt - 0.108e-6) * 1e12 * 1.0274) + 2 * ((wt - 0.108e-6) + (lt - 0.108e-6)) * 1e6
+ * 0.1686 + 0.1468) * 1e-15 * (1 + (temp - 25) *  - 4.13e-5 + (temp - 25)
+ * (temp - 25) *  - 8e-8) cox_para=((lt * 1e6 + 4.04) * (wt * 1e6 + 4.04) * 0.045917
+ + 0.05472 + (lt * 1e6 + 4.04) * 0.007125) * 1e-15
//
ltop ( top n1 ) inductor l=ltop_para * l_mimfac
rtop ( n1 n2 ) resistor r=rtop_para * rctm_mimfac * (0.003 * (temp - 25) + 1)
//cmim ( n2 n3 ) bsource c=cmim_para * (1 + v(n2,n3) * 2.96e-5 + (abs(v(n2,n3))
//+ ** 2) *  - 2.44e-5) * cmim_mimfac
cmim ( n2 n3 ) bsource q=cmim_para * (v(n2,n3) + 0.5*v(n2,n3)**(2) * 2.96e-5 + 1/3*v(n2,n3)
+ ** 3 *  - 2.44e-5) * cmim_mimfac
rbot ( n3 n4 ) resistor r=rbot_para * rctm_mimfac * (0.003 * (temp - 25) + 1)
lbot ( n4 bottom ) inductor l=lbot_para * l_mimfac
cox ( n3 um ) capacitor c=cox_para * cm6_mimfac
//
ends mimcap_um_1p0_sin_rf

subckt mimcap_woum_1p0_sin_rf ( top bottom gnode )
parameters lt=10u wt=10u lay=8 ltop_para=((0.14 * (wt * 1e6) * (log((wt * 1e6) / (lt *
+ 1e6 + 0.05)) + 1.19 + 0.022 * (lt * 1e6 + 0.05) / (wt * 1e6)) / 1 + 1.5) / 3 +
+ 1.78) * 1e-12 lbot_cbm=((0.14 * (wt * 1e6 + 4.04) * (log((wt * 1e6 + 4.04) / ((lt
+ * 1e6 + 4.04) + 0.2)) + 1.19 + 0.022 * ((lt * 1e6 + 4.04) + 0.2) / (wt * 1e6 +
+ 4.04)) / 1 + 1.5) / 3) * 1e-12 lbot_lead=((0.606 + 0.14 * ((lt * 1e6 + 4.04) /
+ 2) * (log(((lt * 1e6 + 4.04) / 2) / (1 + 0.9)) + 1.19 + 0.022 * (1 + 0.9) / ((lt
+ * 1e6 + 4.04) / 2)) / 1 + 1.5) / 2) * 1e-12 lbot_para=(lbot_cbm + lbot_lead) via_v=int((lt
+ * 1e6 / 2 - 1.46) / (1.19) + 1) res_v=(via_v - 1) * (2 * via_v - 1) / (6 * via_v)
+ * 0.0083 + 20.15 / via_v via_h=int((wt * 1e6 - 3.64) / (2.925) + 1) rtop_para=(0.040508475
+ + (via_h - 1) * (2 * via_h - 1) / (6 * via_h) * 0.010169492 + res_v / 2 / via_h
+ + 0.15) r1=(lt * 1e6 + 0.2) / 2 / (wt * 1e6 + 0.2) * 0.293 / 3 r3=(wt * 1e6 +
+ 0.2) / 2 / (lt * 1e6 + 0.2) * 0.293 / 3 rcbm=(1 / (2 / r1 + 2 / r3)) via_left=int((((wt
+ * 1e6 + 4.04) - 0.96 + ((lt * 1e6 + 4.04) / 2 - 3.06)) - 0.76) / (1.21) + 1) res_left=0.002083333
+ + (via_left - 1) * (2 * via_left - 1) / (6 * via_left) * 0.008854167 + 0.54 /
+ via_left via_vert=int((((lt * 1e6 + 4.04) / 2 - 3.06) - 0.76) / (1.21) + 1) res_vert=0.002083333
+ + (via_vert - 1) * (2 * via_vert - 1) / (6 * via_vert) * 0.008854167 + 0.54 /
+ via_vert res_cbm=1 / (1 / res_left + 1 / res_vert) res_lead=(2 / 1.92 + (lt *
+ 1e6 + 4.04) / 2 / 1) * 0.02 res_upper=res_cbm + res_lead rbot_para=(res_upper
+ / 2 + rcbm + 0.15) cmim_para=(((wt - 0.108e-6) * (lt - 0.108e-6) * 1e12 * 1.0274)
+ + 2 * ((wt - 0.108e-6) + (lt - 0.108e-6)) * 1e6 * 0.1686 + 0.1468) * 1e-15 * (1
+ + (temp - 25) *  - 4.13e-5 + (temp - 25) * (temp - 25) *  - 8e-8) cox_para=((lt
+ * 1e6 + 4.04) * (wt * 1e6 + 4.04) * 0.00908 + 0.05472 + (lt * 1e6 + 4.04) * 0.007125)
+ * 1e-15 rsub_para=(1 / (2 / ((lt * 1e6 + 4.04) / 2 / (wt * 1e6 + 4.04) * 1921
+ / 3) + 2 / ((wt * 1e6 + 4.04) / 2 / (lt * 1e6 + 4.04) * 1921 / 3))) * ( - 0.0000114365
+ * (temp - 25) * (temp - 25) + 0.0045985091 * (temp - 25) + 1) csub_para=(312
+ / rsub_para) * 1e-15
//
ltop ( top n1 ) inductor l=ltop_para * l_mimfac
rtop ( n1 n2 ) resistor r=rtop_para * rctm_mimfac * (0.003 * (temp - 25) + 1)
//cmim ( n2 n3 ) bsource c=cmim_para * (1 + v(n2,n3) * 2.96e-5 + (abs(v(n2,n3)) **
//+ 2) *  - 2.44e-5) * cmim_mimfac
cmim ( n2 n3 ) bsource q=cmim_para * (v(n2,n3) + 0.5*v(n2,n3)**(2) * 2.96e-5 + 1/3*v(n2,n3)
+ ** 3 *  - 2.44e-5) * cmim_mimfac
rbot ( n3 n4 ) resistor r=rbot_para * rctm_mimfac * (0.003 * (temp - 25) + 1)
lbot ( n4 bottom ) inductor l=lbot_para * l_mimfac
cox ( n3 n5 ) capacitor c=cox_para*((1/(5.64085+(2.37149)*(lay-4)))/0.0661078) * cm5_mimfac
csub ( n5 gnode ) capacitor c=csub_para * csub_mimfac
rsub ( n5 gnode ) resistor r=rsub_para * rsub_mimfac
//
ends mimcap_woum_1p0_sin_rf
//
//
subckt mimcap_um_1p5_sin_rf ( top bottom um )
parameters lt=10u wt=10u ltop_para=((0.14 * (wt * 1e6) * (log((wt * 1e6) / (lt *
+ 1e6 + 0.05)) + 1.19 + 0.022 * (lt * 1e6 + 0.05) / (wt * 1e6)) / 1 + 1.5) / 3 +
+ 1.78) * 1e-12 lbot_cbm=((0.14 * (wt * 1e6 + 4.04) * (log((wt * 1e6 + 4.04) / ((lt
+ * 1e6 + 4.04) + 0.2)) + 1.19 + 0.022 * ((lt * 1e6 + 4.04) + 0.2) / (wt * 1e6 +
+ 4.04)) / 1 + 1.5) / 3) * 1e-12 lbot_lead=((0.606 + 0.14 * ((lt * 1e6 + 4.04) /
+ 2) * (log(((lt * 1e6 + 4.04) / 2) / (1 + 0.9)) + 1.19 + 0.022 * (1 + 0.9) / ((lt
+ * 1e6 + 4.04) / 2)) / 1 + 1.5) / 2) * 1e-12 lbot_para=(lbot_cbm + lbot_lead) via_v=int((lt
+ * 1e6 / 2 - 1.46) / (1.19) + 1) res_v=(via_v - 1) * (2 * via_v - 1) / (6 * via_v)
+ * 0.0083 + 20.15 / via_v via_h=int((wt * 1e6 - 3.64) / (2.925) + 1) rtop_para=(0.040508475
+ + (via_h - 1) * (2 * via_h - 1) / (6 * via_h) * 0.010169492 + res_v / 2 / via_h
+ + 0.15) r1=(lt * 1e6 + 0.2) / 2 / (wt * 1e6 + 0.2) * 0.293 / 3 r3=(wt * 1e6 +
+ 0.2) / 2 / (lt * 1e6 + 0.2) * 0.293 / 3 rcbm=(1 / (2 / r1 + 2 / r3)) via_left=int((((wt
+ * 1e6 + 4.04) - 0.96 + ((lt * 1e6 + 4.04) / 2 - 3.06)) - 0.76) / (1.21) + 1) res_left=0.002083333
+ + (via_left - 1) * (2 * via_left - 1) / (6 * via_left) * 0.008854167 + 0.54 /
+ via_left via_vert=int((((lt * 1e6 + 4.04) / 2 - 3.06) - 0.76) / (1.21) + 1) res_vert=0.002083333
+ + (via_vert - 1) * (2 * via_vert - 1) / (6 * via_vert) * 0.008854167 + 0.54 /
+ via_vert res_cbm=1 / (1 / res_left + 1 / res_vert) res_lead=(2 / 1.92 + (lt *
+ 1e6 + 4.04) / 2 / 1) * 0.02 res_upper=res_cbm + res_lead rbot_para=(res_upper
+ / 2 + rcbm + 0.15) cmim_para=(((wt - 0.092e-6) * (lt - 0.092e-6) * 1e12 * 1.547)
+ + 2 * ((wt - 0.092e-6) + (lt - 0.092e-6)) * 1e6 * 0.164 + 0.172) * 1e-15 * (1
+ + (temp - 25) *  - 5.016e-5 + (temp - 25) * (temp - 25) * 6.5e-9) cox_para=((lt
+ * 1e6 + 4.04) * (wt * 1e6 + 4.04) * 0.045917 + 0.05472 + (lt * 1e6 + 4.04) * 0.007125)
+ * 1e-15
//
ltop ( top n1 ) inductor l=ltop_para * l_mimfac
rtop ( n1 n2 ) resistor r=rtop_para * rctm_mimfac * (0.003 * (temp - 25) + 1)
//cmim ( n2 n3 ) bsource c=cmim_para * (1 + v(n2,n3) *  - 3.043e-5 + (abs(v(n2,n3))
//+ ** 2) *  - 4.6125e-5) * cmim_mimfac
cmim ( n2 n3 ) bsource q=cmim_para * (v(n2,n3) + 0.5*v(n2,n3)**(2) * - 3.043e-5 + 1/3*v(n2,n3)
+ ** 3 *  - 4.6125e-5) * cmim_mimfac
rbot ( n3 n4 ) resistor r=rbot_para * rctm_mimfac * (0.003 * (temp - 25) + 1)
lbot ( n4 bottom ) inductor l=lbot_para * l_mimfac
cox ( n3 um ) capacitor c=cox_para * cm6_mimfac
//
ends mimcap_um_1p5_sin_rf

subckt mimcap_woum_1p5_sin_rf ( top bottom gnode )
parameters lt=10u wt=10u lay=8 ltop_para=((0.14 * (wt * 1e6) * (log((wt * 1e6) / (lt *
+ 1e6 + 0.05)) + 1.19 + 0.022 * (lt * 1e6 + 0.05) / (wt * 1e6)) / 1 + 1.5) / 3 +
+ 1.78) * 1e-12 lbot_cbm=((0.14 * (wt * 1e6 + 4.04) * (log((wt * 1e6 + 4.04) / ((lt
+ * 1e6 + 4.04) + 0.2)) + 1.19 + 0.022 * ((lt * 1e6 + 4.04) + 0.2) / (wt * 1e6 +
+ 4.04)) / 1 + 1.5) / 3) * 1e-12 lbot_lead=((0.606 + 0.14 * ((lt * 1e6 + 4.04) /
+ 2) * (log(((lt * 1e6 + 4.04) / 2) / (1 + 0.9)) + 1.19 + 0.022 * (1 + 0.9) / ((lt
+ * 1e6 + 4.04) / 2)) / 1 + 1.5) / 2) * 1e-12 lbot_para=(lbot_cbm + lbot_lead) via_v=int((lt
+ * 1e6 / 2 - 1.46) / (1.19) + 1) res_v=(via_v - 1) * (2 * via_v - 1) / (6 * via_v)
+ * 0.0083 + 20.15 / via_v via_h=int((wt * 1e6 - 3.64) / (2.925) + 1) rtop_para=(0.040508475
+ + (via_h - 1) * (2 * via_h - 1) / (6 * via_h) * 0.010169492 + res_v / 2 / via_h
+ + 0.15) r1=(lt * 1e6 + 0.2) / 2 / (wt * 1e6 + 0.2) * 0.293 / 3 r3=(wt * 1e6 +
+ 0.2) / 2 / (lt * 1e6 + 0.2) * 0.293 / 3 rcbm=(1 / (2 / r1 + 2 / r3)) via_left=int((((wt
+ * 1e6 + 4.04) - 0.96 + ((lt * 1e6 + 4.04) / 2 - 3.06)) - 0.76) / (1.21) + 1) res_left=0.002083333
+ + (via_left - 1) * (2 * via_left - 1) / (6 * via_left) * 0.008854167 + 0.54 /
+ via_left via_vert=int((((lt * 1e6 + 4.04) / 2 - 3.06) - 0.76) / (1.21) + 1) res_vert=0.002083333
+ + (via_vert - 1) * (2 * via_vert - 1) / (6 * via_vert) * 0.008854167 + 0.54 /
+ via_vert res_cbm=1 / (1 / res_left + 1 / res_vert) res_lead=(2 / 1.92 + (lt *
+ 1e6 + 4.04) / 2 / 1) * 0.02 res_upper=res_cbm + res_lead rbot_para=(res_upper
+ / 2 + rcbm + 0.15) cmim_para=(((wt - 0.092e-6) * (lt - 0.092e-6) * 1e12 * 1.547)
+ + 2 * ((wt - 0.092e-6) + (lt - 0.092e-6)) * 1e6 * 0.164 + 0.172) * 1e-15 * (1
+ + (temp - 25) *  - 5.016e-5 + (temp - 25) * (temp - 25) * 6.5e-9) cox_para=((lt
+ * 1e6 + 4.04) * (wt * 1e6 + 4.04) * 0.00908 + 0.05472 + (lt * 1e6 + 4.04) * 0.007125)
+ * 1e-15 rsub_para=(1 / (2 / ((lt * 1e6 + 4.04) / 2 / (wt * 1e6 + 4.04) * 1921
+ / 3) + 2 / ((wt * 1e6 + 4.04) / 2 / (lt * 1e6 + 4.04) * 1921 / 3))) * ( - 0.0000114365
+ * (temp - 25) * (temp - 25) + 0.0045985091 * (temp - 25) + 1) csub_para=(312
+ / rsub_para) * 1e-15
//
ltop ( top n1 ) inductor l=ltop_para * l_mimfac
rtop ( n1 n2 ) resistor r=rtop_para * rctm_mimfac * (0.003 * (temp - 25) + 1)
//cmim ( n2 n3 ) bsource c=cmim_para * (1 + v(n2,n3) * 2.96e-5 + (abs(v(n2,n3)) **
//+ 2) *  - 2.44e-5) * cmim_mimfac
cmim ( n2 n3 ) bsource q=cmim_para * (v(n2,n3) + 0.5*v(n2,n3)**(2) * - 3.043e-5 + 1/3*v(n2,n3)
+ ** 3 *  - 4.6125e-5) * cmim_mimfac
rbot ( n3 n4 ) resistor r=rbot_para * rctm_mimfac * (0.003 * (temp - 25) + 1)
lbot ( n4 bottom ) inductor l=lbot_para * l_mimfac
cox ( n3 n5 ) capacitor c=cox_para*((1/(5.64085+(2.37149)*(lay-4)))/0.0661078) * cm5_mimfac
csub ( n5 gnode ) capacitor c=csub_para * csub_mimfac
rsub ( n5 gnode ) resistor r=rsub_para * rsub_mimfac
//
ends mimcap_woum_1p5_sin_rf
//
//  ********************************
//        Mismatch   model         *
//  ********************************
//
subckt mimcap_um_1p0_sin_rf_mis ( top bottom um )
parameters lt=10u wt=10u geo_fac=1 / sqrt(lt * wt * 1e12) factmis=0.004458 * geo_fac
+ * par_rfmim ltop_para=((0.14 * (wt * 1e6) * (log((wt * 1e6) / (lt *
+ 1e6 + 0.05)) + 1.19 + 0.022 * (lt * 1e6 + 0.05) / (wt * 1e6)) / 1 + 1.5) / 3 +
+ 1.78) * 1e-12 lbot_cbm=((0.14 * (wt * 1e6 + 4.04) * (log((wt * 1e6 + 4.04) / ((lt
+ * 1e6 + 4.04) + 0.2)) + 1.19 + 0.022 * ((lt * 1e6 + 4.04) + 0.2) / (wt * 1e6 +
+ 4.04)) / 1 + 1.5) / 3) * 1e-12 lbot_lead=((0.606 + 0.14 * ((lt * 1e6 + 4.04) /
+ 2) * (log(((lt * 1e6 + 4.04) / 2) / (1 + 0.9)) + 1.19 + 0.022 * (1 + 0.9) / ((lt
+ * 1e6 + 4.04) / 2)) / 1 + 1.5) / 2) * 1e-12 lbot_para=(lbot_cbm + lbot_lead) via_v=int((lt
+ * 1e6 / 2 - 1.46) / (1.19) + 1) res_v=(via_v - 1) * (2 * via_v - 1) / (6 * via_v)
+ * 0.0083 + 20.15 / via_v via_h=int((wt * 1e6 - 3.64) / (2.925) + 1) rtop_para=(0.040508475
+ + (via_h - 1) * (2 * via_h - 1) / (6 * via_h) * 0.010169492 + res_v / 2 / via_h
+ + 0.15) r1=(lt * 1e6 + 0.2) / 2 / (wt * 1e6 + 0.2) * 0.293 / 3 r3=(wt * 1e6 +
+ 0.2) / 2 / (lt * 1e6 + 0.2) * 0.293 / 3 rcbm=(1 / (2 / r1 + 2 / r3)) via_left=int((((wt
+ * 1e6 + 4.04) - 0.96 + ((lt * 1e6 + 4.04) / 2 - 3.06)) - 0.76) / (1.21) + 1) res_left=0.002083333
+ + (via_left - 1) * (2 * via_left - 1) / (6 * via_left) * 0.008854167 + 0.54 /
+ via_left via_vert=int((((lt * 1e6 + 4.04) / 2 - 3.06) - 0.76) / (1.21) + 1) res_vert=0.002083333
+ + (via_vert - 1) * (2 * via_vert - 1) / (6 * via_vert) * 0.008854167 + 0.54 /
+ via_vert res_cbm=1 / (1 / res_left + 1 / res_vert) res_lead=(2 / 1.92 + (lt *
+ 1e6 + 4.04) / 2 / 1) * 0.02 res_upper=res_cbm + res_lead rbot_para=(res_upper
+ / 2 + rcbm + 0.15) cmim_para=(1 + factmis) *(((wt - 0.108e-6) * (lt - 0.108e-6) * 1e12 * 1.0274) + 2 * ((wt - 0.108e-6) + (lt - 0.108e-6)) * 1e6
+ * 0.1686 + 0.1468) * 1e-15 * (1 + (temp - 25) *  - 4.13e-5 + (temp - 25)
+ * (temp - 25) *  - 8e-8) cox_para=((lt * 1e6 + 4.04) * (wt * 1e6 + 4.04) * 0.045917
+ + 0.05472 + (lt * 1e6 + 4.04) * 0.007125) * 1e-15
//
ltop ( top n1 ) inductor l=ltop_para * l_mimfac
rtop ( n1 n2 ) resistor r=rtop_para * rctm_mimfac * (0.003 * (temp - 25) + 1)
//cmim ( n2 n3 ) bsource c=cmim_para * (1 + v(n2,n3) * 2.96e-5 + (abs(v(n2,n3))
//+ ** 2) *  - 2.44e-5) * cmim_mimfac
cmim ( n2 n3 ) bsource q=cmim_para * (v(n2,n3) + 0.5*v(n2,n3)**(2) * 2.96e-5 + 1/3*v(n2,n3)
+ ** 3 *  - 2.44e-5) * cmim_mimfac
rbot ( n3 n4 ) resistor r=rbot_para * rctm_mimfac * (0.003 * (temp - 25) + 1)
lbot ( n4 bottom ) inductor l=lbot_para * l_mimfac
cox ( n3 um ) capacitor c=cox_para * cm6_mimfac
//
ends mimcap_um_1p0_sin_rf_mis

subckt mimcap_woum_1p0_sin_rf_mis ( top bottom gnode )
parameters lt=10u wt=10u lay=8 geo_fac=1 / sqrt(lt * wt * 1e12) factmis=0.004458
+ * geo_fac * par_rfmim ltop_para=((0.14 * (wt * 1e6) * (log((wt * 1e6) / (lt *
+ 1e6 + 0.05)) + 1.19 + 0.022 * (lt * 1e6 + 0.05) / (wt * 1e6)) / 1 + 1.5) / 3 +
+ 1.78) * 1e-12 lbot_cbm=((0.14 * (wt * 1e6 + 4.04) * (log((wt * 1e6 + 4.04) / ((lt
+ * 1e6 + 4.04) + 0.2)) + 1.19 + 0.022 * ((lt * 1e6 + 4.04) + 0.2) / (wt * 1e6 +
+ 4.04)) / 1 + 1.5) / 3) * 1e-12 lbot_lead=((0.606 + 0.14 * ((lt * 1e6 + 4.04) /
+ 2) * (log(((lt * 1e6 + 4.04) / 2) / (1 + 0.9)) + 1.19 + 0.022 * (1 + 0.9) / ((lt
+ * 1e6 + 4.04) / 2)) / 1 + 1.5) / 2) * 1e-12 lbot_para=(lbot_cbm + lbot_lead) via_v=int((lt
+ * 1e6 / 2 - 1.46) / (1.19) + 1) res_v=(via_v - 1) * (2 * via_v - 1) / (6 * via_v)
+ * 0.0083 + 20.15 / via_v via_h=int((wt * 1e6 - 3.64) / (2.925) + 1) rtop_para=(0.040508475
+ + (via_h - 1) * (2 * via_h - 1) / (6 * via_h) * 0.010169492 + res_v / 2 / via_h
+ + 0.15) r1=(lt * 1e6 + 0.2) / 2 / (wt * 1e6 + 0.2) * 0.293 / 3 r3=(wt * 1e6 +
+ 0.2) / 2 / (lt * 1e6 + 0.2) * 0.293 / 3 rcbm=(1 / (2 / r1 + 2 / r3)) via_left=int((((wt
+ * 1e6 + 4.04) - 0.96 + ((lt * 1e6 + 4.04) / 2 - 3.06)) - 0.76) / (1.21) + 1) res_left=0.002083333
+ + (via_left - 1) * (2 * via_left - 1) / (6 * via_left) * 0.008854167 + 0.54 /
+ via_left via_vert=int((((lt * 1e6 + 4.04) / 2 - 3.06) - 0.76) / (1.21) + 1) res_vert=0.002083333
+ + (via_vert - 1) * (2 * via_vert - 1) / (6 * via_vert) * 0.008854167 + 0.54 /
+ via_vert res_cbm=1 / (1 / res_left + 1 / res_vert) res_lead=(2 / 1.92 + (lt *
+ 1e6 + 4.04) / 2 / 1) * 0.02 res_upper=res_cbm + res_lead rbot_para=(res_upper
+ / 2 + rcbm + 0.15) cmim_para=(1 + factmis) *(((wt - 0.108e-6) * (lt - 0.108e-6) * 1e12 * 1.0274)
+ + 2 * ((wt - 0.108e-6) + (lt - 0.108e-6)) * 1e6 * 0.1686 + 0.1468) * 1e-15 * (1
+ + (temp - 25) *  - 4.13e-5 + (temp - 25) * (temp - 25) *  - 8e-8) cox_para=((lt
+ * 1e6 + 4.04) * (wt * 1e6 + 4.04) * 0.00908 + 0.05472 + (lt * 1e6 + 4.04) * 0.007125)
+ * 1e-15 rsub_para=(1 / (2 / ((lt * 1e6 + 4.04) / 2 / (wt * 1e6 + 4.04) * 1921
+ / 3) + 2 / ((wt * 1e6 + 4.04) / 2 / (lt * 1e6 + 4.04) * 1921 / 3))) * ( - 0.0000114365
+ * (temp - 25) * (temp - 25) + 0.0045985091 * (temp - 25) + 1) csub_para=(312
+ / rsub_para) * 1e-15
//
ltop ( top n1 ) inductor l=ltop_para * l_mimfac
rtop ( n1 n2 ) resistor r=rtop_para * rctm_mimfac * (0.003 * (temp - 25) + 1)
//cmim ( n2 n3 ) bsource c=cmim_para * (1 + v(n2,n3) * 2.96e-5 + (abs(v(n2,n3)) **
//+ 2) *  - 2.44e-5) * cmim_mimfac
cmim ( n2 n3 ) bsource q=cmim_para * (v(n2,n3) + 0.5*v(n2,n3)**(2) * 2.96e-5 + 1/3*v(n2,n3)
+ ** 3 *  - 2.44e-5) * cmim_mimfac
rbot ( n3 n4 ) resistor r=rbot_para * rctm_mimfac * (0.003 * (temp - 25) + 1)
lbot ( n4 bottom ) inductor l=lbot_para * l_mimfac
cox ( n3 n5 ) capacitor c=cox_para*((1/(5.64085+(2.37149)*(lay-4)))/0.0661078) * cm5_mimfac
csub ( n5 gnode ) capacitor c=csub_para * csub_mimfac
rsub ( n5 gnode ) resistor r=rsub_para * rsub_mimfac
//
ends mimcap_woum_1p0_sin_rf_mis
//
//
subckt mimcap_um_1p5_sin_rf_mis ( top bottom um )
parameters lt=10u wt=10u geo_fac=1 / sqrt(lt * wt * 1e12) factmis=0.006042 * geo_fac
+ * par_rfmim ltop_para=((0.14 * (wt * 1e6) * (log((wt * 1e6) / (lt *
+ 1e6 + 0.05)) + 1.19 + 0.022 * (lt * 1e6 + 0.05) / (wt * 1e6)) / 1 + 1.5) / 3 +
+ 1.78) * 1e-12 lbot_cbm=((0.14 * (wt * 1e6 + 4.04) * (log((wt * 1e6 + 4.04) / ((lt
+ * 1e6 + 4.04) + 0.2)) + 1.19 + 0.022 * ((lt * 1e6 + 4.04) + 0.2) / (wt * 1e6 +
+ 4.04)) / 1 + 1.5) / 3) * 1e-12 lbot_lead=((0.606 + 0.14 * ((lt * 1e6 + 4.04) /
+ 2) * (log(((lt * 1e6 + 4.04) / 2) / (1 + 0.9)) + 1.19 + 0.022 * (1 + 0.9) / ((lt
+ * 1e6 + 4.04) / 2)) / 1 + 1.5) / 2) * 1e-12 lbot_para=(lbot_cbm + lbot_lead) via_v=int((lt
+ * 1e6 / 2 - 1.46) / (1.19) + 1) res_v=(via_v - 1) * (2 * via_v - 1) / (6 * via_v)
+ * 0.0083 + 20.15 / via_v via_h=int((wt * 1e6 - 3.64) / (2.925) + 1) rtop_para=(0.040508475
+ + (via_h - 1) * (2 * via_h - 1) / (6 * via_h) * 0.010169492 + res_v / 2 / via_h
+ + 0.15) r1=(lt * 1e6 + 0.2) / 2 / (wt * 1e6 + 0.2) * 0.293 / 3 r3=(wt * 1e6 +
+ 0.2) / 2 / (lt * 1e6 + 0.2) * 0.293 / 3 rcbm=(1 / (2 / r1 + 2 / r3)) via_left=int((((wt
+ * 1e6 + 4.04) - 0.96 + ((lt * 1e6 + 4.04) / 2 - 3.06)) - 0.76) / (1.21) + 1) res_left=0.002083333
+ + (via_left - 1) * (2 * via_left - 1) / (6 * via_left) * 0.008854167 + 0.54 /
+ via_left via_vert=int((((lt * 1e6 + 4.04) / 2 - 3.06) - 0.76) / (1.21) + 1) res_vert=0.002083333
+ + (via_vert - 1) * (2 * via_vert - 1) / (6 * via_vert) * 0.008854167 + 0.54 /
+ via_vert res_cbm=1 / (1 / res_left + 1 / res_vert) res_lead=(2 / 1.92 + (lt *
+ 1e6 + 4.04) / 2 / 1) * 0.02 res_upper=res_cbm + res_lead rbot_para=(res_upper
+ / 2 + rcbm + 0.15) cmim_para=(1 + factmis) *(((wt - 0.092e-6) * (lt - 0.092e-6) * 1e12 * 1.547)
+ + 2 * ((wt - 0.092e-6) + (lt - 0.092e-6)) * 1e6 * 0.164 + 0.172) * 1e-15 * (1
+ + (temp - 25) *  - 5.016e-5 + (temp - 25) * (temp - 25) * 6.5e-9) cox_para=((lt
+ * 1e6 + 4.04) * (wt * 1e6 + 4.04) * 0.045917 + 0.05472 + (lt * 1e6 + 4.04) * 0.007125)
+ * 1e-15
//
ltop ( top n1 ) inductor l=ltop_para * l_mimfac
rtop ( n1 n2 ) resistor r=rtop_para * rctm_mimfac * (0.003 * (temp - 25) + 1)
//cmim ( n2 n3 ) bsource c=cmim_para * (1 + v(n2,n3) *  - 3.043e-5 + (abs(v(n2,n3))
//+ ** 2) *  - 4.6125e-5) * cmim_mimfac
cmim ( n2 n3 ) bsource q=cmim_para * (v(n2,n3) + 0.5*v(n2,n3)**(2) * - 3.043e-5 + 1/3*v(n2,n3)
+ ** 3 *  - 4.6125e-5) * cmim_mimfac
rbot ( n3 n4 ) resistor r=rbot_para * rctm_mimfac * (0.003 * (temp - 25) + 1)
lbot ( n4 bottom ) inductor l=lbot_para * l_mimfac
cox ( n3 um ) capacitor c=cox_para * cm6_mimfac
//
ends mimcap_um_1p5_sin_rf_mis

subckt mimcap_woum_1p5_sin_rf_mis ( top bottom gnode )
parameters lt=10u wt=10u lay=8 geo_fac=1 / sqrt(lt * wt * 1e12) factmis=0.006042 * geo_fac
+ * par_rfmim ltop_para=((0.14 * (wt * 1e6) * (log((wt * 1e6) / (lt *
+ 1e6 + 0.05)) + 1.19 + 0.022 * (lt * 1e6 + 0.05) / (wt * 1e6)) / 1 + 1.5) / 3 +
+ 1.78) * 1e-12 lbot_cbm=((0.14 * (wt * 1e6 + 4.04) * (log((wt * 1e6 + 4.04) / ((lt
+ * 1e6 + 4.04) + 0.2)) + 1.19 + 0.022 * ((lt * 1e6 + 4.04) + 0.2) / (wt * 1e6 +
+ 4.04)) / 1 + 1.5) / 3) * 1e-12 lbot_lead=((0.606 + 0.14 * ((lt * 1e6 + 4.04) /
+ 2) * (log(((lt * 1e6 + 4.04) / 2) / (1 + 0.9)) + 1.19 + 0.022 * (1 + 0.9) / ((lt
+ * 1e6 + 4.04) / 2)) / 1 + 1.5) / 2) * 1e-12 lbot_para=(lbot_cbm + lbot_lead) via_v=int((lt
+ * 1e6 / 2 - 1.46) / (1.19) + 1) res_v=(via_v - 1) * (2 * via_v - 1) / (6 * via_v)
+ * 0.0083 + 20.15 / via_v via_h=int((wt * 1e6 - 3.64) / (2.925) + 1) rtop_para=(0.040508475
+ + (via_h - 1) * (2 * via_h - 1) / (6 * via_h) * 0.010169492 + res_v / 2 / via_h
+ + 0.15) r1=(lt * 1e6 + 0.2) / 2 / (wt * 1e6 + 0.2) * 0.293 / 3 r3=(wt * 1e6 +
+ 0.2) / 2 / (lt * 1e6 + 0.2) * 0.293 / 3 rcbm=(1 / (2 / r1 + 2 / r3)) via_left=int((((wt
+ * 1e6 + 4.04) - 0.96 + ((lt * 1e6 + 4.04) / 2 - 3.06)) - 0.76) / (1.21) + 1) res_left=0.002083333
+ + (via_left - 1) * (2 * via_left - 1) / (6 * via_left) * 0.008854167 + 0.54 /
+ via_left via_vert=int((((lt * 1e6 + 4.04) / 2 - 3.06) - 0.76) / (1.21) + 1) res_vert=0.002083333
+ + (via_vert - 1) * (2 * via_vert - 1) / (6 * via_vert) * 0.008854167 + 0.54 /
+ via_vert res_cbm=1 / (1 / res_left + 1 / res_vert) res_lead=(2 / 1.92 + (lt *
+ 1e6 + 4.04) / 2 / 1) * 0.02 res_upper=res_cbm + res_lead rbot_para=(res_upper
+ / 2 + rcbm + 0.15) cmim_para=(1 + factmis) *(((wt - 0.092e-6) * (lt - 0.092e-6) * 1e12 * 1.547)
+ + 2 * ((wt - 0.092e-6) + (lt - 0.092e-6)) * 1e6 * 0.164 + 0.172) * 1e-15 * (1
+ + (temp - 25) *  - 5.016e-5 + (temp - 25) * (temp - 25) * 6.5e-9) cox_para=((lt
+ * 1e6 + 4.04) * (wt * 1e6 + 4.04) * 0.00908 + 0.05472 + (lt * 1e6 + 4.04) * 0.007125)
+ * 1e-15 rsub_para=(1 / (2 / ((lt * 1e6 + 4.04) / 2 / (wt * 1e6 + 4.04) * 1921
+ / 3) + 2 / ((wt * 1e6 + 4.04) / 2 / (lt * 1e6 + 4.04) * 1921 / 3))) * ( - 0.0000114365
+ * (temp - 25) * (temp - 25) + 0.0045985091 * (temp - 25) + 1) csub_para=(312
+ / rsub_para) * 1e-15
//
ltop ( top n1 ) inductor l=ltop_para * l_mimfac
rtop ( n1 n2 ) resistor r=rtop_para * rctm_mimfac * (0.003 * (temp - 25) + 1)
//cmim ( n2 n3 ) bsource c=cmim_para * (1 + v(n2,n3) * 2.96e-5 + (abs(v(n2,n3)) **
//+ 2) *  - 2.44e-5) * cmim_mimfac
cmim ( n2 n3 ) bsource q=cmim_para * (v(n2,n3) + 0.5*v(n2,n3)**(2) * - 3.043e-5 + 1/3*v(n2,n3)
+ ** 3 *  - 4.6125e-5) * cmim_mimfac
rbot ( n3 n4 ) resistor r=rbot_para * rctm_mimfac * (0.003 * (temp - 25) + 1)
lbot ( n4 bottom ) inductor l=lbot_para * l_mimfac
cox ( n3 n5 ) capacitor c=cox_para*((1/(5.64085+(2.37149)*(lay-4)))/0.0661078) * cm5_mimfac
csub ( n5 gnode ) capacitor c=csub_para * csub_mimfac
rsub ( n5 gnode ) resistor r=rsub_para * rsub_mimfac
//
ends mimcap_woum_1p5_sin_rf_mis

//
endsection rf_mim

//  *************************************************************************************************
//  SPIRAL INDUCTOR MODEL :
//
//      ## library files:
//
//     The Inductors are modeled with sub-circuit 'spiral_std' and 'spiral_sym' and 'spiral_sym_ct'
//
//      .subckt spiral_std   : Standard model with space=3um(fixed w=3um,9um,15um,30um) for Inductance varies with turn(1/4 turn increments) and radius
//      .subckt spiral_sym   : Symmetric model with space=3um(fixed w=3um,9um,15um,30um) for Inductance varies with turn(integral turn increments) and radius
//      .subckt spiral_sym_ct: Symmetric(center-tapped) model with space=3um(fixed w=3um,9um,15um,30um) for Inductance varies with turn(odd turn increments) and radius
//
//      Inductor model:
//
//         Model name   w(um)        turns          rad(um)          lay
//                     low high    low   high     low   high      low   high
//     ------------------------------------------------------------------------
//     spiral_std       3   30     0.5   5.5      15     90        4     8
//     ------------------------------------------------------------------------
//     spiral_sym       3   30      1     6       15     90        4     8
//     ------------------------------------------------------------------------
//     spiral_sym_ct    3   30      1     5       15     90        4     8
//     ------------------------------------------------------------------------
//	End Model
//     Note:The variable parameters of model are w, nr, rad, and lay(metal layer=4,5,6,7,or 8).
//
//  *************************************************************************************************
section rf_ind

subckt spiral_std ( top bottom gnode )
parameters nr=3 rad=60u w=15u lay=8 di=2 * rad * 1e6 do=2 * (rad * 1e6) + (int(nr
+ + 0.5) * (w * 1e6 + 3) - 3) + ((int(nr) + 1) * (w * 1e6 + 3) - 3) da=(di + do)
+ / 2 c12_a=((w - 9u) * (w - 15u) * (w - 30u) / (3u - 9u) / (3u - 15u) / (3u - 30u)
+ * (1.787199589) + (w - 3u) * (w - 15u) * (w - 30u) / (9u - 3u) / (9u - 15u) /
+ (9u - 30u) * ( - 0.393271276) + (w - 3u) * (w - 9u) * (w - 30u) / (15u - 3u) /
+ (15u - 9u) / (15u - 30u) * (2.446407706) + (w - 3u) * (w - 9u) * (w - 15u) / (30u
+ - 3u) / (30u - 9u) / (30u - 15u) * ( - 0.479444302)) c12_b=((w - 9u) * (w - 15u)
+ * (w - 30u) / (3u - 9u) / (3u - 15u) / (3u - 30u) * (0.029738786) + (w - 3u) *
+ (w - 15u) * (w - 30u) / (9u - 3u) / (9u - 15u) / (9u - 30u) * (0.060728608) +
+ (w - 3u) * (w - 9u) * (w - 30u) / (15u - 3u) / (15u - 9u) / (15u - 30u) * (0.060890433)
+ + (w - 3u) * (w - 9u) * (w - 15u) / (30u - 3u) / (30u - 9u) / (30u - 15u) * (0.126916593))
+ c12_c=((w - 9u) * (w - 15u) * (w - 30u) / (3u - 9u) / (3u - 15u) / (3u - 30u)
+ * ( - 0.275813805) + (w - 3u) * (w - 15u) * (w - 30u) / (9u - 3u) / (9u - 15u)
+ / (9u - 30u) * ( - 0.057835571) + (w - 3u) * (w - 9u) * (w - 30u) / (15u - 3u)
+ / (15u - 9u) / (15u - 30u) * ( - 0.19479562) + (w - 3u) * (w - 9u) * (w - 15u)
+ / (30u - 3u) / (30u - 9u) / (30u - 15u) * ( - 0.34537181)) c12_d=((w - 9u) * (w
+ - 15u) * (w - 30u) / (3u - 9u) / (3u - 15u) / (3u - 30u) * (0.000199665) + (w
+ - 3u) * (w - 15u) * (w - 30u) / (9u - 3u) / (9u - 15u) / (9u - 30u) * (5.64169e-05)
+ + (w - 3u) * (w - 9u) * (w - 30u) / (15u - 3u) / (15u - 9u) / (15u - 30u) * (0.000130772)
+ + (w - 3u) * (w - 9u) * (w - 15u) / (30u - 3u) / (30u - 9u) / (30u - 15u) * (
+ - 9.53794e-05)) c12_e=((w - 9u) * (w - 15u) * (w - 30u) / (3u - 9u) / (3u - 15u)
+ / (3u - 30u) * ( - 0.903525312) + (w - 3u) * (w - 15u) * (w - 30u) / (9u - 3u)
+ / (9u - 15u) / (9u - 30u) * ( - 0.191494763) + (w - 3u) * (w - 9u) * (w - 30u)
+ / (15u - 3u) / (15u - 9u) / (15u - 30u) * ( - 2.368460988) + (w - 3u) * (w - 9u)
+ * (w - 15u) / (30u - 3u) / (30u - 9u) / (30u - 15u) * ( - 2.96088049)) r1_a=((w
+ - 9u) * (w - 15u) * (w - 30u) / (3u - 9u) / (3u - 15u) / (3u - 30u) * (1.05121e-05)
+ + (w - 3u) * (w - 15u) * (w - 30u) / (9u - 3u) / (9u - 15u) / (9u - 30u) * (2.64274e-06)
+ + (w - 3u) * (w - 9u) * (w - 30u) / (15u - 3u) / (15u - 9u) / (15u - 30u) * (2.07274e-06)
+ + (w - 3u) * (w - 9u) * (w - 15u) / (30u - 3u) / (30u - 9u) / (30u - 15u) * (9.25776e-07))
+ r1_b=((w - 9u) * (w - 15u) * (w - 30u) / (3u - 9u) / (3u - 15u) / (3u - 30u) *
+ (0.264941637) + (w - 3u) * (w - 15u) * (w - 30u) / (9u - 3u) / (9u - 15u) / (9u
+ - 30u) * (0.114030484) + (w - 3u) * (w - 9u) * (w - 30u) / (15u - 3u) / (15u -
+ 9u) / (15u - 30u) * (0.089435674) + (w - 3u) * (w - 9u) * (w - 15u) / (30u - 3u)
+ / (30u - 9u) / (30u - 15u) * (0.15831161)) r1_c=((w - 9u) * (w - 15u) * (w - 30u)
+ / (3u - 9u) / (3u - 15u) / (3u - 30u) * (0.004650308) + (w - 3u) * (w - 15u) *
+ (w - 30u) / (9u - 3u) / (9u - 15u) / (9u - 30u) * (0.000431755) + (w - 3u) * (w
+ - 9u) * (w - 30u) / (15u - 3u) / (15u - 9u) / (15u - 30u) * (0.000338632) + (w
+ - 3u) * (w - 9u) * (w - 15u) / (30u - 3u) / (30u - 9u) / (30u - 15u) * ( - 4.89319e-05))
+ r1_d=((w - 9u) * (w - 15u) * (w - 30u) / (3u - 9u) / (3u - 15u) / (3u - 30u) *
+ ( - 0.007577539) + (w - 3u) * (w - 15u) * (w - 30u) / (9u - 3u) / (9u - 15u) /
+ (9u - 30u) * (0.019083118) + (w - 3u) * (w - 9u) * (w - 30u) / (15u - 3u) / (15u
+ - 9u) / (15u - 30u) * (0.014967151) + (w - 3u) * (w - 9u) * (w - 15u) / (30u -
+ 3u) / (30u - 9u) / (30u - 15u) * (0.012129132)) r1_e=((w - 9u) * (w - 15u) * (w
+ - 30u) / (3u - 9u) / (3u - 15u) / (3u - 30u) * (0.209628597) + (w - 3u) * (w -
+ 15u) * (w - 30u) / (9u - 3u) / (9u - 15u) / (9u - 30u) * (0.158215729) + (w -
+ 3u) * (w - 9u) * (w - 30u) / (15u - 3u) / (15u - 9u) / (15u - 30u) * (0.092718219)
+ + (w - 3u) * (w - 9u) * (w - 15u) / (30u - 3u) / (30u - 9u) / (30u - 15u) * (
+ - 0.078258161)) l1_a=((w - 9u) * (w - 15u) * (w - 30u) / (3u - 9u) / (3u - 15u)
+ / (3u - 30u) * (0.00054679) + (w - 3u) * (w - 15u) * (w - 30u) / (9u - 3u) / (9u
+ - 15u) / (9u - 30u) * (0.00047619) + (w - 3u) * (w - 9u) * (w - 30u) / (15u -
+ 3u) / (15u - 9u) / (15u - 30u) * (0.00043814) + (w - 3u) * (w - 9u) * (w - 15u)
+ / (30u - 3u) / (30u - 9u) / (30u - 15u) * (0.000608695)) l1_b=((w - 9u) * (w -
+ 15u) * (w - 30u) / (3u - 9u) / (3u - 15u) / (3u - 30u) * (1.731275617) + (w -
+ 3u) * (w - 15u) * (w - 30u) / (9u - 3u) / (9u - 15u) / (9u - 30u) * (1.731275617)
+ + (w - 3u) * (w - 9u) * (w - 30u) / (15u - 3u) / (15u - 9u) / (15u - 30u) * (1.731275617)
+ + (w - 3u) * (w - 9u) * (w - 15u) / (30u - 3u) / (30u - 9u) / (30u - 15u) * (1.759943486))
+ l1_c=((w - 9u) * (w - 15u) * (w - 30u) / (3u - 9u) / (3u - 15u) / (3u - 30u) *
+ (2.228105758) + (w - 3u) * (w - 15u) * (w - 30u) / (9u - 3u) / (9u - 15u) / (9u
+ - 30u) * (2.228105758) + (w - 3u) * (w - 9u) * (w - 30u) / (15u - 3u) / (15u -
+ 9u) / (15u - 30u) * (2.228105758) + (w - 3u) * (w - 9u) * (w - 15u) / (30u - 3u)
+ / (30u - 9u) / (30u - 15u) * (2.568753818)) l1_d=((w - 9u) * (w - 15u) * (w -
+ 30u) / (3u - 9u) / (3u - 15u) / (3u - 30u) * ( - 1.034846428) + (w - 3u) * (w
+ - 15u) * (w - 30u) / (9u - 3u) / (9u - 15u) / (9u - 30u) * ( - 1.034846428) +
+ (w - 3u) * (w - 9u) * (w - 30u) / (15u - 3u) / (15u - 9u) / (15u - 30u) * ( -
+ 1.034846428) + (w - 3u) * (w - 9u) * (w - 15u) / (30u - 3u) / (30u - 9u) / (30u
+ - 15u) * ( - 1.444498784)) l1_e=((w - 9u) * (w - 15u) * (w - 30u) / (3u - 9u)
+ / (3u - 15u) / (3u - 30u) * ( - 24.04707924) + (w - 3u) * (w - 15u) * (w - 30u)
+ / (9u - 3u) / (9u - 15u) / (9u - 30u) * ( - 20.9420880) + (w - 3u) * (w - 9u)
+ * (w - 30u) / (15u - 3u) / (15u - 9u) / (15u - 30u) * ( - 19.26896387) + (w -
+ 3u) * (w - 9u) * (w - 15u) / (30u - 3u) / (30u - 9u) / (30u - 15u) * (4.64571e-09))
+ l1_f=((w - 9u) * (w - 15u) * (w - 30u) / (3u - 9u) / (3u - 15u) / (3u - 30u) *
+ (0.000996) + (w - 3u) * (w - 15u) * (w - 30u) / (9u - 3u) / (9u - 15u) / (9u -
+ 30u) * (0.000996) + (w - 3u) * (w - 9u) * (w - 30u) / (15u - 3u) / (15u - 9u)
+ / (15u - 30u) * (0.000996) + (w - 3u) * (w - 9u) * (w - 15u) / (30u - 3u) / (30u
+ - 9u) / (30u - 15u) * (10.20291326)) l1_g=((w - 9u) * (w - 15u) * (w - 30u) /
+ (3u - 9u) / (3u - 15u) / (3u - 30u) * (24.1435784) + (w - 3u) * (w - 15u) * (w
+ - 30u) / (9u - 3u) / (9u - 15u) / (9u - 30u) * (21.02613) + (w - 3u) * (w - 9u)
+ * (w - 30u) / (15u - 3u) / (15u - 9u) / (15u - 30u) * (19.3462888) + (w - 3u)
+ * (w - 9u) * (w - 15u) / (30u - 3u) / (30u - 9u) / (30u - 15u) * (0.088063163))
+ rs_a=((w - 9u) * (w - 15u) * (w - 30u) / (3u - 9u) / (3u - 15u) / (3u - 30u) *
+ (5.85408e-06) + (w - 3u) * (w - 15u) * (w - 30u) / (9u - 3u) / (9u - 15u) / (9u
+ - 30u) * (1.30091e-06) + (w - 3u) * (w - 9u) * (w - 30u) / (15u - 3u) / (15u -
+ 9u) / (15u - 30u) * (8.67271e-07) + (w - 3u) * (w - 9u) * (w - 15u) / (30u - 3u)
+ / (30u - 9u) / (30u - 15u) * (4.33636e-07)) rs_b=((w - 9u) * (w - 15u) * (w -
+ 30u) / (3u - 9u) / (3u - 15u) / (3u - 30u) * (1.467932817) + (w - 3u) * (w - 15u)
+ * (w - 30u) / (9u - 3u) / (9u - 15u) / (9u - 30u) * (0.326207293) + (w - 3u) *
+ (w - 9u) * (w - 30u) / (15u - 3u) / (15u - 9u) / (15u - 30u) * (0.217471528) +
+ (w - 3u) * (w - 9u) * (w - 15u) / (30u - 3u) / (30u - 9u) / (30u - 15u) * (0.108735764))
+ rs_c=((w - 9u) * (w - 15u) * (w - 30u) / (3u - 9u) / (3u - 15u) / (3u - 30u) *
+ (0.006313405) + (w - 3u) * (w - 15u) * (w - 30u) / (9u - 3u) / (9u - 15u) / (9u
+ - 30u) * (0.001402979) + (w - 3u) * (w - 9u) * (w - 30u) / (15u - 3u) / (15u -
+ 9u) / (15u - 30u) * (0.000935319) + (w - 3u) * (w - 9u) * (w - 15u) / (30u - 3u)
+ / (30u - 9u) / (30u - 15u) * (0.00046766)) rs_dd=((w - 9u) * (w - 15u) * (w - 30u)
+ / (3u - 9u) / (3u - 15u) / (3u - 30u) * ( - 0.061766404) + (w - 3u) * (w - 15u)
+ * (w - 30u) / (9u - 3u) / (9u - 15u) / (9u - 30u) * ( - 0.013725868) + (w - 3u)
+ * (w - 9u) * (w - 30u) / (15u - 3u) / (15u - 9u) / (15u - 30u) * ( - 0.009150578)
+ + (w - 3u) * (w - 9u) * (w - 15u) / (30u - 3u) / (30u - 9u) / (30u - 15u) * (
+ - 0.004575289)) rs_e=((w - 9u) * (w - 15u) * (w - 30u) / (3u - 9u) / (3u - 15u)
+ / (3u - 30u) * ( - 0.616623468) + (w - 3u) * (w - 15u) * (w - 30u) / (9u - 3u)
+ / (9u - 15u) / (9u - 30u) * ( - 0.137027437) + (w - 3u) * (w - 9u) * (w - 30u)
+ / (15u - 3u) / (15u - 9u) / (15u - 30u) * ( - 0.091351625) + (w - 3u) * (w - 9u)
+ * (w - 15u) / (30u - 3u) / (30u - 9u) / (30u - 15u) * ( - 0.045675812)) ls_a=((w
+ - 9u) * (w - 15u) * (w - 30u) / (3u - 9u) / (3u - 15u) / (3u - 30u) * (0.155184106)
+ + (w - 3u) * (w - 15u) * (w - 30u) / (9u - 3u) / (9u - 15u) / (9u - 30u) * (0.168658742)
+ + (w - 3u) * (w - 9u) * (w - 30u) / (15u - 3u) / (15u - 9u) / (15u - 30u) * (0.155184106)
+ + (w - 3u) * (w - 9u) * (w - 15u) / (30u - 3u) / (30u - 9u) / (30u - 15u) * (0.206912141))
+ ls_b=((w - 9u) * (w - 15u) * (w - 30u) / (3u - 9u) / (3u - 15u) / (3u - 30u) *
+ (0.919577042) + (w - 3u) * (w - 15u) * (w - 30u) / (9u - 3u) / (9u - 15u) / (9u
+ - 30u) * (0.919577042) + (w - 3u) * (w - 9u) * (w - 30u) / (15u - 3u) / (15u -
+ 9u) / (15u - 30u) * (0.919577042) + (w - 3u) * (w - 9u) * (w - 15u) / (30u - 3u)
+ / (30u - 9u) / (30u - 15u) * (0.919577042)) ls_c=((w - 9u) * (w - 15u) * (w -
+ 30u) / (3u - 9u) / (3u - 15u) / (3u - 30u) * (0.089717974) + (w - 3u) * (w - 15u)
+ * (w - 30u) / (9u - 3u) / (9u - 15u) / (9u - 30u) * (0.089717974) + (w - 3u) *
+ (w - 9u) * (w - 30u) / (15u - 3u) / (15u - 9u) / (15u - 30u) * (0.089717974) +
+ (w - 3u) * (w - 9u) * (w - 15u) / (30u - 3u) / (30u - 9u) / (30u - 15u) * (0.089717974))
+ ls_d=((w - 9u) * (w - 15u) * (w - 30u) / (3u - 9u) / (3u - 15u) / (3u - 30u) *
+ (0.001643525) + (w - 3u) * (w - 15u) * (w - 30u) / (9u - 3u) / (9u - 15u) / (9u
+ - 30u) * (0.001643525) + (w - 3u) * (w - 9u) * (w - 30u) / (15u - 3u) / (15u -
+ 9u) / (15u - 30u) * (0.001643525) + (w - 3u) * (w - 9u) * (w - 15u) / (30u - 3u)
+ / (30u - 9u) / (30u - 15u) * (0.001643525)) ls_e=((w - 9u) * (w - 15u) * (w -
+ 30u) / (3u - 9u) / (3u - 15u) / (3u - 30u) * ( - 5.063821028) + (w - 3u) * (w
+ - 15u) * (w - 30u) / (9u - 3u) / (9u - 15u) / (9u - 30u) * ( - 5.503512608) +
+ (w - 3u) * (w - 9u) * (w - 30u) / (15u - 3u) / (15u - 9u) / (15u - 30u) * ( -
+ 5.063821028) + (w - 3u) * (w - 9u) * (w - 15u) / (30u - 3u) / (30u - 9u) / (30u
+ - 15u) * ( - 6.751761371)) ls_f=((w - 9u) * (w - 15u) * (w - 30u) / (3u - 9u)
+ / (3u - 15u) / (3u - 30u) * (0.025088163) + (w - 3u) * (w - 15u) * (w - 30u) /
+ (9u - 3u) / (9u - 15u) / (9u - 30u) * (0.025088163) + (w - 3u) * (w - 9u) * (w
+ - 30u) / (15u - 3u) / (15u - 9u) / (15u - 30u) * (0.025088163) + (w - 3u) * (w
+ - 9u) * (w - 15u) / (30u - 3u) / (30u - 9u) / (30u - 15u) * (0.025088163)) ls_g=((w
+ - 9u) * (w - 15u) * (w - 30u) / (3u - 9u) / (3u - 15u) / (3u - 30u) * (4.887973003)
+ + (w - 3u) * (w - 15u) * (w - 30u) / (9u - 3u) / (9u - 15u) / (9u - 30u) * (5.287395698)
+ + (w - 3u) * (w - 9u) * (w - 30u) / (15u - 3u) / (15u - 9u) / (15u - 30u) * (4.867973003)
+ + (w - 3u) * (w - 9u) * (w - 15u) / (30u - 3u) / (30u - 9u) / (30u - 15u) * (6.482297337))
+ cox1_a=((w - 9u) * (w - 15u) * (w - 30u) / (3u - 9u) / (3u - 15u) / (3u - 30u)
+ * (0.010320009) + (w - 3u) * (w - 15u) * (w - 30u) / (9u - 3u) / (9u - 15u) /
+ (9u - 30u) * (0.030960027) + (w - 3u) * (w - 9u) * (w - 30u) / (15u - 3u) / (15u
+ - 9u) / (15u - 30u) * (0.051600046) + (w - 3u) * (w - 9u) * (w - 15u) / (30u -
+ 3u) / (30u - 9u) / (30u - 15u) * (0.096445633)) cox1_b=((w - 9u) * (w - 15u) *
+ (w - 30u) / (3u - 9u) / (3u - 15u) / (3u - 30u) * (13.39365722) + (w - 3u) * (w
+ - 15u) * (w - 30u) / (9u - 3u) / (9u - 15u) / (9u - 30u) * (22.18097167) + (w
+ - 3u) * (w - 9u) * (w - 30u) / (15u - 3u) / (15u - 9u) / (15u - 30u) * (28.63495279)
+ + (w - 3u) * (w - 9u) * (w - 15u) / (30u - 3u) / (30u - 9u) / (30u - 15u) * (47.37952947))
+ cox2_a=((w - 9u) * (w - 15u) * (w - 30u) / (3u - 9u) / (3u - 15u) / (3u - 30u)
+ * (0.012745627) + (w - 3u) * (w - 15u) * (w - 30u) / (9u - 3u) / (9u - 15u) /
+ (9u - 30u) * (0.03823688) + (w - 3u) * (w - 9u) * (w - 30u) / (15u - 3u) / (15u
+ - 9u) / (15u - 30u) * (0.063728133) + (w - 3u) * (w - 9u) * (w - 15u) / (30u -
+ 3u) / (30u - 9u) / (30u - 15u) * (0.103954139)) cox2_b=((w - 9u) * (w - 15u) *
+ (w - 30u) / (3u - 9u) / (3u - 15u) / (3u - 30u) * (13.10445328) + (w - 3u) * (w
+ - 15u) * (w - 30u) / (9u - 3u) / (9u - 15u) / (9u - 30u) * (24.31335985) + (w
+ - 3u) * (w - 9u) * (w - 30u) / (15u - 3u) / (15u - 9u) / (15u - 30u) * (32.18893309)
+ + (w - 3u) * (w - 9u) * (w - 15u) / (30u - 3u) / (30u - 9u) / (30u - 15u) * (45.30002518))
+ rsub1_a=((w - 9u) * (w - 15u) * (w - 30u) / (3u - 9u) / (3u - 15u) / (3u - 30u)
+ * ( - 1454.526451) + (w - 3u) * (w - 15u) * (w - 30u) / (9u - 3u) / (9u - 15u)
+ / (9u - 30u) * ( - 808.0702503) + (w - 3u) * (w - 9u) * (w - 30u) / (15u - 3u)
+ / (15u - 9u) / (15u - 30u) * ( - 7468.848994) + (w - 3u) * (w - 9u) * (w - 15u)
+ / (30u - 3u) / (30u - 9u) / (30u - 15u) * ( - 3734.424497)) rsub1_b=((w - 9u)
+ * (w - 15u) * (w - 30u) / (3u - 9u) / (3u - 15u) / (3u - 30u) * (40962.92672)
+ + (w - 3u) * (w - 15u) * (w - 30u) / (9u - 3u) / (9u - 15u) / (9u - 30u) * (22757.18151)
+ + (w - 3u) * (w - 9u) * (w - 30u) / (15u - 3u) / (15u - 9u) / (15u - 30u) * (45387.03639)
+ + (w - 3u) * (w - 9u) * (w - 15u) / (30u - 3u) / (30u - 9u) / (30u - 15u) * (22693.51819))
+ rsub1_c=((w - 9u) * (w - 15u) * (w - 30u) / (3u - 9u) / (3u - 15u) / (3u - 30u)
+ * (250.1321061) + (w - 3u) * (w - 15u) * (w - 30u) / (9u - 3u) / (9u - 15u) /
+ (9u - 30u) * (138.9622812) + (w - 3u) * (w - 9u) * (w - 30u) / (15u - 3u) / (15u
+ - 9u) / (15u - 30u) * (197.5304779) + (w - 3u) * (w - 9u) * (w - 15u) / (30u -
+ 3u) / (30u - 9u) / (30u - 15u) * (98.76523893)) rsub1_d=((w - 9u) * (w - 15u)
+ * (w - 30u) / (3u - 9u) / (3u - 15u) / (3u - 30u) * (1755.781783) + (w - 3u) *
+ (w - 15u) * (w - 30u) / (9u - 3u) / (9u - 15u) / (9u - 30u) * (975.4343241) +
+ (w - 3u) * (w - 9u) * (w - 30u) / (15u - 3u) / (15u - 9u) / (15u - 30u) * (550.2279827)
+ + (w - 3u) * (w - 9u) * (w - 15u) / (30u - 3u) / (30u - 9u) / (30u - 15u) * (275.1139913))
+ rsub2_a=((w - 9u) * (w - 15u) * (w - 30u) / (3u - 9u) / (3u - 15u) / (3u - 30u)
+ * (2505.730987) + (w - 3u) * (w - 15u) * (w - 30u) / (9u - 3u) / (9u - 15u) /
+ (9u - 30u) * (1392.072771) + (w - 3u) * (w - 9u) * (w - 30u) / (15u - 3u) / (15u
+ - 9u) / (15u - 30u) * ( - 9133.638083) + (w - 3u) * (w - 9u) * (w - 15u) / (30u
+ - 3u) / (30u - 9u) / (30u - 15u) * ( - 4566.819041)) rsub2_b=((w - 9u) * (w -
+ 15u) * (w - 30u) / (3u - 9u) / (3u - 15u) / (3u - 30u) * (34342.94604) + (w -
+ 3u) * (w - 15u) * (w - 30u) / (9u - 3u) / (9u - 15u) / (9u - 30u) * (19079.41446)
+ + (w - 3u) * (w - 9u) * (w - 30u) / (15u - 3u) / (15u - 9u) / (15u - 30u) * (137761.6699)
+ + (w - 3u) * (w - 9u) * (w - 15u) / (30u - 3u) / (30u - 9u) / (30u - 15u) * (68880.83497))
+ rsub2_c=((w - 9u) * (w - 15u) * (w - 30u) / (3u - 9u) / (3u - 15u) / (3u - 30u)
+ * (313.9535238) + (w - 3u) * (w - 15u) * (w - 30u) / (9u - 3u) / (9u - 15u) /
+ (9u - 30u) * (174.4186244) + (w - 3u) * (w - 9u) * (w - 30u) / (15u - 3u) / (15u
+ - 9u) / (15u - 30u) * (693.0352224) + (w - 3u) * (w - 9u) * (w - 15u) / (30u -
+ 3u) / (30u - 9u) / (30u - 15u) * (346.5176112)) rsub2_d=((w - 9u) * (w - 15u)
+ * (w - 30u) / (3u - 9u) / (3u - 15u) / (3u - 30u) * (1599.603675) + (w - 3u) *
+ (w - 15u) * (w - 30u) / (9u - 3u) / (9u - 15u) / (9u - 30u) * (888.6687081) +
+ (w - 3u) * (w - 9u) * (w - 30u) / (15u - 3u) / (15u - 9u) / (15u - 30u) * (104.1011242)
+ + (w - 3u) * (w - 9u) * (w - 15u) / (30u - 3u) / (30u - 9u) / (30u - 15u) * (252.0505621))
+ cox_1=cox1_a * nr * da + cox1_b cox_2=cox2_a * nr * da + cox2_b rsub_1=(rsub1_a
+ / (nr * da) + rsub1_b / da + rsub1_c / nr + rsub1_d) * ( - 0.0000114365 * (temp
+ - 25) * (temp - 25) + 0.0045985091 * (temp - 25) + 1) rsub_2=(rsub2_a / (nr
+ * da) + rsub2_b / da + rsub2_c / nr + rsub2_d) * ( - 0.0000114365 * (temp -
+ 25) * (temp - 25) + 0.0045985091 * (temp - 25) + 1) csub_1=1.05315e-11 / rsub_1
+ csub_2=1.05315e-11 / rsub_2
//
//
//
//
//
//
//
//
//
//
//
c12 ( top bottom ) capacitor c=(c12_a * nr + c12_b * nr * da + c12_c * nr * nr +
+ c12_d * da * da + c12_e) * 1e-15 * c12_indfac

r1 ( top n1 ) resistor r=(r1_a * nr * da * da + r1_b * nr + r1_c * da + r1_d * nr
+ * nr + r1_e) * (0.0026 * (temp - 25) + 1) * rm8_indfac
l1 ( n1 n3 ) inductor l=(l1_a * nr ** (l1_b) * da ** (l1_c) * do ** (l1_d) + l1_e
+ * nr ** (l1_f) + l1_g) * 1.0e-9 * l_indfac
l2 ( n3 n2 ) inductor l=(l1_a * nr ** (l1_b) * da ** (l1_c) * do ** (l1_d) + l1_e
+ * nr ** (l1_f) + l1_g) * 1.0e-9 * l_indfac
r2 ( n2 bottom ) resistor r=(r1_a * nr * da * da + r1_b * nr + r1_c * da + r1_d
+ * nr * nr + r1_e) * (0.0026 * (temp - 25) + 1) * rm8_indfac

rs1 ( top n11 ) resistor r=(rs_a * nr * da * da + rs_b * nr + rs_c * da + rs_dd *
+ nr * nr + rs_e) * ((0.0026 * (temp - 25) + 1) ** (0.5))
ls1 ( n11 n1 ) inductor l=(ls_a * nr ** (ls_b) * da ** (ls_c) * do ** (ls_d) + ls_e
+ * nr ** (ls_f) + ls_g) * 1e-9
ls2 ( n22 n2 ) inductor l=(ls_a * nr ** (ls_b) * da ** (ls_c) * do ** (ls_d) + ls_e
+ * nr ** (ls_f) + ls_g) * 1e-9
rs2 ( n22 bottom ) resistor r=(rs_a * nr * da * da + rs_b * nr + rs_c * da + rs_dd
+ * nr * nr + rs_e) * ((0.0026 * (temp - 25) + 1) ** (0.5))

cox1 ( top sub1 ) capacitor c=(cox_1) * ((1 / (11.4174 + (2.37149) * (lay - 4)))
+ / (0.0478392)) * 1e-15 * cm8_indfac
cox2 ( bottom sub2 ) capacitor c=(cox_2) * ((1 / (11.4174 + (2.37149) * (lay - 4)))
+ / (0.0478392)) * 1e-15 * cm8_indfac
cox3 ( n3 sub3 ) capacitor c=(cox_1 + cox_2) * ((1 / (11.4174 + (2.37149) * (lay
+ - 4))) / (0.0478392)) * 1e-15 * cm8_indfac

csub1 ( sub1 gnode ) capacitor c=(csub_1) * csub_indfac
csub2 ( sub2 gnode ) capacitor c=(csub_2) * csub_indfac
csub3 ( sub3 gnode ) capacitor c=(csub_1 + csub_2) * csub_indfac
rsub1 ( sub1 gnode ) resistor r=(rsub_1) * rsub_indfac
rsub2 ( sub2 gnode ) resistor r=(rsub_2) * rsub_indfac
rsub3 ( sub3 gnode ) resistor r=(rsub_1 * rsub_2 / (rsub_1 + rsub_2)) * rsub_indfac

ends spiral_std

subckt spiral_sym ( top bottom gnode )
parameters nr=3 rad=60u w=15u lay=8 di=2 * rad * 1e6 do=2 * rad * 1e6 + 2 * (nr
+ * (w * 1e6 + 3) - 3) da=(di + do) / 2 c12_a=((w - 9u) * (w - 15u) * (w - 30u)
+ / (3u - 9u) / (3u - 15u) / (3u - 30u) * ( - 1.896681454) + (w - 3u) * (w - 15u)
+ * (w - 30u) / (9u - 3u) / (9u - 15u) / (9u - 30u) * ( - 3.417120146) + (w - 3u)
+ * (w - 9u) * (w - 30u) / (15u - 3u) / (15u - 9u) / (15u - 30u) * ( - 3.707340569)
+ + (w - 3u) * (w - 9u) * (w - 15u) / (30u - 3u) / (30u - 9u) / (30u - 15u) * (
+ - 5.36508578)) c12_b=((w - 9u) * (w - 15u) * (w - 30u) / (3u - 9u) / (3u - 15u)
+ / (3u - 30u) * (0.078718307) + (w - 3u) * (w - 15u) * (w - 30u) / (9u - 3u) /
+ (9u - 15u) / (9u - 30u) * (0.081470606) + (w - 3u) * (w - 9u) * (w - 30u) / (15u
+ - 3u) / (15u - 9u) / (15u - 30u) * (0.087843107) + (w - 3u) * (w - 9u) * (w -
+ 15u) / (30u - 3u) / (30u - 9u) / (30u - 15u) * (0.113545938)) c12_c=((w - 9u)
+ * (w - 15u) * (w - 30u) / (3u - 9u) / (3u - 15u) / (3u - 30u) * (0.498120289)
+ + (w - 3u) * (w - 15u) * (w - 30u) / (9u - 3u) / (9u - 15u) / (9u - 30u) * (0.65250083)
+ + (w - 3u) * (w - 9u) * (w - 30u) / (15u - 3u) / (15u - 9u) / (15u - 30u) * (1.108171537)
+ + (w - 3u) * (w - 9u) * (w - 15u) / (30u - 3u) / (30u - 9u) / (30u - 15u) * (1.243501848))
+ c12_d=((w - 9u) * (w - 15u) * (w - 30u) / (3u - 9u) / (3u - 15u) / (3u - 30u)
+ * ( - 0.000101633) + (w - 3u) * (w - 15u) * (w - 30u) / (9u - 3u) / (9u - 15u)
+ / (9u - 30u) * ( - 0.000155708) + (w - 3u) * (w - 9u) * (w - 30u) / (15u - 3u)
+ / (15u - 9u) / (15u - 30u) * (3.69495e-05) + (w - 3u) * (w - 9u) * (w - 15u) /
+ (30u - 3u) / (30u - 9u) / (30u - 15u) * (5.11024e-05)) c12_e=((w - 9u) * (w -
+ 15u) * (w - 30u) / (3u - 9u) / (3u - 15u) / (3u - 30u) * ( - 0.969173183) + (w
+ - 3u) * (w - 15u) * (w - 30u) / (9u - 3u) / (9u - 15u) / (9u - 30u) * (0.47887741)
+ + (w - 3u) * (w - 9u) * (w - 30u) / (15u - 3u) / (15u - 9u) / (15u - 30u) * (
+ - 0.409880581) + (w - 3u) * (w - 9u) * (w - 15u) / (30u - 3u) / (30u - 9u) / (30u
+ - 15u) * ( - 2.13097863)) r1_a=((w - 9u) * (w - 15u) * (w - 30u) / (3u - 9u) /
+ (3u - 15u) / (3u - 30u) * (2.33645e-05) + (w - 3u) * (w - 15u) * (w - 30u) / (9u
+ - 3u) / (9u - 15u) / (9u - 30u) * (5.90479e-06) + (w - 3u) * (w - 9u) * (w - 30u)
+ / (15u - 3u) / (15u - 9u) / (15u - 30u) * (1.96488e-06) + (w - 3u) * (w - 9u)
+ * (w - 15u) / (30u - 3u) / (30u - 9u) / (30u - 15u) * (5.60959e-07)) r1_b=((w
+ - 9u) * (w - 15u) * (w - 30u) / (3u - 9u) / (3u - 15u) / (3u - 30u) * (0.150886387)
+ + (w - 3u) * (w - 15u) * (w - 30u) / (9u - 3u) / (9u - 15u) / (9u - 30u) * (0.049017468)
+ + (w - 3u) * (w - 9u) * (w - 30u) / (15u - 3u) / (15u - 9u) / (15u - 30u) * (0.162849086)
+ + (w - 3u) * (w - 9u) * (w - 15u) / (30u - 3u) / (30u - 9u) / (30u - 15u) * (
+ - 0.057821743)) r1_c=((w - 9u) * (w - 15u) * (w - 30u) / (3u - 9u) / (3u - 15u)
+ / (3u - 30u) * (0.003039879) + (w - 3u) * (w - 15u) * (w - 30u) / (9u - 3u) /
+ (9u - 15u) / (9u - 30u) * (0.00181877) + (w - 3u) * (w - 9u) * (w - 30u) / (15u
+ - 3u) / (15u - 9u) / (15u - 30u) * (0.000703993) + (w - 3u) * (w - 9u) * (w -
+ 15u) / (30u - 3u) / (30u - 9u) / (30u - 15u) * (0.000888197)) r1_d=((w - 9u) *
+ (w - 15u) * (w - 30u) / (3u - 9u) / (3u - 15u) / (3u - 30u) * (0.024841922) +
+ (w - 3u) * (w - 15u) * (w - 30u) / (9u - 3u) / (9u - 15u) / (9u - 30u) * (0.033953873)
+ + (w - 3u) * (w - 9u) * (w - 30u) / (15u - 3u) / (15u - 9u) / (15u - 30u) * (0.023359123)
+ + (w - 3u) * (w - 9u) * (w - 15u) / (30u - 3u) / (30u - 9u) / (30u - 15u) * (0.06502045))
+ r1_e=((w - 9u) * (w - 15u) * (w - 30u) / (3u - 9u) / (3u - 15u) / (3u - 30u) *
+ (0.556246772) + (w - 3u) * (w - 15u) * (w - 30u) / (9u - 3u) / (9u - 15u) / (9u
+ - 30u) * (0.244834205) + (w - 3u) * (w - 9u) * (w - 30u) / (15u - 3u) / (15u -
+ 9u) / (15u - 30u) * (0.113816284) + (w - 3u) * (w - 9u) * (w - 15u) / (30u - 3u)
+ / (30u - 9u) / (30u - 15u) * (0.161486385)) l1_a=((w - 9u) * (w - 15u) * (w -
+ 30u) / (3u - 9u) / (3u - 15u) / (3u - 30u) * (0.00035420) + (w - 3u) * (w - 15u)
+ * (w - 30u) / (9u - 3u) / (9u - 15u) / (9u - 30u) * (0.000291748) + (w - 3u) *
+ (w - 9u) * (w - 30u) / (15u - 3u) / (15u - 9u) / (15u - 30u) * (0.00026978) +
+ (w - 3u) * (w - 9u) * (w - 15u) / (30u - 3u) / (30u - 9u) / (30u - 15u) * (0.00022529))
+ l1_b=((w - 9u) * (w - 15u) * (w - 30u) / (3u - 9u) / (3u - 15u) / (3u - 30u) *
+ (1.533019164) + (w - 3u) * (w - 15u) * (w - 30u) / (9u - 3u) / (9u - 15u) / (9u
+ - 30u) * (1.533019164) + (w - 3u) * (w - 9u) * (w - 30u) / (15u - 3u) / (15u -
+ 9u) / (15u - 30u) * (1.533019164) + (w - 3u) * (w - 9u) * (w - 15u) / (30u - 3u)
+ / (30u - 9u) / (30u - 15u) * (1.533019164)) l1_c=((w - 9u) * (w - 15u) * (w -
+ 30u) / (3u - 9u) / (3u - 15u) / (3u - 30u) * (1.655981779) + (w - 3u) * (w - 15u)
+ * (w - 30u) / (9u - 3u) / (9u - 15u) / (9u - 30u) * (1.655981779) + (w - 3u) *
+ (w - 9u) * (w - 30u) / (15u - 3u) / (15u - 9u) / (15u - 30u) * (1.655981779) +
+ (w - 3u) * (w - 9u) * (w - 15u) / (30u - 3u) / (30u - 9u) / (30u - 15u) * (1.655981779))
+ l1_d=((w - 9u) * (w - 15u) * (w - 30u) / (3u - 9u) / (3u - 15u) / (3u - 30u) *
+ ( - 0.442001746) + (w - 3u) * (w - 15u) * (w - 30u) / (9u - 3u) / (9u - 15u) /
+ (9u - 30u) * ( - 0.442001746) + (w - 3u) * (w - 9u) * (w - 30u) / (15u - 3u) /
+ (15u - 9u) / (15u - 30u) * ( - 0.442001746) + (w - 3u) * (w - 9u) * (w - 15u)
+ / (30u - 3u) / (30u - 9u) / (30u - 15u) * ( - 0.442001746)) l1_e=((w - 9u) * (w
+ - 15u) * (w - 30u) / (3u - 9u) / (3u - 15u) / (3u - 30u) * (12.8319390) + (w -
+ 3u) * (w - 15u) * (w - 30u) / (9u - 3u) / (9u - 15u) / (9u - 30u) * (10.56951658)
+ + (w - 3u) * (w - 9u) * (w - 30u) / (15u - 3u) / (15u - 9u) / (15u - 30u) * (9.77372225)
+ + (w - 3u) * (w - 9u) * (w - 15u) / (30u - 3u) / (30u - 9u) / (30u - 15u) * (8.16178071))
+ l1_f=((w - 9u) * (w - 15u) * (w - 30u) / (3u - 9u) / (3u - 15u) / (3u - 30u) *
+ (0.000256121) + (w - 3u) * (w - 15u) * (w - 30u) / (9u - 3u) / (9u - 15u) / (9u
+ - 30u) * (0.000256121) + (w - 3u) * (w - 9u) * (w - 30u) / (15u - 3u) / (15u -
+ 9u) / (15u - 30u) * (0.000256121) + (w - 3u) * (w - 9u) * (w - 15u) / (30u - 3u)
+ / (30u - 9u) / (30u - 15u) * (0.000256121)) l1_g=((w - 9u) * (w - 15u) * (w -
+ 30u) / (3u - 9u) / (3u - 15u) / (3u - 30u) * ( - 12.8000) + (w - 3u) * (w - 15u)
+ * (w - 30u) / (9u - 3u) / (9u - 15u) / (9u - 30u) * ( - 10.53819606) + (w - 3u)
+ * (w - 9u) * (w - 30u) / (15u - 3u) / (15u - 9u) / (15u - 30u) * ( - 9.7447599)
+ + (w - 3u) * (w - 9u) * (w - 15u) / (30u - 3u) / (30u - 9u) / (30u - 15u) * (
+ - 8.1375950)) m_a=((w - 9u) * (w - 15u) * (w - 30u) / (3u - 9u) / (3u - 15u) /
+ (3u - 30u) * (23.33152254) + (w - 3u) * (w - 15u) * (w - 30u) / (9u - 3u) / (9u
+ - 15u) / (9u - 30u) * (7.536628471) + (w - 3u) * (w - 9u) * (w - 30u) / (15u -
+ 3u) / (15u - 9u) / (15u - 30u) * (6.180035346) + (w - 3u) * (w - 9u) * (w - 15u)
+ / (30u - 3u) / (30u - 9u) / (30u - 15u) * (5.51979745)) m_b=((w - 9u) * (w - 15u)
+ * (w - 30u) / (3u - 9u) / (3u - 15u) / (3u - 30u) * (0.010594105) + (w - 3u) *
+ (w - 15u) * (w - 30u) / (9u - 3u) / (9u - 15u) / (9u - 30u) * (0.027843479) +
+ (w - 3u) * (w - 9u) * (w - 30u) / (15u - 3u) / (15u - 9u) / (15u - 30u) * (0.027843479)
+ + (w - 3u) * (w - 9u) * (w - 15u) / (30u - 3u) / (30u - 9u) / (30u - 15u) * (0.027843479))
+ m_c=((w - 9u) * (w - 15u) * (w - 30u) / (3u - 9u) / (3u - 15u) / (3u - 30u) *
+ (0.029125396) + (w - 3u) * (w - 15u) * (w - 30u) / (9u - 3u) / (9u - 15u) / (9u
+ - 30u) * (0.111597388) + (w - 3u) * (w - 9u) * (w - 30u) / (15u - 3u) / (15u -
+ 9u) / (15u - 30u) * (0.111597388) + (w - 3u) * (w - 9u) * (w - 15u) / (30u - 3u)
+ / (30u - 9u) / (30u - 15u) * (0.111597388)) m_d=((w - 9u) * (w - 15u) * (w - 30u)
+ / (3u - 9u) / (3u - 15u) / (3u - 30u) * ( - 0.029496303) + (w - 3u) * (w - 15u)
+ * (w - 30u) / (9u - 3u) / (9u - 15u) / (9u - 30u) * ( - 0.115535359) + (w - 3u)
+ * (w - 9u) * (w - 30u) / (15u - 3u) / (15u - 9u) / (15u - 30u) * ( - 0.115535359)
+ + (w - 3u) * (w - 9u) * (w - 15u) / (30u - 3u) / (30u - 9u) / (30u - 15u) * (
+ - 0.115535359)) m_e=((w - 9u) * (w - 15u) * (w - 30u) / (3u - 9u) / (3u - 15u)
+ / (3u - 30u) * (42.94539264) + (w - 3u) * (w - 15u) * (w - 30u) / (9u - 3u) /
+ (9u - 15u) / (9u - 30u) * (49.56343638) + (w - 3u) * (w - 9u) * (w - 30u) / (15u
+ - 3u) / (15u - 9u) / (15u - 30u) * (40.64201784) + (w - 3u) * (w - 9u) * (w -
+ 15u) / (30u - 3u) / (30u - 9u) / (30u - 15u) * (36.3000685)) m_f=((w - 9u) * (w
+ - 15u) * (w - 30u) / (3u - 9u) / (3u - 15u) / (3u - 30u) * (0.003872214) + (w
+ - 3u) * (w - 15u) * (w - 30u) / (9u - 3u) / (9u - 15u) / (9u - 30u) * (0.005308)
+ + (w - 3u) * (w - 9u) * (w - 30u) / (15u - 3u) / (15u - 9u) / (15u - 30u) * (0.005308)
+ + (w - 3u) * (w - 9u) * (w - 15u) / (30u - 3u) / (30u - 9u) / (30u - 15u) * (0.005308))
+ m_g=((w - 9u) * (w - 15u) * (w - 30u) / (3u - 9u) / (3u - 15u) / (3u - 30u) *
+ ( - 66.08772213) + (w - 3u) * (w - 15u) * (w - 30u) / (9u - 3u) / (9u - 15u) /
+ (9u - 30u) * ( - 56.80037564) + (w - 3u) * (w - 9u) * (w - 30u) / (15u - 3u) /
+ (15u - 9u) / (15u - 30u) * ( - 46.51890803) + (w - 3u) * (w - 9u) * (w - 15u)
+ / (30u - 3u) / (30u - 9u) / (30u - 15u) * ( - 41.46872207)) rs_a=((w - 9u) * (w
+ - 15u) * (w - 30u) / (3u - 9u) / (3u - 15u) / (3u - 30u) * (5.07354e-06) + (w
+ - 3u) * (w - 15u) * (w - 30u) / (9u - 3u) / (9u - 15u) / (9u - 30u) * (1.69118e-06)
+ + (w - 3u) * (w - 9u) * (w - 30u) / (15u - 3u) / (15u - 9u) / (15u - 30u) * (1.01471e-06)
+ + (w - 3u) * (w - 9u) * (w - 15u) / (30u - 3u) / (30u - 9u) / (30u - 15u) * (5.07354e-07))
+ rs_b=((w - 9u) * (w - 15u) * (w - 30u) / (3u - 9u) / (3u - 15u) / (3u - 30u) *
+ (1.272208441) + (w - 3u) * (w - 15u) * (w - 30u) / (9u - 3u) / (9u - 15u) / (9u
+ - 30u) * (0.42406948) + (w - 3u) * (w - 9u) * (w - 30u) / (15u - 3u) / (15u -
+ 9u) / (15u - 30u) * (0.254441688) + (w - 3u) * (w - 9u) * (w - 15u) / (30u - 3u)
+ / (30u - 9u) / (30u - 15u) * (0.127220844)) rs_c=((w - 9u) * (w - 15u) * (w -
+ 30u) / (3u - 9u) / (3u - 15u) / (3u - 30u) * (0.005471618) + (w - 3u) * (w - 15u)
+ * (w - 30u) / (9u - 3u) / (9u - 15u) / (9u - 30u) * (0.001823873) + (w - 3u) *
+ (w - 9u) * (w - 30u) / (15u - 3u) / (15u - 9u) / (15u - 30u) * (0.001094324) +
+ (w - 3u) * (w - 9u) * (w - 15u) / (30u - 3u) / (30u - 9u) / (30u - 15u) * (0.000547162))
+ rs_dd=((w - 9u) * (w - 15u) * (w - 30u) / (3u - 9u) / (3u - 15u) / (3u - 30u) *
+ ( - 0.053530883) + (w - 3u) * (w - 15u) * (w - 30u) / (9u - 3u) / (9u - 15u) /
+ (9u - 30u) * ( - 0.017843628) + (w - 3u) * (w - 9u) * (w - 30u) / (15u - 3u) /
+ (15u - 9u) / (15u - 30u) * ( - 0.010706177) + (w - 3u) * (w - 9u) * (w - 15u)
+ / (30u - 3u) / (30u - 9u) / (30u - 15u) * ( - 0.005353088)) rs_e=((w - 9u) * (w
+ - 15u) * (w - 30u) / (3u - 9u) / (3u - 15u) / (3u - 30u) * ( - 0.534407006) +
+ (w - 3u) * (w - 15u) * (w - 30u) / (9u - 3u) / (9u - 15u) / (9u - 30u) * ( - 0.178135669)
+ + (w - 3u) * (w - 9u) * (w - 30u) / (15u - 3u) / (15u - 9u) / (15u - 30u) * (
+ - 0.106881401) + (w - 3u) * (w - 9u) * (w - 15u) / (30u - 3u) / (30u - 9u) / (30u
+ - 15u) * ( - 0.053440701)) ls_a=((w - 9u) * (w - 15u) * (w - 30u) / (3u - 9u)
+ / (3u - 15u) / (3u - 30u) * (0.131127365) + (w - 3u) * (w - 15u) * (w - 30u) /
+ (9u - 3u) / (9u - 15u) / (9u - 30u) * (0.109628182) + (w - 3u) * (w - 9u) * (w
+ - 30u) / (15u - 3u) / (15u - 9u) / (15u - 30u) * (0.126072409) + (w - 3u) * (w
+ - 9u) * (w - 15u) / (30u - 3u) / (30u - 9u) / (30u - 15u) * (0.128593858)) ls_b=((w
+ - 9u) * (w - 15u) * (w - 30u) / (3u - 9u) / (3u - 15u) / (3u - 30u) * (0.919577042)
+ + (w - 3u) * (w - 15u) * (w - 30u) / (9u - 3u) / (9u - 15u) / (9u - 30u) * (0.919577042)
+ + (w - 3u) * (w - 9u) * (w - 30u) / (15u - 3u) / (15u - 9u) / (15u - 30u) * (0.919577042)
+ + (w - 3u) * (w - 9u) * (w - 15u) / (30u - 3u) / (30u - 9u) / (30u - 15u) * (0.919577042))
+ ls_c=((w - 9u) * (w - 15u) * (w - 30u) / (3u - 9u) / (3u - 15u) / (3u - 30u) *
+ (0.089717974) + (w - 3u) * (w - 15u) * (w - 30u) / (9u - 3u) / (9u - 15u) / (9u
+ - 30u) * (0.089717974) + (w - 3u) * (w - 9u) * (w - 30u) / (15u - 3u) / (15u -
+ 9u) / (15u - 30u) * (0.089717974) + (w - 3u) * (w - 9u) * (w - 15u) / (30u - 3u)
+ / (30u - 9u) / (30u - 15u) * (0.089717974)) ls_d=((w - 9u) * (w - 15u) * (w -
+ 30u) / (3u - 9u) / (3u - 15u) / (3u - 30u) * (0.001643525) + (w - 3u) * (w - 15u)
+ * (w - 30u) / (9u - 3u) / (9u - 15u) / (9u - 30u) * (0.001643525) + (w - 3u) *
+ (w - 9u) * (w - 30u) / (15u - 3u) / (15u - 9u) / (15u - 30u) * (0.001643525) +
+ (w - 3u) * (w - 9u) * (w - 15u) / (30u - 3u) / (30u - 9u) / (30u - 15u) * (0.001643525))
+ ls_e=((w - 9u) * (w - 15u) * (w - 30u) / (3u - 9u) / (3u - 15u) / (3u - 30u) *
+ ( - 4.278824203) + (w - 3u) * (w - 15u) * (w - 30u) / (9u - 3u) / (9u - 15u) /
+ (9u - 30u) * ( - 3.577283195) + (w - 3u) * (w - 9u) * (w - 30u) / (15u - 3u) /
+ (15u - 9u) / (15u - 30u) * ( - 4.113875675) + (w - 3u) * (w - 9u) * (w - 15u)
+ / (30u - 3u) / (30u - 9u) / (30u - 15u) * ( - 4.196153188)) ls_f=((w - 9u) * (w
+ - 15u) * (w - 30u) / (3u - 9u) / (3u - 15u) / (3u - 30u) * (0.025088163) + (w
+ - 3u) * (w - 15u) * (w - 30u) / (9u - 3u) / (9u - 15u) / (9u - 30u) * (0.025088163)
+ + (w - 3u) * (w - 9u) * (w - 30u) / (15u - 3u) / (15u - 9u) / (15u - 30u) * (0.025088163)
+ + (w - 3u) * (w - 9u) * (w - 15u) / (30u - 3u) / (30u - 9u) / (30u - 15u) * (0.025088163))
+ ls_g=((w - 9u) * (w - 15u) * (w - 30u) / (3u - 9u) / (3u - 15u) / (3u - 30u) *
+ (4.110799465) + (w - 3u) * (w - 15u) * (w - 30u) / (9u - 3u) / (9u - 15u) / (9u
+ - 30u) * (3.436807204) + (w - 3u) * (w - 9u) * (w - 30u) / (15u - 3u) / (15u -
+ 9u) / (15u - 30u) * (3.952328285) + (w - 3u) * (w - 9u) * (w - 15u) / (30u - 3u)
+ / (30u - 9u) / (30u - 15u) * (4.03137485)) cox_a=((w - 9u) * (w - 15u) * (w -
+ 30u) / (3u - 9u) / (3u - 15u) / (3u - 30u) * (0.010320009) + (w - 3u) * (w - 15u)
+ * (w - 30u) / (9u - 3u) / (9u - 15u) / (9u - 30u) * (0.030960027) + (w - 3u) *
+ (w - 9u) * (w - 30u) / (15u - 3u) / (15u - 9u) / (15u - 30u) * (0.018576016) +
+ (w - 3u) * (w - 9u) * (w - 15u) / (30u - 3u) / (30u - 9u) / (30u - 15u) * (0.037152033))
+ cox_b=((w - 9u) * (w - 15u) * (w - 30u) / (3u - 9u) / (3u - 15u) / (3u - 30u)
+ * (7.393657225) + (w - 3u) * (w - 15u) * (w - 30u) / (9u - 3u) / (9u - 15u) /
+ (9u - 30u) * (22.18097167) + (w - 3u) * (w - 9u) * (w - 30u) / (15u - 3u) / (15u
+ - 9u) / (15u - 30u) * (23.308583) + (w - 3u) * (w - 9u) * (w - 15u) / (30u - 3u)
+ / (30u - 9u) / (30u - 15u) * (46.61716601)) rsub_a=((w - 9u) * (w - 15u) * (w
+ - 30u) / (3u - 9u) / (3u - 15u) / (3u - 30u) * ( - 18318.08402) + (w - 3u) * (w
+ - 15u) * (w - 30u) / (9u - 3u) / (9u - 15u) / (9u - 30u) * ( - 6106.028006) +
+ (w - 3u) * (w - 9u) * (w - 30u) / (15u - 3u) / (15u - 9u) / (15u - 30u) * (32410.47171)
+ + (w - 3u) * (w - 9u) * (w - 15u) / (30u - 3u) / (30u - 9u) / (30u - 15u) * (16205.23586))
+ rsub_b=((w - 9u) * (w - 15u) * (w - 30u) / (3u - 9u) / (3u - 15u) / (3u - 30u)
+ * (51065.36128) + (w - 3u) * (w - 15u) * (w - 30u) / (9u - 3u) / (9u - 15u) /
+ (9u - 30u) * (17021.78709) + (w - 3u) * (w - 9u) * (w - 30u) / (15u - 3u) / (15u
+ - 9u) / (15u - 30u) * (38567.5839) + (w - 3u) * (w - 9u) * (w - 15u) / (30u -
+ 3u) / (30u - 9u) / (30u - 15u) * (19283.79195)) rsub_c=((w - 9u) * (w - 15u) *
+ (w - 30u) / (3u - 9u) / (3u - 15u) / (3u - 30u) * (373.002901) + (w - 3u) * (w
+ - 15u) * (w - 30u) / (9u - 3u) / (9u - 15u) / (9u - 30u) * (124.3343003) + (w
+ - 3u) * (w - 9u) * (w - 30u) / (15u - 3u) / (15u - 9u) / (15u - 30u) * (111.8815865)
+ + (w - 3u) * (w - 9u) * (w - 15u) / (30u - 3u) / (30u - 9u) / (30u - 15u) * (55.94079325))
+ rsub_d=((w - 9u) * (w - 15u) * (w - 30u) / (3u - 9u) / (3u - 15u) / (3u - 30u)
+ * (188.3175522) + (w - 3u) * (w - 15u) * (w - 30u) / (9u - 3u) / (9u - 15u) /
+ (9u - 30u) * (62.7725174) + (w - 3u) * (w - 9u) * (w - 30u) / (15u - 3u) / (15u
+ - 9u) / (15u - 30u) * (332.8672745) + (w - 3u) * (w - 9u) * (w - 15u) / (30u -
+ 3u) / (30u - 9u) / (30u - 15u) * (166.4336372)) cox_1=cox_a * nr * da + cox_b
+ cox_2=cox_a * nr * da + cox_b rsub_1=(rsub_a / (nr * da) + rsub_b / da + rsub_c
+ / nr + rsub_d) * ( - 0.0000114365 * (temp - 25) * (temp - 25) + 0.0045985091
+ * (temp - 25) + 1) rsub_2=(rsub_a / (nr * da) + rsub_b / da + rsub_c / nr +
+ rsub_d) * ( - 0.0000114365 * (temp - 25) * (temp - 25) + 0.0045985091 * (temp
+ - 25) + 1) csub_1=1.05315e-11 / rsub_1 csub_2=1.05315e-11 / rsub_2
//
//
//
//
//
//
//
//
//
//
//
//
c12 ( top bottom ) capacitor c=(c12_a * nr + c12_b * nr * da + c12_c * nr * nr +
+ c12_d * da * da + c12_e) * 1e-15 * c12_indfac

r1 ( top n1 ) resistor r=(r1_a * nr * da * da + r1_b * nr + r1_c * da + r1_d * nr
+ * nr + r1_e) * (0.0026 * (temp - 25) + 1) * rm8_indfac
l1 ( n1 n3 ) inductor l=(l1_a * nr ** (l1_b) * da ** (l1_c) * do ** (l1_d) + l1_e
+ * nr ** (l1_f) + l1_g) * 1.0e-9 * l_indfac
l2 ( n3 n2 ) inductor l=(l1_a * nr ** (l1_b) * da ** (l1_c) * do ** (l1_d) + l1_e
+ * nr ** (l1_f) + l1_g) * 1.0e-9 * l_indfac
r2 ( n2 bottom ) resistor r=(r1_a * nr * da * da + r1_b * nr + r1_c * da + r1_d
+ * nr * nr + r1_e) * (0.0026 * (temp - 25) + 1) * rm8_indfac

k12 mutual_inductor ind1=l1 ind2=l2 coupling=(m_a * nr ** (m_b) * da ** (m_c) *
+ do ** (m_d) + m_e * nr ** (m_f) + m_g) * l_indfac

rs1 ( top n11 ) resistor r=(rs_a * nr * da * da + rs_b * nr + rs_c * da + rs_dd *
+ nr * nr + rs_e) * ((0.0026 * (temp - 25) + 1) ** (0.5))
ls1 ( n11 n1 ) inductor l=(ls_a * nr ** (ls_b) * da ** (ls_c) * do ** (ls_d) + ls_e
+ * nr ** (ls_f) + ls_g) * 1e-9
ls2 ( n22 n2 ) inductor l=(ls_a * nr ** (ls_b) * da ** (ls_c) * do ** (ls_d) + ls_e
+ * nr ** (ls_f) + ls_g) * 1e-9
rs2 ( n22 bottom ) resistor r=(rs_a * nr * da * da + rs_b * nr + rs_c * da + rs_dd
+ * nr * nr + rs_e) * ((0.0026 * (temp - 25) + 1) ** (0.5))

cox1 ( top sub1 ) capacitor c=(cox_1) * ((1 / (11.4174 + (2.37149) * (lay - 4)))
+ / (0.0478392)) * 1e-15 * cm8_indfac
cox2 ( bottom sub2 ) capacitor c=(cox_2) * ((1 / (11.4174 + (2.37149) * (lay - 4)))
+ / (0.0478392)) * 1e-15 * cm8_indfac
cox3 ( n3 sub3 ) capacitor c=(cox_1 + cox_2) * ((1 / (11.4174 + (2.37149) * (lay
+ - 4))) / (0.0478392)) * 1e-15 * cm8_indfac

csub1 ( sub1 gnode ) capacitor c=(csub_1) * csub_indfac
csub2 ( sub2 gnode ) capacitor c=(csub_2) * csub_indfac
csub3 ( sub3 gnode ) capacitor c=(csub_1 + csub_2) * csub_indfac
rsub1 ( sub1 gnode ) resistor r=(rsub_1) * rsub_indfac
rsub2 ( sub2 gnode ) resistor r=(rsub_2) * rsub_indfac
rsub3 ( sub3 gnode ) resistor r=(rsub_1 * rsub_2 / (rsub_1 + rsub_2)) * rsub_indfac

ends spiral_sym

subckt spiral_sym_ct ( top bottom gnode tap )
parameters nr=3 rad=60u w=15u lay=8 di=2 * rad * 1e6 do=2 * rad * 1e6 + 2 * (nr
+ * (w * 1e6 + 3) - 3) da=(di + do) / 2 c12_a=((w - 9u) * (w - 15u) * (w - 30u)
+ / (3u - 9u) / (3u - 15u) / (3u - 30u) * ( - 1.896681454) + (w - 3u) * (w - 15u)
+ * (w - 30u) / (9u - 3u) / (9u - 15u) / (9u - 30u) * ( - 3.417120146) + (w - 3u)
+ * (w - 9u) * (w - 30u) / (15u - 3u) / (15u - 9u) / (15u - 30u) * ( - 3.707340569)
+ + (w - 3u) * (w - 9u) * (w - 15u) / (30u - 3u) / (30u - 9u) / (30u - 15u) * (
+ - 5.36508578)) c12_b=((w - 9u) * (w - 15u) * (w - 30u) / (3u - 9u) / (3u - 15u)
+ / (3u - 30u) * (0.078718307) + (w - 3u) * (w - 15u) * (w - 30u) / (9u - 3u) /
+ (9u - 15u) / (9u - 30u) * (0.081470606) + (w - 3u) * (w - 9u) * (w - 30u) / (15u
+ - 3u) / (15u - 9u) / (15u - 30u) * (0.087843107) + (w - 3u) * (w - 9u) * (w -
+ 15u) / (30u - 3u) / (30u - 9u) / (30u - 15u) * (0.113545938)) c12_c=((w - 9u)
+ * (w - 15u) * (w - 30u) / (3u - 9u) / (3u - 15u) / (3u - 30u) * (0.498120289)
+ + (w - 3u) * (w - 15u) * (w - 30u) / (9u - 3u) / (9u - 15u) / (9u - 30u) * (0.65250083)
+ + (w - 3u) * (w - 9u) * (w - 30u) / (15u - 3u) / (15u - 9u) / (15u - 30u) * (1.108171537)
+ + (w - 3u) * (w - 9u) * (w - 15u) / (30u - 3u) / (30u - 9u) / (30u - 15u) * (1.243501848))
+ c12_d=((w - 9u) * (w - 15u) * (w - 30u) / (3u - 9u) / (3u - 15u) / (3u - 30u)
+ * ( - 0.000101633) + (w - 3u) * (w - 15u) * (w - 30u) / (9u - 3u) / (9u - 15u)
+ / (9u - 30u) * ( - 0.000155708) + (w - 3u) * (w - 9u) * (w - 30u) / (15u - 3u)
+ / (15u - 9u) / (15u - 30u) * (3.69495e-05) + (w - 3u) * (w - 9u) * (w - 15u) /
+ (30u - 3u) / (30u - 9u) / (30u - 15u) * (5.11024e-05)) c12_e=((w - 9u) * (w -
+ 15u) * (w - 30u) / (3u - 9u) / (3u - 15u) / (3u - 30u) * ( - 0.969173183) + (w
+ - 3u) * (w - 15u) * (w - 30u) / (9u - 3u) / (9u - 15u) / (9u - 30u) * (0.47887741)
+ + (w - 3u) * (w - 9u) * (w - 30u) / (15u - 3u) / (15u - 9u) / (15u - 30u) * (
+ - 0.409880581) + (w - 3u) * (w - 9u) * (w - 15u) / (30u - 3u) / (30u - 9u) / (30u
+ - 15u) * ( - 2.13097863)) r1_a=((w - 9u) * (w - 15u) * (w - 30u) / (3u - 9u) /
+ (3u - 15u) / (3u - 30u) * (2.33645e-05) + (w - 3u) * (w - 15u) * (w - 30u) / (9u
+ - 3u) / (9u - 15u) / (9u - 30u) * (5.90479e-06) + (w - 3u) * (w - 9u) * (w - 30u)
+ / (15u - 3u) / (15u - 9u) / (15u - 30u) * (1.96488e-06) + (w - 3u) * (w - 9u)
+ * (w - 15u) / (30u - 3u) / (30u - 9u) / (30u - 15u) * (5.60959e-07)) r1_b=((w
+ - 9u) * (w - 15u) * (w - 30u) / (3u - 9u) / (3u - 15u) / (3u - 30u) * (0.150886387)
+ + (w - 3u) * (w - 15u) * (w - 30u) / (9u - 3u) / (9u - 15u) / (9u - 30u) * (0.049017468)
+ + (w - 3u) * (w - 9u) * (w - 30u) / (15u - 3u) / (15u - 9u) / (15u - 30u) * (0.162849086)
+ + (w - 3u) * (w - 9u) * (w - 15u) / (30u - 3u) / (30u - 9u) / (30u - 15u) * (
+ - 0.057821743)) r1_c=((w - 9u) * (w - 15u) * (w - 30u) / (3u - 9u) / (3u - 15u)
+ / (3u - 30u) * (0.003039879) + (w - 3u) * (w - 15u) * (w - 30u) / (9u - 3u) /
+ (9u - 15u) / (9u - 30u) * (0.00181877) + (w - 3u) * (w - 9u) * (w - 30u) / (15u
+ - 3u) / (15u - 9u) / (15u - 30u) * (0.000703993) + (w - 3u) * (w - 9u) * (w -
+ 15u) / (30u - 3u) / (30u - 9u) / (30u - 15u) * (0.000888197)) r1_d=((w - 9u) *
+ (w - 15u) * (w - 30u) / (3u - 9u) / (3u - 15u) / (3u - 30u) * (0.024841922) +
+ (w - 3u) * (w - 15u) * (w - 30u) / (9u - 3u) / (9u - 15u) / (9u - 30u) * (0.033953873)
+ + (w - 3u) * (w - 9u) * (w - 30u) / (15u - 3u) / (15u - 9u) / (15u - 30u) * (0.023359123)
+ + (w - 3u) * (w - 9u) * (w - 15u) / (30u - 3u) / (30u - 9u) / (30u - 15u) * (0.06502045))
+ r1_e=((w - 9u) * (w - 15u) * (w - 30u) / (3u - 9u) / (3u - 15u) / (3u - 30u) *
+ (0.556246772) + (w - 3u) * (w - 15u) * (w - 30u) / (9u - 3u) / (9u - 15u) / (9u
+ - 30u) * (0.244834205) + (w - 3u) * (w - 9u) * (w - 30u) / (15u - 3u) / (15u -
+ 9u) / (15u - 30u) * (0.113816284) + (w - 3u) * (w - 9u) * (w - 15u) / (30u - 3u)
+ / (30u - 9u) / (30u - 15u) * (0.161486385)) l1_a=((w - 9u) * (w - 15u) * (w -
+ 30u) / (3u - 9u) / (3u - 15u) / (3u - 30u) * (0.00035420) + (w - 3u) * (w - 15u)
+ * (w - 30u) / (9u - 3u) / (9u - 15u) / (9u - 30u) * (0.000291748) + (w - 3u) *
+ (w - 9u) * (w - 30u) / (15u - 3u) / (15u - 9u) / (15u - 30u) * (0.00026978) +
+ (w - 3u) * (w - 9u) * (w - 15u) / (30u - 3u) / (30u - 9u) / (30u - 15u) * (0.00022529))
+ l1_b=((w - 9u) * (w - 15u) * (w - 30u) / (3u - 9u) / (3u - 15u) / (3u - 30u) *
+ (1.533019164) + (w - 3u) * (w - 15u) * (w - 30u) / (9u - 3u) / (9u - 15u) / (9u
+ - 30u) * (1.533019164) + (w - 3u) * (w - 9u) * (w - 30u) / (15u - 3u) / (15u -
+ 9u) / (15u - 30u) * (1.533019164) + (w - 3u) * (w - 9u) * (w - 15u) / (30u - 3u)
+ / (30u - 9u) / (30u - 15u) * (1.533019164)) l1_c=((w - 9u) * (w - 15u) * (w -
+ 30u) / (3u - 9u) / (3u - 15u) / (3u - 30u) * (1.655981779) + (w - 3u) * (w - 15u)
+ * (w - 30u) / (9u - 3u) / (9u - 15u) / (9u - 30u) * (1.655981779) + (w - 3u) *
+ (w - 9u) * (w - 30u) / (15u - 3u) / (15u - 9u) / (15u - 30u) * (1.655981779) +
+ (w - 3u) * (w - 9u) * (w - 15u) / (30u - 3u) / (30u - 9u) / (30u - 15u) * (1.655981779))
+ l1_d=((w - 9u) * (w - 15u) * (w - 30u) / (3u - 9u) / (3u - 15u) / (3u - 30u) *
+ ( - 0.442001746) + (w - 3u) * (w - 15u) * (w - 30u) / (9u - 3u) / (9u - 15u) /
+ (9u - 30u) * ( - 0.442001746) + (w - 3u) * (w - 9u) * (w - 30u) / (15u - 3u) /
+ (15u - 9u) / (15u - 30u) * ( - 0.442001746) + (w - 3u) * (w - 9u) * (w - 15u)
+ / (30u - 3u) / (30u - 9u) / (30u - 15u) * ( - 0.442001746)) l1_e=((w - 9u) * (w
+ - 15u) * (w - 30u) / (3u - 9u) / (3u - 15u) / (3u - 30u) * (12.8319390) + (w -
+ 3u) * (w - 15u) * (w - 30u) / (9u - 3u) / (9u - 15u) / (9u - 30u) * (10.56951658)
+ + (w - 3u) * (w - 9u) * (w - 30u) / (15u - 3u) / (15u - 9u) / (15u - 30u) * (9.77372225)
+ + (w - 3u) * (w - 9u) * (w - 15u) / (30u - 3u) / (30u - 9u) / (30u - 15u) * (8.16178071))
+ l1_f=((w - 9u) * (w - 15u) * (w - 30u) / (3u - 9u) / (3u - 15u) / (3u - 30u) *
+ (0.000256121) + (w - 3u) * (w - 15u) * (w - 30u) / (9u - 3u) / (9u - 15u) / (9u
+ - 30u) * (0.000256121) + (w - 3u) * (w - 9u) * (w - 30u) / (15u - 3u) / (15u -
+ 9u) / (15u - 30u) * (0.000256121) + (w - 3u) * (w - 9u) * (w - 15u) / (30u - 3u)
+ / (30u - 9u) / (30u - 15u) * (0.000256121)) l1_g=((w - 9u) * (w - 15u) * (w -
+ 30u) / (3u - 9u) / (3u - 15u) / (3u - 30u) * ( - 12.8000) + (w - 3u) * (w - 15u)
+ * (w - 30u) / (9u - 3u) / (9u - 15u) / (9u - 30u) * ( - 10.53819606) + (w - 3u)
+ * (w - 9u) * (w - 30u) / (15u - 3u) / (15u - 9u) / (15u - 30u) * ( - 9.7447599)
+ + (w - 3u) * (w - 9u) * (w - 15u) / (30u - 3u) / (30u - 9u) / (30u - 15u) * (
+ - 8.1375950)) m_a=((w - 9u) * (w - 15u) * (w - 30u) / (3u - 9u) / (3u - 15u) /
+ (3u - 30u) * (23.33152254) + (w - 3u) * (w - 15u) * (w - 30u) / (9u - 3u) / (9u
+ - 15u) / (9u - 30u) * (7.536628471) + (w - 3u) * (w - 9u) * (w - 30u) / (15u -
+ 3u) / (15u - 9u) / (15u - 30u) * (6.180035346) + (w - 3u) * (w - 9u) * (w - 15u)
+ / (30u - 3u) / (30u - 9u) / (30u - 15u) * (5.51979745)) m_b=((w - 9u) * (w - 15u)
+ * (w - 30u) / (3u - 9u) / (3u - 15u) / (3u - 30u) * (0.010594105) + (w - 3u) *
+ (w - 15u) * (w - 30u) / (9u - 3u) / (9u - 15u) / (9u - 30u) * (0.027843479) +
+ (w - 3u) * (w - 9u) * (w - 30u) / (15u - 3u) / (15u - 9u) / (15u - 30u) * (0.027843479)
+ + (w - 3u) * (w - 9u) * (w - 15u) / (30u - 3u) / (30u - 9u) / (30u - 15u) * (0.027843479))
+ m_c=((w - 9u) * (w - 15u) * (w - 30u) / (3u - 9u) / (3u - 15u) / (3u - 30u) *
+ (0.029125396) + (w - 3u) * (w - 15u) * (w - 30u) / (9u - 3u) / (9u - 15u) / (9u
+ - 30u) * (0.111597388) + (w - 3u) * (w - 9u) * (w - 30u) / (15u - 3u) / (15u -
+ 9u) / (15u - 30u) * (0.111597388) + (w - 3u) * (w - 9u) * (w - 15u) / (30u - 3u)
+ / (30u - 9u) / (30u - 15u) * (0.111597388)) m_d=((w - 9u) * (w - 15u) * (w - 30u)
+ / (3u - 9u) / (3u - 15u) / (3u - 30u) * ( - 0.029496303) + (w - 3u) * (w - 15u)
+ * (w - 30u) / (9u - 3u) / (9u - 15u) / (9u - 30u) * ( - 0.115535359) + (w - 3u)
+ * (w - 9u) * (w - 30u) / (15u - 3u) / (15u - 9u) / (15u - 30u) * ( - 0.115535359)
+ + (w - 3u) * (w - 9u) * (w - 15u) / (30u - 3u) / (30u - 9u) / (30u - 15u) * (
+ - 0.115535359)) m_e=((w - 9u) * (w - 15u) * (w - 30u) / (3u - 9u) / (3u - 15u)
+ / (3u - 30u) * (42.94539264) + (w - 3u) * (w - 15u) * (w - 30u) / (9u - 3u) /
+ (9u - 15u) / (9u - 30u) * (49.56343638) + (w - 3u) * (w - 9u) * (w - 30u) / (15u
+ - 3u) / (15u - 9u) / (15u - 30u) * (40.64201784) + (w - 3u) * (w - 9u) * (w -
+ 15u) / (30u - 3u) / (30u - 9u) / (30u - 15u) * (36.3000685)) m_f=((w - 9u) * (w
+ - 15u) * (w - 30u) / (3u - 9u) / (3u - 15u) / (3u - 30u) * (0.003872214) + (w
+ - 3u) * (w - 15u) * (w - 30u) / (9u - 3u) / (9u - 15u) / (9u - 30u) * (0.005308)
+ + (w - 3u) * (w - 9u) * (w - 30u) / (15u - 3u) / (15u - 9u) / (15u - 30u) * (0.005308)
+ + (w - 3u) * (w - 9u) * (w - 15u) / (30u - 3u) / (30u - 9u) / (30u - 15u) * (0.005308))
+ m_g=((w - 9u) * (w - 15u) * (w - 30u) / (3u - 9u) / (3u - 15u) / (3u - 30u) *
+ ( - 66.08772213) + (w - 3u) * (w - 15u) * (w - 30u) / (9u - 3u) / (9u - 15u) /
+ (9u - 30u) * ( - 56.80037564) + (w - 3u) * (w - 9u) * (w - 30u) / (15u - 3u) /
+ (15u - 9u) / (15u - 30u) * ( - 46.51890803) + (w - 3u) * (w - 9u) * (w - 15u)
+ / (30u - 3u) / (30u - 9u) / (30u - 15u) * ( - 41.46872207)) rs_a=((w - 9u) * (w
+ - 15u) * (w - 30u) / (3u - 9u) / (3u - 15u) / (3u - 30u) * (5.07354e-06) + (w
+ - 3u) * (w - 15u) * (w - 30u) / (9u - 3u) / (9u - 15u) / (9u - 30u) * (1.69118e-06)
+ + (w - 3u) * (w - 9u) * (w - 30u) / (15u - 3u) / (15u - 9u) / (15u - 30u) * (1.01471e-06)
+ + (w - 3u) * (w - 9u) * (w - 15u) / (30u - 3u) / (30u - 9u) / (30u - 15u) * (5.07354e-07))
+ rs_b=((w - 9u) * (w - 15u) * (w - 30u) / (3u - 9u) / (3u - 15u) / (3u - 30u) *
+ (1.272208441) + (w - 3u) * (w - 15u) * (w - 30u) / (9u - 3u) / (9u - 15u) / (9u
+ - 30u) * (0.42406948) + (w - 3u) * (w - 9u) * (w - 30u) / (15u - 3u) / (15u -
+ 9u) / (15u - 30u) * (0.254441688) + (w - 3u) * (w - 9u) * (w - 15u) / (30u - 3u)
+ / (30u - 9u) / (30u - 15u) * (0.127220844)) rs_c=((w - 9u) * (w - 15u) * (w -
+ 30u) / (3u - 9u) / (3u - 15u) / (3u - 30u) * (0.005471618) + (w - 3u) * (w - 15u)
+ * (w - 30u) / (9u - 3u) / (9u - 15u) / (9u - 30u) * (0.001823873) + (w - 3u) *
+ (w - 9u) * (w - 30u) / (15u - 3u) / (15u - 9u) / (15u - 30u) * (0.001094324) +
+ (w - 3u) * (w - 9u) * (w - 15u) / (30u - 3u) / (30u - 9u) / (30u - 15u) * (0.000547162))
+ rs_dd=((w - 9u) * (w - 15u) * (w - 30u) / (3u - 9u) / (3u - 15u) / (3u - 30u) *
+ ( - 0.053530883) + (w - 3u) * (w - 15u) * (w - 30u) / (9u - 3u) / (9u - 15u) /
+ (9u - 30u) * ( - 0.017843628) + (w - 3u) * (w - 9u) * (w - 30u) / (15u - 3u) /
+ (15u - 9u) / (15u - 30u) * ( - 0.010706177) + (w - 3u) * (w - 9u) * (w - 15u)
+ / (30u - 3u) / (30u - 9u) / (30u - 15u) * ( - 0.005353088)) rs_e=((w - 9u) * (w
+ - 15u) * (w - 30u) / (3u - 9u) / (3u - 15u) / (3u - 30u) * ( - 0.534407006) +
+ (w - 3u) * (w - 15u) * (w - 30u) / (9u - 3u) / (9u - 15u) / (9u - 30u) * ( - 0.178135669)
+ + (w - 3u) * (w - 9u) * (w - 30u) / (15u - 3u) / (15u - 9u) / (15u - 30u) * (
+ - 0.106881401) + (w - 3u) * (w - 9u) * (w - 15u) / (30u - 3u) / (30u - 9u) / (30u
+ - 15u) * ( - 0.053440701)) ls_a=((w - 9u) * (w - 15u) * (w - 30u) / (3u - 9u)
+ / (3u - 15u) / (3u - 30u) * (0.131127365) + (w - 3u) * (w - 15u) * (w - 30u) /
+ (9u - 3u) / (9u - 15u) / (9u - 30u) * (0.109628182) + (w - 3u) * (w - 9u) * (w
+ - 30u) / (15u - 3u) / (15u - 9u) / (15u - 30u) * (0.126072409) + (w - 3u) * (w
+ - 9u) * (w - 15u) / (30u - 3u) / (30u - 9u) / (30u - 15u) * (0.128593858)) ls_b=((w
+ - 9u) * (w - 15u) * (w - 30u) / (3u - 9u) / (3u - 15u) / (3u - 30u) * (0.919577042)
+ + (w - 3u) * (w - 15u) * (w - 30u) / (9u - 3u) / (9u - 15u) / (9u - 30u) * (0.919577042)
+ + (w - 3u) * (w - 9u) * (w - 30u) / (15u - 3u) / (15u - 9u) / (15u - 30u) * (0.919577042)
+ + (w - 3u) * (w - 9u) * (w - 15u) / (30u - 3u) / (30u - 9u) / (30u - 15u) * (0.919577042))
+ ls_c=((w - 9u) * (w - 15u) * (w - 30u) / (3u - 9u) / (3u - 15u) / (3u - 30u) *
+ (0.089717974) + (w - 3u) * (w - 15u) * (w - 30u) / (9u - 3u) / (9u - 15u) / (9u
+ - 30u) * (0.089717974) + (w - 3u) * (w - 9u) * (w - 30u) / (15u - 3u) / (15u -
+ 9u) / (15u - 30u) * (0.089717974) + (w - 3u) * (w - 9u) * (w - 15u) / (30u - 3u)
+ / (30u - 9u) / (30u - 15u) * (0.089717974)) ls_d=((w - 9u) * (w - 15u) * (w -
+ 30u) / (3u - 9u) / (3u - 15u) / (3u - 30u) * (0.001643525) + (w - 3u) * (w - 15u)
+ * (w - 30u) / (9u - 3u) / (9u - 15u) / (9u - 30u) * (0.001643525) + (w - 3u) *
+ (w - 9u) * (w - 30u) / (15u - 3u) / (15u - 9u) / (15u - 30u) * (0.001643525) +
+ (w - 3u) * (w - 9u) * (w - 15u) / (30u - 3u) / (30u - 9u) / (30u - 15u) * (0.001643525))
+ ls_e=((w - 9u) * (w - 15u) * (w - 30u) / (3u - 9u) / (3u - 15u) / (3u - 30u) *
+ ( - 4.278824203) + (w - 3u) * (w - 15u) * (w - 30u) / (9u - 3u) / (9u - 15u) /
+ (9u - 30u) * ( - 3.577283195) + (w - 3u) * (w - 9u) * (w - 30u) / (15u - 3u) /
+ (15u - 9u) / (15u - 30u) * ( - 4.113875675) + (w - 3u) * (w - 9u) * (w - 15u)
+ / (30u - 3u) / (30u - 9u) / (30u - 15u) * ( - 4.196153188)) ls_f=((w - 9u) * (w
+ - 15u) * (w - 30u) / (3u - 9u) / (3u - 15u) / (3u - 30u) * (0.025088163) + (w
+ - 3u) * (w - 15u) * (w - 30u) / (9u - 3u) / (9u - 15u) / (9u - 30u) * (0.025088163)
+ + (w - 3u) * (w - 9u) * (w - 30u) / (15u - 3u) / (15u - 9u) / (15u - 30u) * (0.025088163)
+ + (w - 3u) * (w - 9u) * (w - 15u) / (30u - 3u) / (30u - 9u) / (30u - 15u) * (0.025088163))
+ ls_g=((w - 9u) * (w - 15u) * (w - 30u) / (3u - 9u) / (3u - 15u) / (3u - 30u) *
+ (4.110799465) + (w - 3u) * (w - 15u) * (w - 30u) / (9u - 3u) / (9u - 15u) / (9u
+ - 30u) * (3.436807204) + (w - 3u) * (w - 9u) * (w - 30u) / (15u - 3u) / (15u -
+ 9u) / (15u - 30u) * (3.952328285) + (w - 3u) * (w - 9u) * (w - 15u) / (30u - 3u)
+ / (30u - 9u) / (30u - 15u) * (4.03137485)) cox_a=((w - 9u) * (w - 15u) * (w -
+ 30u) / (3u - 9u) / (3u - 15u) / (3u - 30u) * (0.010320009) + (w - 3u) * (w - 15u)
+ * (w - 30u) / (9u - 3u) / (9u - 15u) / (9u - 30u) * (0.030960027) + (w - 3u) *
+ (w - 9u) * (w - 30u) / (15u - 3u) / (15u - 9u) / (15u - 30u) * (0.018576016) +
+ (w - 3u) * (w - 9u) * (w - 15u) / (30u - 3u) / (30u - 9u) / (30u - 15u) * (0.037152033))
+ cox_b=((w - 9u) * (w - 15u) * (w - 30u) / (3u - 9u) / (3u - 15u) / (3u - 30u)
+ * (7.393657225) + (w - 3u) * (w - 15u) * (w - 30u) / (9u - 3u) / (9u - 15u) /
+ (9u - 30u) * (22.18097167) + (w - 3u) * (w - 9u) * (w - 30u) / (15u - 3u) / (15u
+ - 9u) / (15u - 30u) * (23.308583) + (w - 3u) * (w - 9u) * (w - 15u) / (30u - 3u)
+ / (30u - 9u) / (30u - 15u) * (46.61716601)) rsub_a=((w - 9u) * (w - 15u) * (w
+ - 30u) / (3u - 9u) / (3u - 15u) / (3u - 30u) * ( - 18318.08402) + (w - 3u) * (w
+ - 15u) * (w - 30u) / (9u - 3u) / (9u - 15u) / (9u - 30u) * ( - 6106.028006) +
+ (w - 3u) * (w - 9u) * (w - 30u) / (15u - 3u) / (15u - 9u) / (15u - 30u) * (32410.47171)
+ + (w - 3u) * (w - 9u) * (w - 15u) / (30u - 3u) / (30u - 9u) / (30u - 15u) * (16205.23586))
+ rsub_b=((w - 9u) * (w - 15u) * (w - 30u) / (3u - 9u) / (3u - 15u) / (3u - 30u)
+ * (51065.36128) + (w - 3u) * (w - 15u) * (w - 30u) / (9u - 3u) / (9u - 15u) /
+ (9u - 30u) * (17021.78709) + (w - 3u) * (w - 9u) * (w - 30u) / (15u - 3u) / (15u
+ - 9u) / (15u - 30u) * (38567.5839) + (w - 3u) * (w - 9u) * (w - 15u) / (30u -
+ 3u) / (30u - 9u) / (30u - 15u) * (19283.79195)) rsub_c=((w - 9u) * (w - 15u) *
+ (w - 30u) / (3u - 9u) / (3u - 15u) / (3u - 30u) * (373.002901) + (w - 3u) * (w
+ - 15u) * (w - 30u) / (9u - 3u) / (9u - 15u) / (9u - 30u) * (124.3343003) + (w
+ - 3u) * (w - 9u) * (w - 30u) / (15u - 3u) / (15u - 9u) / (15u - 30u) * (111.8815865)
+ + (w - 3u) * (w - 9u) * (w - 15u) / (30u - 3u) / (30u - 9u) / (30u - 15u) * (55.94079325))
+ rsub_d=((w - 9u) * (w - 15u) * (w - 30u) / (3u - 9u) / (3u - 15u) / (3u - 30u)
+ * (188.3175522) + (w - 3u) * (w - 15u) * (w - 30u) / (9u - 3u) / (9u - 15u) /
+ (9u - 30u) * (62.7725174) + (w - 3u) * (w - 9u) * (w - 30u) / (15u - 3u) / (15u
+ - 9u) / (15u - 30u) * (332.8672745) + (w - 3u) * (w - 9u) * (w - 15u) / (30u -
+ 3u) / (30u - 9u) / (30u - 15u) * (166.4336372)) rct_a=((w - 9u) * (w - 15u) *
+ (w - 30u) / (3u - 9u) / (3u - 15u) / (3u - 30u) * (0.025) + (w - 3u) * (w - 15u)
+ * (w - 30u) / (9u - 3u) / (9u - 15u) / (9u - 30u) * (0.03) + (w - 3u) * (w - 9u)
+ * (w - 30u) / (15u - 3u) / (15u - 9u) / (15u - 30u) * (0.1) + (w - 3u) * (w -
+ 9u) * (w - 15u) / (30u - 3u) / (30u - 9u) / (30u - 15u) * (0.2)) rct_b=((w - 9u)
+ * (w - 15u) * (w - 30u) / (3u - 9u) / (3u - 15u) / (3u - 30u) * (0.725) + (w -
+ 3u) * (w - 15u) * (w - 30u) / (9u - 3u) / (9u - 15u) / (9u - 30u) * (0.72) + (w
+ - 3u) * (w - 9u) * (w - 30u) / (15u - 3u) / (15u - 9u) / (15u - 30u) * (0.65)
+ + (w - 3u) * (w - 9u) * (w - 15u) / (30u - 3u) / (30u - 9u) / (30u - 15u) * (0.55))
+ lct_a=((w - 9u) * (w - 15u) * (w - 30u) / (3u - 9u) / (3u - 15u) / (3u - 30u)
+ * (0.000250) + (w - 3u) * (w - 15u) * (w - 30u) / (9u - 3u) / (9u - 15u) / (9u
+ - 30u) * (0.000250) + (w - 3u) * (w - 9u) * (w - 30u) / (15u - 3u) / (15u - 9u)
+ / (15u - 30u) * (0.000250) + (w - 3u) * (w - 9u) * (w - 15u) / (30u - 3u) / (30u
+ - 9u) / (30u - 15u) * (0.00025)) lct_b=((w - 9u) * (w - 15u) * (w - 30u) / (3u
+ - 9u) / (3u - 15u) / (3u - 30u) * (0.000500) + (w - 3u) * (w - 15u) * (w - 30u)
+ / (9u - 3u) / (9u - 15u) / (9u - 30u) * (0.001500) + (w - 3u) * (w - 9u) * (w
+ - 30u) / (15u - 3u) / (15u - 9u) / (15u - 30u) * (0.002500) + (w - 3u) * (w -
+ 9u) * (w - 15u) / (30u - 3u) / (30u - 9u) / (30u - 15u) * (0.005)) lct_c=((w -
+ 9u) * (w - 15u) * (w - 30u) / (3u - 9u) / (3u - 15u) / (3u - 30u) * (0.14125)
+ + (w - 3u) * (w - 15u) * (w - 30u) / (9u - 3u) / (9u - 15u) / (9u - 30u) * (0.14025)
+ + (w - 3u) * (w - 9u) * (w - 30u) / (15u - 3u) / (15u - 9u) / (15u - 30u) * (0.13925)
+ + (w - 3u) * (w - 9u) * (w - 15u) / (30u - 3u) / (30u - 9u) / (30u - 15u) * (0.13675))
+ cox_1=cox_a * nr * da + cox_b cox_2=cox_a * nr * da + cox_b rsub_1=(rsub_a / (nr
+ * da) + rsub_b / da + rsub_c / nr + rsub_d) * ( - 0.0000114365 * (temp - 25)
+ * (temp - 25) + 0.0045985091 * (temp - 25) + 1) rsub_2=(rsub_a / (nr * da)
+ + rsub_b / da + rsub_c / nr + rsub_d) * ( - 0.0000114365 * (temp - 25) * (temp
+ - 25) + 0.0045985091 * (temp - 25) + 1) csub_1=1.05315e-11 / rsub_1 csub_2=1.05315e-11
+ / rsub_2
//
//
//
//
//
//
//
//
//
//
//
//
//
//
c12 ( top bottom ) capacitor c=(c12_a * nr + c12_b * nr * da + c12_c * nr * nr +
+ c12_d * da * da + c12_e) * 1e-15 * c12_indfac

r1 ( top n1 ) resistor r=(r1_a * nr * da * da + r1_b * nr + r1_c * da + r1_d * nr
+ * nr + r1_e) * (0.0026 * (temp - 25) + 1) * rm8_indfac
l1 ( n1 n3 ) inductor l=(l1_a * nr ** (l1_b) * da ** (l1_c) * do ** (l1_d) + l1_e
+ * nr ** (l1_f) + l1_g) * 1.0e-9 * l_indfac
l2 ( n3 n2 ) inductor l=(l1_a * nr ** (l1_b) * da ** (l1_c) * do ** (l1_d) + l1_e
+ * nr ** (l1_f) + l1_g) * 1.0e-9 * l_indfac
r2 ( n2 bottom ) resistor r=(r1_a * nr * da * da + r1_b * nr + r1_c * da + r1_d
+ * nr * nr + r1_e) * (0.0026 * (temp - 25) + 1) * rm8_indfac

k12 mutual_inductor ind1=l1 ind2=l2 coupling=(m_a * nr ** (m_b) * da ** (m_c) *
+ do ** (m_d) + m_e * nr ** (m_f) + m_g) * l_indfac

rs1 ( top n11 ) resistor r=(rs_a * nr * da * da + rs_b * nr + rs_c * da + rs_dd *
+ nr * nr + rs_e) * ((0.0026 * (temp - 25) + 1) ** (0.5))
ls1 ( n11 n1 ) inductor l=(ls_a * nr ** (ls_b) * da ** (ls_c) * do ** (ls_d) + ls_e
+ * nr ** (ls_f) + ls_g) * 1e-9
ls2 ( n22 n2 ) inductor l=(ls_a * nr ** (ls_b) * da ** (ls_c) * do ** (ls_d) + ls_e
+ * nr ** (ls_f) + ls_g) * 1e-9
rs2 ( n22 bottom ) resistor r=(rs_a * nr * da * da + rs_b * nr + rs_c * da + rs_dd
+ * nr * nr + rs_e) * ((0.0026 * (temp - 25) + 1) ** (0.5))

cox1 ( top sub1 ) capacitor c=(cox_1) * ((1 / (11.4174 + (2.37149) * (lay - 4)))
+ / (0.0478392)) * 1e-15 * cm8_indfac
cox2 ( bottom sub2 ) capacitor c=(cox_2) * ((1 / (11.4174 + (2.37149) * (lay - 4)))
+ / (0.0478392)) * 1e-15 * cm8_indfac
cox3 ( n3 sub3 ) capacitor c=(cox_1 + cox_2) * ((1 / (11.4174 + (2.37149) * (lay
+ - 4))) / (0.0478392)) * 1e-15 * cm8_indfac

csub1 ( sub1 gnode ) capacitor c=(csub_1) * csub_indfac
csub2 ( sub2 gnode ) capacitor c=(csub_2) * csub_indfac
csub3 ( sub3 gnode ) capacitor c=(csub_1 + csub_2) * csub_indfac
rsub1 ( sub1 gnode ) resistor r=(rsub_1) * rsub_indfac
rsub2 ( sub2 gnode ) resistor r=(rsub_2) * rsub_indfac
rsub3 ( sub3 gnode ) resistor r=(rsub_1 * rsub_2 / (rsub_1 + rsub_2)) * rsub_indfac

rct ( n3 n4 ) resistor r=(rct_a * nr + rct_b) * (0.0026 * (temp - 25) + 1) * rm8_indfac
lct ( n4 tap ) inductor l=(lct_a * nr * nr + lct_b * nr + lct_c) * 1e-9 * l_indfac

ends spiral_sym_ct

endsection rf_ind

//  *******************************************************************************
//  RF MOS VARACTOR MODEL :
//
//
//      ## library files:
//
//
//      Model name          wr (um)          lr (um)           gr	    br
//                        low    high      low    high     low   high    low   high
//      ------------------------------------------------------------------------------
//       moscap_rf         0.5    2        0.3     1.6      1     4       4     64
//       moscap_rf25       0.5    2        0.3     1.6      1     4       4     64
//       moscap_rf_nw      0.5    2        0.3     1.6      1     4       4     64
//       moscap_rf25_nw    0.5    2        0.3     1.6      1     4       4     64
//      ------------------------------------------------------------------------------
//	End Model
//  *************************************************************************

section rf_mvar
subckt moscap_rf ( gate bulk gnode )
parameters wr=2u lr=0.4u gr=2 br=32 cmin_p=1.0e-16 l_eff=(lr - 2 * dlcrf) * gr *
+ br w_eff=(wr - 2 * dwcrf) * gr * br a_eff=(l_eff * w_eff) / gr / br dt=temp
+ - 25 dvgs= - 0.05 * (1 + 3.6e-03 * dt) vgnorm=0.35 * (1 + 2.03e-03 * dt) forward_eff=a_eff
+ * 6e2 gtmp=50e-12 varbf=2.2 rev_eff=a_eff * 1.5e1 varbr=0 ld2d=lr + 2 * 1.1e-7
+ rdm11=0.10482 * (wr + 4.40e-07) / 2e-7 rdcont=12.4911 / int(abs((wr - 0.3e-6)
+ / 0.34e-6 + 1.00001)) rwell=413.69 * (lr / 4 + 1.1e-7 + 2e-7 / 2) / wr rrrd=0.718
+ + (gr - 1) * (2 * gr - 1) / (6 * gr) * rdm11 + (rwell / 2 + rdcont) / gr rdvia_array=0.75
+ * 0.79983 / ((2 * 9.8e-7 + br * ld2d + (br + 1) * 2e-7) / 0.48e-6 / (br + 1) *
+ 2) rrd=rrrd + rdvia_array rdm1=0.10482 * (2e-7 + ld2d) / 1e-06 rdm2=0.05967 *
+ (2e-7 + ld2d) / 2.63e-06 rdmhead=1 / (1 / rdm1 + 1 / rdm2) rd=(rdmhead / 2 + ((br
+ + 1) / 2 - 1) * br / (6 * ((br + 1) / 2)) * rdmhead + rrd / ((br + 1) / 2)) /
+ 2 rgm11=0.10482 * wr / 2e-7 rpo=6.80368 * (wr / 2) / (2 * 2e-7) rrrg=0.52 + (gr
+ + 1 - 1) * (2 * (gr + 1) - 1) / (6 * (gr + 1)) * rgm11 + (rpo / 2 + 10.95169)
+ / (gr + 1) avrrrg=rrrg / (int(abs((lr - 0.3e-6) / 0.34e-6) + 1.00001)) rgviaarray=0.75
+ * 0.79983 / ((2 * 1.36e-6 + (br - 1) * 5.6e-7 + br * 2e-7) / 0.48e-6 / br * 2)
+ rrg=avrrrg + rgviaarray rgm1=0.10482 * (lr + 5.6e-7) / 1e-06 rgm2=0.05967 * (lr
+ + 5.6e-7) / 2.63e-06 rgmhead=1 / (1 / rgm1 + 1 / rgm2) rgg=(rgmhead / 2 + (br
+ / 2 - 1) * (br - 1) / (6 * (br / 2)) * rgmhead + rrg / (br / 2)) / 2 ww=wr * gr
+ + 4.40e-07 * (gr - 1) ll=lr * br + (br - 1) * 4.2e-7 + 2 * 3.6e-7 wtub=ww + 2
+ * 1.41e-6 ltub=ll + 2 * 1.41e-6 area_dio=wtub * ltub pj_dio=2 * (wtub + ltub)
+ rwsti=873.4 * 3e-6 / ll rwod=513.2 * ww / 6 / ll rlsti=873.4 * 3e-6 / ww rlod=513.2
+ * ll / 6 / ww rrsub=1 / (2 / (rwsti + rwod) + 2 / (rlsti + rlod)) rsub=(rrsub
+ + 27.32) * (1 + 3.74m * dt + 9.1u * dt * dt)

lgate ( gate 1 ) inductor l=l_mvfacrf * (2.393 * ((wr * 1e6) ** 1.6319) * ((lr *
+ 1e6) ** ( - 1.5765)) * (gr ** ( - 3.4796)) * (br ** ( - 0.8654)) - 0.0273 * (wr
+ * 1e6) - 0.2596 / (lr * 1e6) + 0.7668 * gr + 5.1437 / br - 0.2041) * 1e-12
rgate ( 1 2 ) resistor r=rm_mvfacrf * (rgg + 30.7549 / (wr * 1e6) / (lr * 1e6) /
+ br / gr + 0.4142 * (wr * 1e6) * (lr * 1e6) + 0.0079 / gr * br - 0.632248) * (1
+ + 2.6m * dt + 8.94u * dt * dt)
//cgate ( 2 3 ) bsource c=((cmin_arf * a_eff + 2 * cmin_lrf * l_eff + 2 * cmin_wrf * w_eff
//+ + cmin_p) + (dcgarf * a_eff + 2 * dcgwrf * w_eff) * (1.0 + tanh((v(2,3) - dvgs) /
//+ vgnorm)))
cgate ( 2 3 ) bsource q=((cmin_arf * a_eff + 2 * cmin_lrf * l_eff + 2 * cmin_wrf * w_eff
+ + cmin_p + (dcgarf * a_eff + 2 * dcgwrf * w_eff))*v(2,3) + vgnorm*(dcgarf * a_eff + 2 * dcgwrf * w_eff) * log(cosh((v(2,3) - dvgs) /
+ vgnorm)))
gdf1 ( 2 3 ) bsource i =fac_varrf * (forward_eff * pow((abs(v(2,3)) + v(2,3)) /
+ 2,varbf + 2) + gtmp * (abs(v(2,3)) + v(2,3)) - rev_eff * pow((abs(v(2,3)) - v(2,3))
+ / 2,varbr + 2))
rsd ( 3 4 ) resistor r=rm_mvfacrf * rd * (1 + 2.93m * dt)
lsd ( 4 bulk ) inductor l=l_mvfacrf * (2.393 * ((wr * 1e6) ** 1.6319) * ((lr * 1e6)
+ ** ( - 1.5765)) * (gr ** ( - 3.4796)) * (br ** ( - 0.8654)) - 0.0273 * (wr * 1e6)
+ - 0.2596 / (lr * 1e6) + 0.7668 * gr + 5.1437 / br - 0.2041) * 1e-12
dio ( 5 3 ) mvdnwpsub area=area_dio pj=pj_dio
r_sub ( 5 gnode ) resistor r=rsub_mvfacrf * rsub
c_sub ( 5 gnode ) capacitor c=csub_mvfacrf * 197f / rsub
ends moscap_rf

subckt moscap_rf_nw ( gate bulk gnode )
parameters wr=2u lr=0.4u gr=2 br=32 cmin_p=1.0e-16 l_eff=(lr - 2 * dlcrf) * gr *
+ br w_eff=(wr - 2 * dwcrf) * gr * br a_eff=(l_eff * w_eff) / gr / br dt=temp
+ - 25 dvgs= - 0.05 * (1 + 3.6e-03 * dt) vgnorm=0.35 * (1 + 2.03e-03 * dt) forward_eff=a_eff
+ * 6e2 gtmp=50e-12 varbf=2.2 rev_eff=a_eff * 1.5e1 varbr=0 ld2d=lr + 2 * 1.1e-7
+ rdm11=0.10482 * (wr + 4.40e-07) / 2e-7 rdcont=12.4911 / int(abs((wr - 0.3e-6)
+ / 0.34e-6 + 1.00001)) rwell=413.69 * (lr / 4 + 1.1e-7 + 2e-7 / 2) / wr rrrd=0.718
+ + (gr - 1) * (2 * gr - 1) / (6 * gr) * rdm11 + (rwell / 2 + rdcont) / gr rdvia_array=0.75
+ * 0.79983 / ((2 * 9.8e-7 + br * ld2d + (br + 1) * 2e-7) / 0.48e-6 / (br + 1) *
+ 2) rrd=rrrd + rdvia_array rdm1=0.10482 * (2e-7 + ld2d) / 1e-06 rdm2=0.05967 *
+ (2e-7 + ld2d) / 2.63e-06 rdmhead=1 / (1 / rdm1 + 1 / rdm2) rd=(rdmhead / 2 + ((br
+ + 1) / 2 - 1) * br / (6 * ((br + 1) / 2)) * rdmhead + rrd / ((br + 1) / 2)) /
+ 2 rgm11=0.10482 * wr / 2e-7 rpo=6.80368 * (wr / 2) / (2 * 2e-7) rrrg=0.52 + (gr
+ + 1 - 1) * (2 * (gr + 1) - 1) / (6 * (gr + 1)) * rgm11 + (rpo / 2 + 10.95169)
+ / (gr + 1) avrrrg=rrrg / (int(abs((lr - 0.3e-6) / 0.34e-6) + 1.00001)) rgviaarray=0.75
+ * 0.79983 / ((2 * 1.36e-6 + (br - 1) * 5.6e-7 + br * 2e-7) / 0.48e-6 / br * 2)
+ rrg=avrrrg + rgviaarray rgm1=0.10482 * (lr + 5.6e-7) / 1e-06 rgm2=0.05967 * (lr
+ + 5.6e-7) / 2.63e-06 rgmhead=1 / (1 / rgm1 + 1 / rgm2) rgg=(rgmhead / 2 + (br
+ / 2 - 1) * (br - 1) / (6 * (br / 2)) * rgmhead + rrg / (br / 2)) / 2 ww=wr * gr
+ + 4.40e-07 * (gr - 1) ll=lr * br + (br - 1) * 4.2e-7 + 2 * 3.6e-7 wtub=ww + 2
+ * 0.81e-6 ltub=ll + 2 * 0.81e-6 area_dio=wtub * ltub pj_dio=2 * (wtub + ltub)
+ rwsti=873.4 * 3e-6 / ll rwod=513.2 * ww / 6 / ll rlsti=873.4 * 3e-6 / ww rlod=513.2
+ * ll / 6 / ww rrsub=1 / (2 / (rwsti + rwod) + 2 / (rlsti + rlod)) rsub=2 * (rrsub
+ + 27.32) * (1 + 3.74m * dt + 9.1u * dt * dt)

lgate ( gate 1 ) inductor l=l_mvfacrf * (2.393 * ((wr * 1e6) ** 1.6319) * ((lr *
+ 1e6) ** ( - 1.5765)) * (gr ** ( - 3.4796)) * (br ** ( - 0.8654)) - 0.0273 * (wr
+ * 1e6) - 0.2596 / (lr * 1e6) + 0.7668 * gr + 5.1437 / br - 0.2041) * 1e-12
rgate ( 1 2 ) resistor r=rm_mvfacrf * (rgg + 30.7549 / (wr * 1e6) / (lr * 1e6) /
+ br / gr + 0.4142 * (wr * 1e6) * (lr * 1e6) + 0.0079 / gr * br - 0.632248) * (1
+ + 2.6m * dt + 8.94u * dt * dt)
cgate ( 2 3 ) bsource c=((cmin_arf * a_eff + 2 * cmin_lrf * l_eff + 2 * cmin_wrf
+ * w_eff + cmin_p) + (dcgarf * a_eff + 2 * dcgwrf * w_eff) * (1.0 + tanh((v(2,3)
+ - dvgs) / vgnorm)))
gdf1 ( 2 3 ) bsource i =fac_varrf * (forward_eff * pow((abs(v(2,3)) + v(2,3)) /
+ 2,varbf + 2) + gtmp * (abs(v(2,3)) + v(2,3)) - rev_eff * pow((abs(v(2,3)) - v(2,3))
+ / 2,varbr + 2))
rsd ( 3 4 ) resistor r=rm_mvfacrf * rd * (1 + 2.93m * dt)
lsd ( 4 bulk ) inductor l=l_mvfacrf * (2.393 * ((wr * 1e6) ** 1.6319) * ((lr * 1e6)
+ ** ( - 1.5765)) * (gr ** ( - 3.4796)) * (br ** ( - 0.8654)) - 0.0273 * (wr * 1e6)
+ - 0.2596 / (lr * 1e6) + 0.7668 * gr + 5.1437 / br - 0.2041) * 1e-12
dio ( 5 3 ) mvnwdio area=area_dio pj=pj_dio
r_sub ( 5 gnode ) resistor r=rsub_mvfacrf * rsub
c_sub ( 5 gnode ) capacitor c=csub_mvfacrf * 3.152p / rsub
ends moscap_rf_nw

include "cr013g_2d5_v1d4.scs" section=dio_mvdnwpsub
include "cr013g_2d5_v1d4.scs" section=dio_mvnwdio
endsection rf_mvar

section dio_mvdnwpsub
model mvdnwpsub diode
+ level=1                   is=976e-9                 rs=202e-12
+ n=1.02                    bv=13.8                   ibv=0.03
+ isw=4.13e-12              area=3.92e-8              pj=8.4e-4
+ cj=1.322062e-4            vj=0.6012182              mj=0.3431207
+ cjsw=1.136579e-9          vjsw=0.6012182            mjsw=0.3037134
+ tlev=1                    eg=1.17                   xti=3
+ tbv1=-1*-7.1e-4           trs=2.65e-3               tlevc=1
+ cta=2.572685e-3           ctp=2.05458e-3            pta=3.145801e-3
+ ptp=3.145801e-3           tnom=25                   fc=0
+ ns=1.02                   nz=1.02                   imax=1e40
+ minr=1e-10                allow_scaling=1
endsection dio_mvdnwpsub

section dio_mvnwdio
model mvnwdio diode
+ level=1                   is=6.20e-7                rs=1.00e-10
+ n=1.02                    bv=13.6                   ibv=0.01
+ isw=3.17e-12              cj=0.0001291              vj=0.8122
+ mj=0.4897                 cjsw=3.009e-10            vjsw=0.8122
+ mjsw=0.2822               tlev=1                    eg=1.17
+ xti=3                     tbv1=-1*-1.29e-3          trs=0.00204
+ tlevc=1                   cta=0.002483              ctp=0.001238
+ pta=0.003184              ptp=0.003184              tnom=25
+ fc=0                      area=3.92e-08             pj=0.00084
+ ns=1.02                   nz=1.02                   imax=1e40
+ minr=1e-10                allow_scaling=1

endsection dio_mvnwdio

section rf_mvar25
subckt moscap_rf25 ( gate bulk gnode )
parameters wr=2u lr=0.4u gr=2 br=32 cmin_p=1e-15 l_eff=(lr - 2 * dlcrf25) * gr *
+ br w_eff=(wr - 2 * dwcrf25) * gr * br a_eff=(l_eff * w_eff) / gr / br dt=temp
+ - 25 dvgs= - 0.15 * (1 + 3.5e-03 * dt) vgnorm=0.5 * (1 + 2.3e-03 * dt) ld2d=lr
+ + 2 * 1.1e-7 rdm11=0.10482 * (wr + 4.40e-07) / 2e-7 rdcont=12.4911 / int(abs((wr
+ - 0.3e-6) / 0.34e-6 + 1.00001)) rwell=413.69 * (lr / 4 + 1.1e-7 + 2e-7 / 2) /
+ wr rrrd=0.718 + (gr - 1) * (2 * gr - 1) / (6 * gr) * rdm11 + (rwell / 2 + rdcont)
+ / gr rdvia_array=0.75 * 0.79983 / ((2 * 9.8e-7 + br * ld2d + (br + 1) * 2e-7)
+ / 0.48e-6 / (br + 1) * 2) rrd=rrrd + rdvia_array rdm1=0.10482 * (2e-7 + ld2d)
+ / 1e-06 rdm2=0.05967 * (2e-7 + ld2d) / 2.63e-06 rdmhead=1 / (1 / rdm1 + 1 / rdm2)
+ rd=(rdmhead / 2 + ((br + 1) / 2 - 1) * br / (6 * ((br + 1) / 2)) * rdmhead + rrd
+ / ((br + 1) / 2)) / 2 rgm11=0.10482 * wr / 2e-7 rpo=6.80368 * (wr / 2) / (2 *
+ 2e-7) rrrg=0.52 + (gr + 1 - 1) * (2 * (gr + 1) - 1) / (6 * (gr + 1)) * rgm11 +
+ (rpo / 2 + 10.95169) / (gr + 1) avrrrg=rrrg / (int(abs((lr - 0.3e-6) / 0.34e-6)
+ + 1.00001)) rgviaarray=0.75 * 0.79983 / ((2 * 1.36e-6 + (br - 1) * 5.6e-7 + br
+ * 2e-7) / 0.48e-6 / br * 2) rrg=avrrrg + rgviaarray rgm1=0.10482 * (lr + 5.6e-7)
+ / 1e-06 rgm2=0.05967 * (lr + 5.6e-7) / 2.63e-06 rgmhead=1 / (1 / rgm1 + 1 / rgm2)
+ rgg=(rgmhead / 2 + (br / 2 - 1) * (br - 1) / (6 * (br / 2)) * rgmhead + rrg /
+ (br / 2)) / 2 ww=wr * gr + 4.40e-07 * (gr - 1) ll=lr * br + (br - 1) * 4.2e-7
+ + 2 * 3.6e-7 wtub=ww + 2 * 1.41e-6 ltub=ll + 2 * 1.41e-6 area_dio=wtub * ltub
+ pj_dio=2 * (wtub + ltub) rwsti=873.4 * 3e-6 / ll rwod=513.2 * ww / 6 / ll rlsti=873.4
+ * 3e-6 / ww rlod=513.2 * ll / 6 / ww rrsub=1 / (2 / (rwsti + rwod) + 2 / (rlsti
+ + rlod)) rsub=(rrsub + 27.32) * (1 + 3.74m * dt + 9.1u * dt * dt)

lgate ( gate 1 ) inductor l=l_mvfacrf25 * (2.393 * ((wr * 1e6) ** 1.6319) * ((lr
+ * 1e6) ** ( - 1.5765)) * (gr ** ( - 3.4796)) * (br ** ( - 0.8654)) - 0.0273 *
+ (wr * 1e6) - 0.2596 / (lr * 1e6) + 0.7668 * gr + 5.1437 / br - 0.2041) * 1e-12
rgate ( 1 2 ) resistor r=rm_mvfacrf25 * (rgg + 38.8738 / (wr * 1e6) / (lr * 1e6)
+ / br / gr + 0.45973 * (wr * 1e6) * (lr * 1e6) + 0.00177 / gr * br - 0.5434) *
+ (1 + 2.6m * dt + 8.94u * dt * dt)
//cgate ( 2 3 ) bsource c=((cmin_arf25 * a_eff + 2 * cmin_lrf25 * l_eff + 2 * cmin_wrf25
//+ * w_eff + cmin_p) + (dcgarf25 * a_eff + 2 * dcgwrf25 * w_eff) * (1.0 + tanh((v(2,3)
//+ - dvgs) / vgnorm)))
cgate ( 2 3 ) bsource q=((cmin_arf25 * a_eff + 2 * cmin_lrf25 * l_eff + 2 * cmin_wrf25 * w_eff
+ + cmin_p + (dcgarf25 * a_eff + 2 * dcgwrf25 * w_eff))*v(2,3) + vgnorm*(dcgarf25 * a_eff + 2 * dcgwrf25 * w_eff) * log(cosh((v(2,3) - dvgs) /
+ vgnorm)))
rsd ( 3 4 ) resistor r=rm_mvfacrf25 * rd * (1 + 2.93m * dt)
lsd ( 4 bulk ) inductor l=l_mvfacrf25 * (2.393 * ((wr * 1e6) ** 1.6319) * ((lr *
+ 1e6) ** ( - 1.5765)) * (gr ** ( - 3.4796)) * (br ** ( - 0.8654)) - 0.0273 * (wr
+ * 1e6) - 0.2596 / (lr * 1e6) + 0.7668 * gr + 5.1437 / br - 0.2041) * 1e-12
dio ( 5 3 ) mvdnwpsub25 area=area_dio pj=pj_dio
r_sub ( 5 gnode ) resistor r=rsub_mvfacrf25 * rsub
c_sub ( 5 gnode ) capacitor c=csub_mvfacrf25 * 197f / rsub
ends moscap_rf25

subckt moscap_rf25_nw ( gate bulk gnode )
parameters wr=2u lr=0.4u gr=2 br=32 cmin_p=1e-15 l_eff=(lr - 2 * dlcrf25) * gr *
+ br w_eff=(wr - 2 * dwcrf25) * gr * br a_eff=(l_eff * w_eff) / gr / br dt=temp
+ - 25 dvgs= - 0.15 * (1 + 3.5e-03 * dt) vgnorm=0.5 * (1 + 2.3e-03 * dt) ld2d=lr
+ + 2 * 1.1e-7 rdm11=0.10482 * (wr + 4.40e-07) / 2e-7 rdcont=12.4911 / int(abs((wr
+ - 0.3e-6) / 0.34e-6 + 1.00001)) rwell=413.69 * (lr / 4 + 1.1e-7 + 2e-7 / 2) /
+ wr rrrd=0.718 + (gr - 1) * (2 * gr - 1) / (6 * gr) * rdm11 + (rwell / 2 + rdcont)
+ / gr rdvia_array=0.75 * 0.79983 / ((2 * 9.8e-7 + br * ld2d + (br + 1) * 2e-7)
+ / 0.48e-6 / (br + 1) * 2) rrd=rrrd + rdvia_array rdm1=0.10482 * (2e-7 + ld2d)
+ / 1e-06 rdm2=0.05967 * (2e-7 + ld2d) / 2.63e-06 rdmhead=1 / (1 / rdm1 + 1 / rdm2)
+ rd=(rdmhead / 2 + ((br + 1) / 2 - 1) * br / (6 * ((br + 1) / 2)) * rdmhead + rrd
+ / ((br + 1) / 2)) / 2 rgm11=0.10482 * wr / 2e-7 rpo=6.80368 * (wr / 2) / (2 *
+ 2e-7) rrrg=0.52 + (gr + 1 - 1) * (2 * (gr + 1) - 1) / (6 * (gr + 1)) * rgm11 +
+ (rpo / 2 + 10.95169) / (gr + 1) avrrrg=rrrg / (int(abs((lr - 0.3e-6) / 0.34e-6)
+ + 1.00001)) rgviaarray=0.75 * 0.79983 / ((2 * 1.36e-6 + (br - 1) * 5.6e-7 + br
+ * 2e-7) / 0.48e-6 / br * 2) rrg=avrrrg + rgviaarray rgm1=0.10482 * (lr + 5.6e-7)
+ / 1e-06 rgm2=0.05967 * (lr + 5.6e-7) / 2.63e-06 rgmhead=1 / (1 / rgm1 + 1 / rgm2)
+ rgg=(rgmhead / 2 + (br / 2 - 1) * (br - 1) / (6 * (br / 2)) * rgmhead + rrg /
+ (br / 2)) / 2 ww=wr * gr + 4.40e-07 * (gr - 1) ll=lr * br + (br - 1) * 4.2e-7
+ + 2 * 3.6e-7 wtub=ww + 2 * 0.81e-6 ltub=ll + 2 * 0.81e-6 area_dio=wtub * ltub
+ pj_dio=2 * (wtub + ltub) rwsti=873.4 * 3e-6 / ll rwod=513.2 * ww / 6 / ll rlsti=873.4
+ * 3e-6 / ww rlod=513.2 * ll / 6 / ww rrsub=1 / (2 / (rwsti + rwod) + 2 / (rlsti
+ + rlod)) rsub=2 * (rrsub + 27.32) * (1 + 3.74m * dt + 9.1u * dt * dt)

lgate ( gate 1 ) inductor l=l_mvfacrf25 * (2.393 * ((wr * 1e6) ** 1.6319) * ((lr
+ * 1e6) ** ( - 1.5765)) * (gr ** ( - 3.4796)) * (br ** ( - 0.8654)) - 0.0273 *
+ (wr * 1e6) - 0.2596 / (lr * 1e6) + 0.7668 * gr + 5.1437 / br - 0.2041) * 1e-12
rgate ( 1 2 ) resistor r=rm_mvfacrf25 * (rgg + 38.8738 / (wr * 1e6) / (lr * 1e6)
+ / br / gr + 0.45973 * (wr * 1e6) * (lr * 1e6) + 0.00177 / gr * br - 0.5434) *
+ (1 + 2.6m * dt + 8.94u * dt * dt)
//cgate ( 2 3 ) bsource c=((cmin_arf25 * a_eff + 2 * cmin_lrf25 * l_eff + 2 * cmin_wrf25
//+ * w_eff + cmin_p) + (dcgarf25 * a_eff + 2 * dcgwrf25 * w_eff) * (1.0 + tanh((v(2,3)
//+ - dvgs) / vgnorm)))
cgate ( 2 3 ) bsource q=((cmin_arf25 * a_eff + 2 * cmin_lrf25 * l_eff + 2 * cmin_wrf25 * w_eff
+ + cmin_p + (dcgarf25 * a_eff + 2 * dcgwrf25 * w_eff))*v(2,3) + vgnorm*(dcgarf25 * a_eff + 2 * dcgwrf25 * w_eff) * log(cosh((v(2,3) - dvgs) /
+ vgnorm)))
rsd ( 3 4 ) resistor r=rm_mvfacrf25 * rd * (1 + 2.93m * dt)
lsd ( 4 bulk ) inductor l=l_mvfacrf25 * (2.393 * ((wr * 1e6) ** 1.6319) * ((lr *
+ 1e6) ** ( - 1.5765)) * (gr ** ( - 3.4796)) * (br ** ( - 0.8654)) - 0.0273 * (wr
+ * 1e6) - 0.2596 / (lr * 1e6) + 0.7668 * gr + 5.1437 / br - 0.2041) * 1e-12
dio ( 5 3 ) mvnwdio25 area=area_dio pj=pj_dio
r_sub ( 5 gnode ) resistor r=rsub_mvfacrf25 * rsub
c_sub ( 5 gnode ) capacitor c=csub_mvfacrf25 * 3.152p / rsub
ends moscap_rf25_nw

include "cr013g_2d5_v1d4.scs" section=dio_mvdnwpsub25
include "cr013g_2d5_v1d4.scs" section=dio_mvnwdio25
endsection rf_mvar25

section dio_mvdnwpsub25
model mvdnwpsub25 diode
+ level=1                   is=976e-9                 rs=202e-12
+ n=1.02                    bv=13.8                   ibv=0.03
+ isw=4.13e-12              area=3.92e-8              pj=8.4e-4
+ cj=1.322062e-4            vj=0.6012182              mj=0.3431207
+ cjsw=1.136579e-9          vjsw=0.6012182            mjsw=0.3037134
+ tlev=1                    eg=1.17                   xti=3
+ tbv1=-1*-7.1e-4           trs=2.65e-3               tlevc=1
+ cta=2.572685e-3           ctp=2.05458e-3            pta=3.145801e-3
+ ptp=3.145801e-3           tnom=25                   fc=0
+ ns=1.02                   nz=1.02                   imax=1e40
+ minr=1e-10                allow_scaling=1
endsection dio_mvdnwpsub25

section dio_mvnwdio25
model mvnwdio25 diode
+ level=1                   is=6.20e-7                rs=1.00e-10
+ n=1.02                    bv=13.6                   ibv=0.01
+ isw=3.17e-12              cj=0.0001291              vj=0.8122
+ mj=0.4897                 cjsw=3.009e-10            vjsw=0.8122
+ mjsw=0.2822               tlev=1                    eg=1.17
+ xti=3                     tbv1=-1*-1.29e-3          trs=0.00204
+ tlevc=1                   cta=0.002483              ctp=0.001238
+ pta=0.003184              ptp=0.003184              tnom=25
+ fc=0                      area=3.92e-08             pj=0.00084
+ ns=1.02                   nz=1.02                   imax=1e40
+ minr=1e-10                allow_scaling=1

endsection dio_mvnwdio25

//  **************************************************************************
//   JUNCTION VARACTOR MODEL :
//
//
//       ## library files:
//
//
//      Model name      L(um)         W(um)             Finger(nr)
//                   low   high      low     high       low    high
//      -------------------------------------------------------------
//       xjvar        0.3    4        2       64         1      96
//       xjvar_nw     0.3    4        2       64         1      96
//      -------------------------------------------------------------
//     End Model
//  ***************************************************************************
section rf_jvar
subckt xjvar ( anode cathode gnode )
parameters l=0.3u w=15u nr=1 ncon=int((w - 0.3u) / 0.34u + 0.1m) + 1 nstrip=int(2.77e6
+ * l + 0.4) area_d1=nr * l * w peri_d1=2 * nr * (l + w) area_d2=((l + 0.72u) *
+ nr + 3.12u) * (w + 2.82u) peri_d2=2 * (((l + 0.72u) * nr + 3.12u) + (w + 2.82u))
+ m1_s_sd=l + 0.72u rr_pnsd=(0.1048 * m1_s_sd / 1u) * (0.0597 * m1_s_sd / 3u) /
+ ((0.1048 * m1_s_sd / 1u) + (0.0597 * m1_s_sd / 3u)) r_1str_p=(0.45413 + ((ncon
+ - 1) * (2 * ncon - 1) / 6 / ncon * 0.118773) + 12.683 / ncon) / nstrip r_1str_n=(0.48657
+ + ((ncon - 1) * (2 * ncon - 1) / 6 / ncon * 0.127257) + 12.491 / ncon)
rpsd ( anode 1 ) resistor r=((rr_pnsd / 2 + ((nr / 2 - 1) * (nr - 1) / 3 / nr *
+ rr_pnsd) + r_1str_p / nr * 2) / 2) * (1 + (temp - 25) * 2.93e-3) * rm_fac
l1 ( 1 2 ) inductor l=(330.3442 * ((w * 1e6) ** ( - 0.007857)) - 357.948 * ((nr)
+ ** (0.002083)) + 0.000107 * ((l * 1e6) ** (3.564764)) + 1.033658 * ((w / l / nr)**(0.598208)) + 0.030037 * (w *
+ 1e6) + 0.046973 * (nr) + 0.069585 * (l * 1e6) + 36.08934) * 1e-12 * l_fac
d1 ( 2 3 ) pdio_xj area=area_d1 pj=peri_d1
rwell ( 3 4 ) resistor r=((1136.21 * 0.21u / w + 413.69 * (l + 0.3u) / 2 / w) /
+ 2 / nr) * (1 + (temp - 25) * 3.74e-3 + (temp - 25) * (temp - 25) * 9.1e-6)
+ * rwell_fac
l2 ( 4 5 ) inductor l=(330.3442 * ((w * 1e6) ** ( - 0.007857)) - 357.948 * ((nr)
+ ** (0.002083)) + 0.000107 * ((l * 1e6) ** (3.564764)) + 1.033658 * ((w/l/nr)**(0.598208)) + 0.030037 * (w *
+ 1e6) + 0.046973 * (nr) + 0.069585 * (l * 1e6) + 36.08934) * 1e-12 * l_fac
rnsd ( 5 cathode ) resistor r=((rr_pnsd / 2 + (((nr + 1) / 2 - 1) * (nr + 1 - 1)
+ / 3 / (nr + 1) * rr_pnsd) + r_1str_n / (nr + 1) * 2) / 2) * (1 + (temp - 25)
+ * 2.93e-3) * rm_fac
csti ( 2 4 ) capacitor c=(30.75e-18 / (0.21e-6) * peri_d1 + 0.899593e-15) * csti_fac
d2 ( 30 3 ) dnwpsub_xj area=area_d2 pj=peri_d2
rsub ( 30 gnode ) resistor r=(1.0991757 * 1 / ((1 / (413.69 * w / 6 / ((l + 0.3u)
+ * nr + 0.3u) + 568.105 * 3u / ((l + 0.3u) * nr + 0.3u))) + 1 / ((413.69 * w /
+ 6 / ((l + 0.3u) * nr + 0.3u)) + 568.105 * 3u / ((l + 0.3u) * nr + 0.3u)) + 1 /
+ (413.69 * ((l + 0.3u) * nr + 0.3u) / 6 / w + 568.105 * 3u / w) + 1 / (413.69 *
+ ((l + 0.3u) * nr + 0.3u) / 6 / w + 568.105 * 3u / w))) * (1 + (temp - 25) *
+ 3.74e-3 + (temp - 25) * (temp - 25) * 9.1e-6) * rsub_fac
csub ( 30 gnode ) capacitor c=(1.97e-13 / ((1.0991757 * 1 / ((1 / (413.69 * w /
+ 6 / ((l + 0.3u) * nr + 0.3u) + 568.105 * 3u / ((l + 0.3u) * nr + 0.3u))) + 1 /
+ ((413.69 * w / 6 / ((l + 0.3u) * nr + 0.3u)) + 568.105 * 3u / ((l + 0.3u) * nr
+ + 0.3u)) + 1 / (413.69 * ((l + 0.3u) * nr + 0.3u) / 6 / w + 568.105 * 3u / w)
+ + 1 / (413.69 * ((l + 0.3u) * nr + 0.3u) / 6 / w + 568.105 * 3u / w))) * (1 +
+ (temp - 25) * 3.74e-3 + (temp - 25) * (temp - 25) * 9.1e-6))) * csub_fac
ends xjvar

subckt xjvar_nw ( anode cathode gnode )
parameters l=0.3u w=15u nr=1 ncon=int((w - 0.3u) / 0.34u + 0.1m) + 1 nstrip=int(2.77e6
+ * l + 0.4) area_d1=nr * l * w peri_d1=2 * nr * (l + w) area_d2=((l + 0.72u) *
+ nr + 1.92u) * (w + 1.62u) peri_d2=2 * (((l + 0.72u) * nr + 1.92u) + (w + 1.62u))
+ m1_s_sd=l + 0.72u rr_pnsd=(0.1048 * m1_s_sd / 1u) * (0.0597 * m1_s_sd / 3u) /
+ ((0.1048 * m1_s_sd / 1u) + (0.0597 * m1_s_sd / 3u)) r_1str_p=(0.45413 + ((ncon
+ - 1) * (2 * ncon - 1) / 6 / ncon * 0.118773) + 12.683 / ncon) / nstrip r_1str_n=(0.48657
+ + ((ncon - 1) * (2 * ncon - 1) / 6 / ncon * 0.127257) + 12.491 / ncon)
rpsd ( anode 1 ) resistor r=((rr_pnsd / 2 + ((nr / 2 - 1) * (nr - 1) / 3 / nr *
+ rr_pnsd) + r_1str_p / nr * 2) / 2) * (1 + (temp - 25) * 2.93e-3) * rm_fac
l1 ( 1 2 ) inductor l=(330.3442 * ((w * 1e6) ** ( - 0.007857)) - 357.948 * ((nr)
+ ** (0.002083)) + 0.000107 * ((l * 1e6) ** (3.564764)) + 1.033658 * ((w/l/nr)**(0.598208)) + 0.030037 * (w *
+ 1e6) + 0.046973 * (nr) + 0.069585 * (l * 1e6) + 36.08934) * 1e-12 * l_fac
d1 ( 2 3 ) pdio_xj area=area_d1 pj=peri_d1
rwell ( 3 4 ) resistor r=((1136.21 * 0.21u / w + 413.69 * (l + 0.3u) / 2 / w) /
+ 2 / nr) * (1 + (temp - 25) * 3.74e-3 + (temp - 25) * (temp - 25) * 9.1e-6)
+ * rwell_fac
l2 ( 4 5 ) inductor l=(330.3442 * ((w * 1e6) ** ( - 0.007857)) - 357.948 * ((nr)
+ ** (0.002083)) + 0.000107 * ((l * 1e6) ** (3.564764)) + 1.033658 * ((w/l/nr)**(0.598208)) + 0.030037 * (w *
+ 1e6) + 0.046973 * (nr) + 0.069585 * (l * 1e6) + 36.08934) * 1e-12 * l_fac
rnsd ( 5 cathode ) resistor r=((rr_pnsd / 2 + (((nr + 1) / 2 - 1) * (nr + 1 - 1)
+ / 3 / (nr + 1) * rr_pnsd) + r_1str_n / (nr + 1) * 2) / 2) * (1 + (temp - 25)
+ * 2.93e-3) * rm_fac
csti ( 2 4 ) capacitor c=(30.75e-18 / (0.21e-6) * peri_d1 + 0.899593e-15) * csti_fac
d2 ( 30 3 ) nwpsub_xj area=area_d2 pj=peri_d2
rsub ( 30 gnode ) resistor r=(2.1983514 * 1 / ((1 / (413.69 * w / 6 / ((l + 0.3u)
+ * nr + 0.3u) + 568.105 * 3u / ((l + 0.3u) * nr + 0.3u))) + 1 / ((413.69 * w /
+ 6 / ((l + 0.3u) * nr + 0.3u)) + 568.105 * 3u / ((l + 0.3u) * nr + 0.3u)) + 1 /
+ (413.69 * ((l + 0.3u) * nr + 0.3u) / 6 / w + 568.105 * 3u / w) + 1 / (413.69 *
+ ((l + 0.3u) * nr + 0.3u) / 6 / w + 568.105 * 3u / w))) * (1 + (temp - 25) *
+ 3.74e-3 + (temp - 25) * (temp - 25) * 9.1e-6) * rsub_fac
csub ( 30 gnode ) capacitor c=(3.152e-12 / ((2.1983514 * 1 / ((1 / (413.69 * w /
+ 6 / ((l + 0.3u) * nr + 0.3u) + 568.105 * 3u / ((l + 0.3u) * nr + 0.3u))) + 1 /
+ ((413.69 * w / 6 / ((l + 0.3u) * nr + 0.3u)) + 568.105 * 3u / ((l + 0.3u) * nr
+ + 0.3u)) + 1 / (413.69 * ((l + 0.3u) * nr + 0.3u) / 6 / w + 568.105 * 3u / w)
+ + 1 / (413.69 * ((l + 0.3u) * nr + 0.3u) / 6 / w + 568.105 * 3u / w))) * (1 +
+ (temp - 25) * 3.74e-3 + (temp - 25) * (temp - 25) * 9.1e-6))) * csub_fac
ends xjvar_nw

include "cr013g_2d5_v1d4.scs" section=dio_pdio
include "cr013g_2d5_v1d4.scs" section=dio_dnwpsub
include "cr013g_2d5_v1d4.scs" section=dio_nwpsub
endsection rf_jvar

section dio_pdio
model pdio_xj diode
+ level=1                   is=1.8e-07                rs=230.3e-12
+ n=1.02                    bv=8.4                    ibv=0.02
+ isw=6.60e-14              cj=1.320e-3*cj_fac        vj=0.9
+ mj=0.4234                 cjsw=47.75e-12*cjsw_fac   vjsw=0.9
+ mjsw=0.1144               tlev=1                    eg=1.17
+ xti=3                     tbv1=-1*-0.000845         trs=0.00289
+ tlevc=1                   cta=0.000820              ctp=0.000275
+ pta=0.001643              ptp=0.001643              tnom=25
+ fc=0                      area=3.92e-08             pj=0.00084
+ ns=1.02                   nz=1.02                   imax=1e40
+ minr=1e-10                allow_scaling=1
endsection dio_pdio

section dio_dnwpsub
model dnwpsub_xj diode
+ level=1                   is=9.76e-7                rs=202.0e-12
+ n=1.02                    bv=13.8                   ibv=0.03
+ isw=4.13e-12              area=3.92e-8              pj=8.4e-4
+ cj=1.322e-4               vj=0.6012                 mj=0.3431
+ cjsw=1.137e-9             vjsw=0.6012               mjsw=0.3037
+ tlev=1                    eg=1.17                   xti=3
+ tbv1=-1*-7.1e-4           trs=2.65e-3               tlevc=1
+ cta=2.573e-3              ctp=2.055e-3              pta=3.146e-3
+ ptp=3.146e-3              tnom=25                   fc=0
+ ns=1.02                   nz=1.02                   imax=1e40
+ minr=1e-10                allow_scaling=1
endsection dio_dnwpsub

section dio_nwpsub
model nwpsub_xj diode
+ level=1                   is=6.20e-7                rs=1.00e-10
+ n=1.02                    bv=13.6                   ibv=0.01
+ isw=3.17e-12              cj=0.0001291              vj=0.8122
+ mj=0.4897                 cjsw=3.009e-10            vjsw=0.8122
+ mjsw=0.2822               tlev=1                    eg=1.17
+ xti=3                     tbv1=-1*-1.29e-3          trs=0.00204
+ tlevc=1                   cta=0.002483              ctp=0.001238
+ pta=0.003184              ptp=0.003184              tnom=25
+ fc=0                      area=3.92e-08             pj=0.00084
+ ns=1.02                   nz=1.02                   imax=1e40
+ minr=1e-10                allow_scaling=1
endsection dio_nwpsub

//  ************************************************************************************************
// 	RESISTOR MODEL - HSPICE
//
//      Model name       W(um)           L(um)              sqr
//                     low   high      low     high       low    high
// ---------------------------------------------------------------------------------------
// rppolyl_rf           2    10        0.45     100        1      20
// rppolys_rf          0.3    2        0.45     100        1      20
// rppolywo_rf	       1    10          2       25        2      10
// rppolyhri_rf         1     2          2        5        2       5
// rppolyl_rf_mis       2    10        0.45     100        1      20
// rppolys_rf_mis      0.3    2        0.45     100        1      20
// rppolywo_rf_mis      1    10          2       25        2      10
// rppolyhri_rf_mis     1     2          2        5        2       5
// ---------------------------------------------------------------------------------------
//            End Model
//
// rppolyl_rf : P+Poly w/i silicide (W>2um)
// rppolys_rf : P+Poly w/i silicide (W<2um)
// rppolywo_rf : P+Poly w/o silicide
// rppolyhri_rf : P-Poly w/o silicide
// rppolyl_rf_mis : P+Poly w/i silicide (W>2um)
// rppolys_rf_mis : P+Poly w/i silicide (W<2um)
// rppolywo_rf_mis : P+Poly w/o silicide
// rppolyhri_rf_mis : P-Poly w/o silicide
//  ************************************************************************************************

section rf_res_sa
subckt rppolyl_rf ( hi lo gnode )
parameters l=20u w=5u mf=1 rsh=rppolyl dw=-0.035u ptc1=2.64e-03 ptc2=1.92e-06 pvc1=3.14e-03
+ pvc2=6.18e-03 pt=temp tfac=1.0 + ptc1 * (pt - 25.0) + ptc2 * (pt - 25.0) * (pt
+ - 25.0) rsubtfac=1.0 + 3.74m * (pt - 25.0) + 9.1u * (pt - 25.0) * (pt - 25.0)
+ rsubx=607.2 / ((1 / (1u + (l + 0.9u) / 6) * (w - dw)) + (1 / (3u + (w - dw) /
+ 6) * (l + 0.9u))) * rsubtfac
rend1 ( hi 1 ) resistor r=11.04 / mf / (int(abs((w - 0.3u) / 0.34u) + 1))
ls1 ( 1 12 ) inductor l=0.02 * l * 1e+6 * (log(l / w) + 0.022 * w / l + 1.19) *
+ 1e-12 * sal_fac / mf
r1 ( 12 2 ) bsource r=1 / 6 * rsh / mf * l / (w - dw) * (1 + pvc1 * abs(v(5,1))
+ + pvc2 * v(5,1) * v(5,1)) * tfac
ls2 ( 2 23 ) inductor l=0.04 * l * 1e+6 * (log(l / w) + 0.022 * w / l + 1.19) *
+ 1e-12 * sal_fac / mf
r2 ( 23 3 ) bsource r=1 / 3 * rsh / mf * l / (w - dw) * (1 + pvc1 * abs(v(5,1))
+ + pvc2 * v(5,1) * v(5,1)) * tfac
ls3 ( 3 34 ) inductor l=0.04 * l * 1e+6 * (log(l / w) + 0.022 * w / l + 1.19) *
+ 1e-12 * sal_fac / mf
r3 ( 34 4 ) bsource r=1 / 3 * rsh / mf * l / (w - dw) * (1 + pvc1 * abs(v(5,1))
+ + pvc2 * v(5,1) * v(5,1)) * tfac
r4 ( 4 45 ) bsource r=1 / 6 * rsh / mf * l / (w - dw) * (1 + pvc1 * abs(v(5,1))
+ + pvc2 * v(5,1) * v(5,1)) * tfac
ls4 ( 45 5 ) inductor l=0.02 * l * 1e+6 * (log(l / w) + 0.022 * w / l + 1.19) *
+ 1e-12 * sal_fac / mf
rend2 ( 5 lo ) resistor r=11.04 / mf / (int(abs((w - 0.3u) / 0.34u) + 1))
cox1 ( 2 6 ) capacitor c=1 / 3 * (0.09677 * w * (l + 0.9u) * 1e+12 + 0.05582 * 2
+ * (w + l + 0.9u) * 1e+6 + 0.1) * 1e-15 * sacox_fac * mf
cox2 ( 3 6 ) capacitor c=1 / 3 * (0.09677 * w * (l + 0.9u) * 1e+12 + 0.05582 * 2
+ * (w + l + 0.9u) * 1e+6 + 0.1) * 1e-15 * sacox_fac * mf
cox3 ( 4 6 ) capacitor c=1 / 3 * (0.09677 * w * (l + 0.9u) * 1e+12 + 0.05582 * 2
+ * (w + l + 0.9u) * 1e+6 + 0.1) * 1e-15 * sacox_fac * mf
rsub ( 6 gnode ) resistor r=rsubx * sarsub_fac / mf
csub ( 6 gnode ) capacitor c=197f / rsubx * sacsub_fac * mf
ends rppolyl_rf

subckt rppolys_rf ( hi lo gnode )
parameters l=20u w=1u mf=1 rsh=rppolys dw=-0.035u ptc1=2.88e-03 ptc2=4.47e-07 pvc1=1.93e-04
+ pvc2=1.99e-03 pt=temp tfac=1.0 + ptc1 * (pt - 25.0) + ptc2 * (pt - 25.0) * (pt
+ - 25.0) rsubtfac=1.0 + 3.74m * (pt - 25.0) + 9.1u * (pt - 25.0) * (pt - 25.0)
+ rsubx=607.2 / ((1 / (1u + (l + 0.9u) / 6) * (w - dw)) + (1 / (3u + (w - dw) /
+ 6) * (l + 0.9u))) * rsubtfac
rend1 ( hi 1 ) resistor r=11.04 / mf / (int(abs((w - 0.3u) / 0.34u) + 1))
ls1 ( 1 12 ) inductor l=0.02 * l * 1e+6 * (log(l / w) + 0.022 * w / l + 1.19) *
+ 1e-12 * sal_fac / mf
r1 ( 12 2 ) bsource r=1 / 6 * rsh / mf * l / (w - dw) * (1 + pvc1 * abs(v(5,1))
+ + pvc2 * v(5,1) * v(5,1)) * tfac
ls2 ( 2 23 ) inductor l=0.04 * l * 1e+6 * (log(l / w) + 0.022 * w / l + 1.19) *
+ 1e-12 * sal_fac / mf
r2 ( 23 3 ) bsource r=1 / 3 * rsh / mf * l / (w - dw) * (1 + pvc1 * abs(v(5,1))
+ + pvc2 * v(5,1) * v(5,1)) * tfac
ls3 ( 3 34 ) inductor l=0.04 * l * 1e+6 * (log(l / w) + 0.022 * w / l + 1.19) *
+ 1e-12 * sal_fac / mf
r3 ( 34 4 ) bsource r=1 / 3 * rsh / mf * l / (w - dw) * (1 + pvc1 * abs(v(5,1))
+ + pvc2 * v(5,1) * v(5,1)) * tfac
r4 ( 4 45 ) bsource r=1 / 6 * rsh / mf * l / (w - dw) * (1 + pvc1 * abs(v(5,1))
+ + pvc2 * v(5,1) * v(5,1)) * tfac
ls4 ( 45 5 ) inductor l=0.02 * l * 1e+6 * (log(l / w) + 0.022 * w / l + 1.19) *
+ 1e-12 * sal_fac / mf
rend2 ( 5 lo ) resistor r=11.04 / mf / (int(abs((w - 0.3u) / 0.34u) + 1))
cox1 ( 2 6 ) capacitor c=1 / 3 * (0.09677 * w * (l + 0.9u) * 1e+12 + 0.05582 * 2
+ * (w + l + 0.9u) * 1e+6 + 0.1) * 1e-15 * sacox_fac * mf
cox2 ( 3 6 ) capacitor c=1 / 3 * (0.09677 * w * (l + 0.9u) * 1e+12 + 0.05582 * 2
+ * (w + l + 0.9u) * 1e+6 + 0.1) * 1e-15 * sacox_fac * mf
cox3 ( 4 6 ) capacitor c=1 / 3 * (0.09677 * w * (l + 0.9u) * 1e+12 + 0.05582 * 2
+ * (w + l + 0.9u) * 1e+6 + 0.1) * 1e-15 * sacox_fac * mf
rsub ( 6 gnode ) resistor r=rsubx * sarsub_fac / mf
csub ( 6 gnode ) capacitor c=197f / rsubx * sacsub_fac * mf
ends rppolys_rf

//  ********************************
//        Mismatch   model         *
//  ********************************
subckt rppolyl_rf_mis ( hi lo gnode )
parameters l=20u w=5u mf=1 geo_fac=1 / sqrt(mf * l * w * 1e12) factmis=0.00871085
+ * geo_fac * par_sarf rsh=rppolyl * (1 + factmis) dw=-0.035u ptc1=2.64e-03 ptc2=1.92e-06
+ pvc1=3.14e-03 pvc2=6.18e-03 pt=temp tfac=1.0 + ptc1 * (pt - 25.0) + ptc2 * (pt
+ - 25.0) * (pt - 25.0) rsubtfac=1.0 + 3.74m * (pt - 25.0) + 9.1u * (pt - 25.0)
+ * (pt - 25.0) rsubx=607.2 / ((1 / (1u + (l + 0.9u) / 6) * (w - dw)) + (1 / (3u
+ + (w - dw) / 6) * (l + 0.9u))) * rsubtfac
rend1 ( hi 1 ) resistor r=11.04 / mf / (int(abs((w - 0.3u) / 0.34u) + 1)) * (1 +
+ factmis)
ls1 ( 1 12 ) inductor l=0.02 * l * 1e+6 * (log(l / w) + 0.022 * w / l + 1.19) *
+ 1e-12 * sal_fac / mf
r1 ( 12 2 ) bsource r=1 / 6 * rsh / mf * l / (w - dw) * (1 + pvc1 * abs(v(5,1))
+ + pvc2 * v(5,1) * v(5,1)) * tfac
ls2 ( 2 23 ) inductor l=0.04 * l * 1e+6 * (log(l / w) + 0.022 * w / l + 1.19) *
+ 1e-12 * sal_fac / mf
r2 ( 23 3 ) bsource r=1 / 3 * rsh / mf * l / (w - dw) * (1 + pvc1 * abs(v(5,1))
+ + pvc2 * v(5,1) * v(5,1)) * tfac
ls3 ( 3 34 ) inductor l=0.04 * l * 1e+6 * (log(l / w) + 0.022 * w / l + 1.19) *
+ 1e-12 * sal_fac / mf
r3 ( 34 4 ) bsource r=1 / 3 * rsh / mf * l / (w - dw) * (1 + pvc1 * abs(v(5,1))
+ + pvc2 * v(5,1) * v(5,1)) * tfac
r4 ( 4 45 ) bsource r=1 / 6 * rsh / mf * l / (w - dw) * (1 + pvc1 * abs(v(5,1))
+ + pvc2 * v(5,1) * v(5,1)) * tfac
ls4 ( 45 5 ) inductor l=0.02 * l * 1e+6 * (log(l / w) + 0.022 * w / l + 1.19) *
+ 1e-12 * sal_fac / mf
rend2 ( 5 lo ) resistor r=11.04 / mf / (int(abs((w - 0.3u) / 0.34u) + 1)) * (1 +
+ factmis)
cox1 ( 2 6 ) capacitor c=1 / 3 * (0.09677 * w * (l + 0.9u) * 1e+12 + 0.05582 * 2
+ * (w + l + 0.9u) * 1e+6 + 0.1) * 1e-15 * sacox_fac * mf
cox2 ( 3 6 ) capacitor c=1 / 3 * (0.09677 * w * (l + 0.9u) * 1e+12 + 0.05582 * 2
+ * (w + l + 0.9u) * 1e+6 + 0.1) * 1e-15 * sacox_fac * mf
cox3 ( 4 6 ) capacitor c=1 / 3 * (0.09677 * w * (l + 0.9u) * 1e+12 + 0.05582 * 2
+ * (w + l + 0.9u) * 1e+6 + 0.1) * 1e-15 * sacox_fac * mf
rsub ( 6 gnode ) resistor r=rsubx * sarsub_fac / mf
csub ( 6 gnode ) capacitor c=197f / rsubx * sacsub_fac * mf
ends rppolyl_rf_mis

subckt rppolys_rf_mis ( hi lo gnode )
parameters l=20u w=1u mf=1 geo_fac=1 / sqrt(mf * l * w * 1e12) factmis=0.00871085
+ * geo_fac * par_sarf rsh=rppolys * (1 + factmis) dw=-0.035u ptc1=2.88e-03 ptc2=4.47e-07
+ pvc1=1.93e-04 pvc2=1.99e-03 pt=temp tfac=1.0 + ptc1 * (pt - 25.0) + ptc2 * (pt
+ - 25.0) * (pt - 25.0) rsubtfac=1.0 + 3.74m * (pt - 25.0) + 9.1u * (pt - 25.0)
+ * (pt - 25.0) rsubx=607.2 / ((1 / (1u + (l + 0.9u) / 6) * (w - dw)) + (1 / (3u
+ + (w - dw) / 6) * (l + 0.9u))) * rsubtfac
rend1 ( hi 1 ) resistor r=11.04 / mf / (int(abs((w - 0.3u) / 0.34u) + 1)) * (1 +
+ factmis)
ls1 ( 1 12 ) inductor l=0.02 * l * 1e+6 * (log(l / w) + 0.022 * w / l + 1.19) *
+ 1e-12 * sal_fac / mf
r1 ( 12 2 ) bsource r=1 / 6 * rsh / mf * l / (w - dw) * (1 + pvc1 * abs(v(5,1))
+ + pvc2 * v(5,1) * v(5,1)) * tfac
ls2 ( 2 23 ) inductor l=0.04 * l * 1e+6 * (log(l / w) + 0.022 * w / l + 1.19) *
+ 1e-12 * sal_fac / mf
r2 ( 23 3 ) bsource r=1 / 3 * rsh / mf * l / (w - dw) * (1 + pvc1 * abs(v(5,1))
+ + pvc2 * v(5,1) * v(5,1)) * tfac
ls3 ( 3 34 ) inductor l=0.04 * l * 1e+6 * (log(l / w) + 0.022 * w / l + 1.19) *
+ 1e-12 * sal_fac / mf
r3 ( 34 4 ) bsource r=1 / 3 * rsh / mf * l / (w - dw) * (1 + pvc1 * abs(v(5,1))
+ + pvc2 * v(5,1) * v(5,1)) * tfac
r4 ( 4 45 ) bsource r=1 / 6 * rsh / mf * l / (w - dw) * (1 + pvc1 * abs(v(5,1))
+ + pvc2 * v(5,1) * v(5,1)) * tfac
ls4 ( 45 5 ) inductor l=0.02 * l * 1e+6 * (log(l / w) + 0.022 * w / l + 1.19) *
+ 1e-12 * sal_fac / mf
rend2 ( 5 lo ) resistor r=11.04 / mf / (int(abs((w - 0.3u) / 0.34u) + 1)) * (1 +
+ factmis)
cox1 ( 2 6 ) capacitor c=1 / 3 * (0.09677 * w * (l + 0.9u) * 1e+12 + 0.05582 * 2
+ * (w + l + 0.9u) * 1e+6 + 0.1) * 1e-15 * sacox_fac * mf
cox2 ( 3 6 ) capacitor c=1 / 3 * (0.09677 * w * (l + 0.9u) * 1e+12 + 0.05582 * 2
+ * (w + l + 0.9u) * 1e+6 + 0.1) * 1e-15 * sacox_fac * mf
cox3 ( 4 6 ) capacitor c=1 / 3 * (0.09677 * w * (l + 0.9u) * 1e+12 + 0.05582 * 2
+ * (w + l + 0.9u) * 1e+6 + 0.1) * 1e-15 * sacox_fac * mf
rsub ( 6 gnode ) resistor r=rsubx * sarsub_fac / mf
csub ( 6 gnode ) capacitor c=197f / rsubx * sacsub_fac * mf
ends rppolys_rf_mis

endsection rf_res_sa

section rf_res_rpo
subckt rppolywo_rf ( hi lo gnode )
parameters l=10u w=5u mf=1 rsh=rppolywo rend0=1.01e-04 dl=0.04698u dw=0.07953u pt=temp
+ pvce1=-9.40e-02 pvce2=6.39e+01 pvce3=-2.71e+00 ptce1=-1.71e-03 ptce2=1.06e-06
+ pvcp1=-1.99e-01 pvcp2=6.05e-06 pvcp3=-3.23e+00 ptcp1=-1.19e-04 ptcp2=6.54e-07
+ tface=1.0 + ptce1 * (pt - 25.0) + ptce2 * (pt - 25.0) * (pt - 25.0) tfacp=1.0
+ + ptcp1 * (pt - 25.0) + ptcp2 * (pt - 25.0) * (pt - 25.0) rsubtfac=1.0 + 3.74m
+ * (pt - 25.0) + 9.1u * (pt - 25.0) * (pt - 25.0) rsubx=607.2 / ((1 / (1u + (l
+ - dl + 0.9u) / 6) * (w - dw)) + (1 / (3u + (w - dw) / 6) * (l - dl + 0.9u))) *
+ rsubtfac
rend1 ( hi 1 ) bsource r=rend0 / (w - dw) * tface * (1 + pvce1 * (tanh(pvce2 * abs(v(hi,1))
+ + pvce3) - tanh(pvce3))) / mf
ls1 ( 1 12 ) inductor l=0.02 * l * 1e+6 * (log(l / w) + 0.022 * w / l + 1.19) *
+ 1e-12 * rpol_fac / mf
r1 ( 12 2 ) bsource r=1 / 6 * rsh * (l - dl) / (w - dw) * tfacp * (1 + pvcp1 * (tanh(pvcp2
+ * abs(v(1,5) / (l - dl)) + pvcp3) - tanh(pvcp3))) / mf  l=(l-dl)/6 w=(w-dw) kf=1.25E-22 af=2 fexp=1.08 wdexp=1 ldexp=1
ls2 ( 2 23 ) inductor l=0.04 * l * 1e+6 * (log(l / w) + 0.022 * w / l + 1.19) *
+ 1e-12 * rpol_fac / mf
r2 ( 23 3 ) bsource r=1 / 3 * rsh * (l - dl) / (w - dw) * tfacp * (1 + pvcp1 * (tanh(pvcp2
+ * abs(v(1,5) / (l - dl)) + pvcp3) - tanh(pvcp3))) / mf  l=(l-dl)/3 w=(w-dw) kf=1.25E-22 af=2 fexp=1.08 wdexp=1 ldexp=1
ls3 ( 3 34 ) inductor l=0.04 * l * 1e+6 * (log(l / w) + 0.022 * w / l + 1.19) *
+ 1e-12 * rpol_fac / mf
r3 ( 34 4 ) bsource r=1 / 3 * rsh * (l - dl) / (w - dw) * tfacp * (1 + pvcp1 * (tanh(pvcp2
+ * abs(v(1,5) / (l - dl)) + pvcp3) - tanh(pvcp3))) / mf  l=(l-dl)/3 w=(w-dw) kf=1.25E-22 af=2 fexp=1.08 wdexp=1 ldexp=1
r4 ( 4 45 ) bsource r=1 / 6 * rsh * (l - dl) / (w - dw) * tfacp * (1 + pvcp1 * (tanh(pvcp2
+ * abs(v(1,5) / (l - dl)) + pvcp3) - tanh(pvcp3))) / mf  l=(l-dl)/6 w=(w-dw) kf=1.25E-22 af=2 fexp=1.08 wdexp=1 ldexp=1
ls4 ( 45 5 ) inductor l=0.02 * l * 1e+6 * (log(l / w) + 0.022 * w / l + 1.19) *
+ 1e-12 * rpol_fac / mf
rend2 ( 5 lo ) bsource r=rend0 / (w - dw) * tface * (1 + pvce1 * (tanh(pvce2 * abs(v(5,lo))
+ + pvce3) - tanh(pvce3))) / mf
cox1 ( 2 6 ) capacitor c=1 / 3 * (0.09677 * w * (l + 0.9u) * 1e+12 + 0.05582 * 2
+ * (w + l + 0.9u) * 1e+6 + 0.1) * 1e-15 * rpocox_fac * mf
cox2 ( 3 6 ) capacitor c=1 / 3 * (0.09677 * w * (l + 0.9u) * 1e+12 + 0.05582 * 2
+ * (w + l + 0.9u) * 1e+6 + 0.1) * 1e-15 * rpocox_fac * mf
cox3 ( 4 6 ) capacitor c=1 / 3 * (0.09677 * w * (l + 0.9u) * 1e+12 + 0.05582 * 2
+ * (w + l + 0.9u) * 1e+6 + 0.1) * 1e-15 * rpocox_fac * mf
rsub ( 6 gnode ) resistor r=rsubx * rporsub_fac / mf
csub ( 6 gnode ) capacitor c=197f / rsubx * rpocsub_fac * mf
ends rppolywo_rf

//  *********************************
//        Mismatch   model         *
//  ********************************
subckt rppolywo_rf_mis ( hi lo gnode )
parameters l=10u w=5u mf=1 geo_fac=1 / sqrt(mf * l * w * 1e12) factmis=0.01456 * geo_fac * par_rporf
+ rsh=rppolywo * (1 + factmis) rend0=1.01e-04 * (1 + factmis) dl=0.04698u dw=0.07953u pt=temp
+ pvce1=-9.40e-02 pvce2=6.39e+01 pvce3=-2.71e+00 ptce1=-1.71e-03 ptce2=1.06e-06
+ pvcp1=-1.99e-01 pvcp2=6.05e-06 pvcp3=-3.23e+00 ptcp1=-1.19e-04 ptcp2=6.54e-07
+ tface=1.0 + ptce1 * (pt - 25.0) + ptce2 * (pt - 25.0) * (pt - 25.0) tfacp=1.0
+ + ptcp1 * (pt - 25.0) + ptcp2 * (pt - 25.0) * (pt - 25.0) rsubtfac=1.0 + 3.74m
+ * (pt - 25.0) + 9.1u * (pt - 25.0) * (pt - 25.0) rsubx=607.2 / ((1 / (1u + (l
+ - dl + 0.9u) / 6) * (w - dw)) + (1 / (3u + (w - dw) / 6) * (l - dl + 0.9u))) *
+ rsubtfac
rend1 ( hi 1 ) bsource r=rend0 / (w - dw) * tface * (1 + pvce1 * (tanh(pvce2 * abs(v(hi,1))
+ + pvce3) - tanh(pvce3))) / mf
ls1 ( 1 12 ) inductor l=0.02 * l * 1e+6 * (log(l / w) + 0.022 * w / l + 1.19) *
+ 1e-12 * rpol_fac / mf
r1 ( 12 2 ) bsource r=1 / 6 * rsh * (l - dl) / (w - dw) * tfacp * (1 + pvcp1 * (tanh(pvcp2
+ * abs(v(1,5) / (l - dl)) + pvcp3) - tanh(pvcp3))) / mf  l=(l-dl)/6 w=(w-dw) kf=1.25E-22 af=2 fexp=1.08 wdexp=1 ldexp=1
ls2 ( 2 23 ) inductor l=0.04 * l * 1e+6 * (log(l / w) + 0.022 * w / l + 1.19) *
+ 1e-12 * rpol_fac / mf
r2 ( 23 3 ) bsource r=1 / 3 * rsh * (l - dl) / (w - dw) * tfacp * (1 + pvcp1 * (tanh(pvcp2
+ * abs(v(1,5) / (l - dl)) + pvcp3) - tanh(pvcp3))) / mf  l=(l-dl)/3 w=(w-dw) kf=1.25E-22 af=2 fexp=1.08 wdexp=1 ldexp=1
ls3 ( 3 34 ) inductor l=0.04 * l * 1e+6 * (log(l / w) + 0.022 * w / l + 1.19) *
+ 1e-12 * rpol_fac / mf
r3 ( 34 4 ) bsource r=1 / 3 * rsh * (l - dl) / (w - dw) * tfacp * (1 + pvcp1 * (tanh(pvcp2
+ * abs(v(1,5) / (l - dl)) + pvcp3) - tanh(pvcp3))) / mf  l=(l-dl)/3 w=(w-dw) kf=1.25E-22 af=2 fexp=1.08 wdexp=1 ldexp=1
r4 ( 4 45 ) bsource r=1 / 6 * rsh * (l - dl) / (w - dw) * tfacp * (1 + pvcp1 * (tanh(pvcp2
+ * abs(v(1,5) / (l - dl)) + pvcp3) - tanh(pvcp3))) / mf  l=(l-dl)/6 w=(w-dw) kf=1.25E-22 af=2 fexp=1.08 wdexp=1 ldexp=1
ls4 ( 45 5 ) inductor l=0.02 * l * 1e+6 * (log(l / w) + 0.022 * w / l + 1.19) *
+ 1e-12 * rpol_fac / mf
rend2 ( 5 lo ) bsource r=rend0 / (w - dw) * tface * (1 + pvce1 * (tanh(pvce2 * abs(v(5,lo))
+ + pvce3) - tanh(pvce3))) / mf
cox1 ( 2 6 ) capacitor c=1 / 3 * (0.09677 * w * (l + 0.9u) * 1e+12 + 0.05582 * 2
+ * (w + l + 0.9u) * 1e+6 + 0.1) * 1e-15 * rpocox_fac * mf
cox2 ( 3 6 ) capacitor c=1 / 3 * (0.09677 * w * (l + 0.9u) * 1e+12 + 0.05582 * 2
+ * (w + l + 0.9u) * 1e+6 + 0.1) * 1e-15 * rpocox_fac * mf
cox3 ( 4 6 ) capacitor c=1 / 3 * (0.09677 * w * (l + 0.9u) * 1e+12 + 0.05582 * 2
+ * (w + l + 0.9u) * 1e+6 + 0.1) * 1e-15 * rpocox_fac * mf
rsub ( 6 gnode ) resistor r=rsubx * rporsub_fac / mf
csub ( 6 gnode ) capacitor c=197f / rsubx * rpocsub_fac * mf
ends rppolywo_rf_mis
endsection rf_res_rpo

section rf_res_hri

subckt rppolyhri_rf ( hi lo gnode )
parameters l=5u w=2u mf=1 rend0=5.320e-05 rsh=rppolyhri dl=0u dw=0.093u pt=temp
+ pvce1=0.5 pvce2=1.25 pvce3=-1.25 ptce1=-6.5e-04 ptce2=3.5e-08 pvcp1=-0.095 pvcp2=1.205e-06
+ pvcp3=-0.873 ptcp1=-7.670e-04 ptcp2=7.594e-07 tface=1.0 + ptce1 * (pt - 25.0)
+ + ptce2 * (pt - 25.0) * (pt - 25.0) tfacp=1.0 + ptcp1 * (pt - 25.0) + ptcp2 *
+ (pt - 25.0) * (pt - 25.0) rsubtfac=1.0 + 3.74m * (pt - 25.0) + 9.1u * (pt - 25.0)
+ * (pt - 25.0) rsubx=607.2 / ((1 / (1u + (l - dl + 0.9u) / 6) * (w - dw)) + (1
+ / (3u + (w - dw) / 6) * (l - dl + 0.9u))) * rsubtfac
rend1 ( hi 1 ) bsource r=rend0 / (w - dw) * tface * (1 + pvce1 * (tanh(pvce2 * abs(v(hi,1))
+ + pvce3) - tanh(pvce3))) / mf
r1 ( 1 2 ) bsource r=1 / 6 * rsh * (l - dl) / (w - dw) * tfacp * (1 + pvcp1 * (tanh(pvcp2
+ * abs(v(1,5) / (l - dl)) + pvcp3) - tanh(pvcp3))) / mf  l=(l-dl)/6 w=(w-dw) kf=1.65E-22 af=2 fexp=0.95 wdexp=1 ldexp=1
r2 ( 2 3 ) bsource r=1 / 3 * rsh * (l - dl) / (w - dw) * tfacp * (1 + pvcp1 * (tanh(pvcp2
+ * abs(v(1,5) / (l - dl)) + pvcp3) - tanh(pvcp3))) / mf  l=(l-dl)/3 w=(w-dw) kf=1.65E-22 af=2 fexp=0.95 wdexp=1 ldexp=1
r3 ( 3 4 ) bsource r=1 / 3 * rsh * (l - dl) / (w - dw) * tfacp * (1 + pvcp1 * (tanh(pvcp2
+ * abs(v(1,5) / (l - dl)) + pvcp3) - tanh(pvcp3))) / mf  l=(l-dl)/3 w=(w-dw) kf=1.65E-22 af=2 fexp=0.95 wdexp=1 ldexp=1
r4 ( 4 5 ) bsource r=1 / 6 * rsh * (l - dl) / (w - dw) * tfacp * (1 + pvcp1 * (tanh(pvcp2
+ * abs(v(1,5) / (l - dl)) + pvcp3) - tanh(pvcp3))) / mf  l=(l-dl)/6 w=(w-dw) kf=1.65E-22 af=2 fexp=0.95 wdexp=1 ldexp=1
rend2 ( 5 lo ) bsource r=rend0 / (w - dw) * tface * (1 + pvce1 * (tanh(pvce2 * abs(v(5,lo))
+ + pvce3) - tanh(pvce3))) / mf
cox1 ( 2 6 ) capacitor c=1 / 3 * (0.09677 * w * (l + 0.9u) * 1e+12 + 0.05582 * 2
+ * (w + l + 0.9u) * 1e+6 + 0.1) * 1e-15 * hricox_fac * mf
cox2 ( 3 6 ) capacitor c=1 / 3 * (0.09677 * w * (l + 0.9u) * 1e+12 + 0.05582 * 2
+ * (w + l + 0.9u) * 1e+6 + 0.1) * 1e-15 * hricox_fac * mf
cox3 ( 4 6 ) capacitor c=1 / 3 * (0.09677 * w * (l + 0.9u) * 1e+12 + 0.05582 * 2
+ * (w + l + 0.9u) * 1e+6 + 0.1) * 1e-15 * hricox_fac * mf
rsub ( 6 gnode ) resistor r=rsubx * hrirsub_fac / mf
csub ( 6 gnode ) capacitor c=197f / rsubx * hricsub_fac * mf
ends rppolyhri_rf

//  *********************************
//        Mismatch   model         *
//  ********************************
subckt rppolyhri_rf_mis ( hi lo gnode )
parameters l=5u w=2u mf=1 geo_fac=1 / sqrt(mf * l * w * 1e12) factmis=0.011823 * geo_fac * par_hrirf
+ rend0=5.320e-05 * (1 + factmis) rsh=rppolyhri * (1 + factmis) dl=0u dw=0.093u pt=temp
+ pvce1=0.5 pvce2=1.25 pvce3=-1.25 ptce1=-6.5e-04 ptce2=3.5e-08 pvcp1=-0.095 pvcp2=1.205e-06
+ pvcp3=-0.873 ptcp1=-7.670e-04 ptcp2=7.594e-07 tface=1.0 + ptce1 * (pt - 25.0)
+ + ptce2 * (pt - 25.0) * (pt - 25.0) tfacp=1.0 + ptcp1 * (pt - 25.0) + ptcp2 *
+ (pt - 25.0) * (pt - 25.0) rsubtfac=1.0 + 3.74m * (pt - 25.0) + 9.1u * (pt - 25.0)
+ * (pt - 25.0) rsubx=607.2 / ((1 / (1u + (l - dl + 0.9u) / 6) * (w - dw)) + (1
+ / (3u + (w - dw) / 6) * (l - dl + 0.9u))) * rsubtfac
rend1 ( hi 1 ) bsource r=rend0 / (w - dw) * tface * (1 + pvce1 * (tanh(pvce2 * abs(v(hi,1))
+ + pvce3) - tanh(pvce3))) / mf
r1 ( 1 2 ) bsource r=1 / 6 * rsh * (l - dl) / (w - dw) * tfacp * (1 + pvcp1 * (tanh(pvcp2
+ * abs(v(1,5) / (l - dl)) + pvcp3) - tanh(pvcp3))) / mf  l=(l-dl)/6 w=(w-dw) kf=1.65E-22 af=2 fexp=0.95 wdexp=1 ldexp=1
r2 ( 2 3 ) bsource r=1 / 3 * rsh * (l - dl) / (w - dw) * tfacp * (1 + pvcp1 * (tanh(pvcp2
+ * abs(v(1,5) / (l - dl)) + pvcp3) - tanh(pvcp3))) / mf  l=(l-dl)/3 w=(w-dw) kf=1.65E-22 af=2 fexp=0.95 wdexp=1 ldexp=1
r3 ( 3 4 ) bsource r=1 / 3 * rsh * (l - dl) / (w - dw) * tfacp * (1 + pvcp1 * (tanh(pvcp2
+ * abs(v(1,5) / (l - dl)) + pvcp3) - tanh(pvcp3))) / mf  l=(l-dl)/3 w=(w-dw) kf=1.65E-22 af=2 fexp=0.95 wdexp=1 ldexp=1
r4 ( 4 5 ) bsource r=1 / 6 * rsh * (l - dl) / (w - dw) * tfacp * (1 + pvcp1 * (tanh(pvcp2
+ * abs(v(1,5) / (l - dl)) + pvcp3) - tanh(pvcp3))) / mf  l=(l-dl)/6 w=(w-dw) kf=1.65E-22 af=2 fexp=0.95 wdexp=1 ldexp=1
rend2 ( 5 lo ) bsource r=rend0 / (w - dw) * tface * (1 + pvce1 * (tanh(pvce2 * abs(v(5,lo))
+ + pvce3) - tanh(pvce3))) / mf
cox1 ( 2 6 ) capacitor c=1 / 3 * (0.09677 * w * (l + 0.9u) * 1e+12 + 0.05582 * 2
+ * (w + l + 0.9u) * 1e+6 + 0.1) * 1e-15 * hricox_fac * mf
cox2 ( 3 6 ) capacitor c=1 / 3 * (0.09677 * w * (l + 0.9u) * 1e+12 + 0.05582 * 2
+ * (w + l + 0.9u) * 1e+6 + 0.1) * 1e-15 * hricox_fac * mf
cox3 ( 4 6 ) capacitor c=1 / 3 * (0.09677 * w * (l + 0.9u) * 1e+12 + 0.05582 * 2
+ * (w + l + 0.9u) * 1e+6 + 0.1) * 1e-15 * hricox_fac * mf
rsub ( 6 gnode ) resistor r=rsubx * hrirsub_fac / mf
csub ( 6 gnode ) capacitor c=197f / rsubx * hricsub_fac * mf
ends rppolyhri_rf_mis
endsection rf_res_hri

// ****************************************************************************
//
//  CMOS 0.13um Schottky Barrier Diode (SBD) Scalable Model
//
//  HSPICE LEVEL 49:
//
//      ## library files:
//        Model Name        l(um)             w(um)               nf
//                        low   high      low     high       low    high
//        --------------------------------------------------------------------
//        sbd_rf           2      4        4       16         1      16
//        sbd_rf_nw        2      4        4       16         1      16
//        --------------------------------------------------------------------
//     End Model
//
// ****************************************************************************

section rf_sbd

// ****************************************************************************
// ****                 Schottky Diode with Deep N-Well                   *****
// ****************************************************************************

subckt sbd_rf ( 1 2 3 )
parameters l=2e-006 w=16e-006 nf=16 lum=l * 1e6 wum=w * 1e6 num_strip=int(6 + (lum
+ - 2) * 2.8) r_strip=(1.16 * 0.09 / 0.16) + (int((wum - 0.08 * 2 + 0.18) / 0.34)
+ - 1) * (2 * int((wum - 0.08 * 2 + 0.18) / 0.34) - 1) / 6 / int((wum - 0.08 * 2
+ + 0.18) / 0.34) * (0.36 / 0.16 * 0.09) + 0.68 / int((wum - 0.08 * 2 + 0.18) /
+ 0.34) leng_strip=r_strip * 0.16 / 0.09 lph_end=(0.36 * int(6 + (lum - 2) * 2.8)
+ + 0.4) * 1.8 num_sidebranch=( - 1) * (int((nf + 1) / 2 - int(nf / 2)) - 1) * nf
+ / 2 + (int((nf + 1) / 2 - int(nf / 2))) * 1 lph_sidex1=lph_end + (num_sidebranch
+ - 1) * (2 * num_sidebranch - 1) / 6 / num_sidebranch * lph_end + r_strip * 0.16
+ / 0.09 / num_sidebranch - int((nf + 1) / 2 - int(nf / 2)) * lph_end / 2 lph_sidex2=lph_sidex1
+ / 2 lph_center=leng_strip * 1.8 a1_eff=(l - 0.18u) * (w - 0.18u) * nf p1_eff=((l
+ - 0.18u) + (w - 0.18u)) * 2 * nf a2_eff=l * w * nf - a1_eff p2_eff=(l + w) * 2
+ * nf + p1_eff ldnw_eff=0.3u * (nf + 1) + (0.36u * 2 + l) * nf + 1.41u * 2 wdnw_eff=w
+ + 1.41u * 2 adnw_eff=ldnw_eff * wdnw_eff pdnw_eff=(ldnw_eff + wdnw_eff) * 2 r_s1=(0.275397)
+ / nf + (0.040389) / lum + (0.476984) / wum + (80.52809) / lum / wum / nf + (1.84136)
+ / lum / wum + (2.915102) / lum / nf + (21.89838) / wum / nf + (0.206569) - 0.2
+ r_s2=(3.38) / nf + (0.40944) / lum + (2.338413) / wum + (127.1533) / lum / wum
+ / nf + (4.11991) / lum / wum + (3.99565) / lum / nf + (31.32444) / wum / nf +
+ ( - 0.17944) r_1=r_strip / num_strip / nf l_1=leng_strip * 2 / num_strip / nf
+ * 1e-12 r_2=r_strip / (nf + 1) / 0.46 * 0.16 l_2=(lph_sidex2 * lph_center / (lph_sidex2
+ + lph_center) * (1 - int((nf + 1) / 2 - int(nf / 2))) + lph_sidex2 * int((nf +
+ 1) / 2 - int(nf / 2))) * 1e-12 r_nwell=((10.68095) / nf + (0.793813) * lum + (7.825079)
+ / wum + (50.65912) * lum / wum / nf + ( - 2.16331) * lum / wum + ( - 1.60032)
+ * lum / nf + (168.78571) / wum / nf + ( - 0.14392)) * (1 - 1.7e-5 * wum ** 1.5
+ * nf ** 1.5 * lum) - 0.6 r_sub=( - 12.291620) / nf + 23.746600 / lum + ( - 19.798286)
+ / wum + ( - 515.426543) / lum / wum / nf + ( - 31.316278) / lum / wum + ( - 45.520722)
+ / lum / nf + (512.782361) / wum / nf + 8.585479 * lum + ( - 86.802801) * lum /
+ nf / wum + 434.279539 * 1 / sqrt(lum * wum * nf) + ( - 2.220411) c_sub=(0.038987
+ * nf + ( - 0.657017) * lum + ( - 0.249364) * wum + 0.003826 * lum * wum * nf +
+ ( - 0.132405) * lum * wum + (0.009054) * lum * nf + (0.011490) * wum * nf + (2.163004)
+ * sqrt(lum * wum) + ( - 0.030696) * sqrt(lum * wum) * nf + 2.742608) * 1e-15 c_sti=((
+ - 0.112288) * nf + ( - 0.013586) * lum + (0.130999) * wum + (0.031009) * lum *
+ wum * nf + (0.006041) * lum * wum + (0.023377) * lum * nf + (0.120170) * wum *
+ nf + ( - 0.033538) * sqrt(wum * lum) + ( - 0.112984)) * 1e-15 c_pp=(( - 0.282619)
+ * nf + ( - 1.328147) * lum + ( - 0.115162) * wum + (0.017999) * lum * wum * nf
+ + ( - 0.043202) * lum * wum + (0.412528) * lum * nf + (0.011854) * wum * nf +
+ (0.751030) * sqrt(wum * lum) + (2.692831)) * 1e-15 is_fdiode1_wi=(( - 30.7221)
+ * lum + ( - 41.6847) * wum + ( - 665.5646) / nf + ( - 7.0269) * lum * wum + (
+ - 183.3680) * lum / nf + ( - 120.9697) * wum / nf + ( - 47.1611) * lum * wum /
+ nf + (978.5453) * sqrt(wum * lum) / nf + 261.7520 * sqrt(wum * lum) + ( - 78.4284))
+ * factor_isf_wi n_fdiode1_wi=(0.088201) / lum + (0.028120) / wum + ( - 0.027211)
+ / lum / wum + (0.007037) * lum + ( - 0.000642) * wum + 0.884969 cj_fdiode1_wi=((
+ - 0.001644) / lum + ( - 0.001983) / wum + (0.001299) / lum / wum + ( - 0.000017)
+ * lum + (4.125926e-06) * wum + (0.004069)) * factor_cjf_wi mj_fdiode1_wi=(0.036552)
+ / lum + (0.104677) / wum + ( - 0.451701) / lum / wum + (0.0128) * lum + (0.000296)
+ * wum + 0.643196 is_rdiode_wi=((-12.83783)* nf + (-90.98964) * lum + (-47.0175) * wum + (5.05497) * lum * wum * nf +
+ (20.70406) * lum * wum + (-6.06581) * lum * nf + (-8.05982) * wum * nf + (114.69857)
+ * sqrt(lum * wum) + (17.08802) * sqrt(lum * wum) * nf + (161.30248)) * factor_isr_wi n_rdiode_wi=( - 0.485714) /
+ lum + ( - 4.025397) / wum + (7.591474) / lum / wum + (0.011111) * lum + ( - 0.011111)
+ * wum + (0.736508) * lum / wum + (0.013968) * wum / lum + 12.972222

// =====================
r1 ( 1 4 ) resistor r=r_1 * factor_rm * (1 + (temp - 25) * 2.93e-3)
l1 ( 4 5 ) inductor l=l_1 * factor_l
csti ( 5 8 ) capacitor c=c_sti * factor_csti
// --- Schottky diode
df1 ( 5 11 ) f_diode1_wi area=a1_eff pj=p1_eff
rs1 ( 11 6 ) resistor r=r_s1 * factor_re_wi
dr ( 11 5 ) r_diode_wi area=a1_eff pj=p1_eff
// --- PN junction diode
df2 ( 5 21 ) f_diode2_wi area=a2_eff pj=p2_eff
rs2 ( 21 6 ) resistor r=r_s2 * factor_re_wi
cpp ( 5 3 ) capacitor c=c_pp
// --- Substrate network
ddnw ( 31 7 ) dio_dnwpsub area=adnw_eff pj=pdnw_eff
rsub ( 31 3 ) resistor r=r_sub * factor_rsub * (1 + (temp - 25) * 3.74e-3 + (temp
+ - 25) * (temp - 25) * 9.1e-6)
csub ( 31 3 ) capacitor c=c_sub * factor_csub * (1 + (temp - 25) * 3.74e-3 + (temp
+ - 25) * (temp - 25) * 9.1e-6)
rnwell1 ( 6 7 ) resistor r=r_nwell / 2 * factor_rnwell * (1 + (temp - 25) * 3.74e-3
+ + (temp - 25) * (temp - 25) * 9.1e-6)
rnwell2 ( 7 8 ) resistor r=r_nwell / 2 * factor_rnwell * (1 + (temp - 25) * 3.74e-3
+ + (temp - 25) * (temp - 25) * 9.1e-6)

r2 ( 8 9 ) resistor r=r_2 * factor_rm * (1 + (temp - 25) * 2.93e-3)
l2 ( 9 2 ) inductor l=l_2 * factor_l

// -- Forward diode No. 1 ---
//
model f_diode1_wi diode
+ level=1                   is=is_fdiode1_wi          rs=1e-010
+ n=n_fdiode1_wi            bv=1e4                    ibv=is_fdiode1_wi
+ ik = 3e+005               ikr = 1e+010
+ isw=3.5e-014              cj=cj_fdiode1_wi          vj=0.8756
+ mj=mj_fdiode1_wi          cjsw=0                    vjsw=0.8956
+ mjsw=0.6823               tlev=2                    eg=0.48
+ xti=2                     tbv1=-1*-0.000888         trs=0.00277
+ tlevc=1                   cta=0.0003067             ctp=0.0002781
+ pta=0.00302               ptp=0.001427              tnom=25
+ fc=0                      ns=n_fdiode1_wi           nz=n_fdiode1_wi
+ imax=1e40                 minr=1e-10                allow_scaling=1

// -- Reverse diode to model leakage current ---
//
model r_diode_wi diode
+ level=1                   is=is_rdiode_wi           rs=1e-010
+ n=n_rdiode_wi             bv=1e4                    ibv=is_rdiode_wi
+ ik = 6e+004               ikr = 5e+005
+ isw=1.55e-013             cj=0                      vj=0.2006
+ mj=0.4528                 cjsw=0                    vjsw=0.7956
+ mjsw=0.2323               tlev=2                    eg=4.50
+ xti=12                    tbv1=-1*-0.000888         trs=0.00277
+ tlevc=1                   cta=0.0009067             ctp=0.0002781
+ pta=0.001427              ptp=0.001427              tnom=25
+ fc=0                      ns=n_rdiode_wi            nz=n_rdiode_wi
+ imax=1e40                 minr=1e-10                allow_scaling=1

// -- Forward diode No. 2, P+/NW STI Diode ---
//
model f_diode2_wi diode
+ level=1                   is=1.8e-007*factor_is_d   rs=1e-010*factor_rs_d
+ n=1.02*factor_n_d         bv=8.33                   ibv=0.02
+ ik = 1e+020               ikr = 1e+010
+ isw=6.6e-014*factor_jsw_d cj=0.001369*factor_cj_d   vj=0.9
+ mj=0.4234                 cjsw=9.8e-011*factor_cjsw_d
+ vjsw=0.9                  mjsw=0.1716               tlev=1
+ eg=1.17                   xti=3                     tbv1=-1*-0.000845
+ trs=0.00289               tlevc=1                   cta=0.000887
+ ctp=0.000298              pta=0.001643              ptp=0.001643
+ tnom=25                   fc=0                      area=3.92e-008
+ pj=0.00084                ns=1.02*factor_n_d        nz=1.02*factor_n_d
+ imax=1e40                 minr=1e-10                allow_scaling=1

// -- DNW/PSUB diode ---
//
model dio_dnwpsub diode
+ level=1                   is=9.76e-007              rs=1e-010
+ n=1.02                    bv=13.8                   ibv=0.03
+ ik = 1e+020               ikr = 1e+010
+ isw=4.13e-012             area=3.92e-008            pj=0.00084
+ cj=0.0001322              vj=0.6012                 mj=0.3431
+ cjsw=1.357e-009           vjsw=0.6012               mjsw=0.3037
+ tlev=1                    eg=1.17                   xti=3
+ tbv1=-1*-0.00071          trs=0.00265               tlevc=1
+ cta=0.002573              ctp=0.002055              pta=0.003146
+ ptp=0.003146              tnom=25                   fc=0
+ ns=1.02                   nz=1.02                   imax=1e40
+ minr=1e-10                allow_scaling=1

ends sbd_rf
//   //
//
//
//
//
// ****************************************************************************
// ****               Schottky Diode with only N-Well                     *****
// ****************************************************************************

subckt sbd_rf_nw ( 1 2 3 )
parameters l=2e-006 w=16e-006 nf=16 lum=l * 1e6 wum=w * 1e6 num_strip=int(6 + (lum
+ - 2) * 2.8) r_strip=(1.16 * 0.09 / 0.16) + (int((wum - 0.08 * 2 + 0.18) / 0.34)
+ - 1) * (2 * int((wum - 0.08 * 2 + 0.18) / 0.34) - 1) / 6 / int((wum - 0.08 * 2
+ + 0.18) / 0.34) * (0.36 / 0.16 * 0.09) + 0.68 / int((wum - 0.08 * 2 + 0.18) /
+ 0.34) leng_strip=r_strip * 0.16 / 0.09 lph_end=(0.36 * int(6 + (lum - 2) * 2.8)
+ + 0.4) * 1.8 num_sidebranch=( - 1) * (int((nf + 1) / 2 - int(nf / 2)) - 1) * nf
+ / 2 + (int((nf + 1) / 2 - int(nf / 2))) * 1 lph_sidex1=lph_end + (num_sidebranch
+ - 1) * (2 * num_sidebranch - 1) / 6 / num_sidebranch * lph_end + r_strip * 0.16
+ / 0.09 / num_sidebranch - int((nf + 1) / 2 - int(nf / 2)) * lph_end / 2 lph_sidex2=lph_sidex1
+ / 2 lph_center=leng_strip * 1.8 a1_eff=(l - 0.18u) * (w - 0.18u) * nf p1_eff=((l
+ - 0.18u) + (w - 0.18u)) * 2 * nf a2_eff=l * w * nf - a1_eff p2_eff=(l + w) * 2
+ * nf + p1_eff lnw_eff=0.3u * (nf + 1) + (0.36u * 2 + l) * nf + 0.81u * 2 wnw_eff=w
+ + 0.81u * 2 anw_eff=lnw_eff * wnw_eff pnw_eff=(lnw_eff + wnw_eff) * 2 r_s1=(0.275397)
+ / nf + (0.040389) / lum + (0.476984) / wum + (80.52809) / lum / wum / nf + (1.84136)
+ / lum / wum + (2.915102) / lum / nf + (21.89838) / wum / nf + (0.206569) - 0.2
+ r_s2=(3.38) / nf + (0.40944) / lum + (2.338413) / wum + (127.1533) / lum / wum
+ / nf + (4.11991) / lum / wum + (3.99565) / lum / nf + (31.32444) / wum / nf +
+ ( - 0.17944) r_1=r_strip / num_strip / nf l_1=leng_strip * 2 / num_strip / nf
+ * 1e-12 r_2=r_strip / (nf + 1) / 0.46 * 0.16 l_2=(lph_sidex2 * lph_center / (lph_sidex2
+ + lph_center) * (1 - int((nf + 1) / 2 - int(nf / 2))) + lph_sidex2 * int((nf +
+ 1) / 2 - int(nf / 2))) * 1e-12 r_nwell=(7.49708) / nf + ( - 0.46359) * lum + (1.34025)
+ / wum + (26.87326) * lum / wum / nf + (3.77392) * lum / wum + (2.46390) * lum
+ / nf + (283.75263) / wum / nf + (2.26658) + ( - 1.4) r_sub=(7.15281) / nf + (3.95866)
+ / lum + ( - 7.70179) / wum + ( - 160.31468) / lum / wum / nf + ( - 41.95392) /
+ lum / wum + ( - 45.36581) / lum / nf + (410.95059) / wum / nf + (6.58653) * lum
+ + ( - 61.9672) * lum / nf / wum + (394.33295) / sqrt(lum * wum * nf) + (39.32448)
+ c_sub=((0.33658) * nf + ( - 3.67044) * lum + ( - 0.83015) * wum + (0.02842) *
+ lum * wum * nf + ( - 0.65046) * lum * wum + ( - 0.01218) * lum * nf + (0.04782)
+ * wum * nf + (10.24635) * sqrt(lum * wum) + ( - 0.10317) * sqrt(lum * wum) * nf
+ + (27.01793)) * 1e-15 c_sti=(( - 0.112288) * nf + ( - 0.013586) * lum + (0.130999)
+ * wum + (0.031009) * lum * wum * nf + (0.006041) * lum * wum + (0.023377) * lum
+ * nf + (0.120170) * wum * nf + ( - 0.033538) * sqrt(wum * lum) + ( - 0.112984))
+ * 1e-15 c_pp=(( - 0.282619) * nf + ( - 1.328147) * lum + ( - 0.115162) * wum +
+ (0.017999) * lum * wum * nf + ( - 0.043202) * lum * wum + (0.412528) * lum * nf
+ + (0.011854) * wum * nf + (0.751030) * sqrt(wum * lum) + (2.692831)) * 1e-15 is_fdiode1_wo=((
+ - 30.7221) * lum + ( - 41.6847) * wum + ( - 665.5646) / nf + ( - 7.0269) * lum
+ * wum + ( - 183.3680) * lum / nf + ( - 120.9697) * wum / nf + ( - 47.1611) * lum
+ * wum / nf + (978.5453) * sqrt(wum * lum) / nf + 261.7520 * sqrt(wum * lum) +
+ ( - 78.4284)) * factor_isf_wo n_fdiode1_wo=(0.088201) / lum + (0.028120) / wum
+ + ( - 0.027211) / lum / wum + (0.007037) * lum + ( - 0.000642) * wum + 0.884969
+ cj_fdiode1_wo=(( - 0.001644) / lum + ( - 0.001983) / wum + (0.001299) / lum /
+ wum + ( - 0.000017) * lum + (4.125926e-06) * wum + (0.004069)) * factor_cjf_wo
+ mj_fdiode1_wo=(0.036552) / lum + (0.104677) / wum + ( - 0.451701) / lum / wum
+ + (0.0128) * lum + (0.000296) * wum + 0.643196 is_rdiode_wo=((-12.83783)* nf + (-90.98964) * lum + (-47.0175) * wum + (5.05497) * lum * wum * nf +
+ (20.70406) * lum * wum + (-6.06581) * lum * nf + (-8.05982) * wum * nf + (114.69857)
+ * sqrt(lum * wum) + (17.08802) * sqrt(lum * wum) * nf + (161.30248)) * factor_isr_wo n_rdiode_wo=(
+ - 0.485714) / lum + ( - 4.025397) / wum + (7.591474) / lum / wum + (0.011111)
+ * lum + ( - 0.011111) * wum + (0.736508) * lum / wum + (0.013968) * wum / lum
+ + 12.972222

// =====================
r1 ( 1 4 ) resistor r=r_1 * factor_rm * (1 + (temp - 25) * 2.93e-3)
l1 ( 4 5 ) inductor l=l_1 * factor_l
csti ( 5 8 ) capacitor c=c_sti * factor_csti
// --- Schottky diode
df1 ( 5 11 ) f_diode1_wo area=a1_eff pj=p1_eff
rs1 ( 11 6 ) resistor r=r_s1 * factor_re_wo
dr ( 11 5 ) r_diode_wo area=a1_eff pj=p1_eff
// --- PN junction diode
df2 ( 5 21 ) f_diode2_wo area=a2_eff pj=p2_eff
rs2 ( 21 6 ) resistor r=r_s2 * factor_re_wo
cpp ( 5 3 ) capacitor c=c_pp
// --- Substrate network
dnw ( 31 7 ) dio_nwpsub area=anw_eff pj=pnw_eff
rsub ( 31 3 ) resistor r=r_sub * factor_rsub * (1 + (temp - 25) * 3.74e-3 + (temp
+ - 25) * (temp - 25) * 9.1e-6)
csub ( 31 3 ) capacitor c=c_sub * factor_csub * (1 + (temp - 25) * 3.74e-3 + (temp
+ - 25) * (temp - 25) * 9.1e-6)
rnwell1 ( 6 7 ) resistor r=r_nwell / 2 * factor_rnwell * (1 + (temp - 25) * 3.74e-3
+ + (temp - 25) * (temp - 25) * 9.1e-6)
rnwell2 ( 7 8 ) resistor r=r_nwell / 2 * factor_rnwell * (1 + (temp - 25) * 3.74e-3
+ + (temp - 25) * (temp - 25) * 9.1e-6)

r2 ( 8 9 ) resistor r=r_2 * factor_rm * (1 + (temp - 25) * 2.93e-3)
l2 ( 9 2 ) inductor l=l_2 * factor_l

// -- Forward diode No. 1 ---
//
model f_diode1_wo diode
+ level=1                   is=is_fdiode1_wo          rs=1e-010
+ n=n_fdiode1_wo            bv=1e4                    ibv=is_fdiode1_wo
+ ik = 3e+005               ikr = 1e+010
+ isw=3.5e-014              cj=cj_fdiode1_wo          vj=0.8756
+ mj=mj_fdiode1_wo          cjsw=0                    vjsw=0.8956
+ mjsw=0.6823               tlev=2                    eg=0.48
+ xti=2                     tbv1=-1*-0.000888         trs=0.00277
+ tlevc=1                   cta=0.0003067             ctp=0.0002781
+ pta=0.00302               ptp=0.001427              tnom=25
+ fc=0                      ns=n_fdiode1_wo           nz=n_fdiode1_wo
+ imax=1e40                 minr=1e-10                allow_scaling=1

// -- Reverse diode to model leakage current ---
//
model r_diode_wo diode
+ level=1                   is=is_rdiode_wo           rs=1e-010
+ n=n_rdiode_wo             bv=1e4                    ibv=is_rdiode_wo
+ ik = 6e+004               ikr = 5e+005
+ isw=1.55e-013             cj=0                      vj=0.2006
+ mj=0.4528                 cjsw=0                    vjsw=0.7956
+ mjsw=0.2323               tlev=1                    eg=4.5
+ xti=12                    tbv1=-1*-0.000888         trs=0.00277
+ tlevc=1                   cta=0.0009067             ctp=0.0002781
+ pta=0.001427              ptp=0.001427              tnom=25
+ fc=0                      ns=n_rdiode_wo            nz=n_rdiode_wo
+ imax=1e40                 minr=1e-10                allow_scaling=1

// -- Forward diode No. 2, P+/NW STI Diode ---
//
model f_diode2_wo diode
+ level=1                   is=1.8e-007*factor_is_d   rs=1e-010*factor_rs_d
+ n=1.02*factor_n_d         bv=8.33                   ibv=0.02
+ ik = 1e+020               ikr = 1e+010
+ isw=6.6e-014*factor_jsw_d cj=0.001369*factor_cj_d   vj=0.9
+ mj=0.4234                 cjsw=9.8e-011*factor_cjsw_d
+ vjsw=0.9                  mjsw=0.1716               tlev=1
+ eg=1.17                   xti=3                     tbv1=-1*-0.000845
+ trs=0.00289               tlevc=1                   cta=0.000887
+ ctp=0.000298              pta=0.001643              ptp=0.001643
+ tnom=25                   fc=0                      area=3.92e-008
+ pj=0.00084                ns=1.02*factor_n_d        nz=1.02*factor_n_d
+ imax=1e40                 minr=1e-10                allow_scaling=1

// -- NW/PSUB diode ---
//
model dio_nwpsub diode
+ level=1                   is=6.2e-007               rs=1e-010
+ n=1.02                    bv=13.6                   ibv=0.01
+ ik = 1e+010               ikr = 1e+020
+ isw=3.17e-012             cj=0.0001291              vj=0.8122
+ mj=0.4897                 cjsw=5.35e-010            vjsw=0.8122
+ mjsw=0.2822               tlev=1                    eg=1.17
+ xti=3                     tbv1=-1*-0.00129          trs=0.00204
+ tlevc=1                   cta=0.002483              ctp=0.001238
+ pta=0.003184              ptp=0.003184              tnom=25
+ fc=0                      area=3.92e-008            pj=0.00084
+ ns=1.02                   nz=1.02                   imax=1e40
+ minr=1e-10                allow_scaling=1

ends sbd_rf_nw
//   //
//
//

endsection rf_sbd
//
// **************************************************************
//                                                              *
//                1.2V STANDARD DEVICES LIB                     *
//                                                              *
// **************************************************************
//

// *****************************    LIBRARY OF TYPICAL CASE    ******************************

section tt
parameters parn1=0
parameters parn2=0
parameters parp1=0
parameters parp2=0

parameters toxn=2.810e-09
parameters dxl=0
parameters dxw=0
parameters cjn=1.376e-03
parameters cjswn=2.060e-10
parameters cjswgn=5.046e-10
parameters cgon=3.300e-10
parameters rshn=6.6
parameters hdifn=1.35e-07
parameters cgln=8.0e-11
parameters dvthn=0
parameters dwvthn=0
parameters dlvthn=0
parameters dpvthn=0
parameters dlvsatn=0
parameters dpvsatn=0
parameters dppclmn=0
parameters dk2n=0
parameters dlk2n=0
parameters toxp=2.850e-09
parameters cjp=1.369e-03
parameters cjswp=9.800e-11
parameters cjswgp=4.531e-10
parameters cgop=2.270e-10
parameters rshp=7.2
parameters hdifp=1.35e-07
parameters cglp=9.0e-11
parameters dvthp=0
parameters dlvthp=0
parameters dwvthp=0
parameters dpvthp=0
parameters dlvsatp=0
parameters dpvsatp=0
parameters dk2p=0
parameters dlk2p=0
include "cr013g_2d5_v1d4.scs" section=mos

endsection tt

// *****************************  LIBRARY OF SNSP CORNER CASE  ******************************

section ss
parameters parn1=0
parameters parn2=0
parameters parp1=0
parameters parp2=0

parameters toxn=2.829e-09
parameters dxl=3.14e-09
parameters dxw=-1.00e-08
parameters cjn=1.445e-03
parameters cjswn=2.266e-10
parameters cjswgn=5.551e-10
parameters cgon=3.126e-10
parameters rshn=6.6
parameters hdifn=1.35e-07
parameters cgln=8.0e-11
parameters dvthn=2.10e-02
parameters dwvthn=3.65e-09
parameters dlvthn=2.42e-09
parameters dpvthn=2.18e-16
parameters dlvsatn=-1.00e-04
parameters dpvsatn=-9.00e-11
parameters dppclmn=0
parameters dk2n=0.005
parameters dlk2n=2.0e-9
parameters toxp=2.869e-09
parameters cjp=1.438e-03
parameters cjswp=1.078e-10
parameters cjswgp=4.984e-10
parameters cgop=2.144e-10
parameters rshp=7.2
parameters hdifp=1.35e-07
parameters cglp=9.0e-11
parameters dvthp=-2.06e-02
parameters dlvthp=-2.50e-09
parameters dwvthp=-4.10e-09
parameters dpvthp=-1.70e-16
parameters dlvsatp=-2.0e-04
parameters dpvsatp=9.00e-11
parameters dk2p=0.01
parameters dlk2p=1.0e-9
include "cr013g_2d5_v1d4.scs" section=mos

endsection ss

// *****************************  LIBRARY OF FNFP CORNER CASE  ******************************

section ff
parameters parn1=0
parameters parn2=0
parameters parp1=0
parameters parp2=0

parameters toxn=2.791e-09
parameters dxl=-3.14e-09
parameters dxw=5.09e-09
parameters cjn=1.307e-03
parameters cjswn=1.854e-10
parameters cjswgn=4.542e-10
parameters cgon=3.474e-10
parameters rshn=6.6
parameters hdifn=1.35e-07
parameters cgln=8.0e-11
parameters dvthn=-2.16e-02
parameters dwvthn=-3.75e-09
parameters dlvthn=-2.30e-09
parameters dpvthn=-2.20e-16
parameters dlvsatn=0.00e+00
parameters dpvsatn=9.00e-11
parameters dppclmn=0
parameters dk2n=-0.005
parameters dlk2n=-2.0e-9
parameters toxp=2.831e-09
parameters cjp=1.301e-03
parameters cjswp=8.820e-11
parameters cjswgp=4.078e-10
parameters cgop=2.395e-10
parameters rshp=7.2
parameters hdifp=1.35e-07
parameters cglp=9.0e-11
parameters dvthp=2.11e-02
parameters dlvthp=2.35e-09
parameters dwvthp=4.43e-09
parameters dpvthp=1.78e-16
parameters dlvsatp=-1.50e-04
parameters dpvsatp=-2.0e-11
parameters dk2p=-0.01
parameters dlk2p=-1.0e-9
include "cr013g_2d5_v1d4.scs" section=mos

endsection ff

// *****************************  LIBRARY OF SNFP CORNER CASE  ******************************

section sf
parameters parn1=0
parameters parn2=0
parameters parp1=0
parameters parp2=0

parameters toxn=2.810e-09
parameters dxl=0
parameters dxw=0
parameters cjn=1.445e-03
parameters cjswn=2.266e-10
parameters cjswgn=5.551e-10
parameters cgon=3.300e-10
parameters rshn=6.6
parameters hdifn=1.35e-07
parameters cgln=8.0e-11
parameters dvthn=2.15e-02
parameters dwvthn=3.31e-09
parameters dlvthn=2.27e-09
parameters dpvthn=2.34e-16
parameters dlvsatn=0
parameters dpvsatn=0
parameters dppclmn=0
parameters dk2n=0.005
parameters dlk2n=2.0e-9
parameters toxp=2.850e-09
parameters cjp=1.301e-03
parameters cjswp=8.820e-11
parameters cjswgp=4.078e-10
parameters cgop=2.270e-10
parameters rshp=7.2
parameters hdifp=1.35e-07
parameters cglp=9.0e-11
parameters dvthp=2.18e-02
parameters dlvthp=2.20e-09
parameters dwvthp=4.19e-09
parameters dpvthp=1.90e-16
parameters dlvsatp=0
parameters dpvsatp=0
parameters dk2p=-0.01
parameters dlk2p=-1.0e-9
include "cr013g_2d5_v1d4.scs" section=mos

endsection sf

// *****************************  LIBRARY OF FNSP CORNER CASE  ******************************

section fs
parameters parn1=0
parameters parn2=0
parameters parp1=0
parameters parp2=0

parameters toxn=2.810e-09
parameters dxl=0
parameters dxw=0
parameters cjn=1.307e-03
parameters cjswn=1.854e-10
parameters cjswgn=4.542e-10
parameters cgon=3.300e-10
parameters rshn=6.6
parameters hdifn=1.35e-07
parameters cgln=8.0e-11
parameters dvthn=-2.20e-02
parameters dwvthn=-3.31e-09
parameters dlvthn=-2.27e-09
parameters dpvthn=-2.35e-16
parameters dlvsatn=0
parameters dpvsatn=0
parameters dppclmn=0
parameters dk2n=-0.005
parameters dlk2n=-2.0e-9
parameters toxp=2.850e-09
parameters cjp=1.438e-03
parameters cjswp=1.078e-10
parameters cjswgp=4.984e-10
parameters cgop=2.270e-10
parameters rshp=7.2
parameters hdifp=1.35e-07
parameters cglp=9.0e-11
parameters dvthp=-2.15e-02
parameters dlvthp=-2.20e-09
parameters dwvthp=-4.19e-09
parameters dpvthp=-1.91e-16
parameters dlvsatp=0
parameters dpvsatp=0
parameters dk2p=0.01
parameters dlk2p=1.0e-9
include "cr013g_2d5_v1d4.scs" section=mos

endsection fs

// ****************************    LIBRARY OF TYPICAL CASE    ******************************

section tt_g
parameters parn1=0
parameters parn2=0
parameters parp1=0
parameters parp2=0

parameters toxn=2.810e-09
parameters dxl=0
parameters dxw=0
parameters cjn=1.376e-03
parameters cjswn=2.060e-10
parameters cjswgn=5.046e-10
parameters cgon=3.300e-10
parameters rshn=0
parameters hdifn=1.35e-07
parameters cgln=8.0e-11
parameters dvthn=0
parameters dwvthn=0
parameters dlvthn=0
parameters dpvthn=0
parameters dlvsatn=0
parameters dpvsatn=0
parameters dppclmn=0
parameters dk2n=0
parameters dlk2n=0
parameters toxp=2.850e-09
parameters cjp=1.369e-03
parameters cjswp=9.800e-11
parameters cjswgp=4.531e-10
parameters cgop=2.270e-10
parameters rshp=0
parameters hdifp=1.35e-07
parameters cglp=9.0e-11
parameters dvthp=0
parameters dlvthp=0
parameters dwvthp=0
parameters dpvthp=0
parameters dlvsatp=0
parameters dpvsatp=0
parameters dk2p=0
parameters dlk2p=0
include "cr013g_2d5_v1d4.scs" section=mos
include "cr013g_2d5_v1d4.scs" section=mac

endsection tt_g

// *****************************  LIBRARY OF SNSP CORNER CASE  ******************************

section ss_g
parameters parn1=0
parameters parn2=0
parameters parp1=0
parameters parp2=0

parameters toxn=2.829e-09
parameters dxl=3.14e-09
parameters dxw=-1.00e-08
parameters cjn=1.445e-03
parameters cjswn=2.266e-10
parameters cjswgn=5.551e-10
parameters cgon=3.126e-10
parameters rshn=0
parameters hdifn=1.35e-07
parameters cgln=8.0e-11
parameters dvthn=2.10e-02
parameters dwvthn=3.65e-09
parameters dlvthn=2.42e-09
parameters dpvthn=2.18e-16
parameters dlvsatn=-1.00e-04
parameters dpvsatn=-9.00e-11
parameters dppclmn=0
parameters dk2n=0.005
parameters dlk2n=2.0e-9
parameters toxp=2.869e-09
parameters cjp=1.438e-03
parameters cjswp=1.078e-10
parameters cjswgp=4.984e-10
parameters cgop=2.144e-10
parameters rshp=0
parameters hdifp=1.35e-07
parameters cglp=9.0e-11
parameters dvthp=-2.06e-02
parameters dlvthp=-2.50e-09
parameters dwvthp=-4.10e-09
parameters dpvthp=-1.70e-16
parameters dlvsatp=-2.0e-04
parameters dpvsatp=9.00e-11
parameters dk2p=0.01
parameters dlk2p=1.0e-9
include "cr013g_2d5_v1d4.scs" section=mos
include "cr013g_2d5_v1d4.scs" section=mac

endsection ss_g

// *****************************  LIBRARY OF FNFP CORNER CASE  ******************************

section ff_g
parameters parn1=0
parameters parn2=0
parameters parp1=0
parameters parp2=0

parameters toxn=2.791e-09
parameters dxl=-3.14e-09
parameters dxw=5.09e-09
parameters cjn=1.307e-03
parameters cjswn=1.854e-10
parameters cjswgn=4.542e-10
parameters cgon=3.474e-10
parameters rshn=0
parameters hdifn=1.35e-07
parameters cgln=8.0e-11
parameters dvthn=-2.16e-02
parameters dwvthn=-3.75e-09
parameters dlvthn=-2.30e-09
parameters dpvthn=-2.20e-16
parameters dlvsatn=0.00e+00
parameters dpvsatn=9.00e-11
parameters dppclmn=0
parameters dk2n=-0.005
parameters dlk2n=-2.0e-9
parameters toxp=2.831e-09
parameters cjp=1.301e-03
parameters cjswp=8.820e-11
parameters cjswgp=4.078e-10
parameters cgop=2.395e-10
parameters rshp=0
parameters hdifp=1.35e-07
parameters cglp=9.0e-11
parameters dvthp=2.11e-02
parameters dlvthp=2.35e-09
parameters dwvthp=4.43e-09
parameters dpvthp=1.78e-16
parameters dlvsatp=-1.50e-04
parameters dpvsatp=-2.0e-11
parameters dk2p=-0.01
parameters dlk2p=-1.0e-9
include "cr013g_2d5_v1d4.scs" section=mos
include "cr013g_2d5_v1d4.scs" section=mac

endsection ff_g

// *****************************  LIBRARY OF SNFP CORNER CASE  ******************************

section sf_g
parameters parn1=0
parameters parn2=0
parameters parp1=0
parameters parp2=0

parameters toxn=2.810e-09
parameters dxl=0
parameters dxw=0
parameters cjn=1.445e-03
parameters cjswn=2.266e-10
parameters cjswgn=5.551e-10
parameters cgon=3.300e-10
parameters rshn=0
parameters hdifn=1.35e-07
parameters cgln=8.0e-11
parameters dvthn=2.15e-02
parameters dwvthn=3.31e-09
parameters dlvthn=2.27e-09
parameters dpvthn=2.34e-16
parameters dlvsatn=0
parameters dpvsatn=0
parameters dppclmn=0
parameters dk2n=0.005
parameters dlk2n=2.0e-9
parameters toxp=2.850e-09
parameters cjp=1.301e-03
parameters cjswp=8.820e-11
parameters cjswgp=4.078e-10
parameters cgop=2.270e-10
parameters rshp=0
parameters hdifp=1.35e-07
parameters cglp=9.0e-11
parameters dvthp=2.18e-02
parameters dlvthp=2.20e-09
parameters dwvthp=4.19e-09
parameters dpvthp=1.90e-16
parameters dlvsatp=0
parameters dpvsatp=0
parameters dk2p=-0.01
parameters dlk2p=-1.0e-9
include "cr013g_2d5_v1d4.scs" section=mos
include "cr013g_2d5_v1d4.scs" section=mac

endsection sf_g

// *****************************  LIBRARY OF FNSP CORNER CASE  ******************************

section fs_g
parameters parn1=0
parameters parn2=0
parameters parp1=0
parameters parp2=0

parameters toxn=2.810e-09
parameters dxl=0
parameters dxw=0
parameters cjn=1.307e-03
parameters cjswn=1.854e-10
parameters cjswgn=4.542e-10
parameters cgon=3.300e-10
parameters rshn=0
parameters hdifn=1.35e-07
parameters cgln=8.0e-11
parameters dvthn=-2.20e-02
parameters dwvthn=-3.31e-09
parameters dlvthn=-2.27e-09
parameters dpvthn=-2.35e-16
parameters dlvsatn=0
parameters dpvsatn=0
parameters dppclmn=0
parameters dk2n=-0.005
parameters dlk2n=-2.0e-9
parameters toxp=2.850e-09
parameters cjp=1.438e-03
parameters cjswp=1.078e-10
parameters cjswgp=4.984e-10
parameters cgop=2.270e-10
parameters rshp=0
parameters hdifp=1.35e-07
parameters cglp=9.0e-11
parameters dvthp=-2.15e-02
parameters dlvthp=-2.20e-09
parameters dwvthp=-4.19e-09
parameters dpvthp=-1.91e-16
parameters dlvsatp=0
parameters dpvsatp=0
parameters dk2p=0.01
parameters dlk2p=1.0e-9
include "cr013g_2d5_v1d4.scs" section=mos
include "cr013g_2d5_v1d4.scs" section=mac

endsection fs_g

// ******************************************************************************************

section mac

inline subckt nch_g ( n11 n2 n33 n4 )
parameters l=1u w=1u multi=1 factor=1 sa=0.35u sb=0.35u ad=2 * hdifn / factor
+ * w as=2 * hdifn / factor * w pd=2 * (2 * hdifn / factor + w) ps=2 * (2 * hdifn
+ / factor + w) nrd=hdifn / factor / w nrs=hdifn / factor / w w1=(w * factor + 0.015e-6
+ + dxw) * multi l1=l * factor - 0.02e-6 + dxl tcc=1 + 1.7e-3 * (temp - 25) area=w1
+ * 2.5e-9 * 1e4 * tcc tox=(toxn - 8.3e-10) * 1e2 jf=2.704e-08 ef=2.623e+07 varaf=
+ - 0.18955 * log(l1) + 0.99251 varbf=0.54 * ef * tox jr=5.065e-7 er=7.43e6 varar=
+ - 0.072266 * log(l1) + 16.394 varbr=0.52 * er * tox forward_eff=area * jf * exp(
+ - ef * tox * varaf) / pow(tox,2.5) reverse_eff=area * jr * exp( - er * tox * varar)
+ / pow(tox,2.5) tmp1=varbf + 2.0 tmp2=varbr + 2.0

nch_g ( n1 n2 n3 n4 ) nch w=w l=l ad=ad as=as pd=pd ps=ps nrd=nrd nrs=nrs m=multi
+ sa=sa sb=sb

gdf1 ( n2 n1 ) bsource i =forward_eff * pow((abs(v(n2,n1)) + v(n2,n1)) / 2,tmp1)
+ - reverse_eff * pow((abs(v(n2,n1)) - v(n2,n1)) / 2,tmp2) + 1e-18 * v(n2,n1)

gdf2 ( n2 n3 ) bsource i =forward_eff * pow((abs(v(n2,n3)) + v(n2,n3)) / 2,tmp1)
+ - reverse_eff * pow((abs(v(n2,n3)) - v(n2,n3)) / 2,tmp2) + 1e-18 * v(n2,n3)

rdn ( n1 n11 ) resistor r=6.6 * nrd / multi
rsn ( n3 n33 ) resistor r=6.6 * nrs / multi
ends nch_g

inline subckt pch_g ( p11 p2 p33 p4 )
parameters l=1u w=1u multi=1 factor=1 sa=0.35u sb=0.35u ad=2 * hdifp / factor
+ * w as=2 * hdifp / factor * w pd=2 * (2 * hdifp / factor + w) ps=2 * (2 * hdifp
+ / factor + w) nrd=hdifp / factor / w nrs=hdifp / factor / w jf=1.1575e-07 ef=7.127e+06
+ jr=2.8e-8 er=4.373e6 w1=(w * factor + 0.015e-6 + dxw) * multi l1=l * factor + dxl
+ - 0.02e-6 tox=(toxp - 8e-10) * 1e2 tcc=1 + 1.4e-3 * (temp - 25) area=w1 * 6.1e-9
+ * 1e4 * tcc varaf= - 0.70902 * log(l1) + 5.9821 varbf=1.2 * ef * tox varbr=0.52
+ * er * tox varar= - 0.31121 * log(l1) + 24.530 forward_eff=area * jf * exp( -
+ ef * tox * varaf) / pow(tox,2.5) reverse_eff=area * jr * exp( - er * tox * varar)
+ / pow(tox,2.5) tmp1=varbf + 2.0 tmp2=varbr + 2.0

pch_g ( p1 p2 p3 p4 ) pch w=w l=l ad=ad as=as pd=pd ps=ps nrd=nrd nrs=nrs m=multi
+ sa=sa sb=sb

gdf1 ( p1 p2 ) bsource i =forward_eff * pow((abs(v(p1,p2)) + v(p1,p2)) / 2,tmp1)
+ - reverse_eff * pow((abs(v(p1,p2)) - v(p1,p2)) / 2,tmp2) + 1e-18 * v(p1,p2)

gdf2 ( p3 p2 ) bsource i =forward_eff * pow((abs(v(p3,p2)) + v(p3,p2)) / 2,tmp1)
+ - reverse_eff * pow((abs(v(p3,p2)) - v(p3,p2)) / 2,tmp2) + 1e-18 * v(p3,p2)

rdp ( p1 p11 ) resistor r=7.2 * nrd / multi
rsp ( p3 p33 ) resistor r=7.2 * nrs / multi
ends pch_g
//
inline subckt nch_g_mis ( n11 n2 n33 n4 )
parameters l=1u w=1u factor=1 multi=1 sa=0.35u sb=0.35u ad=2 * hdifn / factor * w as=2
+ * hdifn / factor * w pd=2 * (2 * hdifn / factor + w) ps=2 * (2 * hdifn / factor +
+ w) nrd=hdifn / factor / w nrs=hdifn / factor / w w1=(w * factor + 0.015e-6 + dxw)
+ * multi l1=l * factor - 0.02e-6 + dxl tcc=1 + 1.7e-3 * (temp - 25) area=w1 *
+ 2.5e-9 * 1e4 * tcc tox=(toxn - 8.3e-10) * 1e2 jf=2.704e-08 ef=2.623e+07 varaf=
+ - 0.18955 * log(l1) + 0.99251 varbf=0.54 * ef * tox jr=5.065e-7 er=7.43e6 varar=
+ - 0.072266 * log(l1) + 16.394 varbr=0.52 * er * tox forward_eff=area * jf * exp(
+ - ef * tox * varaf) / pow(tox,2.5) reverse_eff=area * jr * exp( - er * tox * varar)
+ / pow(tox,2.5)

xmain ( n1 n2 n3 n4 ) nch_mis  w=w l=l ad=ad as=as pd=pd ps=ps nrd=nrd nrs=nrs multi=multi
+ sa=sa sb=sb

parameters tmp1=varbf + 2.0
parameters tmp2=varbr + 2.0
gdf1 ( n2 n1 ) bsource i =forward_eff * pow((abs(v(n2,n1)) + v(n2,n1)) / 2,tmp1)
+ - reverse_eff * pow((abs(v(n2,n1)) - v(n2,n1)) / 2,tmp2) + 1e-18 * v(n2,n1)

gdf2 ( n2 n3 ) bsource i =forward_eff * pow((abs(v(n2,n3)) + v(n2,n3)) / 2,tmp1)
+ - reverse_eff * pow((abs(v(n2,n3)) - v(n2,n3)) / 2,tmp2) + 1e-18 * v(n2,n3)

rdn ( n1 n11 ) resistor r=6.6 * nrd / multi
rsn ( n3 n33 ) resistor r=6.6 * nrs / multi
ends nch_g_mis

inline subckt pch_g_mis ( p11 p2 p33 p4 )
parameters l=1u w=1u factor=1 multi=1 sa=0.35u sb=0.35u ad=2 * hdifp / factor * w as=2
+ * hdifp / factor * w pd=2 * (2 * hdifp / factor + w) ps=2 * (2 * hdifp / factor +
+ w) nrd=hdifp / factor / w nrs=hdifp / factor / w jf=1.1575e-07 ef=7.127e+06 jr=2.8e-8
+ er=4.373e6 w1=(w * factor + 0.015e-6 + dxw) * multi l1=l * factor + dxl - 0.02e-6
+ tox=(toxp - 8e-10) * 1e2 tcc=1 + 1.4e-3 * (temp - 25) area=w1 * 6.1e-9 * 1e4
+ * tcc varaf= - 0.70902 * log(l1) + 5.9821 varbf=1.2 * ef * tox varbr=0.52 * er
+ * tox varar= - 0.31121 * log(l1) + 24.530 forward_eff=area * jf * exp( - ef *
+ tox * varaf) / pow(tox,2.5) reverse_eff=area * jr * exp( - er * tox * varar) /
+ pow(tox,2.5) tmp1=varbf + 2.0 tmp2=varbr + 2.0

xmain ( p1 p2 p3 p4 ) pch_mis  w=w l=l ad=ad as=as pd=pd ps=ps nrd=nrd nrs=nrs multi=multi
+ sa=sa sb=sb

gdf1 ( p1 p2 ) bsource i =forward_eff * pow((abs(v(p1,p2)) + v(p1,p2)) / 2,tmp1)
+ - reverse_eff * pow((abs(v(p1,p2)) - v(p1,p2)) / 2,tmp2) + 1e-18 * v(p1,p2)

gdf2 ( p3 p2 ) bsource i =forward_eff * pow((abs(v(p3,p2)) + v(p3,p2)) / 2,tmp1)
+ - reverse_eff * pow((abs(v(p3,p2)) - v(p3,p2)) / 2,tmp2) + 1e-18 * v(p3,p2)

rdp ( p1 p11 ) resistor r=7.2 * nrd / multi
rsp ( p3 p33 ) resistor r=7.2 * nrs / multi
ends pch_g_mis
endsection mac
//
//
// **************************************************************
//                                                              *
//                 2.5V STANDARD DEVICES LIB                      *
//                                                              *
// **************************************************************
// *****************************    LIBRARY OF TYPICAL CASE    ******************************

section tt_25
parameters parn1_25=0
parameters parn2_25=0
parameters parp1_25=0
parameters parp2_25=0
parameters toxn_25=5.83e-09
parameters dxl_25=0
parameters dxw_25=0
parameters dvthn_25=0
parameters dlvthn_25=0
parameters dwvthn_25=0
parameters dpvthn_25=0
parameters dlvsatn_25=0
parameters cjn_25=9.680e-04
parameters cjswn_25=9.500e-11
parameters cjswgn_25=1.794e-10
parameters cgon_25=2.675e-10
parameters hdifn_25=1.35e-07
parameters cgln_25=9.6e-11
parameters dk2n_25=0
parameters dlk2n_25=0
parameters toxp_25=5.87e-09
parameters dvthp_25=0
parameters dlvthp_25=0
parameters dwvthp_25=0
parameters dpvthp_25=0
parameters dlvsatp_25=0
parameters cjp_25=1.247e-03
parameters cjswp_25=7.700e-11
parameters cjswgp_25=1.630e-10
parameters cgop_25=2.008e-10
parameters hdifp_25=1.35e-07
parameters cglp_25=1.5e-10
parameters dk2p_25=0
parameters dlk2p_25=0
include "cr013g_2d5_v1d4.scs" section=mos_25

endsection tt_25

// *****************************  LIBRARY OF SNSP CORNER CASE  ******************************

section ss_25
parameters parn1_25=0
parameters parn2_25=0
parameters parp1_25=0
parameters parp2_25=0
parameters toxn_25=5.98e-09
parameters dxl_25=7.000e-09
parameters dxw_25=-7.000e-09
parameters dvthn_25=2.82e-02
parameters dlvthn_25=7.13e-09
parameters dwvthn_25=1.51e-09
parameters dpvthn_25=1.50e-16
parameters dlvsatn_25=0
parameters cjn_25=1.016e-03
parameters cjswn_25=1.045e-10
parameters cjswgn_25=1.973e-10
parameters cgon_25=2.534e-10
parameters hdifn_25=1.35e-07
parameters cgln_25=9.6e-11
parameters dk2n_25=0.005
parameters dlk2n_25=2.0e-9
parameters toxp_25=6.02e-09
parameters dvthp_25=-2.82e-02
parameters dlvthp_25=-3.50e-10
parameters dwvthp_25=-1.57e-09
parameters dpvthp_25=-2.73e-16
parameters dlvsatp_25=-3.39e-03
parameters cjp_25=1.309e-03
parameters cjswp_25=8.470e-11
parameters cjswgp_25=1.793e-10
parameters cgop_25=1.893e-10
parameters hdifp_25=1.35e-07
parameters cglp_25=1.5e-10
parameters dk2p_25=0.01
parameters dlk2p_25=1.0e-9
include "cr013g_2d5_v1d4.scs" section=mos_25

endsection ss_25

// *****************************  LIBRARY OF FNFP CORNER CASE  ******************************

section ff_25
parameters parn1_25=0
parameters parn2_25=0
parameters parp1_25=0
parameters parp2_25=0
parameters toxn_25=5.68e-09
parameters dxl_25=-7.000e-09
parameters dxw_25=7.000e-09
parameters dvthn_25=-2.88e-02
parameters dlvthn_25=-6.44e-09
parameters dwvthn_25=-1.59e-09
parameters dpvthn_25=-1.66e-16
parameters dlvsatn_25=0
parameters cjn_25=9.196e-04
parameters cjswn_25=8.550e-11
parameters cjswgn_25=1.615e-10
parameters cgon_25=2.816e-10
parameters hdifn_25=1.35e-07
parameters cgln_25=9.6e-11
parameters dk2n_25=-0.005
parameters dlk2n_25=-2.0e-9
parameters toxp_25=5.72e-09
parameters dvthp_25=2.85e-02
parameters dlvthp_25=2.40e-10
parameters dwvthp_25=1.68e-09
parameters dpvthp_25=2.78e-16
parameters dlvsatp_25=3.32e-03
parameters cjp_25=1.185e-03
parameters cjswp_25=6.930e-11
parameters cjswgp_25=1.467e-10
parameters cgop_25=2.123e-10
parameters hdifp_25=1.35e-07
parameters cglp_25=1.5e-10
parameters dk2p_25=-0.01
parameters dlk2p_25=-1.0e-9
include "cr013g_2d5_v1d4.scs" section=mos_25

endsection ff_25

// *****************************  LIBRARY OF SNFP CORNER CASE  ******************************

section sf_25
parameters parn1_25=0
parameters parn2_25=0
parameters parp1_25=0
parameters parp2_25=0
parameters toxn_25=5.83e-09
parameters dxl_25=0
parameters dxw_25=0
parameters dvthn_25=2.87e-02
parameters dlvthn_25=8.21e-09
parameters dwvthn_25=1.25e-09
parameters dpvthn_25=5.27e-18
parameters dlvsatn_25=0
parameters cjn_25=1.016e-03
parameters cjswn_25=1.045e-10
parameters cjswgn_25=1.973e-10
parameters cgon_25=2.675e-10
parameters hdifn_25=1.35e-07
parameters cgln_25=9.6e-11
parameters dk2n_25=0.005
parameters dlk2n_25=2.0e-9
parameters toxp_25=5.87e-09
parameters dvthp_25=2.93e-02
parameters dlvthp_25=1.56e-09
parameters dwvthp_25=1.50e-09
parameters dpvthp_25=2.16e-16
parameters dlvsatp_25=0
parameters cjp_25=1.185e-03
parameters cjswp_25=6.930e-11
parameters cjswgp_25=1.467e-10
parameters cgop_25=2.008e-10
parameters hdifp_25=1.35e-07
parameters cglp_25=1.5e-10
parameters dk2p_25=-0.01
parameters dlk2p_25=-1.0e-9
include "cr013g_2d5_v1d4.scs" section=mos_25

endsection sf_25

// *****************************  LIBRARY OF FNSP CORNER CASE  ******************************

section fs_25
parameters parn1_25=0
parameters parn2_25=0
parameters parp1_25=0
parameters parp2_25=0
parameters toxn_25=5.83e-09
parameters dxl_25=0
parameters dxw_25=0
parameters dvthn_25=-2.93e-02
parameters dlvthn_25=-8.18e-09
parameters dwvthn_25=-1.20e-09
parameters dpvthn_25=-1.67e-17
parameters dlvsatn_25=0
parameters cjn_25=9.196e-04
parameters cjswn_25=8.550e-11
parameters cjswgn_25=1.615e-10
parameters cgon_25=2.675e-10
parameters hdifn_25=1.35e-07
parameters cgln_25=9.6e-11
parameters dk2n_25=-0.005
parameters dlk2n_25=-2.0e-9
parameters toxp_25=5.87e-09
parameters dvthp_25=-2.89e-02
parameters dlvthp_25=-1.56e-09
parameters dwvthp_25=-1.51e-09
parameters dpvthp_25=-2.15e-16
parameters dlvsatp_25=0
parameters cjp_25=1.309e-03
parameters cjswp_25=8.470e-11
parameters cjswgp_25=1.793e-10
parameters cgop_25=2.008e-10
parameters hdifp_25=1.35e-07
parameters cglp_25=1.5e-10
parameters dk2p_25=0.01
parameters dlk2p_25=1.0e-9
include "cr013g_2d5_v1d4.scs" section=mos_25

endsection fs_25
//
//
//  *************************************************************
//                                                              *
//                    1.2V NATIVE NMOS DEVICES LIB              *
//                                                              *
//  *************************************************************
//  *************** CORNER_LIB OF TYPICAL MODEL ****************************
section tt_na
parameters toxn_na=2.81e-09
parameters cjn_na=0.0001239
parameters cjswn_na=1.727e-10
parameters cjswgn_na=2.559e-10
parameters cgon_na=5.335e-10
parameters rshn_na=6.6
parameters dvthn_na=0
parameters hdifn_na=1.35e-07
parameters dxl_na=0
parameters dxw_na=0
include "cr013g_2d5_v1d4.scs" section=mos_na
endsection tt_na
//  *************** CORNER_LIB OF SNSP MODEL ***************
section ss_na
parameters toxn_na=2.88e-09
parameters cjn_na=1.3010e-4
parameters cjswn_na=1.8997e-10
parameters cjswgn_na=2.8149e-10
parameters cgon_na=5.0740e-10
parameters rshn_na=6.6
parameters dvthn_na=0.10
parameters hdifn_na=1.35e-07
parameters dxl_na=6.67e-9
parameters dxw_na=-1.5e-8
include "cr013g_2d5_v1d4.scs" section=mos_na
endsection ss_na
//  *************** CORNER_LIB OF FNFP MODEL ***************
section ff_na
parameters toxn_na=2.74e-09
parameters cjn_na=1.1771e-4
parameters cjswn_na=1.5543e-10
parameters cjswgn_na=2.3031e-10
parameters cgon_na=5.5950e-10
parameters rshn_na=6.6
parameters dvthn_na=-0.10
parameters hdifn_na=1.35e-07
parameters dxl_na=-6.67e-9
parameters dxw_na=1.5e-8
include "cr013g_2d5_v1d4.scs" section=mos_na
endsection ff_na
//
//
//  *************** CORNER_LIB OF TYPICAL MODEL ****************************
section tt_na_g
parameters toxn_na=2.81e-09
parameters cjn_na=0.0001239
parameters cjswn_na=1.727e-10
parameters cjswgn_na=2.559e-10
parameters cgon_na=5.335e-10
parameters rshn_na=0
parameters dvthn_na=0
parameters hdifn_na=1.35e-07
parameters dxl_na=0
parameters dxw_na=0
include "cr013g_2d5_v1d4.scs" section=mos_na
include "cr013g_2d5_v1d4.scs" section=mac_na
endsection tt_na_g
//  *************** CORNER_LIB OF SNSP MODEL ***************
section ss_na_g
parameters toxn_na=2.88e-09
parameters cjn_na=1.3010e-4
parameters cjswn_na=1.8997e-10
parameters cjswgn_na=2.8149e-10
parameters cgon_na=5.0740e-10
parameters rshn_na=0
parameters dvthn_na=0.10
parameters hdifn_na=1.35e-07
parameters dxl_na=6.67e-9
parameters dxw_na=-1.5e-8
include "cr013g_2d5_v1d4.scs" section=mos_na
include "cr013g_2d5_v1d4.scs" section=mac_na
endsection ss_na_g
//  *************** CORNER_LIB OF FNFP MODEL ***************
section ff_na_g
parameters toxn_na=2.74e-09
parameters cjn_na=1.1771e-4
parameters cjswn_na=1.5543e-10
parameters cjswgn_na=2.3031e-10
parameters cgon_na=5.5950e-10
parameters rshn_na=0
parameters dvthn_na=-0.10
parameters hdifn_na=1.35e-07
parameters dxl_na=-6.67e-9
parameters dxw_na=1.5e-8
include "cr013g_2d5_v1d4.scs" section=mos_na
include "cr013g_2d5_v1d4.scs" section=mac_na
endsection ff_na_g

section mac_na
//
inline subckt nch_na_g ( n11 n2 n33 n4 )
parameters l=1u w=1u factor=1 multi=1 ad=2 * hdifn_na / factor * w as=2 * hdifn_na /
+ factor * w pd=2 * (2 * hdifn_na / factor + w) ps=2 * (2 * hdifn_na / factor + w)
+ nrd=hdifn_na / factor / w nrs=hdifn_na / factor / w w1=(w * factor + 0.015e-6 + dxw_na)
+ * multi l1=l * factor - 0.02e-6 + dxl_na tcc=1 + 1.7e-3 * (temp - 25) area=w1
+ * 2.5e-9 * 1e4 * tcc tox=(toxn_na - 8.3e-10) * 1e2 jf=2.704e-08 ef=2.623e+07 varaf=
+ - 0.18955 * log(l1) + 0.99251 varbf=0.54 * ef * tox jr=5.065e-7 er=7.43e6 varar=
+ - 0.072266 * log(l1) + 16.394 varbr=0.52 * er * tox forward_eff=area * jf * exp(
+ - ef * tox * varaf) / pow(tox,2.5) reverse_eff=area * jr * exp( - er * tox * varar)
+ / pow(tox,2.5) tmp1=varbf + 2.0 tmp2=varbr + 2.0

nch_na_g ( n1 n2 n3 n4 ) nch_na w=w l=l ad=ad as=as pd=pd ps=ps nrd=nrd nrs=nrs m=multi

gdf1 ( n2 n1 ) bsource i =forward_eff * pow((abs(v(n2,n1)) + v(n2,n1)) / 2,tmp1)
+ - reverse_eff * pow((abs(v(n2,n1)) - v(n2,n1)) / 2,tmp2) + 1e-18 * v(n2,n1)

gdf2 ( n2 n3 ) bsource i =forward_eff * pow((abs(v(n2,n3)) + v(n2,n3)) / 2,tmp1)
+ - reverse_eff * pow((abs(v(n2,n3)) - v(n2,n3)) / 2,tmp2) + 1e-18 * v(n2,n3)

rdn ( n1 n11 ) resistor r=6.6 * nrd / multi
rsn ( n3 n33 ) resistor r=6.6 * nrs / multi
ends nch_na_g

endsection mac_na
//
//
// **************************************************************
//                                                              *
//                    1.2V LOW Vt DEVICES LIB                   *
//                                                              *
// **************************************************************
// *****************************    LIBRARY OF TYPICAL CASE    ******************************

section tt_lvt
parameters parn1_lvt=0
parameters parn2_lvt=0
parameters parp1_lvt=0
parameters parp2_lvt=0

parameters toxn_lvt=2.810e-09
parameters dxl_lvt=0
parameters dxw_lvt=0
parameters cjn_lvt=1.097e-03
parameters cjswn_lvt=1.620e-10
parameters cjswgn_lvt=4.872e-10
parameters cgon_lvt=3.400e-10
parameters rshn_lvt=6.6
parameters hdifn_lvt=1.35e-07
parameters dvthn_lvt=0
parameters dlvthn_lvt=0
parameters dwvthn_lvt=0
parameters dpvthn_lvt=0
parameters dlvsatn_lvt=0
parameters dpvsatn_lvt=0
parameters dlpclmn_lvt=0
parameters drdswn_lvt=0
parameters cgln_lvt=5.80e-11
parameters dk2n_lvt=0
parameters dlk2n_lvt=0
parameters toxp_lvt=2.850e-09
parameters cjp_lvt=1.290e-03
parameters cjswp_lvt=8.933e-11
parameters cjswgp_lvt=4.165e-10
parameters cgop_lvt=2.500e-10
parameters rshp_lvt=7.2
parameters hdifp_lvt=1.35e-07
parameters dvthp_lvt=0
parameters dlvthp_lvt=0
parameters dwvthp_lvt=0
parameters dpvthp_lvt=0
parameters dlvsatp_lvt=0
parameters dpvsatp_lvt=0
parameters dlpclmp_lvt=0
parameters dwpclmp_lvt=0
parameters drdswp_lvt=0
parameters cglp_lvt=1.08e-10
parameters dpkt1p_lvt=0
parameters dk2p_lvt=0
parameters dlk2p_lvt=0
include "cr013g_2d5_v1d4.scs" section=mos_lvt

endsection tt_lvt

// *****************************  LIBRARY OF SNSP CORNER CASE  ******************************

section ss_lvt
parameters parn1_lvt=0
parameters parn2_lvt=0
parameters parp1_lvt=0
parameters parp2_lvt=0

parameters toxn_lvt=2.829e-09
parameters dxl_lvt=3.14e-09
parameters dxw_lvt=-1.00e-08
parameters cjn_lvt=1.152e-03
parameters cjswn_lvt=1.782e-10
parameters cjswgn_lvt=5.360e-10
parameters cgon_lvt=3.225e-10
parameters rshn_lvt=6.6
parameters hdifn_lvt=1.35e-07
parameters dvthn_lvt=2.10e-02
parameters dlvthn_lvt=3.13e-09
parameters dwvthn_lvt=4.30e-09
parameters dpvthn_lvt=8.70e-17
parameters dlvsatn_lvt=-6.640e-04
parameters dpvsatn_lvt=-1.38e-10
parameters dlpclmn_lvt=0
parameters drdswn_lvt=0
parameters cgln_lvt=5.80e-11
parameters dk2n_lvt=0.005
parameters dlk2n_lvt=2.0e-9
parameters toxp_lvt=2.869e-09
parameters cjp_lvt=1.355e-03
parameters cjswp_lvt=9.827e-11
parameters cjswgp_lvt=4.582e-10
parameters cgop_lvt=2.360e-10
parameters rshp_lvt=7.2
parameters hdifp_lvt=1.35e-07
parameters dvthp_lvt=-2.10e-02
parameters dlvthp_lvt=-3.10e-09
parameters dwvthp_lvt=-4.80e-09
parameters dpvthp_lvt=-3.02e-16
parameters dlvsatp_lvt=-5.50e-04
parameters dpvsatp_lvt=2.50e-11
parameters dlpclmp_lvt=0
parameters dwpclmp_lvt=0
parameters drdswp_lvt=0
parameters cglp_lvt=1.08e-10
parameters dpkt1p_lvt=2.0e-15
parameters dk2p_lvt=0.01
parameters dlk2p_lvt=1.0e-9
include "cr013g_2d5_v1d4.scs" section=mos_lvt

endsection ss_lvt

// *****************************  LIBRARY OF FNFP CORNER CASE  ******************************

section ff_lvt
parameters parn1_lvt=0
parameters parn2_lvt=0
parameters parp1_lvt=0
parameters parp2_lvt=0

parameters toxn_lvt=2.791e-09
parameters dxl_lvt=-3.14e-09
parameters dxw_lvt=5.09e-09
parameters cjn_lvt=1.043e-03
parameters cjswn_lvt=1.458e-10
parameters cjswgn_lvt=4.385e-10
parameters cgon_lvt=3.575e-10
parameters rshn_lvt=6.6
parameters hdifn_lvt=1.35e-07
parameters dvthn_lvt=-2.15e-02
parameters dlvthn_lvt=-3.00e-09
parameters dwvthn_lvt=-4.32e-09
parameters dpvthn_lvt=-1.04e-16
parameters dlvsatn_lvt=4.323e-04
parameters dpvsatn_lvt=1.68e-10
parameters dlpclmn_lvt=0
parameters drdswn_lvt=0
parameters cgln_lvt=5.80e-11
parameters dk2n_lvt=-0.005
parameters dlk2n_lvt=-2.0e-9
parameters toxp_lvt=2.831e-09
parameters cjp_lvt=1.226e-03
parameters cjswp_lvt=8.040e-11
parameters cjswgp_lvt=3.749e-10
parameters cgop_lvt=2.639e-10
parameters rshp_lvt=7.2
parameters hdifp_lvt=1.35e-07
parameters dvthp_lvt=2.15e-02
parameters dlvthp_lvt=2.92e-09
parameters dwvthp_lvt=5.35e-09
parameters dpvthp_lvt=3.17e-16
parameters dlvsatp_lvt=3.00e-04
parameters dpvsatp_lvt=-2.00e-11
parameters dlpclmp_lvt=0
parameters dwpclmp_lvt=0
parameters drdswp_lvt=0
parameters cglp_lvt=1.08e-10
parameters dpkt1p_lvt=0
parameters dk2p_lvt=-0.01
parameters dlk2p_lvt=-1.0e-9
include "cr013g_2d5_v1d4.scs" section=mos_lvt

endsection ff_lvt

// *****************************  LIBRARY OF SNFP CORNER CASE  ******************************

section sf_lvt
parameters parn1_lvt=0
parameters parn2_lvt=0
parameters parp1_lvt=0
parameters parp2_lvt=0

parameters toxn_lvt=2.810e-09
parameters dxl_lvt=0
parameters dxw_lvt=0
parameters cjn_lvt=1.152e-03
parameters cjswn_lvt=1.782e-10
parameters cjswgn_lvt=5.360e-10
parameters cgon_lvt=3.400e-10
parameters rshn_lvt=6.6
parameters hdifn_lvt=1.35e-07
parameters dvthn_lvt=2.14e-02
parameters dlvthn_lvt=2.87e-09
parameters dwvthn_lvt=4.01e-09
parameters dpvthn_lvt=1.17e-16
parameters dlvsatn_lvt=0
parameters dpvsatn_lvt=0
parameters dlpclmn_lvt=0
parameters drdswn_lvt=0
parameters cgln_lvt=5.80e-11
parameters dk2n_lvt=0.005
parameters dlk2n_lvt=2.0e-9
parameters toxp_lvt=2.850e-09
parameters cjp_lvt=1.226e-03
parameters cjswp_lvt=8.040e-11
parameters cjswgp_lvt=3.749e-10
parameters cgop_lvt=2.500e-10
parameters rshp_lvt=7.2
parameters hdifp_lvt=1.35e-07
parameters dvthp_lvt=2.22e-02
parameters dlvthp_lvt=2.57e-09
parameters dwvthp_lvt=5.14e-09
parameters dpvthp_lvt=3.24e-16
parameters dlvsatp_lvt=0
parameters dpvsatp_lvt=0
parameters dlpclmp_lvt=0
parameters dwpclmp_lvt=0
parameters drdswp_lvt=0
parameters cglp_lvt=1.08e-10
parameters dpkt1p_lvt=0
parameters dk2p_lvt=-0.01
parameters dlk2p_lvt=-1.0e-9
include "cr013g_2d5_v1d4.scs" section=mos_lvt

endsection sf_lvt

// *****************************  LIBRARY OF FNSP CORNER CASE  ******************************

section fs_lvt
parameters parn1_lvt=0
parameters parn2_lvt=0
parameters parp1_lvt=0
parameters parp2_lvt=0

parameters toxn_lvt=2.810e-09
parameters dxl_lvt=0
parameters dxw_lvt=0
parameters cjn_lvt=1.043e-03
parameters cjswn_lvt=1.458e-10
parameters cjswgn_lvt=4.385e-10
parameters cgon_lvt=3.400e-10
parameters rshn_lvt=6.6
parameters hdifn_lvt=1.35e-07
parameters dvthn_lvt=-2.18e-02
parameters dlvthn_lvt=-2.89e-09
parameters dwvthn_lvt=-3.97e-09
parameters dpvthn_lvt=-1.21e-16
parameters dlvsatn_lvt=0
parameters dpvsatn_lvt=0
parameters dlpclmn_lvt=0
parameters drdswn_lvt=0
parameters cgln_lvt=5.80e-11
parameters dk2n_lvt=-0.005
parameters dlk2n_lvt=-2.0e-9
parameters toxp_lvt=2.850e-09
parameters cjp_lvt=1.355e-03
parameters cjswp_lvt=9.827e-11
parameters cjswgp_lvt=4.582e-10
parameters cgop_lvt=2.500e-10
parameters rshp_lvt=7.2
parameters hdifp_lvt=1.35e-07
parameters dvthp_lvt=-2.17e-02
parameters dlvthp_lvt=-2.58e-09
parameters dwvthp_lvt=-5.15e-09
parameters dpvthp_lvt=-3.25e-16
parameters dlvsatp_lvt=0
parameters dpvsatp_lvt=0
parameters dlpclmp_lvt=0
parameters dwpclmp_lvt=0
parameters drdswp_lvt=0
parameters cglp_lvt=1.08e-10
parameters dpkt1p_lvt=1.5e-15
parameters dk2p_lvt=0.01
parameters dlk2p_lvt=1.0e-9
include "cr013g_2d5_v1d4.scs" section=mos_lvt

endsection fs_lvt

// *****************************    LIBRARY OF TYPICAL CASE    ******************************

section tt_lvt_g
parameters parn1_lvt=0
parameters parn2_lvt=0
parameters parp1_lvt=0
parameters parp2_lvt=0

parameters toxn_lvt=2.810e-09
parameters dxl_lvt=0
parameters dxw_lvt=0
parameters cjn_lvt=1.097e-03
parameters cjswn_lvt=1.620e-10
parameters cjswgn_lvt=4.872e-10
parameters cgon_lvt=3.400e-10
parameters rshn_lvt=0
parameters hdifn_lvt=1.35e-07
parameters dvthn_lvt=0
parameters dlvthn_lvt=0
parameters dwvthn_lvt=0
parameters dpvthn_lvt=0
parameters dlvsatn_lvt=0
parameters dpvsatn_lvt=0
parameters dlpclmn_lvt=0
parameters drdswn_lvt=0
parameters cgln_lvt=5.80e-11
parameters dk2n_lvt=0
parameters dlk2n_lvt=0
parameters toxp_lvt=2.850e-09
parameters cjp_lvt=1.290e-03
parameters cjswp_lvt=8.933e-11
parameters cjswgp_lvt=4.165e-10
parameters cgop_lvt=2.500e-10
parameters rshp_lvt=0
parameters hdifp_lvt=1.35e-07
parameters dvthp_lvt=0
parameters dlvthp_lvt=0
parameters dwvthp_lvt=0
parameters dpvthp_lvt=0
parameters dlvsatp_lvt=0
parameters dpvsatp_lvt=0
parameters dlpclmp_lvt=0
parameters dwpclmp_lvt=0
parameters drdswp_lvt=0
parameters cglp_lvt=1.08e-10
parameters dpkt1p_lvt=0
parameters dk2p_lvt=0
parameters dlk2p_lvt=0
include "cr013g_2d5_v1d4.scs" section=mos_lvt
include "cr013g_2d5_v1d4.scs" section=mac_lvt

endsection tt_lvt_g

// *****************************  LIBRARY OF SNSP CORNER CASE  ******************************

section ss_lvt_g
parameters parn1_lvt=0
parameters parn2_lvt=0
parameters parp1_lvt=0
parameters parp2_lvt=0

parameters toxn_lvt=2.829e-09
parameters dxl_lvt=3.14e-09
parameters dxw_lvt=-1.00e-08
parameters cjn_lvt=1.152e-03
parameters cjswn_lvt=1.782e-10
parameters cjswgn_lvt=5.360e-10
parameters cgon_lvt=3.225e-10
parameters rshn_lvt=0
parameters hdifn_lvt=1.35e-07
parameters dvthn_lvt=2.10e-02
parameters dlvthn_lvt=3.13e-09
parameters dwvthn_lvt=4.30e-09
parameters dpvthn_lvt=8.70e-17
parameters dlvsatn_lvt=-6.640e-04
parameters dpvsatn_lvt=-1.38e-10
parameters dlpclmn_lvt=0
parameters drdswn_lvt=0
parameters cgln_lvt=5.80e-11
parameters dk2n_lvt=0.005
parameters dlk2n_lvt=2.0e-9
parameters toxp_lvt=2.869e-09
parameters cjp_lvt=1.355e-03
parameters cjswp_lvt=9.827e-11
parameters cjswgp_lvt=4.582e-10
parameters cgop_lvt=2.360e-10
parameters rshp_lvt=0
parameters hdifp_lvt=1.35e-07
parameters dvthp_lvt=-2.10e-02
parameters dlvthp_lvt=-3.10e-09
parameters dwvthp_lvt=-4.80e-09
parameters dpvthp_lvt=-3.02e-16
parameters dlvsatp_lvt=-5.50e-04
parameters dpvsatp_lvt=2.50e-11
parameters dlpclmp_lvt=0
parameters dwpclmp_lvt=0
parameters drdswp_lvt=0
parameters cglp_lvt=1.08e-10
parameters dpkt1p_lvt=2.0e-15
parameters dk2p_lvt=0.01
parameters dlk2p_lvt=1.0e-9
include "cr013g_2d5_v1d4.scs" section=mos_lvt
include "cr013g_2d5_v1d4.scs" section=mac_lvt

endsection ss_lvt_g

// *****************************  LIBRARY OF FNFP CORNER CASE  ******************************

section ff_lvt_g
parameters parn1_lvt=0
parameters parn2_lvt=0
parameters parp1_lvt=0
parameters parp2_lvt=0

parameters toxn_lvt=2.791e-09
parameters dxl_lvt=-3.14e-09
parameters dxw_lvt=5.09e-09
parameters cjn_lvt=1.043e-03
parameters cjswn_lvt=1.458e-10
parameters cjswgn_lvt=4.385e-10
parameters cgon_lvt=3.575e-10
parameters rshn_lvt=0
parameters hdifn_lvt=1.35e-07
parameters dvthn_lvt=-2.15e-02
parameters dlvthn_lvt=-3.00e-09
parameters dwvthn_lvt=-4.32e-09
parameters dpvthn_lvt=-1.04e-16
parameters dlvsatn_lvt=4.323e-04
parameters dpvsatn_lvt=1.68e-10
parameters dlpclmn_lvt=0
parameters drdswn_lvt=0
parameters cgln_lvt=5.80e-11
parameters dk2n_lvt=-0.005
parameters dlk2n_lvt=-2.0e-9
parameters toxp_lvt=2.831e-09
parameters cjp_lvt=1.226e-03
parameters cjswp_lvt=8.040e-11
parameters cjswgp_lvt=3.749e-10
parameters cgop_lvt=2.639e-10
parameters rshp_lvt=0
parameters hdifp_lvt=1.35e-07
parameters dvthp_lvt=2.15e-02
parameters dlvthp_lvt=2.92e-09
parameters dwvthp_lvt=5.35e-09
parameters dpvthp_lvt=3.17e-16
parameters dlvsatp_lvt=3.00e-04
parameters dpvsatp_lvt=-2.00e-11
parameters dlpclmp_lvt=0
parameters dwpclmp_lvt=0
parameters drdswp_lvt=0
parameters cglp_lvt=1.08e-10
parameters dpkt1p_lvt=0
parameters dk2p_lvt=-0.01
parameters dlk2p_lvt=-1.0e-9
include "cr013g_2d5_v1d4.scs" section=mos_lvt
include "cr013g_2d5_v1d4.scs" section=mac_lvt

endsection ff_lvt_g

// *****************************  LIBRARY OF SNFP CORNER CASE  ******************************

section sf_lvt_g
parameters parn1_lvt=0
parameters parn2_lvt=0
parameters parp1_lvt=0
parameters parp2_lvt=0

parameters toxn_lvt=2.810e-09
parameters dxl_lvt=0
parameters dxw_lvt=0
parameters cjn_lvt=1.152e-03
parameters cjswn_lvt=1.782e-10
parameters cjswgn_lvt=5.360e-10
parameters cgon_lvt=3.400e-10
parameters rshn_lvt=0
parameters hdifn_lvt=1.35e-07
parameters dvthn_lvt=2.14e-02
parameters dlvthn_lvt=2.87e-09
parameters dwvthn_lvt=4.01e-09
parameters dpvthn_lvt=1.17e-16
parameters dlvsatn_lvt=0
parameters dpvsatn_lvt=0
parameters dlpclmn_lvt=0
parameters drdswn_lvt=0
parameters cgln_lvt=5.80e-11
parameters dk2n_lvt=0.005
parameters dlk2n_lvt=2.0e-9
parameters toxp_lvt=2.850e-09
parameters cjp_lvt=1.226e-03
parameters cjswp_lvt=8.040e-11
parameters cjswgp_lvt=3.749e-10
parameters cgop_lvt=2.500e-10
parameters rshp_lvt=0
parameters hdifp_lvt=1.35e-07
parameters dvthp_lvt=2.22e-02
parameters dlvthp_lvt=2.57e-09
parameters dwvthp_lvt=5.14e-09
parameters dpvthp_lvt=3.24e-16
parameters dlvsatp_lvt=0
parameters dpvsatp_lvt=0
parameters dlpclmp_lvt=0
parameters dwpclmp_lvt=0
parameters drdswp_lvt=0
parameters cglp_lvt=1.08e-10
parameters dpkt1p_lvt=0
parameters dk2p_lvt=-0.01
parameters dlk2p_lvt=-1.0e-9
include "cr013g_2d5_v1d4.scs" section=mos_lvt
include "cr013g_2d5_v1d4.scs" section=mac_lvt

endsection sf_lvt_g

// *****************************  LIBRARY OF FNSP CORNER CASE  ******************************

section fs_lvt_g
parameters parn1_lvt=0
parameters parn2_lvt=0
parameters parp1_lvt=0
parameters parp2_lvt=0

parameters toxn_lvt=2.810e-09
parameters dxl_lvt=0
parameters dxw_lvt=0
parameters cjn_lvt=1.043e-03
parameters cjswn_lvt=1.458e-10
parameters cjswgn_lvt=4.385e-10
parameters cgon_lvt=3.400e-10
parameters rshn_lvt=0
parameters hdifn_lvt=1.35e-07
parameters dvthn_lvt=-2.18e-02
parameters dlvthn_lvt=-2.89e-09
parameters dwvthn_lvt=-3.97e-09
parameters dpvthn_lvt=-1.21e-16
parameters dlvsatn_lvt=0
parameters dpvsatn_lvt=0
parameters dlpclmn_lvt=0
parameters drdswn_lvt=0
parameters cgln_lvt=5.80e-11
parameters dk2n_lvt=-0.005
parameters dlk2n_lvt=-2.0e-9
parameters toxp_lvt=2.850e-09
parameters cjp_lvt=1.355e-03
parameters cjswp_lvt=9.827e-11
parameters cjswgp_lvt=4.582e-10
parameters cgop_lvt=2.500e-10
parameters rshp_lvt=0
parameters hdifp_lvt=1.35e-07
parameters dvthp_lvt=-2.17e-02
parameters dlvthp_lvt=-2.58e-09
parameters dwvthp_lvt=-5.15e-09
parameters dpvthp_lvt=-3.25e-16
parameters dlvsatp_lvt=0
parameters dpvsatp_lvt=0
parameters dlpclmp_lvt=0
parameters dwpclmp_lvt=0
parameters drdswp_lvt=0
parameters cglp_lvt=1.08e-10
parameters dpkt1p_lvt=1.5e-15
parameters dk2p_lvt=0.01
parameters dlk2p_lvt=1.0e-9
include "cr013g_2d5_v1d4.scs" section=mos_lvt
include "cr013g_2d5_v1d4.scs" section=mac_lvt

endsection fs_lvt_g

// ******************************************************************************************
//

section mac_lvt

inline subckt nch_lvt_g ( n11 n2 n33 n4 )
parameters l=1u w=1u multi=1 factor=1 sa=0.35u sb=0.35u ad=2 * hdifn_lvt /
+ factor * w as=2 * hdifn_lvt / factor * w pd=2 * (2 * hdifn_lvt / factor + w) ps=2
+ * (2 * hdifn_lvt / factor + w) nrd=hdifn_lvt / factor / w nrs=hdifn_lvt / factor
+ / w w1=(w * factor + 0.015e-6 + dxw_lvt) * multi l1=l * factor - 0.02e-6 + dxl_lvt
+ tcc=1 + 1.7e-3 * (temp - 25) area=w1 * 2.5e-9 * 1e4 * tcc tox=(toxn_lvt - 8.3e-10)
+ * 1e2 jf=2.704e-08 ef=2.623e+07 varaf= - 0.18955 * log(l1) + 0.99251 varbf=0.54
+ * ef * tox jr=5.065e-7 er=7.43e6 varar= - 0.072266 * log(l1) + 16.394 varbr=0.52
+ * er * tox forward_eff=area * jf * exp( - ef * tox * varaf) / pow(tox,2.5) reverse_eff=area
+ * jr * exp( - er * tox * varar) / pow(tox,2.5) tmp1=varbf + 2.0 tmp2=varbr + 2.0

nch_lvt_g ( n1 n2 n3 n4 ) nch_lvt w=w l=l ad=ad as=as pd=pd ps=ps nrd=nrd nrs=nrs m=multi
+ sa=sa sb=sb

gdf1 ( n2 n1 ) bsource i =forward_eff * pow((abs(v(n2,n1)) + v(n2,n1)) / 2,tmp1)
+ - reverse_eff * pow((abs(v(n2,n1)) - v(n2,n1)) / 2,tmp2) + 1e-18 * v(n2,n1)

gdf2 ( n2 n3 ) bsource i =forward_eff * pow((abs(v(n2,n3)) + v(n2,n3)) / 2,tmp1)
+ - reverse_eff * pow((abs(v(n2,n3)) - v(n2,n3)) / 2,tmp2) + 1e-18 * v(n2,n3)

rdn ( n1 n11 ) resistor r=6.6 * nrd / multi
rsn ( n3 n33 ) resistor r=6.6 * nrs / multi
ends nch_lvt_g

inline subckt pch_lvt_g ( p11 p2 p33 p4 )
parameters l=1u w=1u multi=1 factor=1 sa=0.35u sb=0.35u ad=2 * hdifp_lvt /
+ factor * w as=2 * hdifp_lvt / factor * w pd=2 * (2 * hdifp_lvt / factor + w) ps=2
+ * (2 * hdifp_lvt / factor + w) nrd=hdifp_lvt / factor / w nrs=hdifp_lvt / factor
+ / w jf=1.1575e-07 ef=7.127e+06 jr=2.8e-8 er=4.373e6 w1=(w * factor + 0.015e-6
+ + dxw_lvt) * multi l1=l * factor + dxl_lvt - 0.02e-6 tox=(toxp_lvt - 8e-10) * 1e2
+ tcc=1 + 1.4e-3 * (temp - 25) area=w1 * 6.1e-9 * 1e4 * tcc varaf= - 0.70902 *
+ log(l1) + 5.9821 varbf=1.2 * ef * tox varbr=0.52 * er * tox varar= - 0.31121 *
+ log(l1) + 24.530 forward_eff=area * jf * exp( - ef * tox * varaf) / pow(tox,2.5)
+ reverse_eff=area * jr * exp( - er * tox * varar) / pow(tox,2.5) tmp1=varbf + 2.0
+ tmp2=varbr + 2.0

pch_lvt_g ( p1 p2 p3 p4 ) pch_lvt w=w l=l ad=ad as=as pd=pd ps=ps nrd=nrd nrs=nrs m=multi
+ sa=sa sb=sb

gdf1 ( p1 p2 ) bsource i =forward_eff * pow((abs(v(p1,p2)) + v(p1,p2)) / 2,tmp1)
+ - reverse_eff * pow((abs(v(p1,p2)) - v(p1,p2)) / 2,tmp2) + 1e-18 * v(p1,p2)

gdf2 ( p3 p2 ) bsource i =forward_eff * pow((abs(v(p3,p2)) + v(p3,p2)) / 2,tmp1)
+ - reverse_eff * pow((abs(v(p3,p2)) - v(p3,p2)) / 2,tmp2) + 1e-18 * v(p3,p2)

rdp ( p1 p11 ) resistor r=7.2 * nrd / multi
rsp ( p3 p33 ) resistor r=7.2 * nrs / multi
ends pch_lvt_g
//
inline subckt nch_lvt_g_mis ( n11 n2 n33 n4 )
parameters l=1u w=1u factor=1 multi=1 sa=0.35u sb=0.35u ad=2 * hdifn_lvt / factor *
+ w as=2 * hdifn_lvt / factor * w pd=2 * (2 * hdifn_lvt / factor + w) ps=2 * (2 *
+ hdifn_lvt / factor + w) nrd=hdifn_lvt / factor / w nrs=hdifn_lvt / factor / w w1=(w
+ * factor + 0.015e-6 + dxw_lvt) * multi l1=l * factor - 0.02e-6 + dxl_lvt tcc=1 +
+ 1.7e-3 * (temp - 25) area=w1 * 2.5e-9 * 1e4 * tcc tox=(toxn_lvt - 8.3e-10) *
+ 1e2 jf=2.704e-08 ef=2.623e+07 varaf= - 0.18955 * log(l1) + 0.99251 varbf=0.54
+ * ef * tox jr=5.065e-7 er=7.43e6 varar= - 0.072266 * log(l1) + 16.394 varbr=0.52
+ * er * tox forward_eff=area * jf * exp( - ef * tox * varaf) / pow(tox,2.5) reverse_eff=area
+ * jr * exp( - er * tox * varar) / pow(tox,2.5) tmp1=varbf + 2.0 tmp2=varbr + 2.0
xmain ( n1 n2 n3 n4 ) nch_lvt_mis  w=w l=l ad=ad as=as pd=pd ps=ps nrd=nrd nrs=nrs
+ multi=multi sa=sa sb=sb
gdf1 ( n2 n1 ) bsource i =forward_eff * pow((abs(v(n2,n1)) + v(n2,n1)) / 2,tmp1)
+ - reverse_eff * pow((abs(v(n2,n1)) - v(n2,n1)) / 2,tmp2) + 1e-18 * v(n2,n1)
gdf2 ( n2 n3 ) bsource i =forward_eff * pow((abs(v(n2,n3)) + v(n2,n3)) / 2,tmp1)
+ - reverse_eff * pow((abs(v(n2,n3)) - v(n2,n3)) / 2,tmp2) + 1e-18 * v(n2,n3)
rdn ( n1 n11 ) resistor r=6.6 * nrd / multi
rsn ( n3 n33 ) resistor r=6.6 * nrs / multi
ends nch_lvt_g_mis
inline subckt pch_lvt_g_mis ( p11 p2 p33 p4 )
parameters l=1u w=1u factor=1 multi=1 sa=0.35u sb=0.35u ad=2 * hdifp_lvt / factor *
+ w as=2 * hdifp_lvt / factor * w pd=2 * (2 * hdifp_lvt / factor + w) ps=2 * (2 *
+ hdifp_lvt / factor + w) nrd=hdifp_lvt / factor / w nrs=hdifp_lvt / factor / w jf=1.1575e-07
+ ef=7.127e+06 jr=2.8e-8 er=4.373e6 w1=(w * factor + 0.015e-6 + dxw_lvt) * multi
+ l1=l * factor + dxl_lvt - 0.02e-6 tox=(toxp_lvt - 8e-10) * 1e2 tcc=1 + 1.4e-3 *
+ (temp - 25) area=w1 * 6.1e-9 * 1e4 * tcc varaf= - 0.70902 * log(l1) + 5.9821
+ varbf=1.2 * ef * tox varbr=0.52 * er * tox varar= - 0.31121 * log(l1) + 24.530
+ forward_eff=area * jf * exp( - ef * tox * varaf) / pow(tox,2.5) reverse_eff=area
+ * jr * exp( - er * tox * varar) / pow(tox,2.5) tmp1=varbf + 2.0 tmp2=varbr + 2.0
xmain ( p1 p2 p3 p4 ) pch_lvt_mis  w=w l=l ad=ad as=as pd=pd ps=ps nrd=nrd nrs=nrs
+ multi=multi sa=sa sb=sb
gdf1 ( p1 p2 ) bsource i =forward_eff * pow((abs(v(p1,p2)) + v(p1,p2)) / 2,tmp1)
+ - reverse_eff * pow((abs(v(p1,p2)) - v(p1,p2)) / 2,tmp2) + 1e-18 * v(p1,p2)
gdf2 ( p3 p2 ) bsource i =forward_eff * pow((abs(v(p3,p2)) + v(p3,p2)) / 2,tmp1)
+ - reverse_eff * pow((abs(v(p3,p2)) - v(p3,p2)) / 2,tmp2) + 1e-18 * v(p3,p2)
rdp ( p1 p11 ) resistor r=7.2 * nrd / multi
rsp ( p3 p33 ) resistor r=7.2 * nrs / multi
ends pch_lvt_g_mis
endsection mac_lvt
//
//
//  *************************************************************
//                                                              *
//                      2.5V LVT DEVICES LIB                    *
//                                                              *
//  *************************************************************
//  *************** CORNER_LIB OF TYPICAL MODEL ***************

section tt_lvt25
parameters parn1_lvt25=0
parameters parn2_lvt25=0
parameters parp1_lvt25=0
parameters parp2_lvt25=0
parameters toxn_lvt25=5.83e-09
parameters toxp_lvt25=5.87e-09
parameters dvthn_lvt25=0
parameters dvthp_lvt25=0
parameters dxl_lvt25=0
parameters dxw_lvt25=0
parameters cjn_lvt25=9.9226e-04
parameters cjp_lvt25=9.1400e-04
parameters cjswn_lvt25=2.3321e-10
parameters cjswp_lvt25=7.6093e-11
parameters cjswgn_lvt25=2.1402e-10
parameters cjswgp_lvt25=9.9183e-11
parameters cgon_lvt25=2.8338e-10
parameters cgop_lvt25=2.6001e-10
parameters hdifn_lvt25=1.4e-07
parameters hdifp_lvt25=1.4e-07
parameters cgln_lvt25=0.721e-10
parameters cglp_lvt25=0.82e-10
include "cr013g_2d5_v1d4.scs" section=mos_lvt25
endsection tt_lvt25
//  *************** CORNER_LIB OF SNSP MODEL ***************
section ss_lvt25
parameters parn1_lvt25=0
parameters parn2_lvt25=0
parameters parp1_lvt25=0
parameters parp2_lvt25=0
parameters toxn_lvt25=6.10e-09
parameters toxp_lvt25=6.14e-09
parameters dvthn_lvt25=0.1
parameters dvthp_lvt25=-0.09
parameters dxl_lvt25=1.33e-08
parameters dxw_lvt25=-1.5e-08
parameters cjn_lvt25=1.042e-03
parameters cjp_lvt25=9.597e-04
parameters cjswn_lvt25=2.565e-10
parameters cjswp_lvt25=8.370e-11
parameters cjswgn_lvt25=2.354e-10
parameters cjswgp_lvt25=1.091e-10
parameters cgon_lvt25=2.6878e-10
parameters cgop_lvt25=2.4640e-10
parameters hdifn_lvt25=1.4e-07
parameters hdifp_lvt25=1.4e-07
parameters cgln_lvt25=0.721e-10
parameters cglp_lvt25=0.82e-10
include "cr013g_2d5_v1d4.scs" section=mos_lvt25
endsection ss_lvt25
//  *************** CORNER_LIB OF FNFP MODEL ***************
section ff_lvt25
parameters parn1_lvt25=0
parameters parn2_lvt25=0
parameters parp1_lvt25=0
parameters parp2_lvt25=0
parameters toxn_lvt25=5.56e-09
parameters toxp_lvt25=5.60e-09
parameters dvthn_lvt25=-0.1
parameters dvthp_lvt25=0.08
parameters dxl_lvt25=-1.33e-08
parameters dxw_lvt25=1.5e-08
parameters cjn_lvt25=9.426e-04
parameters cjp_lvt25=8.683e-04
parameters cjswn_lvt25=2.099e-10
parameters cjswp_lvt25=6.848e-11
parameters cjswgn_lvt25=1.926e-10
parameters cjswgp_lvt25=8.926e-11
parameters cgon_lvt25=2.9798e-10
parameters cgop_lvt25=2.7362e-10
parameters hdifn_lvt25=1.4e-07
parameters hdifp_lvt25=1.4e-07
parameters cgln_lvt25=0.721e-10
parameters cglp_lvt25=0.82e-10
include "cr013g_2d5_v1d4.scs" section=mos_lvt25
endsection ff_lvt25
//  *************** CORNER_LIB OF SNFP MODEL ***************
section sf_lvt25
parameters parn1_lvt25=0
parameters parn2_lvt25=0
parameters parp1_lvt25=0
parameters parp2_lvt25=0
parameters toxn_lvt25=5.83e-09
parameters toxp_lvt25=5.87e-09
parameters dvthn_lvt25=0.1
parameters dvthp_lvt25=0.08
parameters dxl_lvt25=0
parameters dxw_lvt25=0
parameters cjn_lvt25=1.042e-03
parameters cjp_lvt25=8.683e-04
parameters cjswn_lvt25=2.565e-10
parameters cjswp_lvt25=6.848e-11
parameters cjswgn_lvt25=2.354e-10
parameters cjswgp_lvt25=8.926e-11
parameters cgon_lvt25=2.8338e-10
parameters cgop_lvt25=2.6001e-10
parameters hdifn_lvt25=1.4e-07
parameters hdifp_lvt25=1.4e-07
parameters cgln_lvt25=0.721e-10
parameters cglp_lvt25=0.82e-10
include "cr013g_2d5_v1d4.scs" section=mos_lvt25
endsection sf_lvt25
//  *************** CORNER_LIB OF FNSP MODEL ***************
section fs_lvt25
parameters parn1_lvt25=0
parameters parn2_lvt25=0
parameters parp1_lvt25=0
parameters parp2_lvt25=0
parameters toxn_lvt25=5.83e-09
parameters toxp_lvt25=5.87e-09
parameters dvthn_lvt25=-0.1
parameters dvthp_lvt25=-0.09
parameters dxl_lvt25=0
parameters dxw_lvt25=0
parameters cjn_lvt25=9.426e-04
parameters cjp_lvt25=9.597e-04
parameters cjswn_lvt25=2.099e-10
parameters cjswp_lvt25=8.370e-11
parameters cjswgn_lvt25=1.926e-10
parameters cjswgp_lvt25=1.091e-10
parameters cgon_lvt25=2.8338e-10
parameters cgop_lvt25=2.6001e-10
parameters hdifn_lvt25=1.4e-07
parameters hdifp_lvt25=1.4e-07
parameters cgln_lvt25=0.721e-10
parameters cglp_lvt25=0.82e-10
include "cr013g_2d5_v1d4.scs" section=mos_lvt25
endsection fs_lvt25
//
//
// **************************************************************
//                                                              *
//                    1.2V HIGH Vt DEVICES LIB                  *
//                                                              *
// **************************************************************
// *****************************    LIBRARY OF TYPICAL CASE    ******************************

section tt_hvt
parameters parn1_hvt=0
parameters parn2_hvt=0
parameters parp1_hvt=0
parameters parp2_hvt=0
parameters toxn_hvt=2.810e-09
parameters dxl_hvt=0
parameters dxw_hvt=0
parameters cjn_hvt=1.727e-03
parameters cjswn_hvt=2.450e-10
parameters cjswgn_hvt=4.558e-10
parameters cgon_hvt=3.050e-10
parameters jswn_hvt=5.98e-11
parameters rshn_hvt=6.6
parameters hdifn_hvt=1.35e-07
parameters dvthn_hvt=0
parameters dlvthn_hvt=0
parameters dwvthn_hvt=0
parameters dpvthn_hvt=0
parameters dlvsatn_hvt=0
parameters dpvsatn_hvt=0
parameters cgln_hvt=1.0e-10
parameters dk2n_hvt=0
parameters dlk2n_hvt=0
parameters toxp_hvt=2.850e-09
parameters cjp_hvt=1.427e-03
parameters cjswp_hvt=1.090e-10
parameters cjswgp_hvt=4.040e-10
parameters cgop_hvt=1.920e-10
parameters jswp_hvt=5.0e-12
parameters rshp_hvt=7.2
parameters hdifp_hvt=1.35e-07
parameters dvthp_hvt=0
parameters dlvthp_hvt=0
parameters dwvthp_hvt=0
parameters dpvthp_hvt=0
parameters dlvsatp_hvt=0
parameters dpvsatp_hvt=0
parameters cglp_hvt=1.2e-10
parameters dkt2p_hvt=0
parameters dk2p_hvt=0
parameters dlk2p_hvt=0
include "cr013g_2d5_v1d4.scs" section=mos_hvt

endsection tt_hvt

// *****************************  LIBRARY OF SNSP CORNER CASE  ******************************

section ss_hvt
parameters parn1_hvt=0
parameters parn2_hvt=0
parameters parp1_hvt=0
parameters parp2_hvt=0
parameters toxn_hvt=2.829e-09
parameters dxl_hvt=3.14e-09
parameters dxw_hvt=-1.00e-08
parameters cjn_hvt=1.813e-03
parameters cjswn_hvt=2.695e-10
parameters cjswgn_hvt=5.014e-10
parameters cgon_hvt=2.884e-10
parameters jswn_hvt=5.98e-11
parameters rshn_hvt=6.6
parameters hdifn_hvt=1.35e-07
parameters dvthn_hvt=2.21e-02
parameters dlvthn_hvt=1.69e-09
parameters dwvthn_hvt=3.73e-09
parameters dpvthn_hvt=2.780e-16
parameters dlvsatn_hvt=-4.90e-04
parameters dpvsatn_hvt=-1.50e-11
parameters cgln_hvt=1.0e-10
parameters dk2n_hvt=0.005
parameters dlk2n_hvt=2.0e-9
parameters toxp_hvt=2.869e-09
parameters cjp_hvt=1.498e-03
parameters cjswp_hvt=1.199e-10
parameters cjswgp_hvt=4.444e-10
parameters cgop_hvt=1.807e-10
parameters jswp_hvt=5.0e-12
parameters rshp_hvt=7.2
parameters hdifp_hvt=1.35e-07
parameters dvthp_hvt=-2.23e-02
parameters dlvthp_hvt=-1.10e-09
parameters dwvthp_hvt=-4.90e-09
parameters dpvthp_hvt=-3.50e-16
parameters dlvsatp_hvt=-1.3e-03
parameters dpvsatp_hvt=3.2e-10
parameters cglp_hvt=1.2e-10
parameters dkt2p_hvt=-0.02
parameters dk2p_hvt=0.01
parameters dlk2p_hvt=1.0e-9
include "cr013g_2d5_v1d4.scs" section=mos_hvt

endsection ss_hvt

// *****************************  LIBRARY OF FNFP CORNER CASE  ******************************

section ff_hvt
parameters parn1_hvt=0
parameters parn2_hvt=0
parameters parp1_hvt=0
parameters parp2_hvt=0
parameters toxn_hvt=2.791e-09
parameters dxl_hvt=-3.14e-09
parameters dxw_hvt=5.09e-09
parameters cjn_hvt=1.641e-03
parameters cjswn_hvt=2.205e-10
parameters cjswgn_hvt=4.102e-10
parameters cgon_hvt=3.215e-10
parameters jswn_hvt=5.98e-11
parameters rshn_hvt=6.6
parameters hdifn_hvt=1.35e-07
parameters dvthn_hvt=-2.26e-02
parameters dlvthn_hvt=-1.59e-09
parameters dwvthn_hvt=-3.95e-09
parameters dpvthn_hvt=-2.700e-16
parameters dlvsatn_hvt=2.80e-04
parameters dpvsatn_hvt=1.50e-11
parameters cgln_hvt=1.0e-10
parameters dk2n_hvt=-0.005
parameters dlk2n_hvt=-2.0e-9
parameters toxp_hvt=2.831e-09
parameters cjp_hvt=1.356e-03
parameters cjswp_hvt=9.810e-11
parameters cjswgp_hvt=3.636e-10
parameters cgop_hvt=2.033e-10
parameters jswp_hvt=5.0e-12
parameters rshp_hvt=7.2
parameters hdifp_hvt=1.35e-07
parameters dvthp_hvt=2.28e-02
parameters dlvthp_hvt=1.00e-09
parameters dwvthp_hvt=5.28e-09
parameters dpvthp_hvt=3.40e-16
parameters dlvsatp_hvt=6.0e-04
parameters dpvsatp_hvt=-2.1e-10
parameters cglp_hvt=1.2e-10
parameters dkt2p_hvt=0
parameters dk2p_hvt=-0.01
parameters dlk2p_hvt=-1.0e-9
include "cr013g_2d5_v1d4.scs" section=mos_hvt

endsection ff_hvt

// *****************************  LIBRARY OF SNFP CORNER CASE  ******************************

section sf_hvt
parameters parn1_hvt=0
parameters parn2_hvt=0
parameters parp1_hvt=0
parameters parp2_hvt=0
parameters toxn_hvt=2.810e-09
parameters dxl_hvt=0
parameters dxw_hvt=0
parameters cjn_hvt=1.813e-03
parameters cjswn_hvt=2.695e-10
parameters cjswgn_hvt=5.014e-10
parameters cgon_hvt=3.050e-10
parameters jswn_hvt=5.98e-11
parameters rshn_hvt=6.6
parameters hdifn_hvt=1.35e-07
parameters dvthn_hvt=2.21e-02
parameters dlvthn_hvt=1.67e-09
parameters dwvthn_hvt=3.66e-09
parameters dpvthn_hvt=2.640e-16
parameters dlvsatn_hvt=0
parameters dpvsatn_hvt=0
parameters cgln_hvt=1.0e-10
parameters dk2n_hvt=0.005
parameters dlk2n_hvt=2.0e-9
parameters toxp_hvt=2.850e-09
parameters cjp_hvt=1.356e-03
parameters cjswp_hvt=9.810e-11
parameters cjswgp_hvt=3.636e-10
parameters cgop_hvt=1.920e-10
parameters jswp_hvt=5.0e-12
parameters rshp_hvt=7.2
parameters hdifp_hvt=1.35e-07
parameters dvthp_hvt=2.32e-02
parameters dlvthp_hvt=9.66e-10
parameters dwvthp_hvt=4.98e-09
parameters dpvthp_hvt=3.30e-16
parameters dlvsatp_hvt=0
parameters dpvsatp_hvt=0
parameters cglp_hvt=1.2e-10
parameters dkt2p_hvt=0
parameters dk2p_hvt=-0.01
parameters dlk2p_hvt=-1.0e-9
include "cr013g_2d5_v1d4.scs" section=mos_hvt

endsection sf_hvt

// *****************************  LIBRARY OF FNSP CORNER CASE  ******************************

section fs_hvt
parameters parn1_hvt=0
parameters parn2_hvt=0
parameters parp1_hvt=0
parameters parp2_hvt=0
parameters toxn_hvt=2.810e-09
parameters dxl_hvt=0
parameters dxw_hvt=0
parameters cjn_hvt=1.641e-03
parameters cjswn_hvt=2.205e-10
parameters cjswgn_hvt=4.102e-10
parameters cgon_hvt=3.050e-10
parameters jswn_hvt=5.98e-11
parameters rshn_hvt=6.6
parameters hdifn_hvt=1.35e-07
parameters dvthn_hvt=-2.26e-02
parameters dlvthn_hvt=-1.66e-09
parameters dwvthn_hvt=-3.67e-09
parameters dpvthn_hvt=-2.676e-16
parameters dlvsatn_hvt=0
parameters dpvsatn_hvt=0
parameters cgln_hvt=1.0e-10
parameters dk2n_hvt=-0.005
parameters dlk2n_hvt=-2.0e-9
parameters toxp_hvt=2.850e-09
parameters cjp_hvt=1.498e-03
parameters cjswp_hvt=1.199e-10
parameters cjswgp_hvt=4.444e-10
parameters cgop_hvt=1.920e-10
parameters jswp_hvt=5.0e-12
parameters rshp_hvt=7.2
parameters hdifp_hvt=1.35e-07
parameters dvthp_hvt=-2.27e-02
parameters dlvthp_hvt=-1.00e-09
parameters dwvthp_hvt=-4.99e-09
parameters dpvthp_hvt=-3.24e-16
parameters dlvsatp_hvt=0
parameters dpvsatp_hvt=0
parameters cglp_hvt=1.2e-10
parameters dkt2p_hvt=-0.02
parameters dk2p_hvt=0.01
parameters dlk2p_hvt=1.0e-9
include "cr013g_2d5_v1d4.scs" section=mos_hvt

endsection fs_hvt

//

// ******************************************************************************************
// *****************************    LIBRARY OF TYPICAL CASE    ******************************

section tt_hvt_g
parameters parn1_hvt=0
parameters parn2_hvt=0
parameters parp1_hvt=0
parameters parp2_hvt=0
parameters toxn_hvt=2.810e-09
parameters dxl_hvt=0
parameters dxw_hvt=0
parameters cjn_hvt=1.727e-03
parameters cjswn_hvt=2.450e-10
parameters cjswgn_hvt=4.558e-10
parameters cgon_hvt=3.050e-10
parameters jswn_hvt=5.98e-11
parameters rshn_hvt=0
parameters hdifn_hvt=1.35e-07
parameters dvthn_hvt=0
parameters dlvthn_hvt=0
parameters dwvthn_hvt=0
parameters dpvthn_hvt=0
parameters dlvsatn_hvt=0
parameters dpvsatn_hvt=0
parameters cgln_hvt=1.0e-10
parameters dk2n_hvt=0
parameters dlk2n_hvt=0
parameters toxp_hvt=2.850e-09
parameters cjp_hvt=1.427e-03
parameters cjswp_hvt=1.090e-10
parameters cjswgp_hvt=4.040e-10
parameters cgop_hvt=1.920e-10
parameters jswp_hvt=5.0e-12
parameters rshp_hvt=0
parameters hdifp_hvt=1.35e-07
parameters dvthp_hvt=0
parameters dlvthp_hvt=0
parameters dwvthp_hvt=0
parameters dpvthp_hvt=0
parameters dlvsatp_hvt=0
parameters dpvsatp_hvt=0
parameters cglp_hvt=1.2e-10
parameters dkt2p_hvt=0
parameters dk2p_hvt=0
parameters dlk2p_hvt=0
include "cr013g_2d5_v1d4.scs" section=mos_hvt
include "cr013g_2d5_v1d4.scs" section=mac_hvt

endsection tt_hvt_g

// *****************************  LIBRARY OF SNSP CORNER CASE  ******************************

section ss_hvt_g
parameters parn1_hvt=0
parameters parn2_hvt=0
parameters parp1_hvt=0
parameters parp2_hvt=0
parameters toxn_hvt=2.829e-09
parameters dxl_hvt=3.14e-09
parameters dxw_hvt=-1.00e-08
parameters cjn_hvt=1.813e-03
parameters cjswn_hvt=2.695e-10
parameters cjswgn_hvt=5.014e-10
parameters cgon_hvt=2.884e-10
parameters jswn_hvt=5.98e-11
parameters rshn_hvt=0
parameters hdifn_hvt=1.35e-07
parameters dvthn_hvt=2.21e-02
parameters dlvthn_hvt=1.69e-09
parameters dwvthn_hvt=3.73e-09
parameters dpvthn_hvt=2.780e-16
parameters dlvsatn_hvt=-4.90e-04
parameters dpvsatn_hvt=-1.50e-11
parameters cgln_hvt=1.0e-10
parameters dk2n_hvt=0.005
parameters dlk2n_hvt=2.0e-9
parameters toxp_hvt=2.869e-09
parameters cjp_hvt=1.498e-03
parameters cjswp_hvt=1.199e-10
parameters cjswgp_hvt=4.444e-10
parameters cgop_hvt=1.807e-10
parameters jswp_hvt=5.0e-12
parameters rshp_hvt=0
parameters hdifp_hvt=1.35e-07
parameters dvthp_hvt=-2.23e-02
parameters dlvthp_hvt=-1.10e-09
parameters dwvthp_hvt=-4.90e-09
parameters dpvthp_hvt=-3.50e-16
parameters dlvsatp_hvt=-1.3e-03
parameters dpvsatp_hvt=3.2e-10
parameters cglp_hvt=1.2e-10
parameters dkt2p_hvt=-0.02
parameters dk2p_hvt=0.01
parameters dlk2p_hvt=1.0e-9
include "cr013g_2d5_v1d4.scs" section=mos_hvt
include "cr013g_2d5_v1d4.scs" section=mac_hvt

endsection ss_hvt_g

// *****************************  LIBRARY OF FNFP CORNER CASE  ******************************

section ff_hvt_g
parameters parn1_hvt=0
parameters parn2_hvt=0
parameters parp1_hvt=0
parameters parp2_hvt=0
parameters toxn_hvt=2.791e-09
parameters dxl_hvt=-3.14e-09
parameters dxw_hvt=5.09e-09
parameters cjn_hvt=1.641e-03
parameters cjswn_hvt=2.205e-10
parameters cjswgn_hvt=4.102e-10
parameters cgon_hvt=3.215e-10
parameters jswn_hvt=5.98e-11
parameters rshn_hvt=0
parameters hdifn_hvt=1.35e-07
parameters dvthn_hvt=-2.26e-02
parameters dlvthn_hvt=-1.59e-09
parameters dwvthn_hvt=-3.95e-09
parameters dpvthn_hvt=-2.700e-16
parameters dlvsatn_hvt=2.80e-04
parameters dpvsatn_hvt=1.50e-11
parameters cgln_hvt=1.0e-10
parameters dk2n_hvt=-0.005
parameters dlk2n_hvt=-2.0e-9
parameters toxp_hvt=2.831e-09
parameters cjp_hvt=1.356e-03
parameters cjswp_hvt=9.810e-11
parameters cjswgp_hvt=3.636e-10
parameters cgop_hvt=2.033e-10
parameters jswp_hvt=5.0e-12
parameters rshp_hvt=0
parameters hdifp_hvt=1.35e-07
parameters dvthp_hvt=2.28e-02
parameters dlvthp_hvt=1.00e-09
parameters dwvthp_hvt=5.28e-09
parameters dpvthp_hvt=3.40e-16
parameters dlvsatp_hvt=6.0e-04
parameters dpvsatp_hvt=-2.1e-10
parameters cglp_hvt=1.2e-10
parameters dkt2p_hvt=0
parameters dk2p_hvt=-0.01
parameters dlk2p_hvt=-1.0e-9
include "cr013g_2d5_v1d4.scs" section=mos_hvt
include "cr013g_2d5_v1d4.scs" section=mac_hvt

endsection ff_hvt_g

// *****************************  LIBRARY OF SNFP CORNER CASE  ******************************

section sf_hvt_g
parameters parn1_hvt=0
parameters parn2_hvt=0
parameters parp1_hvt=0
parameters parp2_hvt=0
parameters toxn_hvt=2.810e-09
parameters dxl_hvt=0
parameters dxw_hvt=0
parameters cjn_hvt=1.813e-03
parameters cjswn_hvt=2.695e-10
parameters cjswgn_hvt=5.014e-10
parameters cgon_hvt=3.050e-10
parameters jswn_hvt=5.98e-11
parameters rshn_hvt=0
parameters hdifn_hvt=1.35e-07
parameters dvthn_hvt=2.21e-02
parameters dlvthn_hvt=1.67e-09
parameters dwvthn_hvt=3.66e-09
parameters dpvthn_hvt=2.640e-16
parameters dlvsatn_hvt=0
parameters dpvsatn_hvt=0
parameters cgln_hvt=1.0e-10
parameters dk2n_hvt=0.005
parameters dlk2n_hvt=2.0e-9
parameters toxp_hvt=2.850e-09
parameters cjp_hvt=1.356e-03
parameters cjswp_hvt=9.810e-11
parameters cjswgp_hvt=3.636e-10
parameters cgop_hvt=1.920e-10
parameters jswp_hvt=5.0e-12
parameters rshp_hvt=0
parameters hdifp_hvt=1.35e-07
parameters dvthp_hvt=2.32e-02
parameters dlvthp_hvt=9.66e-10
parameters dwvthp_hvt=4.98e-09
parameters dpvthp_hvt=3.30e-16
parameters dlvsatp_hvt=0
parameters dpvsatp_hvt=0
parameters cglp_hvt=1.2e-10
parameters dkt2p_hvt=0
parameters dk2p_hvt=-0.01
parameters dlk2p_hvt=-1.0e-9
include "cr013g_2d5_v1d4.scs" section=mos_hvt
include "cr013g_2d5_v1d4.scs" section=mac_hvt

endsection sf_hvt_g

// *****************************  LIBRARY OF FNSP CORNER CASE  ******************************

section fs_hvt_g
parameters parn1_hvt=0
parameters parn2_hvt=0
parameters parp1_hvt=0
parameters parp2_hvt=0
parameters toxn_hvt=2.810e-09
parameters dxl_hvt=0
parameters dxw_hvt=0
parameters cjn_hvt=1.641e-03
parameters cjswn_hvt=2.205e-10
parameters cjswgn_hvt=4.102e-10
parameters cgon_hvt=3.050e-10
parameters jswn_hvt=5.98e-11
parameters rshn_hvt=0
parameters hdifn_hvt=1.35e-07
parameters dvthn_hvt=-2.26e-02
parameters dlvthn_hvt=-1.66e-09
parameters dwvthn_hvt=-3.67e-09
parameters dpvthn_hvt=-2.676e-16
parameters dlvsatn_hvt=0
parameters dpvsatn_hvt=0
parameters cgln_hvt=1.0e-10
parameters dk2n_hvt=-0.005
parameters dlk2n_hvt=-2.0e-9
parameters toxp_hvt=2.850e-09
parameters cjp_hvt=1.498e-03
parameters cjswp_hvt=1.199e-10
parameters cjswgp_hvt=4.444e-10
parameters cgop_hvt=1.920e-10
parameters jswp_hvt=5.0e-12
parameters rshp_hvt=0
parameters hdifp_hvt=1.35e-07
parameters dvthp_hvt=-2.27e-02
parameters dlvthp_hvt=-1.00e-09
parameters dwvthp_hvt=-4.99e-09
parameters dpvthp_hvt=-3.24e-16
parameters dlvsatp_hvt=0
parameters dpvsatp_hvt=0
parameters cglp_hvt=1.2e-10
parameters dkt2p_hvt=-0.02
parameters dk2p_hvt=0.01
parameters dlk2p_hvt=1.0e-9
include "cr013g_2d5_v1d4.scs" section=mos_hvt
include "cr013g_2d5_v1d4.scs" section=mac_hvt

endsection fs_hvt_g

//

// ******************************************************************************************
//

section mac_hvt

inline subckt nch_hvt_g ( n11 n2 n33 n4 )
parameters l=1u w=1u multi=1 factor=1 sa=0.35u sb=0.35u ad=2 * hdifn_hvt /
+ factor * w as=2 * hdifn_hvt / factor * w pd=2 * (2 * hdifn_hvt / factor + w) ps=2
+ * (2 * hdifn_hvt / factor + w) nrd=hdifn_hvt / factor / w nrs=hdifn_hvt / factor
+ / w w1=(w * factor + 0.015e-6 + dxw_hvt) * multi l1=l * factor - 0.02e-6 + dxl_hvt
+ tcc=1 + 1.7e-3 * (temp - 25) area=w1 * 2.5e-9 * 1e4 * tcc tox=(toxn_hvt - 8.3e-10)
+ * 1e2 jf=2.704e-08 ef=2.623e+07 varaf= - 0.18955 * log(l1) + 0.99251 varbf=0.54
+ * ef * tox jr=5.065e-7 er=7.43e6 varar= - 0.072266 * log(l1) + 16.394 varbr=0.52
+ * er * tox forward_eff=area * jf * exp( - ef * tox * varaf) / pow(tox,2.5) reverse_eff=area
+ * jr * exp( - er * tox * varar) / pow(tox,2.5) tmp1=varbf + 2.0 tmp2=varbr + 2.0

nch_hvt_g ( n1 n2 n3 n4 ) nch_hvt w=w l=l ad=ad as=as pd=pd ps=ps nrd=nrd nrs=nrs m=multi
+ sa=sa sb=sb

gdf1 ( n2 n1 ) bsource i =forward_eff * pow((abs(v(n2,n1)) + v(n2,n1)) / 2,tmp1)
+ - reverse_eff * pow((abs(v(n2,n1)) - v(n2,n1)) / 2,tmp2) + 1e-18 * v(n2,n1)

gdf2 ( n2 n3 ) bsource i =forward_eff * pow((abs(v(n2,n3)) + v(n2,n3)) / 2,tmp1)
+ - reverse_eff * pow((abs(v(n2,n3)) - v(n2,n3)) / 2,tmp2) + 1e-18 * v(n2,n3)

rdn ( n1 n11 ) resistor r=6.6 * nrd / multi
rsn ( n3 n33 ) resistor r=6.6 * nrs / multi
ends nch_hvt_g

inline subckt pch_hvt_g ( p11 p2 p33 p4 )
parameters l=1u w=1u multi=1 factor=1 sa=0.35u sb=0.35u ad=2 * hdifp_hvt /
+ factor * w as=2 * hdifp_hvt / factor * w pd=2 * (2 * hdifp_hvt / factor + w) ps=2
+ * (2 * hdifp_hvt / factor + w) nrd=hdifp_hvt / factor / w nrs=hdifp_hvt / factor
+ / w jf=1.1575e-07 ef=7.127e+06 jr=2.8e-8 er=4.373e6 w1=(w * factor + 0.015e-6
+ + dxw_hvt) * multi l1=l * factor + dxl_hvt - 0.02e-6 tox=(toxp_hvt - 8e-10) * 1e2
+ tcc=1 + 1.4e-3 * (temp - 25) area=w1 * 6.1e-9 * 1e4 * tcc varaf= - 0.70902 *
+ log(l1) + 5.9821 varbf=1.2 * ef * tox varbr=0.52 * er * tox varar= - 0.31121 *
+ log(l1) + 24.530 forward_eff=area * jf * exp( - ef * tox * varaf) / pow(tox,2.5)
+ reverse_eff=area * jr * exp( - er * tox * varar) / pow(tox,2.5) tmp1=varbf + 2.0
+ tmp2=varbr + 2.0

pch_hvt_g ( p1 p2 p3 p4 ) pch_hvt w=w l=l ad=ad as=as pd=pd ps=ps nrd=nrd nrs=nrs m=multi
+ sa=sa sb=sb

gdf1 ( p1 p2 ) bsource i =forward_eff * pow((abs(v(p1,p2)) + v(p1,p2)) / 2,tmp1)
+ - reverse_eff * pow((abs(v(p1,p2)) - v(p1,p2)) / 2,tmp2) + 1e-18 * v(p1,p2)

gdf2 ( p3 p2 ) bsource i =forward_eff * pow((abs(v(p3,p2)) + v(p3,p2)) / 2,tmp1)
+ - reverse_eff * pow((abs(v(p3,p2)) - v(p3,p2)) / 2,tmp2) + 1e-18 * v(p3,p2)

rdp ( p1 p11 ) resistor r=7.2 * nrd / multi
rsp ( p3 p33 ) resistor r=7.2 * nrs / multi
ends pch_hvt_g
//
inline subckt nch_hvt_g_mis ( n11 n2 n33 n4 )
parameters l=1u w=1u factor=1 multi=1 sa=0.35u sb=0.35u ad=2 * hdifn_hvt / factor *
+ w as=2 * hdifn_hvt / factor * w pd=2 * (2 * hdifn_hvt / factor + w) ps=2 * (2 *
+ hdifn_hvt / factor + w) nrd=hdifn_hvt / factor / w nrs=hdifn_hvt / factor / w w1=(w
+ * factor + 0.015e-6 + dxw_hvt) * multi l1=l * factor - 0.02e-6 + dxl_hvt tcc=1 +
+ 1.7e-3 * (temp - 25) area=w1 * 2.5e-9 * 1e4 * tcc tox=(toxn_hvt - 8.3e-10) *
+ 1e2 jf=2.704e-08 ef=2.623e+07 varaf= - 0.18955 * log(l1) + 0.99251 varbf=0.54
+ * ef * tox jr=5.065e-7 er=7.43e6 varar= - 0.072266 * log(l1) + 16.394 varbr=0.52
+ * er * tox forward_eff=area * jf * exp( - ef * tox * varaf) / pow(tox,2.5) reverse_eff=area
+ * jr * exp( - er * tox * varar) / pow(tox,2.5) tmp1=varbf + 2.0 tmp2=varbr + 2.0
xmain ( n1 n2 n3 n4 ) nch_hvt_mis  w=w l=l ad=ad as=as pd=pd ps=ps nrd=nrd nrs=nrs
+ multi=multi sa=sa sb=sb
gdf1 ( n2 n1 ) bsource i =forward_eff * pow((abs(v(n2,n1)) + v(n2,n1)) / 2,tmp1)
+ - reverse_eff * pow((abs(v(n2,n1)) - v(n2,n1)) / 2,tmp2) + 1e-18 * v(n2,n1)
gdf2 ( n2 n3 ) bsource i =forward_eff * pow((abs(v(n2,n3)) + v(n2,n3)) / 2,tmp1)
+ - reverse_eff * pow((abs(v(n2,n3)) - v(n2,n3)) / 2,tmp2) + 1e-18 * v(n2,n3)
rdn ( n1 n11 ) resistor r=6.6 * nrd / multi
rsn ( n3 n33 ) resistor r=6.6 * nrs / multi
ends nch_hvt_g_mis
inline subckt pch_hvt_g_mis ( p11 p2 p33 p4 )
parameters l=1u w=1u factor=1 multi=1 sa=0.35u sb=0.35u ad=2 * hdifp_hvt / factor *
+ w as=2 * hdifp_hvt / factor * w pd=2 * (2 * hdifp_hvt / factor + w) ps=2 * (2 *
+ hdifp_hvt / factor + w) nrd=hdifp_hvt / factor / w nrs=hdifp_hvt / factor / w jf=1.1575e-07
+ ef=7.127e+06 jr=2.8e-8 er=4.373e6 w1=(w * factor + 0.015e-6 + dxw_hvt) * multi
+ l1=l * factor + dxl_hvt - 0.02e-6 tox=(toxp_hvt - 8e-10) * 1e2 tcc=1 + 1.4e-3 *
+ (temp - 25) area=w1 * 6.1e-9 * 1e4 * tcc varaf= - 0.70902 * log(l1) + 5.9821
+ varbf=1.2 * ef * tox varbr=0.52 * er * tox varar= - 0.31121 * log(l1) + 24.530
+ forward_eff=area * jf * exp( - ef * tox * varaf) / pow(tox,2.5) reverse_eff=area
+ * jr * exp( - er * tox * varar) / pow(tox,2.5) tmp1=varbf + 2.0 tmp2=varbr + 2.0
xmain ( p1 p2 p3 p4 ) pch_hvt_mis  w=w l=l ad=ad as=as pd=pd ps=ps nrd=nrd nrs=nrs
+ multi=multi sa=sa sb=sb
gdf1 ( p1 p2 ) bsource i =forward_eff * pow((abs(v(p1,p2)) + v(p1,p2)) / 2,tmp1)
+ - reverse_eff * pow((abs(v(p1,p2)) - v(p1,p2)) / 2,tmp2) + 1e-18 * v(p1,p2)
gdf2 ( p3 p2 ) bsource i =forward_eff * pow((abs(v(p3,p2)) + v(p3,p2)) / 2,tmp1)
+ - reverse_eff * pow((abs(v(p3,p2)) - v(p3,p2)) / 2,tmp2) + 1e-18 * v(p3,p2)
rdp ( p1 p11 ) resistor r=7.2 * nrd / multi
rsp ( p3 p33 ) resistor r=7.2 * nrs / multi
ends pch_hvt_g_mis
endsection mac_hvt

//
//
// **************************************************************
//                                                              *
//                    1.2V ULTRA HIGH Vt DEVICES LIB            *
//                                                              *
// **************************************************************
// *****************************    LIBRARY OF TYPICAL CASE    ******************************

section tt_uhvt
parameters toxn_uhvt=2.81e-09
parameters dxl_uhvt=0
parameters dxw_uhvt=0
parameters dvthn_uhvt=0
parameters dlvthn_uhvt=0
parameters dwvthn_uhvt=0
parameters dpvthn_uhvt=0
parameters dk2n_uhvt=0
parameters dwk2n_uhvt=0
parameters cjn_uhvt=1.323e-03
parameters cgln_uhvt=1.1e-10
parameters cjswn_uhvt=1.439e-10
parameters cjswgn_uhvt=5.076e-10
parameters cgon_uhvt=2.17e-10
parameters hdifn_uhvt=1.35e-07
parameters rshn_uhvt=6.6
parameters dlua1n_uhvt=0
parameters toxp_uhvt=2.85e-09
parameters dvthp_uhvt=0
parameters dlvthp_uhvt=0
parameters dwvthp_uhvt=0
parameters dpvthp_uhvt=0
parameters dk2p_uhvt=0
parameters dwk2p_uhvt=0
parameters cjp_uhvt=1.458e-03
parameters cjswp_uhvt=7.533e-11
parameters cjswgp_uhvt=5.523e-10
parameters cgop_uhvt=1.81e-10
parameters cglp_uhvt=1.2e-10
parameters hdifp_uhvt=1.35e-07
parameters rshp_uhvt=7.2
parameters dvsatp_uhvt=0
parameters dlkt2p_uhvt=0
include "cr013g_2d5_v1d4.scs" section=mos_uhvt

endsection tt_uhvt

// *****************************  LIBRARY OF SNSP CORNER CASE  ******************************

section ss_uhvt
parameters toxn_uhvt=2.877e-09
parameters dxl_uhvt=6.67e-09
parameters dxw_uhvt=-1.5e-08
parameters dvthn_uhvt=0.026
parameters dlvthn_uhvt=2.9e-09
parameters dwvthn_uhvt=3.8e-09
parameters dpvthn_uhvt=6e-17
parameters dk2n_uhvt=0.012
parameters dwk2n_uhvt=4e-09
parameters cjn_uhvt=1.389e-03
parameters cgln_uhvt=1.1e-10
parameters cjswn_uhvt=1.583e-10
parameters cjswgn_uhvt=5.584e-10
parameters cgon_uhvt=2.061e-10
parameters hdifn_uhvt=1.35e-07
parameters rshn_uhvt=6.6
parameters dlua1n_uhvt=2e-17
parameters toxp_uhvt=2.917e-09
parameters dvthp_uhvt=-0.026
parameters dlvthp_uhvt=-2.9e-09
parameters dwvthp_uhvt=-3e-09
parameters dpvthp_uhvt=-2.5e-16
parameters dk2p_uhvt=0.018
parameters dwk2p_uhvt=4.8e-09
parameters cjp_uhvt=1.531e-03
parameters cjswp_uhvt=8.286e-11
parameters cjswgp_uhvt=6.075e-10
parameters cgop_uhvt=1.72e-10
parameters cglp_uhvt=1.2e-10
parameters hdifp_uhvt=1.35e-07
parameters rshp_uhvt=7.2
parameters dvsatp_uhvt=30000
parameters dlkt2p_uhvt=-2.5e-9
include "cr013g_2d5_v1d4.scs" section=mos_uhvt

endsection ss_uhvt

// *****************************  LIBRARY OF FNFP CORNER CASE  ******************************

section ff_uhvt
parameters toxn_uhvt=2.743e-09
parameters dxl_uhvt=-6.67e-09
parameters dxw_uhvt=1.5e-08
parameters dvthn_uhvt=-0.026
parameters dlvthn_uhvt=-2.8e-09
parameters dwvthn_uhvt=-4.2e-09
parameters dpvthn_uhvt=-8e-17
parameters dk2n_uhvt=-0.012
parameters dwk2n_uhvt=-4.5e-09
parameters cjn_uhvt=1.257e-03
parameters cgln_uhvt=1.1e-10
parameters cjswn_uhvt=1.295e-10
parameters cjswgn_uhvt=4.568e-10
parameters cgon_uhvt=2.279e-10
parameters hdifn_uhvt=1.35e-07
parameters rshn_uhvt=6.6
parameters dlua1n_uhvt=0
parameters toxp_uhvt=2.783e-09
parameters dvthp_uhvt=0.026
parameters dlvthp_uhvt=2.6e-09
parameters dwvthp_uhvt=3.5e-09
parameters dpvthp_uhvt=3e-16
parameters dk2p_uhvt=-0.018
parameters dwk2p_uhvt=-5e-09
parameters cjp_uhvt=1.385e-03
parameters cjswp_uhvt=6.780e-11
parameters cjswgp_uhvt=4.971e-10
parameters cgop_uhvt=1.901e-10
parameters cglp_uhvt=1.2e-10
parameters hdifp_uhvt=1.35e-07
parameters rshp_uhvt=7.2
parameters dvsatp_uhvt=-28000
parameters dlkt2p_uhvt=0
include "cr013g_2d5_v1d4.scs" section=mos_uhvt

endsection ff_uhvt

// *****************************  LIBRARY OF SNFP CORNER CASE  ******************************

section sf_uhvt
parameters toxn_uhvt=2.81e-09
parameters dxl_uhvt=0
parameters dxw_uhvt=0
parameters dvthn_uhvt=0.026
parameters dlvthn_uhvt=1.5e-09
parameters dwvthn_uhvt=3.8e-09
parameters dpvthn_uhvt=6e-17
parameters dk2n_uhvt=0
parameters dwk2n_uhvt=0
parameters cjn_uhvt=1.389e-03
parameters cgln_uhvt=1.1e-10
parameters cjswn_uhvt=1.583e-10
parameters cjswgn_uhvt=5.584e-10
parameters cgon_uhvt=2.17e-10
parameters hdifn_uhvt=1.35e-07
parameters rshn_uhvt=6.6
parameters dlua1n_uhvt=1.1e-16
parameters toxp_uhvt=2.85e-09
parameters dvthp_uhvt=0.026
parameters dlvthp_uhvt=2.0e-09
parameters dwvthp_uhvt=3.5e-09
parameters dpvthp_uhvt=3e-16
parameters dk2p_uhvt=0
parameters dwk2p_uhvt=0
parameters cjp_uhvt=1.385e-03
parameters cjswp_uhvt=6.780e-11
parameters cjswgp_uhvt=4.971e-10
parameters cgop_uhvt=1.81e-10
parameters cglp_uhvt=1.2e-10
parameters hdifp_uhvt=1.35e-07
parameters rshp_uhvt=7.2
parameters dvsatp_uhvt=-28000
parameters dlkt2p_uhvt=0
include "cr013g_2d5_v1d4.scs" section=mos_uhvt

endsection sf_uhvt

// *****************************  LIBRARY OF FNSP CORNER CASE  ******************************

section fs_uhvt
parameters toxn_uhvt=2.81e-09
parameters dxl_uhvt=0
parameters dxw_uhvt=0
parameters dvthn_uhvt=-0.026
parameters dlvthn_uhvt=-1.5e-09
parameters dwvthn_uhvt=-4.2e-09
parameters dpvthn_uhvt=-8e-17
parameters dk2n_uhvt=0
parameters dwk2n_uhvt=0
parameters cjn_uhvt=1.257e-03
parameters cgln_uhvt=1.1e-10
parameters cjswn_uhvt=1.295e-10
parameters cjswgn_uhvt=4.568e-10
parameters cgon_uhvt=2.17e-10
parameters hdifn_uhvt=1.35e-07
parameters rshn_uhvt=6.6
parameters dlua1n_uhvt=0
parameters toxp_uhvt=2.85e-09
parameters dvthp_uhvt=-0.026
parameters dlvthp_uhvt=-2.0e-09
parameters dwvthp_uhvt=-3e-09
parameters dpvthp_uhvt=-2.5e-16
parameters dk2p_uhvt=0
parameters dwk2p_uhvt=0
parameters cjp_uhvt=1.531e-03
parameters cjswp_uhvt=8.286e-11
parameters cjswgp_uhvt=6.075e-10
parameters cgop_uhvt=1.81e-10
parameters cglp_uhvt=1.2e-10
parameters hdifp_uhvt=1.35e-07
parameters rshp_uhvt=7.2
parameters dvsatp_uhvt=30000
parameters dlkt2p_uhvt=-1.5e-9
include "cr013g_2d5_v1d4.scs" section=mos_uhvt

endsection fs_uhvt
//
// *****************************    LIBRARY OF TYPICAL CASE    ******************************

section tt_uhvt_g
parameters toxn_uhvt=2.81e-09
parameters dxl_uhvt=0
parameters dxw_uhvt=0
parameters dvthn_uhvt=0
parameters dlvthn_uhvt=0
parameters dwvthn_uhvt=0
parameters dpvthn_uhvt=0
parameters dk2n_uhvt=0
parameters dwk2n_uhvt=0
parameters cjn_uhvt=1.323e-03
parameters cgln_uhvt=1.1e-10
parameters cjswn_uhvt=1.439e-10
parameters cjswgn_uhvt=5.076e-10
parameters cgon_uhvt=2.17e-10
parameters hdifn_uhvt=1.35e-07
parameters rshn_uhvt=0
parameters dlua1n_uhvt=0
parameters toxp_uhvt=2.85e-09
parameters dvthp_uhvt=0
parameters dlvthp_uhvt=0
parameters dwvthp_uhvt=0
parameters dpvthp_uhvt=0
parameters dk2p_uhvt=0
parameters dwk2p_uhvt=0
parameters cjp_uhvt=1.458e-03
parameters cjswp_uhvt=7.533e-11
parameters cjswgp_uhvt=5.523e-10
parameters cgop_uhvt=1.81e-10
parameters cglp_uhvt=1.2e-10
parameters hdifp_uhvt=1.35e-07
parameters rshp_uhvt=0
parameters dvsatp_uhvt=0
parameters dlkt2p_uhvt=0
include "cr013g_2d5_v1d4.scs" section=mos_uhvt
include "cr013g_2d5_v1d4.scs" section=mac_uhvt

endsection tt_uhvt_g

// *****************************  LIBRARY OF SNSP CORNER CASE  ******************************

section ss_uhvt_g
parameters toxn_uhvt=2.877e-09
parameters dxl_uhvt=6.67e-09
parameters dxw_uhvt=-1.5e-08
parameters dvthn_uhvt=0.026
parameters dlvthn_uhvt=2.9e-09
parameters dwvthn_uhvt=3.8e-09
parameters dpvthn_uhvt=6e-17
parameters dk2n_uhvt=0.012
parameters dwk2n_uhvt=4e-09
parameters cjn_uhvt=1.389e-03
parameters cgln_uhvt=1.1e-10
parameters cjswn_uhvt=1.583e-10
parameters cjswgn_uhvt=5.584e-10
parameters cgon_uhvt=2.061e-10
parameters hdifn_uhvt=1.35e-07
parameters rshn_uhvt=0
parameters dlua1n_uhvt=2e-17
parameters toxp_uhvt=2.917e-09
parameters dvthp_uhvt=-0.026
parameters dlvthp_uhvt=-2.9e-09
parameters dwvthp_uhvt=-3e-09
parameters dpvthp_uhvt=-2.5e-16
parameters dk2p_uhvt=0.018
parameters dwk2p_uhvt=4.8e-09
parameters cjp_uhvt=1.531e-03
parameters cjswp_uhvt=8.286e-11
parameters cjswgp_uhvt=6.075e-10
parameters cgop_uhvt=1.72e-10
parameters cglp_uhvt=1.2e-10
parameters hdifp_uhvt=1.35e-07
parameters rshp_uhvt=0
parameters dvsatp_uhvt=30000
parameters dlkt2p_uhvt=-2.5e-9
include "cr013g_2d5_v1d4.scs" section=mos_uhvt
include "cr013g_2d5_v1d4.scs" section=mac_uhvt

endsection ss_uhvt_g

// *****************************  LIBRARY OF FNFP CORNER CASE  ******************************

section ff_uhvt_g
parameters toxn_uhvt=2.743e-09
parameters dxl_uhvt=-6.67e-09
parameters dxw_uhvt=1.5e-08
parameters dvthn_uhvt=-0.026
parameters dlvthn_uhvt=-2.8e-09
parameters dwvthn_uhvt=-4.2e-09
parameters dpvthn_uhvt=-8e-17
parameters dk2n_uhvt=-0.012
parameters dwk2n_uhvt=-4.5e-09
parameters cjn_uhvt=1.257e-03
parameters cgln_uhvt=1.1e-10
parameters cjswn_uhvt=1.295e-10
parameters cjswgn_uhvt=4.568e-10
parameters cgon_uhvt=2.279e-10
parameters hdifn_uhvt=1.35e-07
parameters rshn_uhvt=0
parameters dlua1n_uhvt=0
parameters toxp_uhvt=2.783e-09
parameters dvthp_uhvt=0.026
parameters dlvthp_uhvt=2.6e-09
parameters dwvthp_uhvt=3.5e-09
parameters dpvthp_uhvt=3e-16
parameters dk2p_uhvt=-0.018
parameters dwk2p_uhvt=-5e-09
parameters cjp_uhvt=1.385e-03
parameters cjswp_uhvt=6.780e-11
parameters cjswgp_uhvt=4.971e-10
parameters cgop_uhvt=1.901e-10
parameters cglp_uhvt=1.2e-10
parameters hdifp_uhvt=1.35e-07
parameters rshp_uhvt=0
parameters dvsatp_uhvt=-28000
parameters dlkt2p_uhvt=0
include "cr013g_2d5_v1d4.scs" section=mos_uhvt
include "cr013g_2d5_v1d4.scs" section=mac_uhvt

endsection ff_uhvt_g

// *****************************  LIBRARY OF SNFP CORNER CASE  ******************************

section sf_uhvt_g
parameters toxn_uhvt=2.81e-09
parameters dxl_uhvt=0
parameters dxw_uhvt=0
parameters dvthn_uhvt=0.026
parameters dlvthn_uhvt=1.5e-09
parameters dwvthn_uhvt=3.8e-09
parameters dpvthn_uhvt=6e-17
parameters dk2n_uhvt=0
parameters dwk2n_uhvt=0
parameters cjn_uhvt=1.389e-03
parameters cgln_uhvt=1.1e-10
parameters cjswn_uhvt=1.583e-10
parameters cjswgn_uhvt=5.584e-10
parameters cgon_uhvt=2.17e-10
parameters hdifn_uhvt=1.35e-07
parameters rshn_uhvt=0
parameters dlua1n_uhvt=1.1e-16
parameters toxp_uhvt=2.85e-09
parameters dvthp_uhvt=0.026
parameters dlvthp_uhvt=2.0e-09
parameters dwvthp_uhvt=3.5e-09
parameters dpvthp_uhvt=3e-16
parameters dk2p_uhvt=0
parameters dwk2p_uhvt=0
parameters cjp_uhvt=1.385e-03
parameters cjswp_uhvt=6.780e-11
parameters cjswgp_uhvt=4.971e-10
parameters cgop_uhvt=1.81e-10
parameters cglp_uhvt=1.2e-10
parameters hdifp_uhvt=1.35e-07
parameters rshp_uhvt=0
parameters dvsatp_uhvt=-28000
parameters dlkt2p_uhvt=0
include "cr013g_2d5_v1d4.scs" section=mos_uhvt
include "cr013g_2d5_v1d4.scs" section=mac_uhvt

endsection sf_uhvt_g

// *****************************  LIBRARY OF FNSP CORNER CASE  ******************************

section fs_uhvt_g
parameters toxn_uhvt=2.81e-09
parameters dxl_uhvt=0
parameters dxw_uhvt=0
parameters dvthn_uhvt=-0.026
parameters dlvthn_uhvt=-1.5e-09
parameters dwvthn_uhvt=-4.2e-09
parameters dpvthn_uhvt=-8e-17
parameters dk2n_uhvt=0
parameters dwk2n_uhvt=0
parameters cjn_uhvt=1.257e-03
parameters cgln_uhvt=1.1e-10
parameters cjswn_uhvt=1.295e-10
parameters cjswgn_uhvt=4.568e-10
parameters cgon_uhvt=2.17e-10
parameters hdifn_uhvt=1.35e-07
parameters rshn_uhvt=0
parameters dlua1n_uhvt=0
parameters toxp_uhvt=2.85e-09
parameters dvthp_uhvt=-0.026
parameters dlvthp_uhvt=-2.0e-09
parameters dwvthp_uhvt=-3e-09
parameters dpvthp_uhvt=-2.5e-16
parameters dk2p_uhvt=0
parameters dwk2p_uhvt=0
parameters cjp_uhvt=1.531e-03
parameters cjswp_uhvt=8.286e-11
parameters cjswgp_uhvt=6.075e-10
parameters cgop_uhvt=1.81e-10
parameters cglp_uhvt=1.2e-10
parameters hdifp_uhvt=1.35e-07
parameters rshp_uhvt=0
parameters dvsatp_uhvt=30000
parameters dlkt2p_uhvt=-1.5e-9
include "cr013g_2d5_v1d4.scs" section=mos_uhvt
include "cr013g_2d5_v1d4.scs" section=mac_uhvt

endsection fs_uhvt_g
// ******************************************************************************************
//

section mac_uhvt

inline subckt nch_uhvt_g ( n11 n2 n33 n4 )
parameters l=1u w=1u multi=1 factor=1 sa=0.35u sb=0.35u ad=2 * hdifn_uhvt
+ / factor * w as=2 * hdifn_uhvt / factor * w pd=2 * (2 * hdifn_uhvt / factor +
+ w) ps=2 * (2 * hdifn_uhvt / factor + w) nrd=hdifn_uhvt / factor / w nrs=hdifn_uhvt
+ / factor / w w1=(w * factor + 0.015e-6 + dxw_uhvt) * multi l1=l * factor - 0.02e-6
+ + dxl_uhvt tcc=1 + 1.7e-3 * (temp - 25) area=w1 * 2.5e-9 * 1e4 * tcc tox=(toxn_uhvt
+ - 8.3e-10) * 1e2 jf=2.704e-08 ef=2.623e+07 varaf= - 0.18955 * log(l1) + 0.99251
+ varbf=0.54 * ef * tox jr=5.065e-7 er=7.43e6 varar= - 0.072266 * log(l1) + 16.394
+ varbr=0.52 * er * tox forward_eff=0.5 * area * jf * exp( - ef * tox * varaf) /
+ pow(tox,2.5) reverse_eff=0.5 * area * jr * exp( - er * tox * varar) / pow(tox,2.5)
+ tmp1=varbf + 2.0 tmp2=varbr + 2.0

nch_uhvt_g ( n1 n2 n3 n4 ) nch_uhvt w=w l=l ad=ad as=as pd=pd ps=ps nrd=nrd nrs=nrs m=multi
+ sa=sa sb=sb

gdf1 ( n2 n1 ) bsource i =forward_eff * pow((abs(v(n2,n1)) + v(n2,n1)) / 2,tmp1)
+ - reverse_eff * pow((abs(v(n2,n1)) - v(n2,n1)) / 2,tmp2) + 1e-18 * v(n2,n1)

gdf2 ( n2 n3 ) bsource i =forward_eff * pow((abs(v(n2,n3)) + v(n2,n3)) / 2,tmp1)
+ - reverse_eff * pow((abs(v(n2,n3)) - v(n2,n3)) / 2,tmp2) + 1e-18 * v(n2,n3)

rdn ( n1 n11 ) resistor r=6.6 * nrd / multi
rsn ( n3 n33 ) resistor r=6.6 * nrs / multi
ends nch_uhvt_g

inline subckt pch_uhvt_g ( p11 p2 p33 p4 )
parameters l=1u w=1u multi=1 factor=1 sa=0.35u sb=0.35u ad=2 * hdifp_uhvt
+ / factor * w as=2 * hdifp_uhvt / factor * w pd=2 * (2 * hdifp_uhvt / factor +
+ w) ps=2 * (2 * hdifp_uhvt / factor + w) nrd=hdifp_uhvt / factor / w nrs=hdifp_uhvt
+ / factor / w jf=1.1575e-07 ef=7.127e+06 jr=2.8e-8 er=4.373e6 w1=(w * factor +
+ 0.015e-6 + dxw_uhvt) * multi l1=l * factor + dxl_uhvt - 0.02e-6 tox=(toxp_uhvt
+ - 8e-10) * 1e2 tcc=1 + 1.4e-3 * (temp - 25) area=w1 * 6.1e-9 * 1e4 * tcc varaf=
+ - 0.70902 * log(l1) + 5.9821 varbf=1.2 * ef * tox varbr=0.52 * er * tox varar=
+ - 0.31121 * log(l1) + 24.530 forward_eff=area * jf * exp( - ef * tox * varaf)
+ / pow(tox,2.5) reverse_eff=4.5 * area * jr * exp( - er * tox * varar) / pow(tox,2.5)
+ tmp1=varbf + 2.0 tmp2=varbr + 2.0

pch_uhvt_g ( p1 p2 p3 p4 ) pch_uhvt w=w l=l ad=ad as=as pd=pd ps=ps nrd=nrd nrs=nrs m=multi
+ sa=sa sb=sb

gdf1 ( p1 p2 ) bsource i =forward_eff * pow((abs(v(p1,p2)) + v(p1,p2)) / 2,tmp1)
+ - reverse_eff * pow((abs(v(p1,p2)) - v(p1,p2)) / 2,tmp2) + 1e-18 * v(p1,p2)

gdf2 ( p3 p2 ) bsource i =forward_eff * pow((abs(v(p3,p2)) + v(p3,p2)) / 2,tmp1)
+ - reverse_eff * pow((abs(v(p3,p2)) - v(p3,p2)) / 2,tmp2) + 1e-18 * v(p3,p2)

rdp ( p1 p11 ) resistor r=7.2 * nrd / multi
rsp ( p3 p33 ) resistor r=7.2 * nrs / multi
ends pch_uhvt_g

endsection mac_uhvt
//
//
//
//  *************************************************************
//                                                              *
//                    2.5V NATIVE NMOS DEVICES LIB              *
//                                                              *
//  *************************************************************
//  *************** CORNER_LIB OF TYPICAL MODEL ***************

section tt_na25
parameters toxn_na25=5.83e-09
parameters dvthn_na25=0
parameters dxwn_na25=0
parameters dxln_na25=0
parameters cjn_na25=1.223e-4
parameters cjswn_na25=1.968e-10
parameters cjswgn_na25=1.639e-10
parameters cgon_na25=4.504e-10
parameters hdifn_na25=1.35e-07
include "cr013g_2d5_v1d4.scs" section=mos_na25
endsection tt_na25
//  *************** CORNER_LIB OF SNSP MODEL ***************
section ss_na25
parameters toxn_na25=6.1e-09
parameters dvthn_na25=0.15
parameters dxwn_na25=-1.5e-8
parameters dxln_na25=1.33e-8
parameters cjn_na25=1.309e-4
parameters cjswn_na25=2.106e-10
parameters cjswgn_na25=1.754e-10
parameters cgon_na25=4.195e-10
parameters hdifn_na25=1.35e-07
include "cr013g_2d5_v1d4.scs" section=mos_na25
endsection ss_na25
//  *************** CORNER_LIB OF FNFP MODEL ***************
section ff_na25
parameters toxn_na25=5.56e-09
parameters dvthn_na25=-0.15
parameters dxwn_na25=1.5e-8
parameters dxln_na25=-1.33e-8
parameters cjn_na25=1.137e-4
parameters cjswn_na25=1.830e-10
parameters cjswgn_na25=1.524e-10
parameters cgon_na25=4.812e-10
parameters hdifn_na25=1.35e-07
include "cr013g_2d5_v1d4.scs" section=mos_na25
endsection ff_na25
//
//
section mos
//
// **************************************************************
//                                                              *
//                1.2V NMOS DEVICES MODEL                       *
//                                                              *
// **************************************************************
//
model nch bsim3v3  {
     1: type=n
+ lmin=8.00e-07-dxl         lmax=2.1e-05              wmin=1.0005e-05-dxw
+ wmax=0.0009001            tnom=25                   version=3.24
+ tox=toxn                  toxm=toxn                 xj=1.9e-07
+ nch=6.14815e+17           lln=1                     lwn=1
+ wln=1                     wwn=-1                    lint=0
+ ll=0                      lw=0                      lwl=0
+ wint=1.25e-08             wl=0                      ww=0
+ wwl=0                     mobmod=1                  binunit=2
+ xl=-2.0e-08+dxl           xw=1.5e-08+dxw            dwg=0
+ dwb=0                     vth0=0.3186263+dvthn      lvth0=3.77315e-08+dlvthn
+ pvth0=0+dpvthn            k1=0.4020326              lk1=2.961456e-08
+ k2=-0.01+dk2n             lk2=0+dlk2n               k3=0
+ dvt0=0                    dvt1=0                    dvt2=0
+ dvt0w=0                   dvt1w=0                   dvt2w=0
+ nlx=0                     w0=0                      k3b=0
+ vfb=-0.9638587            vsat=92000                pvsat=0+dpvsatn
+ lvsat=0+dlvsatn           ua=6.957609e-10           lua=4.230652e-17
+ ub=1.29963e-18            lub=7.022882e-25          uc=9.558696e-11
+ luc=1.438422e-16          rdsw=102.9                prwb=0
+ prwg=0                    wr=1                      u0=0.05146012
+ lu0=8.222194e-09          a0=1.2                    keta=-0.003169565
+ lketa=1.692261e-09        a1=0                      a2=0.99
+ ags=0.620326              lags=2.961457e-07         b0=0
+ b1=0                      voff=-0.1336783           lvoff=6.769044e-09
+ nfactor=0.4491304         lnfactor=5.076783e-07     cit=0
+ cdsc=0                    cdscb=0                   cdscd=0
+ eta0=-7.847857e-06        leta0=1.176121e-09        etab=0.0001458695
+ letab=-2.453778e-09       dsub=0                    pclm=0.55
+ ppclm=0+dppclmn           pdiblc1=0                 pdiblc2=0.0008728261
+ lpdiblc2=1.269195e-09     pdiblcb=0                 drout=0
+ pscbe1=1.8e+08            pscbe2=5e-08              pvag=0
+ delta=0.004576087         ldelta=4.230652e-09       kt1=-0.1783044
+ lkt1=-1.69226e-08         kt2=-0.02                 at=44152.18
+ lat=0.008461304           ute=-1.5                  ua1=2.469456e-09
+ lua1=8.038239e-16         ub1=-2.330435e-18         lub1=-1.692261e-24
+ uc1=7.561846e-11          luc1=-2.828424e-16        kt1l=0
+ prt=0                     alpha0=0                  alpha1=0.009179
+ beta0=6.415               cj=cjn                    mj=0.4528
+ pb=0.7956                 cjsw=cjswn                mjsw=0.2323
+ pbsw=0.7956               cjswg=cjswgn              mjswg=0.4087
+ pbswg=0.7956              tcj=0.0009067             tcjsw=0.0002781
+ tcjswg=0.0002781          tpb=0.001427              tpbsw=0.001427
+ tpbswg=0.001427           js=8.00e-7                jsw=1.55e-12
+ cgdo=cgon                 cgso=cgon                 cgbo=0
+ capmod=3                  nqsmod=0                  xpart=1
+ cf=0                      tlev=1                    tlevc=1
+ xti=3                     n=1                       hdif=hdifn
+ ldif=8e-08                rsh=rshn                  rs=0
+ rd=0                      dlc=1.72e-8               wvth0=0+dwvthn
+ cgdl=cgln                 cgsl=cgln                 wwc=-4.5e-2
+ dwc=0                     noia=7.0e+18              noib=2.5e+4
+ noic=1.0e-13              em=4.1e+7                 ef=1.009
+ noimod=2                  sa0=0.35e-6               sb0=0.35e-6
+ kvsat=0.4                 wlod=0.5e-6               tku0=0.03
+ ku0=-0.62e-7              llodku0=1                 wlodku0=1
+ lku0=2.0e-7               wku0=0.7e-6               pku0=-0.5e-13
+ kvth0=5.2e-9              stk2=2.5e-9               steta0=-1.1e-10
+ lkvth0=-1.0e-8            wkvth0=2.2e-6             pkvth0=-5e-14
+ llodvth=1.0               wlodvth=1                 lodk2=1
+ lodeta0=2                 minr=1e-3                 imax=0.01
+ imelt=0.01

     2: type=n
+ lmin=3.50e-07-dxl         lmax=8.00e-07-dxl         wmin=1.0005e-05-dxw
+ wmax=0.0009001            tnom=25                   version=3.24
+ tox=toxn                  toxm=toxn                 xj=1.9e-07
+ nch=6.14815e+17           lln=1                     lwn=1
+ wln=1                     wwn=-1                    lint=0
+ ll=0                      lw=0                      lwl=0
+ wint=1.25e-08             wl=0                      ww=0
+ wwl=0                     mobmod=1                  binunit=2
+ xl=-2.0e-08+dxl           xw=1.5e-08+dxw            dwg=0
+ dwb=0                     vth0=0.3464667+dvthn      lvth0=1.6016e-08+dlvthn
+ pvth0=0+dpvthn            k1=0.4253333              lk1=1.144001e-08
+ k2=-0.01+dk2n             lk2=0+dlk2n               k3=0
+ dvt0=0                    dvt1=0                    dvt2=0
+ dvt0w=0                   dvt1w=0                   dvt2w=0
+ nlx=0                     w0=0                      k3b=0
+ vfb=-0.9549471            vsat=92000                pvsat=0+dpvsatn
+ lvsat=0+dlvsatn           ua=8.966667e-10           lua=-1.144e-16
+ ub=1.833333e-18           lub=2.860001e-25          uc=2.323333e-10
+ luc=3.718e-17             rdsw=102.9                prwb=0
+ prwg=0                    wr=1                      u0=0.05833474
+ lu0=2.859993e-09          a0=1.2                    keta=-0.001
+ a1=0                      a2=0.99                   ags=1
+ b0=0                      b1=0                      voff=-0.1242667
+ lvoff=-5.720012e-10       nfactor=0.9533334         lnfactor=1.144e-07
+ cit=0                     cdsc=0                    cdscb=0
+ cdscd=0                   eta0=0.0003999999         leta0=8.580001e-10
+ etab=-0.0019              letab=-8.579999e-10       dsub=0
+ pclm=0.55                 ppclm=0+dppclmn           pdiblc1=0
+ pdiblc2=0.0025            pdiblcb=0                 drout=0
+ pscbe1=1.8e+08            pscbe2=5e-08              pvag=0
+ delta=0.01                kt1=-0.2088               lkt1=6.864006e-09
+ kt2=-0.02                 at=69666.67               lat=-0.01144
+ ute=-1.5                  ua1=3.866667e-09          lua1=-2.860001e-16
+ ub1=-4.683333e-18         lub1=1.43e-25             uc1=-2.408e-10
+ luc1=-3.6036e-17          kt1l=0                    prt=0
+ alpha0=0                  alpha1=0.009179           beta0=6.415
+ cj=cjn                    mj=0.4528                 pb=0.7956
+ cjsw=cjswn                mjsw=0.2323               pbsw=0.7956
+ cjswg=cjswgn              mjswg=0.4087              pbswg=0.7956
+ tcj=0.0009067             tcjsw=0.0002781           tcjswg=0.0002781
+ tpb=0.001427              tpbsw=0.001427            tpbswg=0.001427
+ js=8.00e-7                jsw=1.55e-12              cgdo=cgon
+ cgso=cgon                 cgbo=0                    capmod=3
+ nqsmod=0                  xpart=1                   cf=0
+ tlev=1                    tlevc=1                   xti=3
+ n=1                       hdif=hdifn                ldif=8e-08
+ rsh=rshn                  rs=0                      rd=0
+ dlc=1.72e-8               wvth0=0+dwvthn            cgdl=cgln
+ cgsl=cgln                 wwc=-4.5e-2               dwc=0
+ noia=7.0e+18              noib=2.5e+4               noic=1.0e-13
+ em=4.1e+7                 ef=1.009                  noimod=2
+ sa0=0.35e-6               sb0=0.35e-6               kvsat=0.4
+ wlod=0.5e-6               tku0=0.03                 ku0=-0.62e-7
+ llodku0=1                 wlodku0=1                 lku0=2.0e-7
+ wku0=0.7e-6               pku0=-0.5e-13             kvth0=5.2e-9
+ stk2=2.5e-9               steta0=-1.1e-10           lkvth0=-1.0e-8
+ wkvth0=2.2e-6             pkvth0=-5e-14             llodvth=1.0
+ wlodvth=1                 lodk2=1                   lodeta0=2
+ minr=1e-3                 imax=0.01                 imelt=0.01

     3: type=n
+ lmin=1.30e-07             lmax=3.50e-07-dxl         wmin=1.0005e-05-dxw
+ wmax=0.0009001            tnom=25                   version=3.24
+ tox=toxn                  toxm=toxn                 xj=1.9e-07
+ nch=6.14815e+17           lln=1                     lwn=1
+ wln=1                     wwn=-1                    lint=0
+ ll=0                      lw=0                      lwl=0
+ wint=1.25e-08             wl=0                      ww=0
+ wwl=0                     mobmod=1                  binunit=2
+ xl=-2.0e-08+dxl           xw=1.5e-08+dxw            dwg=0
+ dwb=0                     vth0=0.372+dvthn          lvth0=7.590001e-09+dlvthn
+ pvth0=0+dpvthn            k1=0.4625                 lk1=-8.249992e-10
+ k2=-0.01+dk2n             lk2=0+dlk2n               k3=0
+ dvt0=0                    dvt1=0                    dvt2=0
+ dvt0w=0                   dvt1w=0                   dvt2w=0
+ nlx=0                     w0=0                      k3b=0
+ vfb=-0.904175             vsat=92475                pvsat=0+dpvsatn
+ lvsat=-0.00015675+dlvsatn ua=5.6e-10                lua=-3.3e-18
+ ub=2.7e-18                uc=2.95e-10               luc=1.65e-17
+ rdsw=102.9                prwb=0                    prwg=0
+ wr=1                      u0=0.06050138             lu0=2.145002e-09
+ a0=1.2                    keta=-0.001               a1=0
+ a2=0.99                   ags=1                     b0=0
+ b1=0                      voff=-0.124               lvoff=-6.599989e-10
+ nfactor=1.05              lnfactor=8.25e-08         cit=-4.9000010e-04
+ lcit=1.6170001e-10        cdsc=0                    cdscb=0
+ cdscd=0                   eta0=0.0004999998         leta0=8.250001e-10
+ etab=-0.003249999         letab=-4.125001e-10       dsub=0
+ pclm=0.225                lpclm=1.0725e-07          ppclm=0+dppclmn
+ pdiblc1=0                 pdiblc2=0.00125           lpdiblc2=4.125e-10
+ pdiblcb=0                 drout=0                   pscbe1=1.8e+08
+ pscbe2=5e-08              pvag=0                    delta=0.01
+ kt1=-0.182                lkt1=-1.980001e-09        kt2=-0.02
+ at=35000                  ute=-1.45                 lute=-1.65e-08
+ ua1=3.5e-09               lua1=-1.65e-16            ub1=-4.825e-18
+ lub1=1.8975e-25           uc1=-3.75e-10             luc1=8.250001e-18
+ kt1l=0                    prt=0                     alpha0=0
+ alpha1=0.009179           beta0=6.415               cj=cjn
+ mj=0.4528                 pb=0.7956                 cjsw=cjswn
+ mjsw=0.2323               pbsw=0.7956               cjswg=cjswgn
+ mjswg=0.4087              pbswg=0.7956              tcj=0.0009067
+ tcjsw=0.0002781           tcjswg=0.0002781          tpb=0.001427
+ tpbsw=0.001427            tpbswg=0.001427           js=8.00e-7
+ jsw=1.55e-12              cgdo=cgon                 cgso=cgon
+ cgbo=0                    capmod=3                  nqsmod=0
+ xpart=1                   cf=0                      tlev=1
+ tlevc=1                   xti=3                     n=1
+ hdif=hdifn                ldif=8e-08                rsh=rshn
+ rs=0                      rd=0                      dlc=1.72e-8
+ wvth0=0+dwvthn            cgdl=cgln                 cgsl=cgln
+ wwc=-4.5e-2               dwc=0                     noia=7.0e+18
+ noib=2.5e+4               noic=1.0e-13              em=4.1e+7
+ ef=1.009                  noimod=2                  sa0=0.35e-6
+ sb0=0.35e-6               kvsat=0.4                 wlod=0.5e-6
+ tku0=0.03                 ku0=-0.62e-7              llodku0=1
+ wlodku0=1                 lku0=2.0e-7               wku0=0.7e-6
+ pku0=-0.5e-13             kvth0=5.2e-9              stk2=2.5e-9
+ steta0=-1.1e-10           lkvth0=-1.0e-8            wkvth0=2.2e-6
+ pkvth0=-5e-14             llodvth=1.0               wlodvth=1
+ lodk2=1                   lodeta0=2                 minr=1e-3
+ imax=0.01                 imelt=0.01

     4: type=n
+ lmin=8.00e-07-dxl         lmax=2.1e-05              wmin=1.205e-06-dxw
+ wmax=1.0005e-05-dxw       tnom=25                   version=3.24
+ tox=toxn                  toxm=toxn                 xj=1.9e-07
+ nch=6.14815e+17           lln=1                     lwn=1
+ wln=1                     wwn=-1                    lint=0
+ ll=0                      lw=0                      lwl=0
+ wint=1.25e-08             wl=0                      ww=0
+ wwl=0                     mobmod=1                  binunit=2
+ xl=-2.0e-08+dxl           xw=1.5e-08+dxw            dwg=0
+ dwb=0                     vth0=0.3192846+dvthn      lvth0=3.848904e-08+dlvthn
+ wvth0=-6.580117e-09+dwvthn                          pvth0=-7.571634e-15+dpvthn
+ k1=0.4019175              lk1=3.076357e-08          wk1=1.150731e-09
+ pk1=-1.148431e-14         k2=-0.01+dk2n             lk2=0+dlk2n
+ k3=0                      dvt0=0                    dvt1=0
+ dvt2=0                    dvt0w=0                   dvt1w=0
+ dvt2w=0                   nlx=0                     w0=0
+ k3b=0                     vfb=-0.9663146            vsat=92000
+ ua=6.956929e-10           lua=1.587938e-17          pvsat=0+dpvsatn
+ lvsat=0+dlvsatn           wua=6.786699e-19          pua=2.641394e-22
+ ub=1.301512e-18           lub=8.258063e-25          wub=-1.88102e-26
+ pub=-1.234564e-30         uc=9.466591e-11           luc=1.530342e-16
+ wuc=9.205861e-18          puc=-9.187456e-23         rdsw=102.9
+ prwb=0                    prwg=0                    wr=1
+ u0=0.05210034             lu0=8.993866e-09          wu0=-6.399003e-09
+ pu0=-7.712874e-15         a0=1.2                    keta=-0.003169565
+ lketa=1.692261e-09        a1=0                      a2=0.99
+ ags=0.620326              lags=2.961457e-07         b0=0
+ b1=0                      voff=-0.1330592           lvoff=8.722355e-09
+ wvoff=-6.187405e-09       pvoff=-1.952335e-14       nfactor=0.3913584
+ lnfactor=5.421484e-07     wnfactor=5.774322e-07     pnfactor=-3.445296e-13
+ cit=0                     cdsc=0                    cdscb=0
+ cdscd=0                   eta0=-7.847857e-06        leta0=1.176121e-09
+ etab=0.0001458695         letab=-2.453778e-09       dsub=0
+ pclm=0.55                 ppclm=0+dppclmn           pdiblc1=0
+ pdiblc2=0.0008728261      lpdiblc2=1.269195e-09     pdiblcb=0
+ drout=0                   pscbe1=1.8e+08            pscbe2=5e-08
+ pvag=0                    delta=0.004576087         ldelta=4.230652e-09
+ kt1=-0.1789258            lkt1=-1.749711e-08        wkt1=6.211026e-09
+ pkt1=5.742155e-15         kt2=-0.02                 at=44094.61
+ lat=0.009035808           wat=0.0005753656          pat=-5.742161e-09
+ ute=-1.5                  ua1=2.516867e-09          lua1=8.727644e-16
+ wua1=-4.738664e-16        pua1=-6.890593e-22        ub1=-2.308542e-18
+ lub1=-1.788777e-24        wub1=-2.188163e-25        pub1=9.646825e-31
+ uc1=7.515796e-11          luc1=-2.782464e-16        wuc1=4.602911e-18
+ puc1=-4.593729e-23        kt1l=0                    prt=0
+ alpha0=0                  alpha1=0.009179           beta0=6.415
+ cj=cjn                    mj=0.4528                 pb=0.7956
+ cjsw=cjswn                mjsw=0.2323               pbsw=0.7956
+ cjswg=cjswgn              mjswg=0.4087              pbswg=0.7956
+ tcj=0.0009067             tcjsw=0.0002781           tcjswg=0.0002781
+ tpb=0.001427              tpbsw=0.001427            tpbswg=0.001427
+ js=8.00e-7                jsw=1.55e-12              cgdo=cgon
+ cgso=cgon                 cgbo=0                    capmod=3
+ nqsmod=0                  xpart=1                   cf=0
+ tlev=1                    tlevc=1                   xti=3
+ n=1                       hdif=hdifn                ldif=8e-08
+ rsh=rshn                  rs=0                      rd=0
+ dlc=1.72e-8               cgdl=cgln                 cgsl=cgln
+ wwc=-4.5e-2               dwc=0                     noia=7.0e+18
+ noib=2.5e+4               noic=1.0e-13              em=4.1e+7
+ ef=1.009                  noimod=2                  sa0=0.35e-6
+ sb0=0.35e-6               kvsat=0.4                 wlod=0.5e-6
+ tku0=0.03                 ku0=-0.62e-7              llodku0=1
+ wlodku0=1                 lku0=2.0e-7               wku0=0.7e-6
+ pku0=-0.5e-13             kvth0=5.2e-9              stk2=2.5e-9
+ steta0=-1.1e-10           lkvth0=-1.0e-8            wkvth0=2.2e-6
+ pkvth0=-5e-14             llodvth=1.0               wlodvth=1
+ lodk2=1                   lodeta0=2                 minr=1e-3
+ imax=0.01                 imelt=0.01

     5: type=n
+ lmin=3.50e-07-dxl         lmax=8.00e-07-dxl         wmin=1.205e-06-dxw
+ wmax=1.0005e-05-dxw       tnom=25                   version=3.24
+ tox=toxn                  toxm=toxn                 xj=1.9e-07
+ nch=6.14815e+17           lln=1                     lwn=1
+ wln=1                     wwn=-1                    lint=0
+ ll=0                      lw=0                      lwl=0
+ wint=1.25e-08             wl=0                      ww=0
+ wwl=0                     mobmod=1                  binunit=2
+ xl=-2.0e-08+dxl           xw=1.5e-08+dxw            dwg=0
+ dwb=0                     vth0=0.3487933+dvthn      lvth0=1.547228e-08+dlvthn
+ wvth0=-2.325469e-08+dwvthn                          pvth0=5.434531e-15+dpvthn
+ k1=0.4276871              lk1=1.066326e-08          wk1=-2.352609e-08
+ pk1=7.763609e-15          k2=-0.01+dk2n             lk2=0+dlk2n
+ k3=0                      dvt0=0                    dvt1=0
+ dvt2=0                    dvt0w=0                   dvt1w=0
+ dvt2w=0                   nlx=0                     w0=0
+ k3b=0                     vfb=-0.9599471            vsat=92099.59
+ lvsat=-7.767496e-05+dlvsatn                         wvsat=-0.0009953355
+ pvsat=7.763617e-10+dpvsatn                          ua=8.477803e-10
+ lua=-1.027488e-16         wua=4.886192e-16          pua=-1.164542e-22
+ ub=1.989588e-18           lub=2.891071e-25          wub=-1.561772e-24
+ pub=-3.105452e-32         uc=2.387157e-10           luc=4.067538e-17
+ wuc=-6.379194e-17         puc=-3.493628e-23         rdsw=102.9
+ prwb=0                    prwg=0                    wr=1
+ u0=0.05966554             lu0=3.093016e-09          wu0=-1.330132e-08
+ pu0=-2.329068e-15         a0=1.2                    keta=-0.001
+ a1=0                      a2=0.99                   ags=1.024896
+ lags=-1.941873e-08        wags=-2.488339e-07        pags=1.940904e-13
+ b0=0                      b1=0                      voff=-0.1192513
+ lvoff=-2.047826e-09       wvoff=-5.012873e-08       pvoff=1.475088e-14
+ nfactor=0.9347747         lnfactor=1.182837e-07     wnfactor=1.854943e-07
+ pnfactor=-3.881805e-14    cit=0                     cdsc=0
+ cdscb=0                   cdscd=0                   eta0=0.000345229
+ leta0=9.007213e-10        weta0=5.474347e-10        peta0=-4.269989e-16
+ etab=-0.001800417         letab=-9.35675e-10        wetab=-9.95335e-10
+ petab=7.763614e-16        dsub=0                    pclm=0.55
+ ppclm=0+dppclmn           pdiblc1=0                 pdiblc2=0.0025
+ pdiblcb=0                 drout=0                   pscbe1=1.8e+08
+ pscbe2=5e-08              pvag=0                    delta=0.01
+ kt1=-0.211353             lkt1=7.796106e-09         wkt1=2.55168e-08
+ pkt1=-9.316348e-15        kt2=-0.02                 at=70843.56
+ lat=-0.01182838           wat=-0.01176305           pat=3.881808e-09
+ ute=-1.5                  ua1=4.032337e-09          lua1=-3.093026e-16
+ wua1=-1.655877e-15        pua1=2.329085e-22         ub1=-4.78518e-18
+ lub1=1.43e-25             wub1=1.017956e-24         uc1=-2.271028e-10
+ luc1=-4.248302e-17        wuc1=-1.369039e-16        puc1=6.443801e-23
+ kt1l=0                    prt=0                     alpha0=0
+ alpha1=0.009179           beta0=6.415               cj=cjn
+ mj=0.4528                 pb=0.7956                 cjsw=cjswn
+ mjsw=0.2323               pbsw=0.7956               cjswg=cjswgn
+ mjswg=0.4087              pbswg=0.7956              tcj=0.0009067
+ tcjsw=0.0002781           tcjswg=0.0002781          tpb=0.001427
+ tpbsw=0.001427            tpbswg=0.001427           js=8.00e-7
+ jsw=1.55e-12              cgdo=cgon                 cgso=cgon
+ cgbo=0                    capmod=3                  nqsmod=0
+ xpart=1                   cf=0                      tlev=1
+ tlevc=1                   xti=3                     n=1
+ hdif=hdifn                ldif=8e-08                rsh=rshn
+ rs=0                      rd=0                      dlc=1.72e-8
+ cgdl=cgln                 cgsl=cgln                 wwc=-4.5e-2
+ dwc=0                     noia=7.0e+18              noib=2.5e+4
+ noic=1.0e-13              em=4.1e+7                 ef=1.009
+ noimod=2                  sa0=0.35e-6               sb0=0.35e-6
+ kvsat=0.4                 wlod=0.5e-6               tku0=0.03
+ ku0=-0.62e-7              llodku0=1                 wlodku0=1
+ lku0=2.0e-7               wku0=0.7e-6               pku0=-0.5e-13
+ kvth0=5.2e-9              stk2=2.5e-9               steta0=-1.1e-10
+ lkvth0=-1.0e-8            wkvth0=2.2e-6             pkvth0=-5e-14
+ llodvth=1.0               wlodvth=1                 lodk2=1
+ lodeta0=2                 minr=1e-3                 imax=0.01
+ imelt=0.01

     6: type=n
+ lmin=1.30e-07             lmax=3.50e-07-dxl         wmin=1.205e-06-dxw
+ wmax=1.0005e-05-dxw       tnom=25                   version=3.24
+ tox=toxn                  toxm=toxn                 xj=1.9e-07
+ nch=6.14815e+17           lln=1                     lwn=1
+ wln=1                     wwn=-1                    lint=0
+ ll=0                      lw=0                      lwl=0
+ wint=1.25e-08             wl=0                      ww=0
+ wwl=0                     mobmod=1                  binunit=2
+ xl=-2.0e-08+dxl           xw=1.5e-08+dxw            dwg=0
+ dwb=0                     vth0=0.3731874+dvthn      lvth0=7.422214e-09+dlvthn
+ wvth0=-1.186831e-08+dwvthn                          pvth0=1.677027e-15+dpvthn
+ k1=0.4624763              lk1=-8.17183e-10          wk1=2.367341e-10
+ pk1=-7.812222e-17         k2=-0.01+dk2n             lk2=0+dlk2n
+ k3=0                      dvt0=0                    dvt1=0
+ dvt2=0                    dvt0w=0                   dvt1w=0
+ dvt2w=0                   nlx=0                     w0=0
+ k3b=0                     vfb=-0.905175             vsat=92367.39
+ lvsat=-0.0001660512+dlvsatn                         wvsat=0.001075562
+ pvsat=9.296548e-11+dpvsatn                          ua=5.390622e-10
+ lua=-8.717873e-19         wua=2.09273e-16           pua=-2.426999e-23
+ ub=2.801752e-18           lub=2.109314e-26          wub=-1.01701e-24
+ pub=-2.108259e-31         uc=2.99737e-10            luc=2.053834e-17
+ wuc=-4.73468e-17          puc=-4.036318e-23         rdsw=102.9
+ prwb=0                    prwg=0                    wr=1
+ u0=0.06172818             lu0=2.412345e-09          wu0=-1.226186e-08
+ pu0=-2.672088e-15         a0=1.2                    keta=-0.001
+ a1=0                      a2=0.99                   ags=0.9478924
+ lags=5.99237e-09          wags=5.208151e-07         pags=-5.989373e-14
+ b0=0                      b1=0                      voff=-0.1260906
+ lvoff=2.091559e-10        wvoff=2.089575e-08        pvoff=-8.687199e-15
+ nfactor=1.041947          lnfactor=8.291686e-08     wnfactor=8.048968e-08
+ pnfactor=-4.166534e-15    cit=-5.5653970e-04        lcit=1.8365813e-10
+ wcit=6.6506490e-10        pcit=-2.1947146e-16       cdsc=0
+ cdscb=0                   cdscd=0                   eta0=0.0003695728
+ leta0=8.926878e-10        weta0=1.303616e-09        peta0=-6.765388e-16
+ etab=-0.003397638         letab=-4.08592e-10        wetab=1.475642e-09
+ petab=-3.906104e-17       dsub=0                    pclm=0.2353426
+ lpclm=1.03837e-07         wpclm=-1.033738e-07       ppclm=3.411337e-14+dppclmn
+ pdiblc1=0                 pdiblc2=0.001378058       lpdiblc2=3.702408e-10
+ wpdiblc2=-1.279943e-09    ppdiblc2=4.223811e-16     pdiblcb=0
+ drout=0                   pscbe1=1.8e+08            pscbe2=5e-08
+ pvag=0                    delta=0.01                kt1=-0.1794609
+ lkt1=-2.728266e-09        wkt1=-2.53779e-08         pkt1=7.478905e-15
+ kt2=-0.02                 at=35000                  ute=-1.44321
+ lute=-1.874063e-08        wute=-6.786381e-08        pute=2.239505e-14
+ ua1=3.56853e-09           lua1=-1.56246e-16         wua1=-6.849511e-16
+ pua1=-8.74969e-23         ub1=-4.90324e-18          lub1=1.819599e-25
+ wub1=7.820111e-25         pub1=7.786192e-32         uc1=-3.769706e-10
+ luc1=6.973365e-18         wuc1=1.969626e-17         puc1=1.275997e-23
+ kt1l=0                    prt=0                     alpha0=0
+ alpha1=0.009179           beta0=6.415               cj=cjn
+ mj=0.4528                 pb=0.7956                 cjsw=cjswn
+ mjsw=0.2323               pbsw=0.7956               cjswg=cjswgn
+ mjswg=0.4087              pbswg=0.7956              tcj=0.0009067
+ tcjsw=0.0002781           tcjswg=0.0002781          tpb=0.001427
+ tpbsw=0.001427            tpbswg=0.001427           js=8.00e-7
+ jsw=1.55e-12              cgdo=cgon                 cgso=cgon
+ cgbo=0                    capmod=3                  nqsmod=0
+ xpart=1                   cf=0                      tlev=1
+ tlevc=1                   xti=3                     n=1
+ hdif=hdifn                ldif=8e-08                rsh=rshn
+ rs=0                      rd=0                      dlc=1.72e-8
+ cgdl=cgln                 cgsl=cgln                 wwc=-4.5e-2
+ dwc=0                     noia=7.0e+18              noib=2.5e+4
+ noic=1.0e-13              em=4.1e+7                 ef=1.009
+ noimod=2                  sa0=0.35e-6               sb0=0.35e-6
+ kvsat=0.4                 wlod=0.5e-6               tku0=0.03
+ ku0=-0.62e-7              llodku0=1                 wlodku0=1
+ lku0=2.0e-7               wku0=0.7e-6               pku0=-0.5e-13
+ kvth0=5.2e-9              stk2=2.5e-9               steta0=-1.1e-10
+ lkvth0=-1.0e-8            wkvth0=2.2e-6             pkvth0=-5e-14
+ llodvth=1.0               wlodvth=1                 lodk2=1
+ lodeta0=2                 minr=1e-3                 imax=0.01
+ imelt=0.01

     7: type=n
+ lmin=8.00e-07-dxl         lmax=2.1e-05              wmin=5.85e-07-dxw
+ wmax=1.205e-06-dxw        tnom=25                   version=3.24
+ tox=toxn                  toxm=toxn                 xj=1.9e-07
+ nch=6.14815e+17           lln=1                     lwn=1
+ wln=1                     wwn=-1                    lint=0
+ ll=0                      lw=0                      lwl=0
+ wint=1.25e-08             wl=0                      ww=0
+ wwl=0                     mobmod=1                  binunit=2
+ xl=-2.0e-08+dxl           xw=1.5e-08+dxw            dwg=0
+ dwb=0                     vth0=0.3284845+dvthn      lvth0=4.1804960e-08+dlvthn
+ wvth0=-1.7573974e-08+dwvthn                         pvth0=-1.1534162e-14+dpvthn
+ k1=0.4028804              lk1=2.115326e-08          k2=-0.01+dk2n
+ lk2=0+dlk2n               k3=0                      dvt0=0
+ dvt1=0                    dvt2=0                    dvt0w=0
+ dvt1w=0                   dvt2w=0                   nlx=0
+ w0=0                      k3b=0                     vfb=-0.9963146
+ vsat=9.1850600e+04        lvsat=1.4909640e-03+dlvsatn
+ wvsat=1.7852732e-04       pvsat=-1.7817019e-09+dpvsatn
+ ua=6.970471e-10           lua=2.290693e-16          wua=-9.396122e-19
+ pua=9.377379e-24          ub=1.734552e-18           lub=-2.896972e-25
+ wub=-5.362924e-25         pub=9.846243e-32          uc=1.00797e-10
+ luc=9.184609e-17          wuc=1.879232e-18          puc=-1.875476e-23
+ rdsw=102.9                prwb=0                    prwg=0
+ wr=1                      u0=5.1684090e-02          lu0=-2.1917292e-10
+ wu0=-5.9015850e-09        pu0=3.2967090e-15         a0=1.2
+ keta=-0.003169565         lketa=1.692261e-09        a1=0
+ a2=0.99                   ags=0.628189              lags=2.176739e-07
+ wags=-9.396179e-09        pags=9.37738e-14          b0=0
+ b1=0                      voff=-0.1273277           lvoff=-1.467764e-08
+ wvoff=-1.303659e-08       pvoff=8.439643e-15        nfactor=0.7739603
+ lnfactor=3.32311e-07      wnfactor=1.202228e-07     pnfactor=-9.37738e-14
+ cit=0                     cdsc=0                    cdscb=0
+ cdscd=0                   eta0=-7.847708e-06        leta0=1.176121e-09
+ etab=0.0001458695         letab=-2.453778e-09       dsub=0
+ pclm=0.3459678            wpclm=2.438185e-07        ppclm=0+dppclmn
+ pdiblc1=0                 pdiblc2=0.0008728262      lpdiblc2=1.269195e-09
+ pdiblcb=0                 drout=0                   pscbe1=1.8e+08
+ pscbe2=5e-08              pvag=0                    delta=0.004576087
+ ldelta=4.230652e-09       kt1=-0.172942             lkt1=-2.053913e-08
+ wkt1=-9.396166e-10        pkt1=9.37737e-15          kt2=-0.02
+ at=44182.94               lat=0.008154241           wat=0.0004698085
+ pat=-4.688689e-09         ute=-1.449698             lute=-3.923585e-08
+ wute=-6.011134e-08        pute=4.688685e-14         ua1=2.700366e-09
+ lua1=6.073042e-17         wua1=-6.931482e-16        pua1=2.813212e-22
+ ub1=-2.647418e-18         lub1=-1.185538e-24        wub1=1.861403e-25
+ pub1=2.438121e-31         uc1=2.461553e-10          luc1=-4.615289e-16
+ wuc1=-1.997389e-16        puc1=1.730853e-22         kt1l=0
+ prt=0                     alpha0=0                  alpha1=0.009179
+ beta0=6.415               cj=cjn                    mj=0.4528
+ pb=0.7956                 cjsw=cjswn                mjsw=0.2323
+ pbsw=0.7956               cjswg=cjswgn              mjswg=0.4087
+ pbswg=0.7956              tcj=0.0009067             tcjsw=0.0002781
+ tcjswg=0.0002781          tpb=0.001427              tpbsw=0.001427
+ tpbswg=0.001427           js=8.00e-7                jsw=1.55e-12
+ cgdo=cgon                 cgso=cgon                 cgbo=0
+ capmod=3                  nqsmod=0                  xpart=1
+ cf=0                      tlev=1                    tlevc=1
+ xti=3                     n=1                       hdif=hdifn
+ ldif=8e-08                rsh=rshn                  rs=0
+ rd=0                      dlc=1.72e-8               cgdl=cgln
+ cgsl=cgln                 wwc=-4.5e-2               dwc=0
+ noia=7.0e+18              noib=2.5e+4               noic=1.0e-13
+ em=4.1e+7                 ef=1.009                  noimod=2
+ sa0=0.35e-6               sb0=0.35e-6               kvsat=0.4
+ wlod=0.5e-6               tku0=0.03                 ku0=-0.62e-7
+ llodku0=1                 wlodku0=1                 lku0=2.0e-7
+ wku0=0.7e-6               pku0=-0.5e-13             kvth0=5.2e-9
+ stk2=2.5e-9               steta0=-1.1e-10           lkvth0=-1.0e-8
+ wkvth0=2.2e-6             pkvth0=-5e-14             llodvth=1.0
+ wlodvth=1                 lodk2=1                   lodeta0=2
+ minr=1e-3                 imax=0.01                 imelt=0.01

     8: type=n
+ lmin=3.50e-07-dxl         lmax=8.00e-07-dxl         wmin=5.85e-07-dxw
+ wmax=1.205e-06-dxw        tnom=25                   version=3.24
+ tox=toxn                  toxm=toxn                 xj=1.9e-07
+ nch=6.14815e+17           lln=1                     lwn=1
+ wln=1                     wwn=-1                    lint=0
+ ll=0                      lw=0                      lwl=0
+ wint=1.25e-08             wl=0                      ww=0
+ wwl=0                     mobmod=1                  binunit=2
+ xl=-2.0e-08+dxl           xw=1.5e-08+dxw            dwg=0
+ dwb=0                     vth0=0.3558019+dvthn      lvth0=2.0497435e-08+dlvthn
+ wvth0=-3.1629910e-08+dwvthn                         pvth0=-5.7053570e-16+dpvthn
+ k1=0.3841963              lk1=3.572693e-08          wk1=2.844549e-08
+ pk1=-2.218749e-14         k2=-0.01+dk2n             lk2=0+dlk2n
+ k3=0                      dvt0=0                    dvt1=0
+ dvt2=0                    dvt0w=0                   dvt1w=0
+ dvt2w=0                   nlx=0                     w0=0
+ k3b=0                     vfb=-0.9585425            vsat=9.6021230e+04
+ lvsat=-1.7621288e-03+dlvsatn                        wvsat=-5.6817110e-03
+ pvsat=2.7892844e-09+dpvsatn                         ua=1.322204e-09
+ lua=-2.585532e-16         wua=-7.831745e-17         pua=6.973212e-23
+ ub=7.894746e-19           lub=4.474632e-25          wub=-1.276354e-25
+ pub=-2.202901e-31         uc=1.698764e-10           luc=3.79642e-17
+ wuc=1.84711e-17           puc=-3.169642e-23         rdsw=102.9
+ prwb=0                    prwg=0                    wr=1
+ u0=4.8604370e-02          lu0=2.1830155e-09         wu0=-8.3217630e-11
+ pu0=-1.2416175e-15        a0=1.2                    keta=-0.001
+ a1=0                      a2=0.99                   ags=0.6559139
+ lags=1.960484e-07         wags=1.920995e-07         pags=-6.339284e-14
+ b0=0                      b1=0                      voff=-0.164786
+ lvoff=1.453988e-08        wvoff=4.285292e-09        pvoff=-5.071427e-15
+ nfactor=1.09              lnfactor=8.58e-08         cit=0
+ cdsc=0                    cdscb=0                   cdscd=0
+ eta0=0.0005312903         leta0=7.555936e-10        weta0=3.250914e-10
+ peta0=-2.535713e-16       etab=-0.002633333         letab=-2.860001e-10
+ dsub=0                    pclm=0.3459678            wpclm=2.438185e-07
+ ppclm=0+dppclmn           pdiblc1=0                 pdiblc2=0.005220429
+ lpdiblc2=-2.121935e-09    wpdiblc2=-3.250914e-09    ppdiblc2=2.535713e-15
+ pdiblcb=0                 drout=0                   pscbe1=1.8e+08
+ pscbe2=5e-08              pvag=0                    delta=0.01
+ kt1=-0.1992742            wkt1=1.108265e-08         kt2=-0.02
+ at=69037.63               lat=-0.01123242           wat=-0.009604974
+ pat=3.169641e-09          ute=-1.534005             lute=2.652416e-08
+ wute=4.063638e-08         pute=-3.169638e-14        ua1=2.584839e-09
+ lua1=1.508418e-16         wua1=7.38843e-17          pua1=-3.169641e-22
+ ub1=-4.180646e-18         lub1=1.037907e-26         wub1=2.955378e-25
+ pub1=1.584821e-31         uc1=-4.080266e-10         luc1=4.873301e-17
+ wuc1=7.930013e-17         puc1=-4.456515e-23        kt1l=0
+ prt=0                     alpha0=0                  alpha1=0.009179
+ beta0=6.415               cj=cjn                    mj=0.4528
+ pb=0.7956                 cjsw=cjswn                mjsw=0.2323
+ pbsw=0.7956               cjswg=cjswgn              mjswg=0.4087
+ pbswg=0.7956              tcj=0.0009067             tcjsw=0.0002781
+ tcjswg=0.0002781          tpb=0.001427              tpbsw=0.001427
+ tpbswg=0.001427           js=8.00e-7                jsw=1.55e-12
+ cgdo=cgon                 cgso=cgon                 cgbo=0
+ capmod=3                  nqsmod=0                  xpart=1
+ cf=0                      tlev=1                    tlevc=1
+ xti=3                     n=1                       hdif=hdifn
+ ldif=8e-08                rsh=rshn                  rs=0
+ rd=0                      dlc=1.72e-8               cgdl=cgln
+ cgsl=cgln                 wwc=-4.5e-2               dwc=0
+ noia=7.0e+18              noib=2.5e+4               noic=1.0e-13
+ em=4.1e+7                 ef=1.009                  noimod=2
+ sa0=0.35e-6               sb0=0.35e-6               kvsat=0.4
+ wlod=0.5e-6               tku0=0.03                 ku0=-0.62e-7
+ llodku0=1                 wlodku0=1                 lku0=2.0e-7
+ wku0=0.7e-6               pku0=-0.5e-13             kvth0=5.2e-9
+ stk2=2.5e-9               steta0=-1.1e-10           lkvth0=-1.0e-8
+ wkvth0=2.2e-6             pkvth0=-5e-14             llodvth=1.0
+ wlodvth=1                 lodk2=1                   lodeta0=2
+ minr=1e-3                 imax=0.01                 imelt=0.01

     9: type=n
+ lmin=1.30e-07             lmax=3.50e-07-dxl         wmin=5.85e-07-dxw
+ wmax=1.205e-06-dxw        tnom=25                   version=3.24
+ tox=toxn                  toxm=toxn                 xj=1.9e-07
+ nch=6.14815e+17           lln=1                     lwn=1
+ wln=1                     wwn=-1                    lint=0
+ ll=0                      lw=0                      lwl=0
+ wint=1.25e-08             wl=0                      ww=0
+ wwl=0                     mobmod=1                  binunit=2
+ xl=-2.0e-08+dxl           xw=1.5e-08+dxw            dwg=0
+ dwb=0                     vth0=0.3983640+dvthn      lvth0=6.4519300e-09+dlvthn
+ wvth0=-4.1954310e-08+dwvthn                         pvth0=2.8365164e-15+dpvthn
+ k1=0.502575               lk1=-3.338058e-09         wk1=-4.76812e-08
+ pk1=2.934325e-15          k2=-0.01+dk2n             lk2=0+dlk2n
+ k3=0                      dvt0=0                    dvt1=0
+ dvt2=0                    dvt0w=0                   dvt1w=0
+ dvt2w=0                   nlx=0                     w0=0
+ k3b=0                     vfb=-0.9060867            vsat=8.9024170e+04
+ lvsat=5.4690130e-04+dlvsatn                         wvsat=5.0707040e-03
+ pvsat=-7.5901280e-10+dpvsatn                        ua=5.433684e-10
+ lua=-1.537363e-18         wua=2.041272e-16          pua=-2.347462e-23
+ ub=2.892675e-18           lub=-2.465931e-25         wub=-1.125663e-24
+ pub=1.090592e-31          uc=3.399175e-10           luc=-1.814938e-17
+ wuc=-9.536245e-17         puc=5.868657e-24          rdsw=102.9
+ prwb=0                    prwg=0                    wr=1
+ u0=5.5166480e-02          lu0=1.7517475e-11         wu0=-4.4206360e-09
+ pu0=1.8973025e-16         a0=1.2                    keta=-0.001
+ a1=0                      a2=0.99                   ags=1.383721
+ lags=-4.412791e-08        b0=0                      b1=0
+ voff=-0.1092517           lvoff=-3.786461e-09       wvoff=7.731984e-10
+ pvoff=-3.912437e-15       nfactor=1.109302          lnfactor=7.943022e-08
+ cit=0                     cdsc=0                    cdscb=0
+ cdscd=0                   eta0=0.002029857          leta0=2.610664e-10
+ weta0=-6.804239e-10       peta0=7.824874e-17        etab=-0.002162791
+ letab=-4.412791e-10       dsub=0                    pclm=-0.1147222
+ lpclm=1.520277e-07        wpclm=3.149537e-07        ppclm=-2.347461e-14+dppclmn
+ pdiblc1=0                 pdiblc2=-0.005386946      lpdiblc2=1.378499e-09
+ wpdiblc2=6.804239e-09     ppdiblc2=-7.824874e-16    pdiblcb=0
+ drout=0                   pscbe1=1.8e+08            pscbe2=5e-08
+ pvag=0                    delta=0.01                kt1=-0.2149325
+ lkt1=5.167233e-09         wkt1=1.701058e-08         pkt1=-1.956217e-15
+ kt2=-0.02                 at=35000                  ute=-1.428826
+ lute=-8.185006e-09        wute=-8.50529e-08         pute=9.781084e-15
+ ua1=4.183739e-09          lua1=-3.767954e-16        wua1=-1.420127e-15
+ pua1=1.760597e-22         ub1=-5.245274e-18         lub1=3.617065e-25
+ wub1=1.190742e-24         pub1=-1.369353e-31        uc1=-2.888873e-10
+ luc1=9.417043e-18         wuc1=-8.556327e-17        puc1=9.839777e-24
+ kt1l=0                    prt=0                     alpha0=0
+ alpha1=0.009179           beta0=6.415               cj=cjn
+ mj=0.4528                 pb=0.7956                 cjsw=cjswn
+ mjsw=0.2323               pbsw=0.7956               cjswg=cjswgn
+ mjswg=0.4087              pbswg=0.7956              tcj=0.0009067
+ tcjsw=0.0002781           tcjswg=0.0002781          tpb=0.001427
+ tpbsw=0.001427            tpbswg=0.001427           js=8.00e-7
+ jsw=1.55e-12              cgdo=cgon                 cgso=cgon
+ cgbo=0                    capmod=3                  nqsmod=0
+ xpart=1                   cf=0                      tlev=1
+ tlevc=1                   xti=3                     n=1
+ hdif=hdifn                ldif=8e-08                rsh=rshn
+ rs=0                      rd=0                      dlc=1.72e-8
+ cgdl=cgln                 cgsl=cgln                 wwc=-4.5e-2
+ dwc=0                     noia=7.0e+18              noib=2.5e+4
+ noic=1.0e-13              em=4.1e+7                 ef=1.009
+ noimod=2                  sa0=0.35e-6               sb0=0.35e-6
+ kvsat=0.4                 wlod=0.5e-6               tku0=0.03
+ ku0=-0.62e-7              llodku0=1                 wlodku0=1
+ lku0=2.0e-7               wku0=0.7e-6               pku0=-0.5e-13
+ kvth0=5.2e-9              stk2=2.5e-9               steta0=-1.1e-10
+ lkvth0=-1.0e-8            wkvth0=2.2e-6             pkvth0=-5e-14
+ llodvth=1.0               wlodvth=1                 lodk2=1
+ lodeta0=2                 minr=1e-3                 imax=0.01
+ imelt=0.01

     10: type=n
+ lmin=8.00e-07-dxl         lmax=2.1e-05              wmin=1.50e-07
+ wmax=5.85e-07-dxw         tnom=25                   version=3.24
+ tox=toxn                  toxm=toxn                 xj=1.9e-07
+ nch=6.14815e+17           lln=1                     lwn=1
+ wln=1                     wwn=-1                    lint=0
+ ll=0                      lw=0                      lwl=0
+ wint=1.25e-08             wl=0                      ww=0
+ wwl=0                     mobmod=1                  binunit=2
+ xl=-2.0e-08+dxl           xw=1.5e-08+dxw            dwg=0
+ dwb=0                     vth0=0.3224927+dvthn      lvth0=2.4630785e-08+dlvthn
+ wvth0=-1.4128652e-08+dwvthn                         pvth0=-1.6590077e-15+dpvthn
+ k1=0.4222209              lk1=3.222062e-08          wk1=-1.112078e-08
+ pk1=-6.363734e-15         k2=-0.01+dk2n             lk2=0+dlk2n
+ k3=0                      dvt0=0                    dvt1=0
+ dvt2=0                    dvt0w=0                   dvt1w=0
+ dvt2w=0                   nlx=0                     w0=0
+ k3b=0                     vfb=-0.9856448            vsat=9.2284750e+04
+ lvsat=-2.8330884e-03+dlvsatn                        wvsat=-7.1107980e-05
+ pvsat=7.0462840e-10+dpvsatn                         ua=6.921215e-10
+ lua=2.782275e-16          wua=1.892642e-18          pua=-1.888861e-23
+ ub=8.560726e-19           lub=-7.63039e-26          wub=-3.116676e-26
+ pub=-2.423873e-32         uc=1.007737e-10           luc=9.207889e-17
+ wuc=1.892646e-18          puc=-1.888861e-23         rdsw=102.9
+ prwb=0                    prwg=0                    wr=1
+ u0=4.2063040e-02          lu0=4.9411750e-09         wu0=-3.6947580e-10
+ pu0=3.2950860e-16         a0=1.2                    keta=-0.003169565
+ lketa=1.692261e-09        a1=0                      a2=0.99
+ ags=0.6163363             lags=3.359636e-07         wags=-2.58088e-09
+ pags=2.57572e-14          b0=0                      b1=0
+ voff=-0.1589086           lvoff=1.442836e-09        wvoff=5.122456e-09
+ pvoff=-8.296319e-16       nfactor=0.9770589         lnfactor=2.289529e-07
+ wnfactor=3.441172e-09     pnfactor=-3.434294e-14    cit=0
+ cdsc=0                    cdscb=0                   cdscd=0
+ eta0=-1.532852e-05        leta0=1.25078e-09         weta0=4.301469e-12
+ peta0=-4.292868e-17       etab=0.0001458695         letab=-2.453778e-09
+ dsub=0                    pclm=0.77                 ppclm=0+dppclmn
+ pdiblc1=0                 pdiblc2=0.000992519       lpdiblc2=7.465881e-11
+ wpdiblc2=-6.882347e-11    ppdiblc2=6.868587e-16     pdiblcb=0
+ drout=0                   pscbe1=1.8e+08            pscbe2=5e-08
+ pvag=0                    delta=0.004576087         ldelta=4.230652e-09
+ kt1=-0.1732908            lkt1=-2.480245e-09        wkt1=-7.390387e-10
+ pkt1=-1.006489e-15        kt2=-0.02                 at=45000
+ ute=-1.570084             lute=5.466567e-08         wute=9.110945e-09
+ pute=-7.106536e-15        ua1=1.653343e-09          lua1=4.263927e-16
+ wua1=-9.110954e-17        pua1=7.106544e-23         ub1=-2.525806e-18
+ lub1=-4.937533e-25        wub1=1.162138e-25         pub1=-1.539644e-31
+ uc1=-9.120629e-11         luc1=-1.73825e-16         wuc1=-5.756021e-18
+ puc1=7.65558e-24          kt1l=0                    prt=0
+ alpha0=0                  alpha1=0.009179           beta0=6.415
+ cj=cjn                    mj=0.4528                 pb=0.7956
+ cjsw=cjswn                mjsw=0.2323               pbsw=0.7956
+ cjswg=cjswgn              mjswg=0.4087              pbswg=0.7956
+ tcj=0.0009067             tcjsw=0.0002781           tcjswg=0.0002781
+ tpb=0.001427              tpbsw=0.001427            tpbswg=0.001427
+ js=8.00e-7                jsw=1.55e-12              cgdo=cgon
+ cgso=cgon                 cgbo=0                    capmod=3
+ nqsmod=0                  xpart=1                   cf=0
+ tlev=1                    tlevc=1                   xti=3
+ n=1                       hdif=hdifn                ldif=8e-08
+ rsh=rshn                  rs=0                      rd=0
+ dlc=1.72e-8               cgdl=cgln                 cgsl=cgln
+ wwc=-4.5e-2               dwc=0                     noia=7.0e+18
+ noib=2.5e+4               noic=1.0e-13              em=4.1e+7
+ ef=1.009                  noimod=2                  sa0=0.35e-6
+ sb0=0.35e-6               kvsat=0.4                 wlod=0.5e-6
+ tku0=0.03                 ku0=-0.62e-7              llodku0=1
+ wlodku0=1                 lku0=2.0e-7               wku0=0.7e-6
+ pku0=-0.5e-13             kvth0=5.2e-9              stk2=2.5e-9
+ steta0=-1.1e-10           lkvth0=-1.0e-8            wkvth0=2.2e-6
+ pkvth0=-5e-14             llodvth=1.0               wlodvth=1
+ lodk2=1                   lodeta0=2                 minr=1e-3
+ imax=0.01                 imelt=0.01

     11: type=n
+ lmin=3.50e-07-dxl         lmax=8.00e-07-dxl         wmin=1.50e-07
+ wmax=5.85e-07-dxw         tnom=25                   version=3.24
+ tox=toxn                  toxm=toxn                 xj=1.9e-07
+ nch=6.14815e+17           lln=1                     lwn=1
+ wln=1                     wwn=-1                    lint=0
+ ll=0                      lw=0                      lwl=0
+ wint=1.25e-08             wl=0                      ww=0
+ wwl=0                     mobmod=1                  binunit=2
+ xl=-2.0e-08+dxl           xw=1.5e-08+dxw            dwg=0
+ dwb=0                     vth0=0.3288051+dvthn      lvth0=1.9707079e-08+dlvthn
+ wvth0=-1.6106766e-08+dwvthn                         pvth0=-1.1608031e-16+dpvthn
+ k1=0.4736666              lk1=-7.907047e-09         wk1=-2.299999e-08
+ pk1=2.902055e-15          k2=-0.01+dk2n             lk2=0+dlk2n
+ k3=0                      dvt0=0                    dvt1=0
+ dvt2=0                    dvt0w=0                   dvt1w=0
+ dvt2w=0                   nlx=0                     w0=0
+ k3b=0                     vfb=-0.9727331            vsat=8.5442910e+04
+ lvsat=2.5035434e-03+dlvsatn                         wvsat=4.0082220e-04
+ pvsat=3.3652270e-10+dpvsatn                         ua=1.253294e-09
+ lua=-1.59487e-16          wua=-3.86941e-17          pua=1.276905e-23
+ ub=6.052177e-19           lub=1.193629e-25          wub=-2.168765e-26
+ pub=-3.163244e-32         uc=2.434117e-10           luc=-1.917882e-17
+ wuc=-2.381176e-17         puc=1.160823e-24          rdsw=102.9
+ prwb=0                    prwg=0                    wr=1
+ u0=4.8421280e-02          lu0=-1.8254915e-11        wu0=2.2056844e-11
+ pu0=2.4113091e-17         a0=1.2                    keta=-0.001
+ a1=0                      a2=0.99                   ags=0.8982354
+ lags=1.160823e-07         wags=5.276469e-08         pags=-1.741235e-14
+ b0=0                      b1=0                      voff=-0.1669804
+ lvoff=7.738826e-09        wvoff=5.547061e-09        pvoff=-1.160824e-15
+ nfactor=1.121765          lnfactor=1.160824e-07     wnfactor=-1.826471e-08
+ pnfactor=-1.741235e-14    cit=0                     cdsc=0
+ cdscb=0                   cdscd=0                   eta0=0.001236667
+ leta0=2.742235e-10        weta0=-8.050002e-11       peta0=2.321648e-17
+ etab=-0.002633333         letab=-2.860001e-10       dsub=0
+ pclm=0.8295293            lpclm=-4.643294e-08       wpclm=-3.422941e-08
+ ppclm=2.669894e-14+dppclmn                          pdiblc1=0
+ pdiblc2=-0.002000392      lpdiblc2=2.40913e-09      wpdiblc2=9.010587e-10
+ ppdiblc2=-6.964942e-17    pdiblcb=0                 drout=0
+ pscbe1=1.8e+08            pscbe2=5e-08              pvag=0
+ delta=0.01                kt1=-0.1725882            lkt1=-3.028235e-09
+ wkt1=-4.261762e-09        pkt1=1.741235e-15         kt2=-0.02
+ at=50133.34               lat=-0.004004001          wat=0.001265
+ pat=-9.867001e-10         ute=-1.463333             lute=-2.859998e-08
+ ua1=2.842745e-09          lua1=-5.013412e-16        wua1=-7.441175e-17
+ pua1=5.804117e-23         ub1=-3.654902e-18         lub1=3.869413e-25
+ wub1=-6.764658e-27        pub1=-5.804119e-32        uc1=-2.641533e-10
+ luc1=-3.892628e-17        wuc1=-3.426998e-18        puc1=5.838941e-24
+ kt1l=0                    prt=0                     alpha0=0
+ alpha1=0.009179           beta0=6.415               cj=cjn
+ mj=0.4528                 pb=0.7956                 cjsw=cjswn
+ mjsw=0.2323               pbsw=0.7956               cjswg=cjswgn
+ mjswg=0.4087              pbswg=0.7956              tcj=0.0009067
+ tcjsw=0.0002781           tcjswg=0.0002781          tpb=0.001427
+ tpbsw=0.001427            tpbswg=0.001427           js=8.00e-7
+ jsw=1.55e-12              cgdo=cgon                 cgso=cgon
+ cgbo=0                    capmod=3                  nqsmod=0
+ xpart=1                   cf=0                      tlev=1
+ tlevc=1                   xti=3                     n=1
+ hdif=hdifn                ldif=8e-08                rsh=rshn
+ rs=0                      rd=0                      dlc=1.72e-8
+ cgdl=cgln                 cgsl=cgln                 wwc=-4.5e-2
+ dwc=0                     noia=7.0e+18              noib=2.5e+4
+ noic=1.0e-13              em=4.1e+7                 ef=1.009
+ noimod=2                  sa0=0.35e-6               sb0=0.35e-6
+ kvsat=0.4                 wlod=0.5e-6               tku0=0.03
+ ku0=-0.62e-7              llodku0=1                 wlodku0=1
+ lku0=2.0e-7               wku0=0.7e-6               pku0=-0.5e-13
+ kvth0=5.2e-9              stk2=2.5e-9               steta0=-1.1e-10
+ lkvth0=-1.0e-8            wkvth0=2.2e-6             pkvth0=-5e-14
+ llodvth=1.0               wlodvth=1                 lodk2=1
+ lodeta0=2                 minr=1e-3                 imax=0.01
+ imelt=0.01

     12: type=n
+ lmin=1.30e-07             lmax=3.50e-07-dxl         wmin=1.50e-07
+ wmax=5.85e-07-dxw         tnom=25                   version=3.24
+ tox=toxn                  toxm=toxn                 xj=1.9e-07
+ nch=6.14815e+17           lln=1                     lwn=1
+ wln=1                     wwn=-1                    lint=0
+ ll=0                      lw=0                      lwl=0
+ wint=1.25e-08             wl=0                      ww=0
+ wwl=0                     mobmod=1                  binunit=2
+ xl=-2.0e-08+dxl           xw=1.5e-08+dxw            dwg=0
+ dwb=0                     vth0=0.3500490+dvthn      lvth0=1.2696601e-08+dlvthn
+ wvth0=-1.4173159e-08+dwvthn                         pvth0=-7.5417040e-16+dpvthn
+ k1=0.4418194              lk1=2.602556e-09          wk1=-1.274671e-08
+ pk1=-4.815287e-16         k2=-0.01+dk2n             lk2=0+dlk2n
+ k3=0                      dvt0=0                    dvt1=0
+ dvt2=0                    dvt0w=0                   dvt1w=0
+ dvt2w=0                   nlx=0                     w0=0
+ k3b=0                     vfb=-0.9247332            vsat=9.6200910e+04
+ lvsat=-1.0465960e-03+dlvsatn                        wvsat=9.4407860e-04
+ pvsat=1.5724812e-10+dpvsatn                         ua=8.405689e-10
+ lua=-2.328776e-17         wua=3.323681e-17          pua=-1.096815e-23
+ ub=1.219954e-18           lub=-8.349997e-26         wub=-1.638484e-25
+ pub=1.528061e-32          uc=2.174414e-10           luc=-1.060862e-17
+ wuc=-2.493871e-17         puc=1.532718e-24          rdsw=102.9
+ prwb=0                    prwg=0                    wr=1
+ u0=4.7356230e-02          lu0=3.3321140e-10         wu0=7.0259580e-11
+ pu0=8.2061830e-18         a0=1.163095               la0=1.217857e-08
+ wa0=2.122024e-08          pa0=-7.00268e-15          keta=-0.001
+ a1=0                      a2=0.99                   ags=1.423844
+ lags=-5.736857e-08        wags=-2.307085e-08        pags=7.613379e-15
+ b0=0                      b1=0                      voff=-0.1041251
+ lvoff=-1.300342e-08       wvoff=-2.17458e-09        pvoff=1.387317e-15
+ nfactor=1.288803          lnfactor=6.095963e-08     wnfactor=-1.03213e-07
+ pnfactor=1.062059e-14     cit=0                     cdsc=0
+ cdscb=0                   cdscd=0                   eta0=0.0008440161
+ leta0=4.037982e-10        weta0=1.434869e-12        peta0=-3.822031e-18
+ etab=-0.002130606         letab=-4.518999e-10       wetab=-1.850606e-11
+ petab=6.106991e-18        dsub=0                    pclm=0.3585052
+ lpclm=1.09005e-07         wpclm=4.284785e-08        ppclm=1.263441e-15+dppclmn
+ pdiblc1=0                 pdiblc2=0.005364868       lpdiblc2=-2.14062e-11
+ wpdiblc2=6.219454e-10     ppdiblc2=2.245796e-17     pdiblcb=0
+ drout=0                   pscbe1=1.8e+08            pscbe2=5e-08
+ pvag=0                    delta=0.01                kt1=-0.1890473
+ lkt1=2.403242e-09         wkt1=2.126591e-09         pkt1=-3.669215e-16
+ kt2=-0.02                 at=40422.62               lat=-0.0007994639
+ wat=-0.003118006          pat=4.596919e-10          ute=-1.577388
+ lute=9.03799e-09          wute=3.701206e-10         pute=-1.221397e-16
+ ua1=1.528207e-09          lua1=-6.754351e-17        wua1=1.068044e-16
+ pua1=-1.760166e-24        ub1=-2.801067e-18         lub1=1.051756e-25
+ wub1=-2.146773e-25        pub1=1.056997e-32         uc1=-4.953533e-10
+ luc1=3.736971e-17         wuc1=3.315467e-17         puc1=-6.23301e-24
+ kt1l=0                    prt=0                     alpha0=0
+ alpha1=0.009179           beta0=6.415               cj=cjn
+ mj=0.4528                 pb=0.7956                 cjsw=cjswn
+ mjsw=0.2323               pbsw=0.7956               cjswg=cjswgn
+ mjswg=0.4087              pbswg=0.7956              tcj=0.0009067
+ tcjsw=0.0002781           tcjswg=0.0002781          tpb=0.001427
+ tpbsw=0.001427            tpbswg=0.001427           js=8.00e-7
+ jsw=1.55e-12              cgdo=cgon                 cgso=cgon
+ cgbo=0                    capmod=3                  nqsmod=0
+ xpart=1                   cf=0                      tlev=1
+ tlevc=1                   xti=3                     n=1
+ hdif=hdifn                ldif=8e-08                rsh=rshn
+ rs=0                      rd=0                      dlc=1.72e-8
+ cgdl=cgln                 cgsl=cgln                 wwc=-4.5e-2
+ dwc=0                     noia=7.0e+18              noib=2.5e+4
+ noic=1.0e-13              em=4.1e+7                 ef=1.009
+ noimod=2                  sa0=0.35e-6               sb0=0.35e-6
+ kvsat=0.4                 wlod=0.5e-6               tku0=0.03
+ ku0=-0.62e-7              llodku0=1                 wlodku0=1
+ lku0=2.0e-7               wku0=0.7e-6               pku0=-0.5e-13
+ kvth0=5.2e-9              stk2=2.5e-9               steta0=-1.1e-10
+ lkvth0=-1.0e-8            wkvth0=2.2e-6             pkvth0=-5e-14
+ llodvth=1.0               wlodvth=1                 lodk2=1
+ lodeta0=2                 minr=1e-3                 imax=0.01
+ imelt=0.01
//
// **************************************************************
//                                                              *
//                1.2V PMOS DEVICES MODEL                       *
//                                                              *
// **************************************************************
//
     }
model pch bsim3v3  {
     1: type=p
+ lmin=8.00e-07-dxl         lmax=2.1e-05              wmin=1.0005e-05-dxw
+ wmax=0.0009001            tnom=25                   version=3.24
+ tox=toxp                  toxm=toxp                 xj=2.1e-07
+ nch=7.3e+17               lln=1                     lwn=1
+ wln=1                     wwn=-1                    lint=4e-09
+ ll=0                      lw=0                      lwl=0
+ wint=-6.5e-09             wl=0                      ww=0
+ wwl=0                     mobmod=1                  binunit=2
+ xl=-2.0e-08+dxl           xw=1.5e-08+dxw            dwg=0
+ dwb=0                     vth0=-0.2932273+dvthp     lvth0=-2.066847e-08+dlvthp
+ pvth0=0+dpvthp            k1=0.4394179              lk1=8.3678e-09
+ k2=-0.001+dk2p            lk2=0+dlk2p               k3=0
+ dvt0=0                    dvt1=0                    dvt2=0
+ dvt0w=0                   dvt1w=0                   dvt2w=0
+ nlx=0                     w0=0                      k3b=0
+ vfb=-1.031548             vsat=80000                pvsat=0+dpvsatp
+ lvsat=0+dlvsatp           ua=2.530576e-09           lua=-4.183904e-16
+ ub=-7.355376e-19          lub=1.031064e-25          uc=-1.865951e-10
+ luc=8.367809e-18          rdsw=445                  prwb=0
+ prwg=0                    wr=1                      u0=0.0139415
+ a0=1.312587               la0=-1.255171e-07         keta=-0.001
+ a1=0                      a2=0.99                   ags=0.3466435
+ lags=3.347123e-08         b0=0                      b1=0
+ voff=-0.1248322           lvoff=-1.673565e-09       nfactor=0.6832174
+ lnfactor=1.673561e-07     cit=0                     cdsc=0
+ cdscb=0                   cdscd=0                   eta0=0.0003741305
+ leta0=1.255171e-09        etab=-0.0001              dsub=0
+ pclm=0.77                 pdiblc1=0                 pdiblc2=0.0001
+ pdiblcb=0                 drout=0                   pscbe1=4.24e+08
+ pscbe2=1e-07              pvag=0                    delta=0.005
+ kt1=-0.1874826            lkt1=-2.510342e-08        kt2=0.01
+ at=103000                 ute=-1                    ua1=1.995804e-09
+ lua1=4.183904e-17         ub1=-3.364265e-18         lub1=1.422528e-25
+ uc1=-3.044239e-10         luc1=-2.568917e-17        kt1l=0
+ prt=0                     alpha0=0                  alpha1=0.001435
+ beta0=9.351               cj=cjp                    mj=0.4234
+ pb=0.9                    cjsw=cjswp                mjsw=0.1716
+ pbsw=0.9                  cjswg=cjswgp              mjswg=0.4413
+ pbswg=0.9                 tcj=0.000887              tcjsw=0.000298
+ tcjswg=0.000298           tpb=0.001643              tpbsw=0.001643
+ tpbswg=0.001643           js=1.80e-7                jsw=8.055e-13
+ cgdo=cgop                 cgso=cgop                 cgbo=0
+ capmod=3                  nqsmod=0                  xpart=1
+ cf=0                      tlev=1                    tlevc=1
+ xti=3                     n=1                       hdif=hdifp
+ ldif=8e-08                rsh=rshp                  rs=0
+ rd=0                      dlc=1.20e-8               wvth0=0+dwvthp
+ cgdl=cglp                 cgsl=cglp                 wwc=-4e-2
+ dwc=0                     noia=1.0e+19              noib=1.0e+3
+ noic=1.0e-11              em=1.0e+8                 ef=1.107
+ noimod=2                  sa0=0.35e-6               sb0=0.35e-6
+ kvsat=-0.6                wlod=0.3e-6               tku0=0.50
+ ku0=1.14e-7               llodku0=1                 wlodku0=1
+ lku0=6e-8                 wku0=3.0e-7               pku0=1e-14
+ kvth0=-2.3e-9             stk2=0e-9                 steta0=0
+ lkvth0=1e-8               wkvth0=2.5e-7             pkvth0=4e-14
+ llodvth=1                 wlodvth=1                 lodk2=1
+ lodeta0=1                 minr=1e-3                 imax=0.01
+ imelt=0.01

     2: type=p
+ lmin=3.50e-07-dxl         lmax=8.00e-07-dxl         wmin=1.0005e-05-dxw
+ wmax=0.0009001            tnom=25                   version=3.24
+ tox=toxp                  toxm=toxp                 xj=2.1e-07
+ nch=7.3e+17               lln=1                     lwn=1
+ wln=1                     wwn=-1                    lint=4e-09
+ ll=0                      lw=0                      lwl=0
+ wint=-6.5e-09             wl=0                      ww=0
+ wwl=0                     mobmod=1                  binunit=2
+ xl=-2.0e-08+dxl           xw=1.5e-08+dxw            dwg=0
+ dwb=0                     vth0=-0.3068838+dvthp     lvth0=-1.012566e-08+dlvthp
+ pvth0=0+dpvthp            k1=0.450257               k2=-0.001+dk2p
+ lk2=0+dlk2p               k3=0                      dvt0=0
+ dvt1=0                    dvt2=0                    dvt0w=0
+ dvt1w=0                   dvt2w=0                   nlx=0
+ w0=0                      k3b=0                     vfb=-1.013218
+ vsat=80000                ua=2.060176e-09           pvsat=0+dpvsatp
+ lvsat=0+dlvsatp           lua=-5.52409e-17          ub=-4.803356e-19
+ lub=-9.390952e-26         uc=-1.75756e-10           rdsw=445
+ prwb=0                    prwg=0                    wr=1
+ u0=0.0139415              a0=1.257333               la0=-8.286134e-08
+ keta=-0.001               a1=0                      a2=0.99
+ ags=0.3828444             lags=5.524101e-09         b0=0
+ b1=0                      voff=-0.1262845           lvoff=-5.524101e-10
+ nfactor=0.9               cit=0                     cdsc=0
+ cdscb=0                   cdscd=0                   eta0=0.001642222
+ leta0=2.762044e-10        etab=-0.0001              dsub=0
+ pclm=0.77                 pdiblc1=0                 pdiblc2=0.0001
+ pdiblcb=0                 drout=0                   pscbe1=4.24e+08
+ pscbe2=1e-07              pvag=0                    delta=0.005
+ kt1=-0.2343111            lkt1=1.104818e-08         kt2=0.01
+ at=155235.6               lat=-0.04032586           ute=-1.143111
+ lute=1.104818e-07         ua1=2.193111e-09          lua1=-1.104818e-16
+ ub1=-4.095911e-18         lub1=7.070835e-25         uc1=-3.017075e-10
+ luc1=-2.778616e-17        kt1l=0                    prt=0
+ alpha0=0                  alpha1=0.001435           beta0=9.351
+ cj=cjp                    mj=0.4234                 pb=0.9
+ cjsw=cjswp                mjsw=0.1716               pbsw=0.9
+ cjswg=cjswgp              mjswg=0.4413              pbswg=0.9
+ tcj=0.000887              tcjsw=0.000298            tcjswg=0.000298
+ tpb=0.001643              tpbsw=0.001643            tpbswg=0.001643
+ js=1.80e-7                jsw=8.055e-13             cgdo=cgop
+ cgso=cgop                 cgbo=0                    capmod=3
+ nqsmod=0                  xpart=1                   cf=0
+ tlev=1                    tlevc=1                   xti=3
+ n=1                       hdif=hdifp                ldif=8e-08
+ rsh=rshp                  rs=0                      rd=0
+ dlc=1.20e-8               wvth0=0+dwvthp            cgdl=cglp
+ cgsl=cglp                 wwc=-4e-2                 dwc=0
+ noia=1.0e+19              noib=1.0e+3               noic=1.0e-11
+ em=1.0e+8                 ef=1.107                  noimod=2
+ sa0=0.35e-6               sb0=0.35e-6               kvsat=-0.6
+ wlod=0.3e-6               tku0=0.50                 ku0=1.14e-7
+ llodku0=1                 wlodku0=1                 lku0=6e-8
+ wku0=3.0e-7               pku0=1e-14                kvth0=-2.3e-9
+ stk2=0e-9                 steta0=0                  lkvth0=1e-8
+ wkvth0=2.5e-7             pkvth0=4e-14              llodvth=1
+ wlodvth=1                 lodk2=1                   lodeta0=1
+ minr=1e-3                 imax=0.01                 imelt=0.01

     3: type=p
+ lmin=1.30e-07             lmax=3.50e-07-dxl         wmin=1.0005e-05-dxw
+ wmax=0.0009001            tnom=25                   version=3.24
+ tox=toxp                  toxm=toxp                 xj=2.1e-07
+ nch=7.3e+17               lln=1                     lwn=1
+ wln=1                     wwn=-1                    lint=4e-09
+ ll=0                      lw=0                      lwl=0
+ wint=-6.5e-09             wl=0                      ww=0
+ wwl=0                     mobmod=1                  binunit=2
+ xl=-2.0e-08+dxl           xw=1.5e-08+dxw            dwg=0
+ dwb=0                     vth0=-0.2995375+dvthp     lvth0=-1.2491168e-08+dlvthp
+ pvth0=0+dpvthp            k1=0.4363479              lk1=4.478727e-09
+ k2=-0.001+dk2p            lk2=0+dlk2p               k3=0
+ dvt0=0                    dvt1=0                    dvt2=0
+ dvt0w=0                   dvt1w=0                   dvt2w=0
+ nlx=0                     w0=0                      k3b=0
+ vfb=-0.9703192            vsat=7.5641820e+04        pvsat=0+dpvsatp
+ lvsat=1.4033344e-03+dlvsatp                         ua=1.999253e-09
+ lua=-3.562378e-17         ub=-6.570817e-19          lub=-3.699726e-26
+ uc=-1.75756e-10           rdsw=445                  prwb=0
+ prwg=0                    wr=1                      u0=0.0139415
+ a0=1                      keta=-0.001               a1=0
+ a2=0.99                   ags=0.4                   b0=0
+ b1=0                      voff=-0.1154818           lvoff=-4.030853e-09
+ nfactor=0.8072727         lnfactor=2.985818e-08     cit=-3.5236360e-04
+ lcit=1.1346109e-10        cdsc=0                    cdscb=0
+ cdscd=0                   eta0=1.8181870e-04        leta0=7.4645450e-10
+ etab=0.001476364          letab=-5.075891e-10       dsub=0
+ pclm=0.6633636            lpclm=3.433691e-08        pdiblc1=0
+ pdiblc2=-0.0003172727     lpdiblc2=1.343618e-10     pdiblcb=0
+ drout=0                   pscbe1=4.24e+08           pscbe2=1e-07
+ pvag=0                    delta=0.005               kt1=-0.1907273
+ lkt1=-2.985817e-09        kt2=0.01                  at=37881.82
+ lat=-0.002537945          ute=-0.8                  ua1=1.757273e-09
+ lua1=2.985817e-17         ub1=-1.649636e-18         lub1=-8.061709e-26
+ uc1=-4.113209e-10         luc1=7.50933e-18          kt1l=0
+ prt=0                     alpha0=0                  alpha1=0.001435
+ beta0=9.351               cj=cjp                    mj=0.4234
+ pb=0.9                    cjsw=cjswp                mjsw=0.1716
+ pbsw=0.9                  cjswg=cjswgp              mjswg=0.4413
+ pbswg=0.9                 tcj=0.000887              tcjsw=0.000298
+ tcjswg=0.000298           tpb=0.001643              tpbsw=0.001643
+ tpbswg=0.001643           js=1.80e-7                jsw=8.055e-13
+ cgdo=cgop                 cgso=cgop                 cgbo=0
+ capmod=3                  nqsmod=0                  xpart=1
+ cf=0                      tlev=1                    tlevc=1
+ xti=3                     n=1                       hdif=hdifp
+ ldif=8e-08                rsh=rshp                  rs=0
+ rd=0                      dlc=1.20e-8               wvth0=0+dwvthp
+ cgdl=cglp                 cgsl=cglp                 wwc=-4e-2
+ dwc=0                     noia=1.0e+19              noib=1.0e+3
+ noic=1.0e-11              em=1.0e+8                 ef=1.107
+ noimod=2                  sa0=0.35e-6               sb0=0.35e-6
+ kvsat=-0.6                wlod=0.3e-6               tku0=0.50
+ ku0=1.14e-7               llodku0=1                 wlodku0=1
+ lku0=6e-8                 wku0=3.0e-7               pku0=1e-14
+ kvth0=-2.3e-9             stk2=0e-9                 steta0=0
+ lkvth0=1e-8               wkvth0=2.5e-7             pkvth0=4e-14
+ llodvth=1                 wlodvth=1                 lodk2=1
+ lodeta0=1                 minr=1e-3                 imax=0.01
+ imelt=0.01

     4: type=p
+ lmin=8.00e-07-dxl         lmax=2.1e-05              wmin=1.205e-06-dxw
+ wmax=1.0005e-05-dxw       tnom=25                   version=3.24
+ tox=toxp                  toxm=toxp                 xj=2.1e-07
+ nch=7.3e+17               lln=1                     lwn=1
+ wln=1                     wwn=-1                    lint=4e-09
+ ll=0                      lw=0                      lwl=0
+ wint=-6.5e-09             wl=0                      ww=0
+ wwl=0                     mobmod=1                  binunit=2
+ xl=-2.0e-08+dxl           xw=1.5e-08+dxw            dwg=0
+ dwb=0                     vth0=-0.2946285+dvthp     lvth0=-2.066847e-08+dlvthp
+ pvth0=0+dpvthp            wvth0=1.405763e-08+dwvthp k1=0.4393003
+ lk1=9.540242e-09          wk1=1.179614e-09          pk1=-1.176312e-14
+ k2=-0.001+dk2p            lk2=0+dlk2p               k3=0
+ dvt0=0                    dvt1=0                    dvt2=0
+ dvt0w=0                   dvt1w=0                   dvt2w=0
+ nlx=0                     w0=0                      k3b=0
+ vfb=-1.031958             vsat=80000                pvsat=0+dpvsatp
+ lvsat=0+dlvsatp           ua=2.530576e-09           lua=-4.183904e-16
+ ub=-7.365039e-19          lub=9.877072e-26          wub=9.695372e-27
+ pub=4.35001e-32           uc=-1.881138e-10          luc=9.540252e-18
+ wuc=1.523722e-17          puc=-1.176313e-23         rdsw=445
+ prwb=0                    prwg=0                    wr=1
+ u0=0.0141423              lu0=1.172443e-11          wu0=-2.014606e-09
+ pu0=-1.176313e-16         a0=1.312587               la0=-1.255171e-07
+ keta=-0.001               a1=0                      a2=0.99
+ ags=0.3461732             lags=3.8161e-08           wags=4.718462e-09
+ pags=-4.705251e-14        b0=0                      b1=0
+ voff=-0.1240611           lvoff=-2.377031e-09       wvoff=-7.736563e-09
+ pvoff=7.057875e-15        nfactor=0.6756238         lnfactor=1.732184e-07
+ wnfactor=7.618609e-08     pnfactor=-5.881567e-14    cit=0
+ cdsc=0                    cdscb=0                   cdscd=0
+ eta0=0.0003741306         leta0=1.255171e-09        etab=-0.0001
+ dsub=0                    pclm=0.77                 pdiblc1=0
+ pdiblc2=0.0001            pdiblcb=0                 drout=0
+ pscbe1=4.24e+08           pscbe2=1e-07              pvag=0
+ delta=0.005               kt1=-0.1872475            lkt1=-2.744831e-08
+ wkt1=-2.359228e-09        pkt1=2.352626e-14         kt2=0.01
+ at=103000                 ute=-0.9976485            lute=-2.344887e-08
+ wute=-2.359231e-08        pute=2.352626e-13         ua1=1.969202e-09
+ lua1=1.370039e-17         wua1=2.668989e-16         pua1=2.823152e-22
+ ub1=-3.264863e-18         lub1=8.714795e-26         wub1=-9.973013e-25
+ pub1=5.528672e-31         uc1=-2.993632e-10         luc1=-3.284108e-17
+ wuc1=-5.077419e-17        puc1=7.175508e-23         kt1l=0
+ prt=0                     alpha0=0                  alpha1=0.001435
+ beta0=9.351               cj=cjp                    mj=0.4234
+ pb=0.9                    cjsw=cjswp                mjsw=0.1716
+ pbsw=0.9                  cjswg=cjswgp              mjswg=0.4413
+ pbswg=0.9                 tcj=0.000887              tcjsw=0.000298
+ tcjswg=0.000298           tpb=0.001643              tpbsw=0.001643
+ tpbswg=0.001643           js=1.80e-7                jsw=8.055e-13
+ cgdo=cgop                 cgso=cgop                 cgbo=0
+ capmod=3                  nqsmod=0                  xpart=1
+ cf=0                      tlev=1                    tlevc=1
+ xti=3                     n=1                       hdif=hdifp
+ ldif=8e-08                rsh=rshp                  rs=0
+ rd=0                      dlc=1.20e-8               cgdl=cglp
+ cgsl=cglp                 wwc=-4e-2                 dwc=0
+ noia=1.0e+19              noib=1.0e+3               noic=1.0e-11
+ em=1.0e+8                 ef=1.107                  noimod=2
+ sa0=0.35e-6               sb0=0.35e-6               kvsat=-0.6
+ wlod=0.3e-6               tku0=0.50                 ku0=1.14e-7
+ llodku0=1                 wlodku0=1                 lku0=6e-8
+ wku0=3.0e-7               pku0=1e-14                kvth0=-2.3e-9
+ stk2=0e-9                 steta0=0                  lkvth0=1e-8
+ wkvth0=2.5e-7             pkvth0=4e-14              llodvth=1
+ wlodvth=1                 lodk2=1                   lodeta0=1
+ minr=1e-3                 imax=0.01                 imelt=0.01

     5: type=p
+ lmin=3.50e-07-dxl         lmax=8.00e-07-dxl         wmin=1.205e-06-dxw
+ wmax=1.0005e-05-dxw       tnom=25                   version=3.24
+ tox=toxp                  toxm=toxp                 xj=2.1e-07
+ nch=7.3e+17               lln=1                     lwn=1
+ wln=1                     wwn=-1                    lint=4e-09
+ ll=0                      lw=0                      lwl=0
+ wint=-6.5e-09             wl=0                      ww=0
+ wwl=0                     mobmod=1                  binunit=2
+ xl=-2.0e-08+dxl           xw=1.5e-08+dxw            dwg=0
+ dwb=0                     vth0=-0.3084855+dvthp     lvth0=-9.970861e-09+dlvthp
+ wvth0=1.606939e-08+dwvthp pvth0=-1.553112e-15+dpvthp
+ k1=0.4526607              lk1=-7.739997e-10         wk1=-2.411658e-08
+ pk1=7.765538e-15          k2=-0.001+dk2p            lk2=0+dlk2p
+ k3=0                      dvt0=0                    dvt1=0
+ dvt2=0                    dvt0w=0                   dvt1w=0
+ dvt2w=0                   nlx=0                     w0=0
+ k3b=0                     vfb=-1.021218             vsat=80000
+ ua=2.070201e-09           lua=-6.298091e-17         pvsat=0+dpvsatp
+ lvsat=0+dlvsatp           wua=-1.0059e-16           pua=7.765547e-23
+ ub=-4.846101e-19          lub=-9.569127e-26         wub=4.288687e-26
+ pub=1.787626e-32          uc=-1.75756e-10           rdsw=445
+ prwb=0                    prwg=0                    wr=1
+ u0=0.01417167             lu0=-1.095212e-11         wu0=-2.309313e-09
+ pu0=1.098825e-16          a0=1.257333               la0=-8.286133e-08
+ keta=-0.001               a1=0                      a2=0.99
+ ags=0.3924593             lags=2.428099e-09         wags=-9.646639e-08
+ pags=3.106218e-14         b0=0                      b1=0
+ voff=-0.1264246           lvoff=-5.524101e-10       wvoff=1.405763e-09
+ nfactor=0.9               cit=0                     cdsc=0
+ cdscb=0                   cdscd=0                   eta0=0.001642222
+ leta0=2.762044e-10        etab=-0.0001              dsub=0
+ pclm=0.77                 pdiblc1=0                 pdiblc2=0.0001
+ pdiblcb=0                 drout=0                   pscbe1=4.24e+08
+ pscbe2=1e-07              pvag=0                    delta=0.005
+ kt1=-0.2401212            lkt1=1.337018e-08         wkt1=5.829218e-08
+ pkt1=-2.329663e-14        kt2=0.01                  at=155235.6
+ lat=-0.04032585           ute=-1.191186             lute=1.259618e-07
+ wute=4.82332e-07          pute=-1.553109e-13        ua1=2.115021e-09
+ lua1=-9.887172e-17        wua1=7.834772e-16         pua1=-1.164833e-22
+ ub1=-4.107992e-18         lub1=7.380436e-25         wub1=1.212076e-25
+ pub1=-3.106218e-31        uc1=-3.000959e-10         luc1=-3.227537e-17
+ wuc1=-1.616938e-17        puc1=4.504016e-23         kt1l=0
+ prt=0                     alpha0=0                  alpha1=0.001435
+ beta0=9.351               cj=cjp                    mj=0.4234
+ pb=0.9                    cjsw=cjswp                mjsw=0.1716
+ pbsw=0.9                  cjswg=cjswgp              mjswg=0.4413
+ pbswg=0.9                 tcj=0.000887              tcjsw=0.000298
+ tcjswg=0.000298           tpb=0.001643              tpbsw=0.001643
+ tpbswg=0.001643           js=1.80e-7                jsw=8.055e-13
+ cgdo=cgop                 cgso=cgop                 cgbo=0
+ capmod=3                  nqsmod=0                  xpart=1
+ cf=0                      tlev=1                    tlevc=1
+ xti=3                     n=1                       hdif=hdifp
+ ldif=8e-08                rsh=rshp                  rs=0
+ rd=0                      dlc=1.20e-8               cgdl=cglp
+ cgsl=cglp                 wwc=-4e-2                 dwc=0
+ noia=1.0e+19              noib=1.0e+3               noic=1.0e-11
+ em=1.0e+8                 ef=1.107                  noimod=2
+ sa0=0.35e-6               sb0=0.35e-6               kvsat=-0.6
+ wlod=0.3e-6               tku0=0.50                 ku0=1.14e-7
+ llodku0=1                 wlodku0=1                 lku0=6e-8
+ wku0=3.0e-7               pku0=1e-14                kvth0=-2.3e-9
+ stk2=0e-9                 steta0=0                  lkvth0=1e-8
+ wkvth0=2.5e-7             pkvth0=4e-14              llodvth=1
+ wlodvth=1                 lodk2=1                   lodeta0=1
+ minr=1e-3                 imax=0.01                 imelt=0.01

     6: type=p
+ lmin=1.30e-07             lmax=3.50e-07-dxl         wmin=1.205e-06-dxw
+ wmax=1.0005e-05-dxw       tnom=25                   version=3.24
+ tox=toxp                  toxm=toxp                 xj=2.1e-07
+ nch=7.3e+17               lln=1                     lwn=1
+ wln=1                     wwn=-1                    lint=4e-09
+ ll=0                      lw=0                      lwl=0
+ wint=-6.5e-09             wl=0                      ww=0
+ wwl=0                     mobmod=1                  binunit=2
+ xl=-2.0e-08+dxl           xw=1.5e-08+dxw            dwg=0
+ dwb=0                     vth0=-0.3007786+dvthp     lvth0=-1.2452491e-08+dlvthp
+ wvth0=1.2451168e-08+dwvthp                          pvth0=-3.8804420e-16+dpvthp
+ k1=0.4343991              lk1=5.106258e-09          wk1=1.955284e-08
+ pk1=-6.296016e-15         k2=-0.001+dk2p            lk2=0+dlk2p
+ k3=0                      dvt0=0                    dvt1=0
+ dvt2=0                    dvt0w=0                   dvt1w=0
+ dvt2w=0                   nlx=0                     w0=0
+ k3b=0                     vfb=-0.9415483            vsat=7.5100910e+04
+ lvsat=1.5775075e-03+dlvsatp                         wvsat=5.4269470e-03
+ pvsat=-1.7474771e-09+dpvsatp                        ua=1.97713e-09
+ lua=-3.3012e-17           wua=2.219549e-16          pua=-2.6204e-23
+ ub=-6.506528e-19          lub=-4.222554e-26         wub=-6.450149e-26
+ pub=5.245532e-32          uc=-1.75756e-10           rdsw=445
+ prwb=0                    prwg=0                    wr=1
+ u0=0.01419055             lu0=-1.703087e-11         wu0=-2.498718e-09
+ pu0=1.708708e-16          a0=1                      keta=-0.001
+ a1=0                      a2=0.99                   ags=0.4
+ b0=0                      b1=0                      voff=-0.1158204
+ lvoff=-3.966937e-09       wvoff=3.397306e-09        pvoff=-6.412771e-16
+ nfactor=0.8082265         lnfactor=2.955105e-08     wnfactor=-9.569868e-09
+ pnfactor=3.081497e-15     cit=-4.0173460e-04        lcit=1.2935854e-10
+ wcit=4.9533890e-10        pcit=-1.5949910e-16       cdsc=0
+ cdscb=0                   cdscd=0                   eta0=1.5685277e-04
+ leta0=7.5449350e-10       weta0=2.5048039e-10       peta0=-8.0654780e-17
+ etab=0.001460148          letab=-5.023678e-10       wetab=1.626878e-10
+ petab=-5.238544e-17       dsub=0                    pclm=0.6714336
+ lpclm=3.173837e-08        wpclm=-8.096643e-08       ppclm=2.607119e-14
+ pdiblc1=0                 pdiblc2=-0.0003129804     lpdiblc2=1.329797e-10
+ wpdiblc2=-4.306437e-11    ppdiblc2=1.386674e-17     pdiblcb=0
+ drout=0                   pscbe1=4.24e+08           pscbe2=1e-07
+ pvag=0                    delta=0.005               kt1=-0.1887242
+ lkt1=-3.179637e-09        wkt1=-2.00967e-08         pkt1=1.944595e-15
+ kt2=0.01                  at=37800.74               lat=-0.002511839
+ wat=0.0008134381          pat=-2.619272e-10         ute=-0.8
+ ua1=1.691787e-09          lua1=3.740971e-17         wua1=6.570216e-16
+ pua1=-7.576462e-23        ub1=-1.550013e-18         lub1=-8.562571e-26
+ wub1=-9.995162e-25        pub1=5.025138e-32         uc1=-4.330339e-10
+ luc1=1.053065e-17         wuc1=2.178463e-16         puc1=-3.031291e-23
+ kt1l=0                    prt=0                     alpha0=0
+ alpha1=0.001435           beta0=9.351               cj=cjp
+ mj=0.4234                 pb=0.9                    cjsw=cjswp
+ mjsw=0.1716               pbsw=0.9                  cjswg=cjswgp
+ mjswg=0.4413              pbswg=0.9                 tcj=0.000887
+ tcjsw=0.000298            tcjswg=0.000298           tpb=0.001643
+ tpbsw=0.001643            tpbswg=0.001643           js=1.80e-7
+ jsw=8.055e-13             cgdo=cgop                 cgso=cgop
+ cgbo=0                    capmod=3                  nqsmod=0
+ xpart=1                   cf=0                      tlev=1
+ tlevc=1                   xti=3                     n=1
+ hdif=hdifp                ldif=8e-08                rsh=rshp
+ rs=0                      rd=0                      dlc=1.20e-8
+ cgdl=cglp                 cgsl=cglp                 wwc=-4e-2
+ dwc=0                     noia=1.0e+19              noib=1.0e+3
+ noic=1.0e-11              em=1.0e+8                 ef=1.107
+ noimod=2                  sa0=0.35e-6               sb0=0.35e-6
+ kvsat=-0.6                wlod=0.3e-6               tku0=0.50
+ ku0=1.14e-7               llodku0=1                 wlodku0=1
+ lku0=6e-8                 wku0=3.0e-7               pku0=1e-14
+ kvth0=-2.3e-9             stk2=0e-9                 steta0=0
+ lkvth0=1e-8               wkvth0=2.5e-7             pkvth0=4e-14
+ llodvth=1                 wlodvth=1                 lodk2=1
+ lodeta0=1                 minr=1e-3                 imax=0.01
+ imelt=0.01

     7: type=p
+ lmin=8.00e-07-dxl         lmax=2.1e-05              wmin=5.85e-07-dxw
+ wmax=1.205e-06-dxw        tnom=25                   version=3.24
+ tox=toxp                  toxm=toxp                 xj=2.1e-07
+ nch=7.3e+17               lln=1                     lwn=1
+ wln=1                     wwn=-1                    lint=4e-09
+ ll=0                      lw=0                      lwl=0
+ wint=-6.5e-09             wl=0                      ww=0
+ wwl=0                     mobmod=1                  binunit=2
+ xl=-2.0e-08+dxl           xw=1.5e-08+dxw            dwg=0
+ dwb=0                     vth0=-0.2969828+dvthp     lvth0=-1.4629e-08+dlvthp
+ wvth0=1.696048e-08+dwvthp pvth0=-7.446704e-15+dpvthp
+ k1=0.4711628              lk1=-1.240999e-08         wk1=-3.810682e-08
+ pk1=1.530152e-14          k2=-0.001+dk2p            lk2=0+dlk2p
+ k3=0                      dvt0=0                    dvt1=0
+ dvt2=0                    dvt0w=0                   dvt1w=0
+ dvt2w=0                   nlx=0                     w0=0
+ k3b=0                     vfb=-1.023573             vsat=7.9751100e+04
+ lvsat=2.4820000e-03+dlvsatp                         wvsat=3.0688976e-04
+ pvsat=-3.0603062e-09+dpvsatp                        ua=2.530576e-09
+ lua=-4.183904e-16         ub=-7.175091e-19          lub=1.216406e-25
+ wub=-1.372522e-26         pub=1.530152e-32          uc=-1.75756e-10
+ rdsw=445                  prwb=0                    prwg=0
+ wr=1                      u0=1.2917879e-02          lu0=5.1613850e-10
+ wu0=-5.0489850e-10        pu0=-7.3957400e-16        a0=1.312587
+ la0=-1.255171e-07         keta=-0.001               a1=0
+ a2=0.99                   ags=0.35                  b0=0
+ b1=0                      voff=-0.1306675           lvoff=6.656445e-09
+ wvoff=4.091857e-10        pvoff=-4.080401e-15       nfactor=0.737413
+ lnfactor=1.255171e-07     cit=0                     cdsc=0
+ cdscb=0                   cdscd=0                   eta0=0.0003741305
+ leta0=1.255171e-09        etab=-0.0001              dsub=0
+ pclm=0.77                 pdiblc1=0                 pdiblc2=0.0001
+ pdiblcb=0                 drout=0                   pscbe1=4.24e+08
+ pscbe2=1e-07              pvag=0                    delta=0.005
+ kt1=-0.1891609            lkt1=-8.367812e-09        kt2=0.01
+ at=103000                 ute=-1.016783             lute=1.673561e-07
+ ua1=2.3319e-09            lua1=8.54893e-16          wua1=-1.803072e-16
+ pua1=-7.548755e-22        ub1=-4.149071e-18         lub1=-9.323311e-26
+ wub1=9.29261e-26          pub1=7.752772e-31         uc1=-3.108813e-10
+ luc1=2.535445e-17         wuc1=-3.657238e-17        kt1l=0
+ prt=0                     alpha0=0                  alpha1=0.001435
+ beta0=9.351               cj=cjp                    mj=0.4234
+ pb=0.9                    cjsw=cjswp                mjsw=0.1716
+ pbsw=0.9                  cjswg=cjswgp              mjswg=0.4413
+ pbswg=0.9                 tcj=0.000887              tcjsw=0.000298
+ tcjswg=0.000298           tpb=0.001643              tpbsw=0.001643
+ tpbswg=0.001643           js=1.80e-7                jsw=8.055e-13
+ cgdo=cgop                 cgso=cgop                 cgbo=0
+ capmod=3                  nqsmod=0                  xpart=1
+ cf=0                      tlev=1                    tlevc=1
+ xti=3                     n=1                       hdif=hdifp
+ ldif=8e-08                rsh=rshp                  rs=0
+ rd=0                      dlc=1.20e-8               cgdl=cglp
+ cgsl=cglp                 wwc=-4e-2                 dwc=0
+ noia=1.0e+19              noib=1.0e+3               noic=1.0e-11
+ em=1.0e+8                 ef=1.107                  noimod=2
+ sa0=0.35e-6               sb0=0.35e-6               kvsat=-0.6
+ wlod=0.3e-6               tku0=0.50                 ku0=1.14e-7
+ llodku0=1                 wlodku0=1                 lku0=6e-8
+ wku0=3.0e-7               pku0=1e-14                kvth0=-2.3e-9
+ stk2=0e-9                 steta0=0                  lkvth0=1e-8
+ wkvth0=2.5e-7             pkvth0=4e-14              llodvth=1
+ wlodvth=1                 lodk2=1                   lodeta0=1
+ minr=1e-3                 imax=0.01                 imelt=0.01

     8: type=p
+ lmin=3.50e-07-dxl         lmax=8.00e-07-dxl         wmin=5.85e-07-dxw
+ wmax=1.205e-06-dxw        tnom=25                   version=3.24
+ tox=toxp                  toxm=toxp                 xj=2.1e-07
+ nch=7.3e+17               lln=1                     lwn=1
+ wln=1                     wwn=-1                    lint=4e-09
+ ll=0                      lw=0                      lwl=0
+ wint=-6.5e-09             wl=0                      ww=0
+ wwl=0                     mobmod=1                  binunit=2
+ xl=-2.0e-08+dxl           xw=1.5e-08+dxw            dwg=0
+ dwb=0                     vth0=-0.3049012+dvthp     lvth0=-8.516014e-09+dlvthp
+ wvth0=1.16499e-08+dwvthp  pvth0=-3.346938e-15+dpvthp
+ k1=0.4443947              lk1=8.254944e-09          wk1=-1.392461e-08
+ pk1=-3.367149e-15         k2=-0.001+dk2p            lk2=0+dlk2p
+ k3=0                      dvt0=0                    dvt1=0
+ dvt2=0                    dvt0w=0                   dvt1w=0
+ dvt2w=0                   nlx=0                     w0=0
+ k3b=0                     vfb=-1.003068             vsat=8.5088560e+04
+ lvsat=-1.6385169e-03+dlvsatp                        wvsat=-6.2741950e-03
+ pvsat=2.0202910e-09+dpvsatp                         ua=1.995695e-09
+ lua=-5.461724e-18         wua=-8.723193e-18         pua=6.734304e-24
+ ub=-2.515979e-19          lub=-2.380428e-25         wub=-2.444172e-25
+ pub=1.933957e-31          uc=-1.75756e-10           rdsw=445
+ prwb=0                    prwg=0                    wr=1
+ u0=1.3768193e-02          lu0=-1.4030341e-10        wu0=-1.8118242e-09
+ pu0=2.6937265e-16         a0=1.257333               la0=-8.286133e-08
+ keta=-0.001               a1=0                      a2=0.99
+ ags=0.3142222             lags=2.762046e-08         b0=0
+ b1=0                      voff=-0.124867            lvoff=2.178457e-09
+ wvoff=-5.147034e-10       pvoff=-3.367159e-15       nfactor=0.9
+ cit=0                     cdsc=0                    cdscb=0
+ cdscd=0                   eta0=0.001642222          leta0=2.762044e-10
+ etab=-0.0001              dsub=0                    pclm=0.77
+ pdiblc1=0                 pdiblc2=0.0001            pdiblcb=0
+ drout=0                   pscbe1=4.24e+08           pscbe2=1e-07
+ pvag=0                    delta=0.005               kt1=-0.1999192
+ lkt1=-6.23589e-11         wkt1=8.723196e-09         pkt1=-6.734307e-15
+ kt2=0.01                  at=155235.6               lat=-0.04032585
+ ute=-0.8                  ua1=4.715561e-09          lua1=-9.852931e-16
+ wua1=-2.422988e-15        pua1=9.76474e-22          ub1=-6.668221e-18
+ lub1=1.851551e-24         wub1=3.277969e-24         pub1=-1.683576e-30
+ uc1=-3.243699e-10         luc1=3.57677e-17          wuc1=1.376045e-17
+ puc1=-3.885694e-23        kt1l=0                    prt=0
+ alpha0=0                  alpha1=0.001435           beta0=9.351
+ cj=cjp                    mj=0.4234                 pb=0.9
+ cjsw=cjswp                mjsw=0.1716               pbsw=0.9
+ cjswg=cjswgp              mjswg=0.4413              pbswg=0.9
+ tcj=0.000887              tcjsw=0.000298            tcjswg=0.000298
+ tpb=0.001643              tpbsw=0.001643            tpbswg=0.001643
+ js=1.80e-7                jsw=8.055e-13             cgdo=cgop
+ cgso=cgop                 cgbo=0                    capmod=3
+ nqsmod=0                  xpart=1                   cf=0
+ tlev=1                    tlevc=1                   xti=3
+ n=1                       hdif=hdifp                ldif=8e-08
+ rsh=rshp                  rs=0                      rd=0
+ dlc=1.20e-8               cgdl=cglp                 cgsl=cglp
+ wwc=-4e-2                 dwc=0                     noia=1.0e+19
+ noib=1.0e+3               noic=1.0e-11              em=1.0e+8
+ ef=1.107                  noimod=2                  sa0=0.35e-6
+ sb0=0.35e-6               kvsat=-0.6                wlod=0.3e-6
+ tku0=0.50                 ku0=1.14e-7               llodku0=1
+ wlodku0=1                 lku0=6e-8                 wku0=3.0e-7
+ pku0=1e-14                kvth0=-2.3e-9             stk2=0e-9
+ steta0=0                  lkvth0=1e-8               wkvth0=2.5e-7
+ pkvth0=4e-14              llodvth=1                 wlodvth=1
+ lodk2=1                   lodeta0=1                 minr=1e-3
+ imax=0.01                 imelt=0.01

     9: type=p
+ lmin=1.30e-07             lmax=3.50e-07-dxl         wmin=5.85e-07-dxw
+ wmax=1.205e-06-dxw        tnom=25                   version=3.24
+ tox=toxp                  toxm=toxp                 xj=2.1e-07
+ nch=7.3e+17               lln=1                     lwn=1
+ wln=1                     wwn=-1                    lint=4e-09
+ ll=0                      lw=0                      lwl=0
+ wint=-6.5e-09             wl=0                      ww=0
+ wwl=0                     mobmod=1                  binunit=2
+ xl=-2.0e-08+dxl           xw=1.5e-08+dxw            dwg=0
+ dwb=0                     vth0=-0.2904834+dvthp     lvth0=-1.315855e-08+dlvthp
+ wvth0=-2.428481e-10+dwvthp                          pvth0=4.825279e-16+dpvthp
+ k1=0.4872531              lk1=-5.545465e-09         wk1=-4.561625e-08
+ pk1=6.837558e-15          k2=-0.001+dk2p            lk2=0+dlk2p
+ k3=0                      dvt0=0                    dvt1=0
+ dvt2=0                    dvt0w=0                   dvt1w=0
+ dvt2w=0                   nlx=0                     w0=0
+ k3b=0                     vfb=-0.9594337            vsat=7.8026160e+04
+ lvsat=6.3557680e-04+dlvsatp                         wvsat=1.8201134e-03
+ pvsat=-5.8607660e-10+dpvsatp                        ua=2.142335e-09
+ lua=-5.267981e-17         wua=1.825783e-17          pua=-1.953588e-24
+ ub=-9.879987e-19          lub=-9.217233e-28         wub=3.514461e-25
+ pub=1.527712e-33          uc=-1.48693e-10           luc=-8.714301e-18
+ wuc=-3.336873e-17         puc=1.074473e-23          rdsw=445
+ prwb=0                    prwg=0                    wr=1
+ u0=1.2659749e-02          lu0=2.1661563e-10         wu0=-6.1124070e-10
+ pu0=-1.1721530e-16        a0=1                      keta=-0.001
+ a1=0                      a2=0.99                   ags=0.4
+ b0=0                      b1=0                      voff=-0.1046588
+ lvoff=-4.328589e-09       wvoff=-1.036501e-08       pvoff=-1.953594e-16
+ nfactor=0.800465          lnfactor=3.205024e-08     cit=0
+ cdsc=0                    cdscb=0                   cdscd=0
+ eta0=-3.364374e-05        leta0=8.158335e-10        weta0=4.853635e-10
+ peta0=-1.562871e-16       etab=0.001346065          letab=-4.65633e-10
+ wetab=3.033523e-10        petab=-9.767944e-17       dsub=0
+ pclm=0.5565619            lpclm=6.872708e-08        wpclm=6.067044e-08
+ ppclm=-1.953589e-14       pdiblc1=0                 pdiblc2=-0.0006923457
+ lpdiblc2=2.551354e-10     wpdiblc2=4.246931e-10     ppdiblc2=-1.367512e-16
+ pdiblcb=0                 drout=0                   pscbe1=4.24e+08
+ pscbe2=1e-07              pvag=0                    delta=0.005
+ kt1=-0.185295             lkt1=-4.771351e-09        wkt1=-2.432489e-08
+ pkt1=3.907179e-15         kt2=0.01                  at=38460.46
+ lat=-0.00272427           ute=-0.8                  ua1=1.435063e-09
+ lua1=7.102744e-17         wua1=9.735622e-16         pua1=-1.172153e-22
+ ub1=-3.063422e-19         lub1=-1.969745e-25        wub1=-2.532963e-24
+ pub1=1.875445e-31         uc1=-2.545728e-10         luc1=1.329303e-17
+ wuc1=-2.19609e-18         puc1=-3.371893e-23        kt1l=0
+ prt=0                     alpha0=0                  alpha1=0.001435
+ beta0=9.351               cj=cjp                    mj=0.4234
+ pb=0.9                    cjsw=cjswp                mjsw=0.1716
+ pbsw=0.9                  cjswg=cjswgp              mjswg=0.4413
+ pbswg=0.9                 tcj=0.000887              tcjsw=0.000298
+ tcjswg=0.000298           tpb=0.001643              tpbsw=0.001643
+ tpbswg=0.001643           js=1.80e-7                jsw=8.055e-13
+ cgdo=cgop                 cgso=cgop                 cgbo=0
+ capmod=3                  nqsmod=0                  xpart=1
+ cf=0                      tlev=1                    tlevc=1
+ xti=3                     n=1                       hdif=hdifp
+ ldif=8e-08                rsh=rshp                  rs=0
+ rd=0                      dlc=1.20e-8               cgdl=cglp
+ cgsl=cglp                 wwc=-4e-2                 dwc=0
+ noia=1.0e+19              noib=1.0e+3               noic=1.0e-11
+ em=1.0e+8                 ef=1.107                  noimod=2
+ sa0=0.35e-6               sb0=0.35e-6               kvsat=-0.6
+ wlod=0.3e-6               tku0=0.50                 ku0=1.14e-7
+ llodku0=1                 wlodku0=1                 lku0=6e-8
+ wku0=3.0e-7               pku0=1e-14                kvth0=-2.3e-9
+ stk2=0e-9                 steta0=0                  lkvth0=1e-8
+ wkvth0=2.5e-7             pkvth0=4e-14              llodvth=1
+ wlodvth=1                 lodk2=1                   lodeta0=1
+ minr=1e-3                 imax=0.01                 imelt=0.01

     10: type=p
+ lmin=8.00e-07-dxl         lmax=2.1e-05              wmin=1.50e-07
+ wmax=5.85e-07-dxw         tnom=25                   version=3.24
+ tox=toxp                  toxm=toxp                 xj=2.1e-07
+ nch=7.3e+17               lln=1                     lwn=1
+ wln=1                     wwn=-1                    lint=4e-09
+ ll=0                      lw=0                      lwl=0
+ wint=-6.5e-09             wl=0                      ww=0
+ wwl=0                     mobmod=1                  binunit=2
+ xl=-2.0e-08+dxl           xw=1.5e-08+dxw            dwg=0
+ dwb=0                     vth0=-0.2798276+dvthp     lvth0=-3.129704e-08+dlvthp
+ wvth0=6.444338e-09+dwvthp pvth0=2.77081e-15+dpvthp  k1=0.4469916
+ lk1=1.015345e-08          wk1=-2.32899e-08          pk1=1.470128e-15
+ k2=-0.001+dk2p            lk2=0+dlk2p               k3=0
+ dvt0=0                    dvt1=0                    dvt2=0
+ dvt0w=0                   dvt1w=0                   dvt2w=0
+ nlx=0                     w0=0                      k3b=0
+ vfb=-0.9818085            vsat=8.0251740e+04        pvsat=0+dpvsatp
+ lvsat=-2.5103423e-03+dlvsatp                        ua=2.527534e-09
+ lua=-3.880463e-16         wua=1.865315e-18          pua=-1.860093e-23
+ ub=-4.750965e-19          lub=4.64211e-26           wub=-1.623242e-25
+ pub=6.14111e-32           uc=-1.75756e-10           rdsw=445
+ prwb=0                    prwg=0                    wr=1
+ u0=1.2096630e-02          lu0=-7.1431280e-10        wu0=-1.4734067e-12
+ pu0=1.4692774e-17         a0=1.312587               la0=-1.255171e-07
+ keta=-0.001               a1=0                      a2=0.99
+ ags=0.35                  b0=0                      b1=0
+ voff=-0.128429            lvoff=-4.371794e-09       wvoff=-9.630188e-10
+ pvoff=2.67991e-15         nfactor=0.737413          lnfactor=1.255171e-07
+ cit=0                     cdsc=0                    cdscb=0
+ cdscd=0                   eta0=0.0003741306         leta0=1.255171e-09
+ etab=-0.0001              dsub=0                    pclm=0.77
+ pdiblc1=0                 pdiblc2=0.0001            pdiblcb=0
+ drout=0                   pscbe1=4.24e+08           pscbe2=1e-07
+ pvag=0                    delta=0.005               kt1=-0.1930813
+ lkt1=-6.920771e-09        wkt1=2.403198e-09         pkt1=-8.870365e-16
+ kt2=0.01                  at=103000                 ute=-1.016783
+ lute=1.673561e-07         ua1=2.048204e-09          lua1=-6.689221e-16
+ wua1=-6.401409e-18        pua1=1.792233e-22         ub1=-4.325127e-18
+ lub1=1.803517e-24         wub1=2.008491e-25         pub1=-3.874307e-31
+ uc1=-3.768008e-10         luc1=4.635038e-17         wuc1=3.836331e-18
+ puc1=-1.287051e-23        kt1l=0                    prt=0
+ alpha0=0                  alpha1=0.001435           beta0=9.351
+ cj=cjp                    mj=0.4234                 pb=0.9
+ cjsw=cjswp                mjsw=0.1716               pbsw=0.9
+ cjswg=cjswgp              mjswg=0.4413              pbswg=0.9
+ tcj=0.000887              tcjsw=0.000298            tcjswg=0.000298
+ tpb=0.001643              tpbsw=0.001643            tpbswg=0.001643
+ js=1.80e-7                jsw=8.055e-13             cgdo=cgop
+ cgso=cgop                 cgbo=0                    capmod=3
+ nqsmod=0                  xpart=1                   cf=0
+ tlev=1                    tlevc=1                   xti=3
+ n=1                       hdif=hdifp                ldif=8e-08
+ rsh=rshp                  rs=0                      rd=0
+ dlc=1.20e-8               cgdl=cglp                 cgsl=cglp
+ wwc=-4e-2                 dwc=0                     noia=1.0e+19
+ noib=1.0e+3               noic=1.0e-11              em=1.0e+8
+ ef=1.107                  noimod=2                  sa0=0.35e-6
+ sb0=0.35e-6               kvsat=-0.6                wlod=0.3e-6
+ tku0=0.50                 ku0=1.14e-7               llodku0=1
+ wlodku0=1                 lku0=6e-8                 wku0=3.0e-7
+ pku0=1e-14                kvth0=-2.3e-9             stk2=0e-9
+ steta0=0                  lkvth0=1e-8               wkvth0=2.5e-7
+ pkvth0=4e-14              llodvth=1                 wlodvth=1
+ lodk2=1                   lodeta0=1                 minr=1e-3
+ imax=0.01                 imelt=0.01

     11: type=p
+ lmin=3.50e-07-dxl         lmax=8.00e-07-dxl         wmin=1.50e-07
+ wmax=5.85e-07-dxw         tnom=25                   version=3.24
+ tox=toxp                  toxm=toxp                 xj=2.1e-07
+ nch=7.3e+17               lln=1                     lwn=1
+ wln=1                     wwn=-1                    lint=4e-09
+ ll=0                      lw=0                      lwl=0
+ wint=-6.5e-09             wl=0                      ww=0
+ wwl=0                     mobmod=1                  binunit=2
+ xl=-2.0e-08+dxl           xw=1.5e-08+dxw            dwg=0
+ dwb=0                     vth0=-0.3039332+dvthp     lvth0=-1.26875e-08+dlvthp
+ wvth0=1.105655e-08+dwvthp pvth0=-7.898166e-16+dpvthp
+ k1=0.4581052              lk1=1.573731e-09          wk1=-2.232916e-08
+ pk1=7.28435e-16           k2=-0.001+dk2p            lk2=0+dlk2p
+ k3=0                      dvt0=0                    dvt1=0
+ dvt2=0                    dvt0w=0                   dvt1w=0
+ dvt2w=0                   nlx=0                     w0=0
+ k3b=0                     vfb=-0.9606453            vsat=7.3974930e+04
+ lvsat=2.3353568e-03+dlvsatp                         wvsat=5.3846300e-04
+ pvsat=-4.1569350e-10+dpvsatp                        ua=2.014799e-09
+ lua=7.784523e-18          wua=-2.043428e-17         pua=-1.385645e-24
+ ub=-5.357826e-19          lub=9.327074e-26          wub=-7.021202e-26
+ pub=-9.699508e-33         uc=-1.75756e-10           rdsw=445
+ prwb=0                    prwg=0                    wr=1
+ u0=1.0734105e-02          lu0=3.3755760e-10         wu0=4.8071810e-11
+ pu0=-2.3556135e-17        a0=1.257333               la0=-8.286133e-08
+ keta=-0.001               a1=0                      a2=0.99
+ ags=0.3142222             lags=2.762046e-08         b0=0
+ b1=0                      voff=-0.1324338           lvoff=-1.280073e-09
+ wvoff=4.123756e-09        pvoff=-1.24708e-15        nfactor=0.9
+ cit=0                     cdsc=0                    cdscb=0
+ cdscd=0                   eta0=0.001642222          leta0=2.762044e-10
+ etab=-0.0001              dsub=0                    pclm=0.77
+ pdiblc1=0                 pdiblc2=0.0001            pdiblcb=0
+ drout=0                   pscbe1=4.24e+08           pscbe2=1e-07
+ pvag=0                    delta=0.005               kt1=-0.1848069
+ lkt1=-1.330861e-08        wkt1=-5.406888e-10        pkt1=1.385644e-15
+ kt2=0.01                  at=155235.6               lat=-0.04032585
+ ute=-0.8                  ua1=1.310912e-10          lua1=8.110887e-16
+ wua1=3.87292e-16          pua1=-1.24708e-22         ub1=-4.491228e-19
+ lub1=-1.188759e-24        wub1=-5.343381e-25        pub1=1.801338e-31
+ uc1=-2.573048e-10         luc1=-4.590057e-17        wuc1=-2.735048e-17
+ puc1=1.120571e-23         kt1l=0                    prt=0
+ alpha0=0                  alpha1=0.001435           beta0=9.351
+ cj=cjp                    mj=0.4234                 pb=0.9
+ cjsw=cjswp                mjsw=0.1716               pbsw=0.9
+ cjswg=cjswgp              mjswg=0.4413              pbswg=0.9
+ tcj=0.000887              tcjsw=0.000298            tcjswg=0.000298
+ tpb=0.001643              tpbsw=0.001643            tpbswg=0.001643
+ js=1.80e-7                jsw=8.055e-13             cgdo=cgop
+ cgso=cgop                 cgbo=0                    capmod=3
+ nqsmod=0                  xpart=1                   cf=0
+ tlev=1                    tlevc=1                   xti=3
+ n=1                       hdif=hdifp                ldif=8e-08
+ rsh=rshp                  rs=0                      rd=0
+ dlc=1.20e-8               cgdl=cglp                 cgsl=cglp
+ wwc=-4e-2                 dwc=0                     noia=1.0e+19
+ noib=1.0e+3               noic=1.0e-11              em=1.0e+8
+ ef=1.107                  noimod=2                  sa0=0.35e-6
+ sb0=0.35e-6               kvsat=-0.6                wlod=0.3e-6
+ tku0=0.50                 ku0=1.14e-7               llodku0=1
+ wlodku0=1                 lku0=6e-8                 wku0=3.0e-7
+ pku0=1e-14                kvth0=-2.3e-9             stk2=0e-9
+ steta0=0                  lkvth0=1e-8               wkvth0=2.5e-7
+ pkvth0=4e-14              llodvth=1                 wlodvth=1
+ lodk2=1                   lodeta0=1                 minr=1e-3
+ imax=0.01                 imelt=0.01

     12: type=p
+ lmin=1.30e-07             lmax=3.50e-07-dxl         wmin=1.50e-07
+ wmax=5.85e-07-dxw         tnom=25                   version=3.24
+ tox=toxp                  toxm=toxp                 xj=2.1e-07
+ nch=7.3e+17               lln=1                     lwn=1
+ wln=1                     wwn=-1                    lint=4e-09
+ ll=0                      lw=0                      lwl=0
+ wint=-6.5e-09             wl=0                      ww=0
+ wwl=0                     mobmod=1                  binunit=2
+ xl=-2.0e-08+dxl           xw=1.5e-08+dxw            dwg=0
+ dwb=0                     vth0=-0.3048250+dvthp     lvth0=-1.2400367e-08+dlvthp
+ wvth0=8.5485470e-09+dwvthp                          pvth0=1.7760218e-17+dpvthp
+ k1=0.4427917              lk1=6.504686e-09          wk1=-1.83614e-08
+ pk1=-5.491839e-16         k2=-0.001+dk2p            lk2=0+dlk2p
+ k3=0                      dvt0=0                    dvt1=0
+ dvt2=0                    dvt0w=0                   dvt1w=0
+ dvt2w=0                   nlx=0                     w0=0
+ k3b=0                     vfb=-0.9194162            vsat=8.1796750e+04
+ lvsat=-1.8327007e-04+dlvsatp                        wvsat=-4.9125760e-04
+ pvsat=-8.4123390e-11+dpvsatp                        ua=2.236433e-09
+ lua=-6.358157e-17         wua=-3.942444e-17         pua=4.729189e-24
+ ub=-1.957686e-19          lub=-1.621375e-26         wub=-1.34191e-25
+ pub=1.090173e-32          uc=-2.152362e-10          luc=1.271263e-17
+ wuc=7.422278e-18          puc=-2.389974e-24         rdsw=445
+ prwb=0                    prwg=0                    wr=1
+ u0=1.1699615e-02          lu0=2.6663165e-11         wu0=-2.2678760e-11
+ pu0=-7.7444550e-19        a0=1                      keta=-0.001
+ a1=0                      a2=0.99                   ags=0.4
+ b0=0                      b1=0                      voff=-0.1196788
+ lvoff=-5.387188e-09       wvoff=-1.157738e-09       pvoff=4.535614e-16
+ nfactor=0.7974537         lnfactor=3.30199e-08      wnfactor=1.845967e-09
+ pnfactor=-5.944019e-16    cit=0                     cdsc=0
+ cdscb=0                   cdscd=0                   eta0=0.0008490036
+ leta0=5.316207e-10        weta0=-5.569997e-11       peta0=1.793541e-17
+ etab=0.002002198          letab=-6.769076e-10       wetab=-9.885673e-11
+ petab=3.183187e-17        dsub=0                    pclm=0.6500209
+ lpclm=3.863327e-08        wpclm=3.380071e-09        ppclm=-1.088382e-15
+ pdiblc1=0                 pdiblc2=0.0001410173      lpdiblc2=-1.32076e-11
+ wpdiblc2=-8.615851e-11    ppdiblc2=2.774305e-17     pdiblcb=0
+ drout=0                   pscbe1=4.24e+08           pscbe2=1e-07
+ pvag=0                    delta=0.005               kt1=-0.2279583
+ lkt1=5.861558e-10         wkt1=1.827687e-09         pkt1=6.230266e-16
+ kt2=0.01                  at=38101.16               lat=-0.002608573
+ wat=0.0002202548          pat=-7.092206e-11         ute=-0.8
+ ua1=3.024294e-09          lua1=-1.205227e-16        wua1=-6.363516e-19
+ pua1=2.049077e-25         ub1=-4.582381e-18         lub1=1.421507e-25
+ wub1=8.824908e-26         pub1=-2.033927e-32        uc1=-2.43311e-10
+ luc1=-5.040653e-17        wuc1=-9.099546e-18        puc1=5.328908e-24
+ kt1l=0                    prt=0                     alpha0=0
+ alpha1=0.001435           beta0=9.351               cj=cjp
+ mj=0.4234                 pb=0.9                    cjsw=cjswp
+ mjsw=0.1716               pbsw=0.9                  cjswg=cjswgp
+ mjswg=0.4413              pbswg=0.9                 tcj=0.000887
+ tcjsw=0.000298            tcjswg=0.000298           tpb=0.001643
+ tpbsw=0.001643            tpbswg=0.001643           js=1.80e-7
+ jsw=8.055e-13             cgdo=cgop                 cgso=cgop
+ cgbo=0                    capmod=3                  nqsmod=0
+ xpart=1                   cf=0                      tlev=1
+ tlevc=1                   xti=3                     n=1
+ hdif=hdifp                ldif=8e-08                rsh=rshp
+ rs=0                      rd=0                      dlc=1.20e-8
+ cgdl=cglp                 cgsl=cglp                 wwc=-4e-2
+ dwc=0                     noia=1.0e+19              noib=1.0e+3
+ noic=1.0e-11              em=1.0e+8                 ef=1.107
+ noimod=2                  sa0=0.35e-6               sb0=0.35e-6
+ kvsat=-0.6                wlod=0.3e-6               tku0=0.50
+ ku0=1.14e-7               llodku0=1                 wlodku0=1
+ lku0=6e-8                 wku0=3.0e-7               pku0=1e-14
+ kvth0=-2.3e-9             stk2=0e-9                 steta0=0
+ lkvth0=1e-8               wkvth0=2.5e-7             pkvth0=4e-14
+ llodvth=1                 wlodvth=1                 lodk2=1
+ lodeta0=1                 minr=1e-3                 imax=0.01
+ imelt=0.01
//

     }

// *********************************
//        Mismatch   model         *
// *********************************

inline subckt nch_mis ( d g s b )
parameters l=1u w=1u multi=1 factor=1 sa=0.35e-6 sb=0.35e-6 ad=2 * hdifn
+ / factor * w as=2 * hdifn / factor * w pd=2 * (2 * hdifn / factor + w) ps=2 *
+ (2 * hdifn / factor + w) nrd=hdifn / factor / w nrs=hdifn / factor / w temp1=parn1
+ temp2=parn2 fac1=0.630 * temp1 + 0.776 * temp2 fac2=0.630 * temp1 - 0.776 * temp2
+ lef=l - 2.0e-8 wef=w + 1.5e-8 geo_fac=1 / sqrt(multi * lef * wef * 1e12) vthmisn=0.002536
+ * geo_fac * fac1 dlmisn=0.002159 * geo_fac * lef * fac2 dwmisn= - 0.002159 * geo_fac
+ * wef * fac2 toxmisn=0.002159 * geo_fac * toxn * fac2
nch_mis ( d g s b ) nch w=w l=l ad=ad as=as pd=pd ps=ps nrd=nrd nrs=nrs m=multi sa=sa
+ sb=sb
model nch bsim3v3  {
     1: type=n
+ lmin=8.00e-07-(dxl+dlmisn)                          lmax=2.1e-05
+ wmin=1.0005e-05-(dxw+dwmisn)                        wmax=0.0009001
+ tnom=25                   version=3.24              tox=(toxn+toxmisn)
+ toxm=(toxn+toxmisn)       xj=1.9e-07                nch=6.14815e+17
+ lln=1                     lwn=1                     wln=1
+ wwn=-1                    lint=0                    ll=0
+ lw=0                      lwl=0                     wint=1.25e-08
+ wl=0                      ww=0                      wwl=0
+ mobmod=1                  binunit=2                 xl=-2.0e-08+(dxl+dlmisn)
+ xw=1.5e-08+(dxw+dwmisn)   dwg=0                     dwb=0
+ vth0=0.3186263+(dvthn+vthmisn)                      lvth0=3.77315e-08+dlvthn
+ pvth0=0+dpvthn            k1=0.4020326              lk1=2.961456e-08
+ k2=-0.01+dk2n             lk2=0+dlk2n               k3=0
+ dvt0=0                    dvt1=0                    dvt2=0
+ dvt0w=0                   dvt1w=0                   dvt2w=0
+ nlx=0                     w0=0                      k3b=0
+ vfb=-0.9638587            vsat=92000                pvsat=0+dpvsatn
+ lvsat=0+dlvsatn           ua=6.957609e-10           lua=4.230652e-17
+ ub=1.29963e-18            lub=7.022882e-25          uc=9.558696e-11
+ luc=1.438422e-16          rdsw=102.9                prwb=0
+ prwg=0                    wr=1                      u0=0.05146012
+ lu0=8.222194e-09          a0=1.2                    keta=-0.003169565
+ lketa=1.692261e-09        a1=0                      a2=0.99
+ ags=0.620326              lags=2.961457e-07         b0=0
+ b1=0                      voff=-0.1336783           lvoff=6.769044e-09
+ nfactor=0.4491304         lnfactor=5.076783e-07     cit=0
+ cdsc=0                    cdscb=0                   cdscd=0
+ eta0=-7.847857e-06        leta0=1.176121e-09        etab=0.0001458695
+ letab=-2.453778e-09       dsub=0                    pclm=0.55
+ ppclm=0+dppclmn           pdiblc1=0                 pdiblc2=0.0008728261
+ lpdiblc2=1.269195e-09     pdiblcb=0                 drout=0
+ pscbe1=1.8e+08            pscbe2=5e-08              pvag=0
+ delta=0.004576087         ldelta=4.230652e-09       kt1=-0.1783044
+ lkt1=-1.69226e-08         kt2=-0.02                 at=44152.18
+ lat=0.008461304           ute=-1.5                  ua1=2.469456e-09
+ lua1=8.038239e-16         ub1=-2.330435e-18         lub1=-1.692261e-24
+ uc1=7.561846e-11          luc1=-2.828424e-16        kt1l=0
+ prt=0                     alpha0=0                  alpha1=0.009179
+ beta0=6.415               cj=cjn                    mj=0.4528
+ pb=0.7956                 cjsw=cjswn                mjsw=0.2323
+ pbsw=0.7956               cjswg=cjswgn              mjswg=0.4087
+ pbswg=0.7956              tcj=0.0009067             tcjsw=0.0002781
+ tcjswg=0.0002781          tpb=0.001427              tpbsw=0.001427
+ tpbswg=0.001427           js=8.00e-7                jsw=1.55e-12
+ cgdo=cgon                 cgso=cgon                 cgbo=0
+ capmod=3                  nqsmod=0                  xpart=1
+ cf=0                      tlev=1                    tlevc=1
+ xti=3                     n=1                       hdif=hdifn
+ ldif=8e-08                rsh=rshn                  rs=0
+ rd=0                      dlc=1.72e-8               wvth0=0+dwvthn
+ cgdl=cgln                 cgsl=cgln                 wwc=-4.5e-2
+ dwc=0                     noia=7.0e+18              noib=2.5e+4
+ noic=1.0e-13              em=4.1e+7                 ef=1.009
+ noimod=2                  sa0=0.35e-6               sb0=0.35e-6
+ kvsat=0.4                 wlod=0.5e-6               tku0=0.03
+ ku0=-0.62e-7              llodku0=1                 wlodku0=1
+ lku0=2.0e-7               wku0=0.7e-6               pku0=-0.5e-13
+ kvth0=5.2e-9              stk2=2.5e-9               steta0=-1.1e-10
+ lkvth0=-1.0e-8            wkvth0=2.2e-6             pkvth0=-5e-14
+ llodvth=1.0               wlodvth=1                 lodk2=1
+ lodeta0=2                 minr=1e-3                 imax=0.01
+ imelt=0.01

     2: type=n
+ lmin=3.50e-07-(dxl+dlmisn)                          lmax=8.00e-07-(dxl+dlmisn)
+ wmin=1.0005e-05-(dxw+dwmisn)                        wmax=0.0009001
+ tnom=25                   version=3.24              tox=(toxn+toxmisn)
+ toxm=(toxn+toxmisn)       xj=1.9e-07                nch=6.14815e+17
+ lln=1                     lwn=1                     wln=1
+ wwn=-1                    lint=0                    ll=0
+ lw=0                      lwl=0                     wint=1.25e-08
+ wl=0                      ww=0                      wwl=0
+ mobmod=1                  binunit=2                 xl=-2.0e-08+(dxl+dlmisn)
+ xw=1.5e-08+(dxw+dwmisn)   dwg=0                     dwb=0
+ vth0=0.3464667+(dvthn+vthmisn)                      lvth0=1.6016e-08+dlvthn
+ pvth0=0+dpvthn            k1=0.4253333              lk1=1.144001e-08
+ k2=-0.01+dk2n             lk2=0+dlk2n               k3=0
+ dvt0=0                    dvt1=0                    dvt2=0
+ dvt0w=0                   dvt1w=0                   dvt2w=0
+ nlx=0                     w0=0                      k3b=0
+ vfb=-0.9549471            vsat=92000                pvsat=0+dpvsatn
+ lvsat=0+dlvsatn           ua=8.966667e-10           lua=-1.144e-16
+ ub=1.833333e-18           lub=2.860001e-25          uc=2.323333e-10
+ luc=3.718e-17             rdsw=102.9                prwb=0
+ prwg=0                    wr=1                      u0=0.05833474
+ lu0=2.859993e-09          a0=1.2                    keta=-0.001
+ a1=0                      a2=0.99                   ags=1
+ b0=0                      b1=0                      voff=-0.1242667
+ lvoff=-5.720012e-10       nfactor=0.9533334         lnfactor=1.144e-07
+ cit=0                     cdsc=0                    cdscb=0
+ cdscd=0                   eta0=0.0003999999         leta0=8.580001e-10
+ etab=-0.0019              letab=-8.579999e-10       dsub=0
+ pclm=0.55                 ppclm=0+dppclmn           pdiblc1=0
+ pdiblc2=0.0025            pdiblcb=0                 drout=0
+ pscbe1=1.8e+08            pscbe2=5e-08              pvag=0
+ delta=0.01                kt1=-0.2088               lkt1=6.864006e-09
+ kt2=-0.02                 at=69666.67               lat=-0.01144
+ ute=-1.5                  ua1=3.866667e-09          lua1=-2.860001e-16
+ ub1=-4.683333e-18         lub1=1.43e-25             uc1=-2.408e-10
+ luc1=-3.6036e-17          kt1l=0                    prt=0
+ alpha0=0                  alpha1=0.009179           beta0=6.415
+ cj=cjn                    mj=0.4528                 pb=0.7956
+ cjsw=cjswn                mjsw=0.2323               pbsw=0.7956
+ cjswg=cjswgn              mjswg=0.4087              pbswg=0.7956
+ tcj=0.0009067             tcjsw=0.0002781           tcjswg=0.0002781
+ tpb=0.001427              tpbsw=0.001427            tpbswg=0.001427
+ js=8.00e-7                jsw=1.55e-12              cgdo=cgon
+ cgso=cgon                 cgbo=0                    capmod=3
+ nqsmod=0                  xpart=1                   cf=0
+ tlev=1                    tlevc=1                   xti=3
+ n=1                       hdif=hdifn                ldif=8e-08
+ rsh=rshn                  rs=0                      rd=0
+ dlc=1.72e-8               wvth0=0+dwvthn            cgdl=cgln
+ cgsl=cgln                 wwc=-4.5e-2               dwc=0
+ noia=7.0e+18              noib=2.5e+4               noic=1.0e-13
+ em=4.1e+7                 ef=1.009                  noimod=2
+ sa0=0.35e-6               sb0=0.35e-6               kvsat=0.4
+ wlod=0.5e-6               tku0=0.03                 ku0=-0.62e-7
+ llodku0=1                 wlodku0=1                 lku0=2.0e-7
+ wku0=0.7e-6               pku0=-0.5e-13             kvth0=5.2e-9
+ stk2=2.5e-9               steta0=-1.1e-10           lkvth0=-1.0e-8
+ wkvth0=2.2e-6             pkvth0=-5e-14             llodvth=1.0
+ wlodvth=1                 lodk2=1                   lodeta0=2
+ minr=1e-3                 imax=0.01                 imelt=0.01

     3: type=n
+ lmin=1.30e-07             lmax=3.50e-07-(dxl+dlmisn)
+ wmin=1.0005e-05-(dxw+dwmisn)                        wmax=0.0009001
+ tnom=25                   version=3.24              tox=(toxn+toxmisn)
+ toxm=(toxn+toxmisn)       xj=1.9e-07                nch=6.14815e+17
+ lln=1                     lwn=1                     wln=1
+ wwn=-1                    lint=0                    ll=0
+ lw=0                      lwl=0                     wint=1.25e-08
+ wl=0                      ww=0                      wwl=0
+ mobmod=1                  binunit=2                 xl=-2.0e-08+(dxl+dlmisn)
+ xw=1.5e-08+(dxw+dwmisn)   dwg=0                     dwb=0
+ vth0=0.372+(dvthn+vthmisn)                          lvth0=7.590001e-09+dlvthn
+ pvth0=0+dpvthn            k1=0.4625                 lk1=-8.249992e-10
+ k2=-0.01+dk2n             lk2=0+dlk2n               k3=0
+ dvt0=0                    dvt1=0                    dvt2=0
+ dvt0w=0                   dvt1w=0                   dvt2w=0
+ nlx=0                     w0=0                      k3b=0
+ vfb=-0.904175             vsat=92475                pvsat=0+dpvsatn
+ lvsat=-0.00015675+dlvsatn ua=5.6e-10                lua=-3.3e-18
+ ub=2.7e-18                uc=2.95e-10               luc=1.65e-17
+ rdsw=102.9                prwb=0                    prwg=0
+ wr=1                      u0=0.06050138             lu0=2.145002e-09
+ a0=1.2                    keta=-0.001               a1=0
+ a2=0.99                   ags=1                     b0=0
+ b1=0                      voff=-0.124               lvoff=-6.599989e-10
+ nfactor=1.05              lnfactor=8.25e-08         cit=-4.9000010e-04
+ lcit=1.6170001e-10        cdsc=0                    cdscb=0
+ cdscd=0                   eta0=0.0004999998         leta0=8.250001e-10
+ etab=-0.003249999         letab=-4.125001e-10       dsub=0
+ pclm=0.225                lpclm=1.0725e-07          ppclm=0+dppclmn
+ pdiblc1=0                 pdiblc2=0.00125           lpdiblc2=4.125e-10
+ pdiblcb=0                 drout=0                   pscbe1=1.8e+08
+ pscbe2=5e-08              pvag=0                    delta=0.01
+ kt1=-0.182                lkt1=-1.980001e-09        kt2=-0.02
+ at=35000                  ute=-1.45                 lute=-1.65e-08
+ ua1=3.5e-09               lua1=-1.65e-16            ub1=-4.825e-18
+ lub1=1.8975e-25           uc1=-3.75e-10             luc1=8.250001e-18
+ kt1l=0                    prt=0                     alpha0=0
+ alpha1=0.009179           beta0=6.415               cj=cjn
+ mj=0.4528                 pb=0.7956                 cjsw=cjswn
+ mjsw=0.2323               pbsw=0.7956               cjswg=cjswgn
+ mjswg=0.4087              pbswg=0.7956              tcj=0.0009067
+ tcjsw=0.0002781           tcjswg=0.0002781          tpb=0.001427
+ tpbsw=0.001427            tpbswg=0.001427           js=8.00e-7
+ jsw=1.55e-12              cgdo=cgon                 cgso=cgon
+ cgbo=0                    capmod=3                  nqsmod=0
+ xpart=1                   cf=0                      tlev=1
+ tlevc=1                   xti=3                     n=1
+ hdif=hdifn                ldif=8e-08                rsh=rshn
+ rs=0                      rd=0                      dlc=1.72e-8
+ wvth0=0+dwvthn            cgdl=cgln                 cgsl=cgln
+ wwc=-4.5e-2               dwc=0                     noia=7.0e+18
+ noib=2.5e+4               noic=1.0e-13              em=4.1e+7
+ ef=1.009                  noimod=2                  sa0=0.35e-6
+ sb0=0.35e-6               kvsat=0.4                 wlod=0.5e-6
+ tku0=0.03                 ku0=-0.62e-7              llodku0=1
+ wlodku0=1                 lku0=2.0e-7               wku0=0.7e-6
+ pku0=-0.5e-13             kvth0=5.2e-9              stk2=2.5e-9
+ steta0=-1.1e-10           lkvth0=-1.0e-8            wkvth0=2.2e-6
+ pkvth0=-5e-14             llodvth=1.0               wlodvth=1
+ lodk2=1                   lodeta0=2                 minr=1e-3
+ imax=0.01                 imelt=0.01

     4: type=n
+ lmin=8.00e-07-(dxl+dlmisn)                          lmax=2.1e-05
+ wmin=1.205e-06-(dxw+dwmisn)                         wmax=1.0005e-05-(dxw+dwmisn)
+ tnom=25                   version=3.24              tox=(toxn+toxmisn)
+ toxm=(toxn+toxmisn)       xj=1.9e-07                nch=6.14815e+17
+ lln=1                     lwn=1                     wln=1
+ wwn=-1                    lint=0                    ll=0
+ lw=0                      lwl=0                     wint=1.25e-08
+ wl=0                      ww=0                      wwl=0
+ mobmod=1                  binunit=2                 xl=-2.0e-08+(dxl+dlmisn)
+ xw=1.5e-08+(dxw+dwmisn)   dwg=0                     dwb=0
+ vth0=0.3192846+(dvthn+vthmisn)                      lvth0=3.848904e-08+dlvthn
+ wvth0=-6.580117e-09+dwvthn                          pvth0=-7.571634e-15+dpvthn
+ k1=0.4019175              lk1=3.076357e-08          wk1=1.150731e-09
+ pk1=-1.148431e-14         k2=-0.01+dk2n             lk2=0+dlk2n
+ k3=0                      dvt0=0                    dvt1=0
+ dvt2=0                    dvt0w=0                   dvt1w=0
+ dvt2w=0                   nlx=0                     w0=0
+ k3b=0                     vfb=-0.9663146            vsat=92000
+ ua=6.956929e-10           lua=1.587938e-17          pvsat=0+dpvsatn
+ lvsat=0+dlvsatn           wua=6.786699e-19          pua=2.641394e-22
+ ub=1.301512e-18           lub=8.258063e-25          wub=-1.88102e-26
+ pub=-1.234564e-30         uc=9.466591e-11           luc=1.530342e-16
+ wuc=9.205861e-18          puc=-9.187456e-23         rdsw=102.9
+ prwb=0                    prwg=0                    wr=1
+ u0=0.05210034             lu0=8.993866e-09          wu0=-6.399003e-09
+ pu0=-7.712874e-15         a0=1.2                    keta=-0.003169565
+ lketa=1.692261e-09        a1=0                      a2=0.99
+ ags=0.620326              lags=2.961457e-07         b0=0
+ b1=0                      voff=-0.1330592           lvoff=8.722355e-09
+ wvoff=-6.187405e-09       pvoff=-1.952335e-14       nfactor=0.3913584
+ lnfactor=5.421484e-07     wnfactor=5.774322e-07     pnfactor=-3.445296e-13
+ cit=0                     cdsc=0                    cdscb=0
+ cdscd=0                   eta0=-7.847857e-06        leta0=1.176121e-09
+ etab=0.0001458695         letab=-2.453778e-09       dsub=0
+ pclm=0.55                 ppclm=0+dppclmn           pdiblc1=0
+ pdiblc2=0.0008728261      lpdiblc2=1.269195e-09     pdiblcb=0
+ drout=0                   pscbe1=1.8e+08            pscbe2=5e-08
+ pvag=0                    delta=0.004576087         ldelta=4.230652e-09
+ kt1=-0.1789258            lkt1=-1.749711e-08        wkt1=6.211026e-09
+ pkt1=5.742155e-15         kt2=-0.02                 at=44094.61
+ lat=0.009035808           wat=0.0005753656          pat=-5.742161e-09
+ ute=-1.5                  ua1=2.516867e-09          lua1=8.727644e-16
+ wua1=-4.738664e-16        pua1=-6.890593e-22        ub1=-2.308542e-18
+ lub1=-1.788777e-24        wub1=-2.188163e-25        pub1=9.646825e-31
+ uc1=7.515796e-11          luc1=-2.782464e-16        wuc1=4.602911e-18
+ puc1=-4.593729e-23        kt1l=0                    prt=0
+ alpha0=0                  alpha1=0.009179           beta0=6.415
+ cj=cjn                    mj=0.4528                 pb=0.7956
+ cjsw=cjswn                mjsw=0.2323               pbsw=0.7956
+ cjswg=cjswgn              mjswg=0.4087              pbswg=0.7956
+ tcj=0.0009067             tcjsw=0.0002781           tcjswg=0.0002781
+ tpb=0.001427              tpbsw=0.001427            tpbswg=0.001427
+ js=8.00e-7                jsw=1.55e-12              cgdo=cgon
+ cgso=cgon                 cgbo=0                    capmod=3
+ nqsmod=0                  xpart=1                   cf=0
+ tlev=1                    tlevc=1                   xti=3
+ n=1                       hdif=hdifn                ldif=8e-08
+ rsh=rshn                  rs=0                      rd=0
+ dlc=1.72e-8               cgdl=cgln                 cgsl=cgln
+ wwc=-4.5e-2               dwc=0                     noia=7.0e+18
+ noib=2.5e+4               noic=1.0e-13              em=4.1e+7
+ ef=1.009                  noimod=2                  sa0=0.35e-6
+ sb0=0.35e-6               kvsat=0.4                 wlod=0.5e-6
+ tku0=0.03                 ku0=-0.62e-7              llodku0=1
+ wlodku0=1                 lku0=2.0e-7               wku0=0.7e-6
+ pku0=-0.5e-13             kvth0=5.2e-9              stk2=2.5e-9
+ steta0=-1.1e-10           lkvth0=-1.0e-8            wkvth0=2.2e-6
+ pkvth0=-5e-14             llodvth=1.0               wlodvth=1
+ lodk2=1                   lodeta0=2                 minr=1e-3
+ imax=0.01                 imelt=0.01

     5: type=n
+ lmin=3.50e-07-(dxl+dlmisn)                          lmax=8.00e-07-(dxl+dlmisn)
+ wmin=1.205e-06-(dxw+dwmisn)                         wmax=1.0005e-05-(dxw+dwmisn)
+ tnom=25                   version=3.24              tox=(toxn+toxmisn)
+ toxm=(toxn+toxmisn)       xj=1.9e-07                nch=6.14815e+17
+ lln=1                     lwn=1                     wln=1
+ wwn=-1                    lint=0                    ll=0
+ lw=0                      lwl=0                     wint=1.25e-08
+ wl=0                      ww=0                      wwl=0
+ mobmod=1                  binunit=2                 xl=-2.0e-08+(dxl+dlmisn)
+ xw=1.5e-08+(dxw+dwmisn)   dwg=0                     dwb=0
+ vth0=0.3487933+(dvthn+vthmisn)                      lvth0=1.547228e-08+dlvthn
+ wvth0=-2.325469e-08+dwvthn                          pvth0=5.434531e-15+dpvthn
+ k1=0.4276871              lk1=1.066326e-08          wk1=-2.352609e-08
+ pk1=7.763609e-15          k2=-0.01+dk2n             lk2=0+dlk2n
+ k3=0                      dvt0=0                    dvt1=0
+ dvt2=0                    dvt0w=0                   dvt1w=0
+ dvt2w=0                   nlx=0                     w0=0
+ k3b=0                     vfb=-0.9599471            vsat=92099.59
+ lvsat=-7.767496e-05+dlvsatn                         wvsat=-0.0009953355
+ pvsat=7.763617e-10+dpvsatn                          ua=8.477803e-10
+ lua=-1.027488e-16         wua=4.886192e-16          pua=-1.164542e-22
+ ub=1.989588e-18           lub=2.891071e-25          wub=-1.561772e-24
+ pub=-3.105452e-32         uc=2.387157e-10           luc=4.067538e-17
+ wuc=-6.379194e-17         puc=-3.493628e-23         rdsw=102.9
+ prwb=0                    prwg=0                    wr=1
+ u0=0.05966554             lu0=3.093016e-09          wu0=-1.330132e-08
+ pu0=-2.329068e-15         a0=1.2                    keta=-0.001
+ a1=0                      a2=0.99                   ags=1.024896
+ lags=-1.941873e-08        wags=-2.488339e-07        pags=1.940904e-13
+ b0=0                      b1=0                      voff=-0.1192513
+ lvoff=-2.047826e-09       wvoff=-5.012873e-08       pvoff=1.475088e-14
+ nfactor=0.9347747         lnfactor=1.182837e-07     wnfactor=1.854943e-07
+ pnfactor=-3.881805e-14    cit=0                     cdsc=0
+ cdscb=0                   cdscd=0                   eta0=0.000345229
+ leta0=9.007213e-10        weta0=5.474347e-10        peta0=-4.269989e-16
+ etab=-0.001800417         letab=-9.35675e-10        wetab=-9.95335e-10
+ petab=7.763614e-16        dsub=0                    pclm=0.55
+ ppclm=0+dppclmn           pdiblc1=0                 pdiblc2=0.0025
+ pdiblcb=0                 drout=0                   pscbe1=1.8e+08
+ pscbe2=5e-08              pvag=0                    delta=0.01
+ kt1=-0.211353             lkt1=7.796106e-09         wkt1=2.55168e-08
+ pkt1=-9.316348e-15        kt2=-0.02                 at=70843.56
+ lat=-0.01182838           wat=-0.01176305           pat=3.881808e-09
+ ute=-1.5                  ua1=4.032337e-09          lua1=-3.093026e-16
+ wua1=-1.655877e-15        pua1=2.329085e-22         ub1=-4.78518e-18
+ lub1=1.43e-25             wub1=1.017956e-24         uc1=-2.271028e-10
+ luc1=-4.248302e-17        wuc1=-1.369039e-16        puc1=6.443801e-23
+ kt1l=0                    prt=0                     alpha0=0
+ alpha1=0.009179           beta0=6.415               cj=cjn
+ mj=0.4528                 pb=0.7956                 cjsw=cjswn
+ mjsw=0.2323               pbsw=0.7956               cjswg=cjswgn
+ mjswg=0.4087              pbswg=0.7956              tcj=0.0009067
+ tcjsw=0.0002781           tcjswg=0.0002781          tpb=0.001427
+ tpbsw=0.001427            tpbswg=0.001427           js=8.00e-7
+ jsw=1.55e-12              cgdo=cgon                 cgso=cgon
+ cgbo=0                    capmod=3                  nqsmod=0
+ xpart=1                   cf=0                      tlev=1
+ tlevc=1                   xti=3                     n=1
+ hdif=hdifn                ldif=8e-08                rsh=rshn
+ rs=0                      rd=0                      dlc=1.72e-8
+ cgdl=cgln                 cgsl=cgln                 wwc=-4.5e-2
+ dwc=0                     noia=7.0e+18              noib=2.5e+4
+ noic=1.0e-13              em=4.1e+7                 ef=1.009
+ noimod=2                  sa0=0.35e-6               sb0=0.35e-6
+ kvsat=0.4                 wlod=0.5e-6               tku0=0.03
+ ku0=-0.62e-7              llodku0=1                 wlodku0=1
+ lku0=2.0e-7               wku0=0.7e-6               pku0=-0.5e-13
+ kvth0=5.2e-9              stk2=2.5e-9               steta0=-1.1e-10
+ lkvth0=-1.0e-8            wkvth0=2.2e-6             pkvth0=-5e-14
+ llodvth=1.0               wlodvth=1                 lodk2=1
+ lodeta0=2                 minr=1e-3                 imax=0.01
+ imelt=0.01

     6: type=n
+ lmin=1.30e-07             lmax=3.50e-07-(dxl+dlmisn)
+ wmin=1.205e-06-(dxw+dwmisn)                         wmax=1.0005e-05-(dxw+dwmisn)
+ tnom=25                   version=3.24              tox=(toxn+toxmisn)
+ toxm=(toxn+toxmisn)       xj=1.9e-07                nch=6.14815e+17
+ lln=1                     lwn=1                     wln=1
+ wwn=-1                    lint=0                    ll=0
+ lw=0                      lwl=0                     wint=1.25e-08
+ wl=0                      ww=0                      wwl=0
+ mobmod=1                  binunit=2                 xl=-2.0e-08+(dxl+dlmisn)
+ xw=1.5e-08+(dxw+dwmisn)   dwg=0                     dwb=0
+ vth0=0.3731874+(dvthn+vthmisn)                      lvth0=7.422214e-09+dlvthn
+ wvth0=-1.186831e-08+dwvthn                          pvth0=1.677027e-15+dpvthn
+ k1=0.4624763              lk1=-8.17183e-10          wk1=2.367341e-10
+ pk1=-7.812222e-17         k2=-0.01+dk2n             lk2=0+dlk2n
+ k3=0                      dvt0=0                    dvt1=0
+ dvt2=0                    dvt0w=0                   dvt1w=0
+ dvt2w=0                   nlx=0                     w0=0
+ k3b=0                     vfb=-0.905175             vsat=92367.39
+ lvsat=-0.0001660512+dlvsatn                         wvsat=0.001075562
+ pvsat=9.296548e-11+dpvsatn                          ua=5.390622e-10
+ lua=-8.717873e-19         wua=2.09273e-16           pua=-2.426999e-23
+ ub=2.801752e-18           lub=2.109314e-26          wub=-1.01701e-24
+ pub=-2.108259e-31         uc=2.99737e-10            luc=2.053834e-17
+ wuc=-4.73468e-17          puc=-4.036318e-23         rdsw=102.9
+ prwb=0                    prwg=0                    wr=1
+ u0=0.06172818             lu0=2.412345e-09          wu0=-1.226186e-08
+ pu0=-2.672088e-15         a0=1.2                    keta=-0.001
+ a1=0                      a2=0.99                   ags=0.9478924
+ lags=5.99237e-09          wags=5.208151e-07         pags=-5.989373e-14
+ b0=0                      b1=0                      voff=-0.1260906
+ lvoff=2.091559e-10        wvoff=2.089575e-08        pvoff=-8.687199e-15
+ nfactor=1.041947          lnfactor=8.291686e-08     wnfactor=8.048968e-08
+ pnfactor=-4.166534e-15    cit=-5.5653970e-04        lcit=1.8365813e-10
+ wcit=6.6506490e-10        pcit=-2.1947146e-16       cdsc=0
+ cdscb=0                   cdscd=0                   eta0=0.0003695728
+ leta0=8.926878e-10        weta0=1.303616e-09        peta0=-6.765388e-16
+ etab=-0.003397638         letab=-4.08592e-10        wetab=1.475642e-09
+ petab=-3.906104e-17       dsub=0                    pclm=0.2353426
+ lpclm=1.03837e-07         wpclm=-1.033738e-07       ppclm=3.411337e-14+dppclmn
+ pdiblc1=0                 pdiblc2=0.001378058       lpdiblc2=3.702408e-10
+ wpdiblc2=-1.279943e-09    ppdiblc2=4.223811e-16     pdiblcb=0
+ drout=0                   pscbe1=1.8e+08            pscbe2=5e-08
+ pvag=0                    delta=0.01                kt1=-0.1794609
+ lkt1=-2.728266e-09        wkt1=-2.53779e-08         pkt1=7.478905e-15
+ kt2=-0.02                 at=35000                  ute=-1.44321
+ lute=-1.874063e-08        wute=-6.786381e-08        pute=2.239505e-14
+ ua1=3.56853e-09           lua1=-1.56246e-16         wua1=-6.849511e-16
+ pua1=-8.74969e-23         ub1=-4.90324e-18          lub1=1.819599e-25
+ wub1=7.820111e-25         pub1=7.786192e-32         uc1=-3.769706e-10
+ luc1=6.973365e-18         wuc1=1.969626e-17         puc1=1.275997e-23
+ kt1l=0                    prt=0                     alpha0=0
+ alpha1=0.009179           beta0=6.415               cj=cjn
+ mj=0.4528                 pb=0.7956                 cjsw=cjswn
+ mjsw=0.2323               pbsw=0.7956               cjswg=cjswgn
+ mjswg=0.4087              pbswg=0.7956              tcj=0.0009067
+ tcjsw=0.0002781           tcjswg=0.0002781          tpb=0.001427
+ tpbsw=0.001427            tpbswg=0.001427           js=8.00e-7
+ jsw=1.55e-12              cgdo=cgon                 cgso=cgon
+ cgbo=0                    capmod=3                  nqsmod=0
+ xpart=1                   cf=0                      tlev=1
+ tlevc=1                   xti=3                     n=1
+ hdif=hdifn                ldif=8e-08                rsh=rshn
+ rs=0                      rd=0                      dlc=1.72e-8
+ cgdl=cgln                 cgsl=cgln                 wwc=-4.5e-2
+ dwc=0                     noia=7.0e+18              noib=2.5e+4
+ noic=1.0e-13              em=4.1e+7                 ef=1.009
+ noimod=2                  sa0=0.35e-6               sb0=0.35e-6
+ kvsat=0.4                 wlod=0.5e-6               tku0=0.03
+ ku0=-0.62e-7              llodku0=1                 wlodku0=1
+ lku0=2.0e-7               wku0=0.7e-6               pku0=-0.5e-13
+ kvth0=5.2e-9              stk2=2.5e-9               steta0=-1.1e-10
+ lkvth0=-1.0e-8            wkvth0=2.2e-6             pkvth0=-5e-14
+ llodvth=1.0               wlodvth=1                 lodk2=1
+ lodeta0=2                 minr=1e-3                 imax=0.01
+ imelt=0.01

     7: type=n
+ lmin=8.00e-07-(dxl+dlmisn)                          lmax=2.1e-05
+ wmin=5.85e-07-(dxw+dwmisn)                          wmax=1.205e-06-(dxw+dwmisn)
+ tnom=25                   version=3.24              tox=(toxn+toxmisn)
+ toxm=(toxn+toxmisn)       xj=1.9e-07                nch=6.14815e+17
+ lln=1                     lwn=1                     wln=1
+ wwn=-1                    lint=0                    ll=0
+ lw=0                      lwl=0                     wint=1.25e-08
+ wl=0                      ww=0                      wwl=0
+ mobmod=1                  binunit=2                 xl=-2.0e-08+(dxl+dlmisn)
+ xw=1.5e-08+(dxw+dwmisn)   dwg=0                     dwb=0
+ vth0=0.3284845+(dvthn+vthmisn)                      lvth0=4.1804960e-08+dlvthn
+ wvth0=-1.7573974e-08+dwvthn                         pvth0=-1.1534162e-14+dpvthn
+ k1=0.4028804              lk1=2.115326e-08          k2=-0.01+dk2n
+ lk2=0+dlk2n               k3=0                      dvt0=0
+ dvt1=0                    dvt2=0                    dvt0w=0
+ dvt1w=0                   dvt2w=0                   nlx=0
+ w0=0                      k3b=0                     vfb=-0.9963146
+ vsat=9.1850600e+04        lvsat=1.4909640e-03+dlvsatn
+ wvsat=1.7852732e-04       pvsat=-1.7817019e-09+dpvsatn
+ ua=6.970471e-10           lua=2.290693e-16          wua=-9.396122e-19
+ pua=9.377379e-24          ub=1.734552e-18           lub=-2.896972e-25
+ wub=-5.362924e-25         pub=9.846243e-32          uc=1.00797e-10
+ luc=9.184609e-17          wuc=1.879232e-18          puc=-1.875476e-23
+ rdsw=102.9                prwb=0                    prwg=0
+ wr=1                      u0=5.1684090e-02          lu0=-2.1917292e-10
+ wu0=-5.9015850e-09        pu0=3.2967090e-15         a0=1.2
+ keta=-0.003169565         lketa=1.692261e-09        a1=0
+ a2=0.99                   ags=0.628189              lags=2.176739e-07
+ wags=-9.396179e-09        pags=9.37738e-14          b0=0
+ b1=0                      voff=-0.1273277           lvoff=-1.467764e-08
+ wvoff=-1.303659e-08       pvoff=8.439643e-15        nfactor=0.7739603
+ lnfactor=3.32311e-07      wnfactor=1.202228e-07     pnfactor=-9.37738e-14
+ cit=0                     cdsc=0                    cdscb=0
+ cdscd=0                   eta0=-7.847708e-06        leta0=1.176121e-09
+ etab=0.0001458695         letab=-2.453778e-09       dsub=0
+ pclm=0.3459678            wpclm=2.438185e-07        ppclm=0+dppclmn
+ pdiblc1=0                 pdiblc2=0.0008728262      lpdiblc2=1.269195e-09
+ pdiblcb=0                 drout=0                   pscbe1=1.8e+08
+ pscbe2=5e-08              pvag=0                    delta=0.004576087
+ ldelta=4.230652e-09       kt1=-0.172942             lkt1=-2.053913e-08
+ wkt1=-9.396166e-10        pkt1=9.37737e-15          kt2=-0.02
+ at=44182.94               lat=0.008154241           wat=0.0004698085
+ pat=-4.688689e-09         ute=-1.449698             lute=-3.923585e-08
+ wute=-6.011134e-08        pute=4.688685e-14         ua1=2.700366e-09
+ lua1=6.073042e-17         wua1=-6.931482e-16        pua1=2.813212e-22
+ ub1=-2.647418e-18         lub1=-1.185538e-24        wub1=1.861403e-25
+ pub1=2.438121e-31         uc1=2.461553e-10          luc1=-4.615289e-16
+ wuc1=-1.997389e-16        puc1=1.730853e-22         kt1l=0
+ prt=0                     alpha0=0                  alpha1=0.009179
+ beta0=6.415               cj=cjn                    mj=0.4528
+ pb=0.7956                 cjsw=cjswn                mjsw=0.2323
+ pbsw=0.7956               cjswg=cjswgn              mjswg=0.4087
+ pbswg=0.7956              tcj=0.0009067             tcjsw=0.0002781
+ tcjswg=0.0002781          tpb=0.001427              tpbsw=0.001427
+ tpbswg=0.001427           js=8.00e-7                jsw=1.55e-12
+ cgdo=cgon                 cgso=cgon                 cgbo=0
+ capmod=3                  nqsmod=0                  xpart=1
+ cf=0                      tlev=1                    tlevc=1
+ xti=3                     n=1                       hdif=hdifn
+ ldif=8e-08                rsh=rshn                  rs=0
+ rd=0                      dlc=1.72e-8               cgdl=cgln
+ cgsl=cgln                 wwc=-4.5e-2               dwc=0
+ noia=7.0e+18              noib=2.5e+4               noic=1.0e-13
+ em=4.1e+7                 ef=1.009                  noimod=2
+ sa0=0.35e-6               sb0=0.35e-6               kvsat=0.4
+ wlod=0.5e-6               tku0=0.03                 ku0=-0.62e-7
+ llodku0=1                 wlodku0=1                 lku0=2.0e-7
+ wku0=0.7e-6               pku0=-0.5e-13             kvth0=5.2e-9
+ stk2=2.5e-9               steta0=-1.1e-10           lkvth0=-1.0e-8
+ wkvth0=2.2e-6             pkvth0=-5e-14             llodvth=1.0
+ wlodvth=1                 lodk2=1                   lodeta0=2
+ minr=1e-3                 imax=0.01                 imelt=0.01

     8: type=n
+ lmin=3.50e-07-(dxl+dlmisn)                          lmax=8.00e-07-(dxl+dlmisn)
+ wmin=5.85e-07-(dxw+dwmisn)                          wmax=1.205e-06-(dxw+dwmisn)
+ tnom=25                   version=3.24              tox=(toxn+toxmisn)
+ toxm=(toxn+toxmisn)       xj=1.9e-07                nch=6.14815e+17
+ lln=1                     lwn=1                     wln=1
+ wwn=-1                    lint=0                    ll=0
+ lw=0                      lwl=0                     wint=1.25e-08
+ wl=0                      ww=0                      wwl=0
+ mobmod=1                  binunit=2                 xl=-2.0e-08+(dxl+dlmisn)
+ xw=1.5e-08+(dxw+dwmisn)   dwg=0                     dwb=0
+ vth0=0.3558019+(dvthn+vthmisn)                      lvth0=2.0497435e-08+dlvthn
+ wvth0=-3.1629910e-08+dwvthn                         pvth0=-5.7053570e-16+dpvthn
+ k1=0.3841963              lk1=3.572693e-08          wk1=2.844549e-08
+ pk1=-2.218749e-14         k2=-0.01+dk2n             lk2=0+dlk2n
+ k3=0                      dvt0=0                    dvt1=0
+ dvt2=0                    dvt0w=0                   dvt1w=0
+ dvt2w=0                   nlx=0                     w0=0
+ k3b=0                     vfb=-0.9585425            vsat=9.6021230e+04
+ lvsat=-1.7621288e-03+dlvsatn                        wvsat=-5.6817110e-03
+ pvsat=2.7892844e-09+dpvsatn                         ua=1.322204e-09
+ lua=-2.585532e-16         wua=-7.831745e-17         pua=6.973212e-23
+ ub=7.894746e-19           lub=4.474632e-25          wub=-1.276354e-25
+ pub=-2.202901e-31         uc=1.698764e-10           luc=3.79642e-17
+ wuc=1.84711e-17           puc=-3.169642e-23         rdsw=102.9
+ prwb=0                    prwg=0                    wr=1
+ u0=4.8604370e-02          lu0=2.1830155e-09         wu0=-8.3217630e-11
+ pu0=-1.2416175e-15        a0=1.2                    keta=-0.001
+ a1=0                      a2=0.99                   ags=0.6559139
+ lags=1.960484e-07         wags=1.920995e-07         pags=-6.339284e-14
+ b0=0                      b1=0                      voff=-0.164786
+ lvoff=1.453988e-08        wvoff=4.285292e-09        pvoff=-5.071427e-15
+ nfactor=1.09              lnfactor=8.58e-08         cit=0
+ cdsc=0                    cdscb=0                   cdscd=0
+ eta0=0.0005312903         leta0=7.555936e-10        weta0=3.250914e-10
+ peta0=-2.535713e-16       etab=-0.002633333         letab=-2.860001e-10
+ dsub=0                    pclm=0.3459678            wpclm=2.438185e-07
+ ppclm=0+dppclmn           pdiblc1=0                 pdiblc2=0.005220429
+ lpdiblc2=-2.121935e-09    wpdiblc2=-3.250914e-09    ppdiblc2=2.535713e-15
+ pdiblcb=0                 drout=0                   pscbe1=1.8e+08
+ pscbe2=5e-08              pvag=0                    delta=0.01
+ kt1=-0.1992742            wkt1=1.108265e-08         kt2=-0.02
+ at=69037.63               lat=-0.01123242           wat=-0.009604974
+ pat=3.169641e-09          ute=-1.534005             lute=2.652416e-08
+ wute=4.063638e-08         pute=-3.169638e-14        ua1=2.584839e-09
+ lua1=1.508418e-16         wua1=7.38843e-17          pua1=-3.169641e-22
+ ub1=-4.180646e-18         lub1=1.037907e-26         wub1=2.955378e-25
+ pub1=1.584821e-31         uc1=-4.080266e-10         luc1=4.873301e-17
+ wuc1=7.930013e-17         puc1=-4.456515e-23        kt1l=0
+ prt=0                     alpha0=0                  alpha1=0.009179
+ beta0=6.415               cj=cjn                    mj=0.4528
+ pb=0.7956                 cjsw=cjswn                mjsw=0.2323
+ pbsw=0.7956               cjswg=cjswgn              mjswg=0.4087
+ pbswg=0.7956              tcj=0.0009067             tcjsw=0.0002781
+ tcjswg=0.0002781          tpb=0.001427              tpbsw=0.001427
+ tpbswg=0.001427           js=8.00e-7                jsw=1.55e-12
+ cgdo=cgon                 cgso=cgon                 cgbo=0
+ capmod=3                  nqsmod=0                  xpart=1
+ cf=0                      tlev=1                    tlevc=1
+ xti=3                     n=1                       hdif=hdifn
+ ldif=8e-08                rsh=rshn                  rs=0
+ rd=0                      dlc=1.72e-8               cgdl=cgln
+ cgsl=cgln                 wwc=-4.5e-2               dwc=0
+ noia=7.0e+18              noib=2.5e+4               noic=1.0e-13
+ em=4.1e+7                 ef=1.009                  noimod=2
+ sa0=0.35e-6               sb0=0.35e-6               kvsat=0.4
+ wlod=0.5e-6               tku0=0.03                 ku0=-0.62e-7
+ llodku0=1                 wlodku0=1                 lku0=2.0e-7
+ wku0=0.7e-6               pku0=-0.5e-13             kvth0=5.2e-9
+ stk2=2.5e-9               steta0=-1.1e-10           lkvth0=-1.0e-8
+ wkvth0=2.2e-6             pkvth0=-5e-14             llodvth=1.0
+ wlodvth=1                 lodk2=1                   lodeta0=2
+ minr=1e-3                 imax=0.01                 imelt=0.01

     9: type=n
+ lmin=1.30e-07             lmax=3.50e-07-(dxl+dlmisn)
+ wmin=5.85e-07-(dxw+dwmisn)                          wmax=1.205e-06-(dxw+dwmisn)
+ tnom=25                   version=3.24              tox=(toxn+toxmisn)
+ toxm=(toxn+toxmisn)       xj=1.9e-07                nch=6.14815e+17
+ lln=1                     lwn=1                     wln=1
+ wwn=-1                    lint=0                    ll=0
+ lw=0                      lwl=0                     wint=1.25e-08
+ wl=0                      ww=0                      wwl=0
+ mobmod=1                  binunit=2                 xl=-2.0e-08+(dxl+dlmisn)
+ xw=1.5e-08+(dxw+dwmisn)   dwg=0                     dwb=0
+ vth0=0.3983640+(dvthn+vthmisn)                      lvth0=6.4519300e-09+dlvthn
+ wvth0=-4.1954310e-08+dwvthn                         pvth0=2.8365164e-15+dpvthn
+ k1=0.502575               lk1=-3.338058e-09         wk1=-4.76812e-08
+ pk1=2.934325e-15          k2=-0.01+dk2n             lk2=0+dlk2n
+ k3=0                      dvt0=0                    dvt1=0
+ dvt2=0                    dvt0w=0                   dvt1w=0
+ dvt2w=0                   nlx=0                     w0=0
+ k3b=0                     vfb=-0.9060867            vsat=8.9024170e+04
+ lvsat=5.4690130e-04+dlvsatn                         wvsat=5.0707040e-03
+ pvsat=-7.5901280e-10+dpvsatn                        ua=5.433684e-10
+ lua=-1.537363e-18         wua=2.041272e-16          pua=-2.347462e-23
+ ub=2.892675e-18           lub=-2.465931e-25         wub=-1.125663e-24
+ pub=1.090592e-31          uc=3.399175e-10           luc=-1.814938e-17
+ wuc=-9.536245e-17         puc=5.868657e-24          rdsw=102.9
+ prwb=0                    prwg=0                    wr=1
+ u0=5.5166480e-02          lu0=1.7517475e-11         wu0=-4.4206360e-09
+ pu0=1.8973025e-16         a0=1.2                    keta=-0.001
+ a1=0                      a2=0.99                   ags=1.383721
+ lags=-4.412791e-08        b0=0                      b1=0
+ voff=-0.1092517           lvoff=-3.786461e-09       wvoff=7.731984e-10
+ pvoff=-3.912437e-15       nfactor=1.109302          lnfactor=7.943022e-08
+ cit=0                     cdsc=0                    cdscb=0
+ cdscd=0                   eta0=0.002029857          leta0=2.610664e-10
+ weta0=-6.804239e-10       peta0=7.824874e-17        etab=-0.002162791
+ letab=-4.412791e-10       dsub=0                    pclm=-0.1147222
+ lpclm=1.520277e-07        wpclm=3.149537e-07        ppclm=-2.347461e-14+dppclmn
+ pdiblc1=0                 pdiblc2=-0.005386946      lpdiblc2=1.378499e-09
+ wpdiblc2=6.804239e-09     ppdiblc2=-7.824874e-16    pdiblcb=0
+ drout=0                   pscbe1=1.8e+08            pscbe2=5e-08
+ pvag=0                    delta=0.01                kt1=-0.2149325
+ lkt1=5.167233e-09         wkt1=1.701058e-08         pkt1=-1.956217e-15
+ kt2=-0.02                 at=35000                  ute=-1.428826
+ lute=-8.185006e-09        wute=-8.50529e-08         pute=9.781084e-15
+ ua1=4.183739e-09          lua1=-3.767954e-16        wua1=-1.420127e-15
+ pua1=1.760597e-22         ub1=-5.245274e-18         lub1=3.617065e-25
+ wub1=1.190742e-24         pub1=-1.369353e-31        uc1=-2.888873e-10
+ luc1=9.417043e-18         wuc1=-8.556327e-17        puc1=9.839777e-24
+ kt1l=0                    prt=0                     alpha0=0
+ alpha1=0.009179           beta0=6.415               cj=cjn
+ mj=0.4528                 pb=0.7956                 cjsw=cjswn
+ mjsw=0.2323               pbsw=0.7956               cjswg=cjswgn
+ mjswg=0.4087              pbswg=0.7956              tcj=0.0009067
+ tcjsw=0.0002781           tcjswg=0.0002781          tpb=0.001427
+ tpbsw=0.001427            tpbswg=0.001427           js=8.00e-7
+ jsw=1.55e-12              cgdo=cgon                 cgso=cgon
+ cgbo=0                    capmod=3                  nqsmod=0
+ xpart=1                   cf=0                      tlev=1
+ tlevc=1                   xti=3                     n=1
+ hdif=hdifn                ldif=8e-08                rsh=rshn
+ rs=0                      rd=0                      dlc=1.72e-8
+ cgdl=cgln                 cgsl=cgln                 wwc=-4.5e-2
+ dwc=0                     noia=7.0e+18              noib=2.5e+4
+ noic=1.0e-13              em=4.1e+7                 ef=1.009
+ noimod=2                  sa0=0.35e-6               sb0=0.35e-6
+ kvsat=0.4                 wlod=0.5e-6               tku0=0.03
+ ku0=-0.62e-7              llodku0=1                 wlodku0=1
+ lku0=2.0e-7               wku0=0.7e-6               pku0=-0.5e-13
+ kvth0=5.2e-9              stk2=2.5e-9               steta0=-1.1e-10
+ lkvth0=-1.0e-8            wkvth0=2.2e-6             pkvth0=-5e-14
+ llodvth=1.0               wlodvth=1                 lodk2=1
+ lodeta0=2                 minr=1e-3                 imax=0.01
+ imelt=0.01

     10: type=n
+ lmin=8.00e-07-(dxl+dlmisn)                          lmax=2.1e-05
+ wmin=1.50e-07             wmax=5.85e-07-(dxw+dwmisn)
+ tnom=25                   version=3.24              tox=(toxn+toxmisn)
+ toxm=(toxn+toxmisn)       xj=1.9e-07                nch=6.14815e+17
+ lln=1                     lwn=1                     wln=1
+ wwn=-1                    lint=0                    ll=0
+ lw=0                      lwl=0                     wint=1.25e-08
+ wl=0                      ww=0                      wwl=0
+ mobmod=1                  binunit=2                 xl=-2.0e-08+(dxl+dlmisn)
+ xw=1.5e-08+(dxw+dwmisn)   dwg=0                     dwb=0
+ vth0=0.3224927+(dvthn+vthmisn)                      lvth0=2.4630785e-08+dlvthn
+ wvth0=-1.4128652e-08+dwvthn                         pvth0=-1.6590077e-15+dpvthn
+ k1=0.4222209              lk1=3.222062e-08          wk1=-1.112078e-08
+ pk1=-6.363734e-15         k2=-0.01+dk2n             lk2=0+dlk2n
+ k3=0                      dvt0=0                    dvt1=0
+ dvt2=0                    dvt0w=0                   dvt1w=0
+ dvt2w=0                   nlx=0                     w0=0
+ k3b=0                     vfb=-0.9856448            vsat=9.2284750e+04
+ lvsat=-2.8330884e-03+dlvsatn                        wvsat=-7.1107980e-05
+ pvsat=7.0462840e-10+dpvsatn                         ua=6.921215e-10
+ lua=2.782275e-16          wua=1.892642e-18          pua=-1.888861e-23
+ ub=8.560726e-19           lub=-7.63039e-26          wub=-3.116676e-26
+ pub=-2.423873e-32         uc=1.007737e-10           luc=9.207889e-17
+ wuc=1.892646e-18          puc=-1.888861e-23         rdsw=102.9
+ prwb=0                    prwg=0                    wr=1
+ u0=4.2063040e-02          lu0=4.9411750e-09         wu0=-3.6947580e-10
+ pu0=3.2950860e-16         a0=1.2                    keta=-0.003169565
+ lketa=1.692261e-09        a1=0                      a2=0.99
+ ags=0.6163363             lags=3.359636e-07         wags=-2.58088e-09
+ pags=2.57572e-14          b0=0                      b1=0
+ voff=-0.1589086           lvoff=1.442836e-09        wvoff=5.122456e-09
+ pvoff=-8.296319e-16       nfactor=0.9770589         lnfactor=2.289529e-07
+ wnfactor=3.441172e-09     pnfactor=-3.434294e-14    cit=0
+ cdsc=0                    cdscb=0                   cdscd=0
+ eta0=-1.532852e-05        leta0=1.25078e-09         weta0=4.301469e-12
+ peta0=-4.292868e-17       etab=0.0001458695         letab=-2.453778e-09
+ dsub=0                    pclm=0.77                 ppclm=0+dppclmn
+ pdiblc1=0                 pdiblc2=0.000992519       lpdiblc2=7.465881e-11
+ wpdiblc2=-6.882347e-11    ppdiblc2=6.868587e-16     pdiblcb=0
+ drout=0                   pscbe1=1.8e+08            pscbe2=5e-08
+ pvag=0                    delta=0.004576087         ldelta=4.230652e-09
+ kt1=-0.1732908            lkt1=-2.480245e-09        wkt1=-7.390387e-10
+ pkt1=-1.006489e-15        kt2=-0.02                 at=45000
+ ute=-1.570084             lute=5.466567e-08         wute=9.110945e-09
+ pute=-7.106536e-15        ua1=1.653343e-09          lua1=4.263927e-16
+ wua1=-9.110954e-17        pua1=7.106544e-23         ub1=-2.525806e-18
+ lub1=-4.937533e-25        wub1=1.162138e-25         pub1=-1.539644e-31
+ uc1=-9.120629e-11         luc1=-1.73825e-16         wuc1=-5.756021e-18
+ puc1=7.65558e-24          kt1l=0                    prt=0
+ alpha0=0                  alpha1=0.009179           beta0=6.415
+ cj=cjn                    mj=0.4528                 pb=0.7956
+ cjsw=cjswn                mjsw=0.2323               pbsw=0.7956
+ cjswg=cjswgn              mjswg=0.4087              pbswg=0.7956
+ tcj=0.0009067             tcjsw=0.0002781           tcjswg=0.0002781
+ tpb=0.001427              tpbsw=0.001427            tpbswg=0.001427
+ js=8.00e-7                jsw=1.55e-12              cgdo=cgon
+ cgso=cgon                 cgbo=0                    capmod=3
+ nqsmod=0                  xpart=1                   cf=0
+ tlev=1                    tlevc=1                   xti=3
+ n=1                       hdif=hdifn                ldif=8e-08
+ rsh=rshn                  rs=0                      rd=0
+ dlc=1.72e-8               cgdl=cgln                 cgsl=cgln
+ wwc=-4.5e-2               dwc=0                     noia=7.0e+18
+ noib=2.5e+4               noic=1.0e-13              em=4.1e+7
+ ef=1.009                  noimod=2                  sa0=0.35e-6
+ sb0=0.35e-6               kvsat=0.4                 wlod=0.5e-6
+ tku0=0.03                 ku0=-0.62e-7              llodku0=1
+ wlodku0=1                 lku0=2.0e-7               wku0=0.7e-6
+ pku0=-0.5e-13             kvth0=5.2e-9              stk2=2.5e-9
+ steta0=-1.1e-10           lkvth0=-1.0e-8            wkvth0=2.2e-6
+ pkvth0=-5e-14             llodvth=1.0               wlodvth=1
+ lodk2=1                   lodeta0=2                 minr=1e-3
+ imax=0.01                 imelt=0.01

     11: type=n
+ lmin=3.50e-07-(dxl+dlmisn)                          lmax=8.00e-07-(dxl+dlmisn)
+ wmin=1.50e-07             wmax=5.85e-07-(dxw+dwmisn)
+ tnom=25                   version=3.24              tox=(toxn+toxmisn)
+ toxm=(toxn+toxmisn)       xj=1.9e-07                nch=6.14815e+17
+ lln=1                     lwn=1                     wln=1
+ wwn=-1                    lint=0                    ll=0
+ lw=0                      lwl=0                     wint=1.25e-08
+ wl=0                      ww=0                      wwl=0
+ mobmod=1                  binunit=2                 xl=-2.0e-08+(dxl+dlmisn)
+ xw=1.5e-08+(dxw+dwmisn)   dwg=0                     dwb=0
+ vth0=0.3288051+(dvthn+vthmisn)                      lvth0=1.9707079e-08+dlvthn
+ wvth0=-1.6106766e-08+dwvthn                         pvth0=-1.1608031e-16+dpvthn
+ k1=0.4736666              lk1=-7.907047e-09         wk1=-2.299999e-08
+ pk1=2.902055e-15          k2=-0.01+dk2n             lk2=0+dlk2n
+ k3=0                      dvt0=0                    dvt1=0
+ dvt2=0                    dvt0w=0                   dvt1w=0
+ dvt2w=0                   nlx=0                     w0=0
+ k3b=0                     vfb=-0.9727331            vsat=8.5442910e+04
+ lvsat=2.5035434e-03+dlvsatn                         wvsat=4.0082220e-04
+ pvsat=3.3652270e-10+dpvsatn                         ua=1.253294e-09
+ lua=-1.59487e-16          wua=-3.86941e-17          pua=1.276905e-23
+ ub=6.052177e-19           lub=1.193629e-25          wub=-2.168765e-26
+ pub=-3.163244e-32         uc=2.434117e-10           luc=-1.917882e-17
+ wuc=-2.381176e-17         puc=1.160823e-24          rdsw=102.9
+ prwb=0                    prwg=0                    wr=1
+ u0=4.8421280e-02          lu0=-1.8254915e-11        wu0=2.2056844e-11
+ pu0=2.4113091e-17         a0=1.2                    keta=-0.001
+ a1=0                      a2=0.99                   ags=0.8982354
+ lags=1.160823e-07         wags=5.276469e-08         pags=-1.741235e-14
+ b0=0                      b1=0                      voff=-0.1669804
+ lvoff=7.738826e-09        wvoff=5.547061e-09        pvoff=-1.160824e-15
+ nfactor=1.121765          lnfactor=1.160824e-07     wnfactor=-1.826471e-08
+ pnfactor=-1.741235e-14    cit=0                     cdsc=0
+ cdscb=0                   cdscd=0                   eta0=0.001236667
+ leta0=2.742235e-10        weta0=-8.050002e-11       peta0=2.321648e-17
+ etab=-0.002633333         letab=-2.860001e-10       dsub=0
+ pclm=0.8295293            lpclm=-4.643294e-08       wpclm=-3.422941e-08
+ ppclm=2.669894e-14+dppclmn                          pdiblc1=0
+ pdiblc2=-0.002000392      lpdiblc2=2.40913e-09      wpdiblc2=9.010587e-10
+ ppdiblc2=-6.964942e-17    pdiblcb=0                 drout=0
+ pscbe1=1.8e+08            pscbe2=5e-08              pvag=0
+ delta=0.01                kt1=-0.1725882            lkt1=-3.028235e-09
+ wkt1=-4.261762e-09        pkt1=1.741235e-15         kt2=-0.02
+ at=50133.34               lat=-0.004004001          wat=0.001265
+ pat=-9.867001e-10         ute=-1.463333             lute=-2.859998e-08
+ ua1=2.842745e-09          lua1=-5.013412e-16        wua1=-7.441175e-17
+ pua1=5.804117e-23         ub1=-3.654902e-18         lub1=3.869413e-25
+ wub1=-6.764658e-27        pub1=-5.804119e-32        uc1=-2.641533e-10
+ luc1=-3.892628e-17        wuc1=-3.426998e-18        puc1=5.838941e-24
+ kt1l=0                    prt=0                     alpha0=0
+ alpha1=0.009179           beta0=6.415               cj=cjn
+ mj=0.4528                 pb=0.7956                 cjsw=cjswn
+ mjsw=0.2323               pbsw=0.7956               cjswg=cjswgn
+ mjswg=0.4087              pbswg=0.7956              tcj=0.0009067
+ tcjsw=0.0002781           tcjswg=0.0002781          tpb=0.001427
+ tpbsw=0.001427            tpbswg=0.001427           js=8.00e-7
+ jsw=1.55e-12              cgdo=cgon                 cgso=cgon
+ cgbo=0                    capmod=3                  nqsmod=0
+ xpart=1                   cf=0                      tlev=1
+ tlevc=1                   xti=3                     n=1
+ hdif=hdifn                ldif=8e-08                rsh=rshn
+ rs=0                      rd=0                      dlc=1.72e-8
+ cgdl=cgln                 cgsl=cgln                 wwc=-4.5e-2
+ dwc=0                     noia=7.0e+18              noib=2.5e+4
+ noic=1.0e-13              em=4.1e+7                 ef=1.009
+ noimod=2                  sa0=0.35e-6               sb0=0.35e-6
+ kvsat=0.4                 wlod=0.5e-6               tku0=0.03
+ ku0=-0.62e-7              llodku0=1                 wlodku0=1
+ lku0=2.0e-7               wku0=0.7e-6               pku0=-0.5e-13
+ kvth0=5.2e-9              stk2=2.5e-9               steta0=-1.1e-10
+ lkvth0=-1.0e-8            wkvth0=2.2e-6             pkvth0=-5e-14
+ llodvth=1.0               wlodvth=1                 lodk2=1
+ lodeta0=2                 minr=1e-3                 imax=0.01
+ imelt=0.01

     12: type=n
+ lmin=1.30e-07             lmax=3.50e-07-(dxl+dlmisn)
+ wmin=1.50e-07             wmax=5.85e-07-(dxw+dwmisn)
+ tnom=25                   version=3.24              tox=(toxn+toxmisn)
+ toxm=(toxn+toxmisn)       xj=1.9e-07                nch=6.14815e+17
+ lln=1                     lwn=1                     wln=1
+ wwn=-1                    lint=0                    ll=0
+ lw=0                      lwl=0                     wint=1.25e-08
+ wl=0                      ww=0                      wwl=0
+ mobmod=1                  binunit=2                 xl=-2.0e-08+(dxl+dlmisn)
+ xw=1.5e-08+(dxw+dwmisn)   dwg=0                     dwb=0
+ vth0=0.3500490+(dvthn+vthmisn)                      lvth0=1.2696601e-08+dlvthn
+ wvth0=-1.4173159e-08+dwvthn                         pvth0=-7.5417040e-16+dpvthn
+ k1=0.4418194              lk1=2.602556e-09          wk1=-1.274671e-08
+ pk1=-4.815287e-16         k2=-0.01+dk2n             lk2=0+dlk2n
+ k3=0                      dvt0=0                    dvt1=0
+ dvt2=0                    dvt0w=0                   dvt1w=0
+ dvt2w=0                   nlx=0                     w0=0
+ k3b=0                     vfb=-0.9247332            vsat=9.6200910e+04
+ lvsat=-1.0465960e-03+dlvsatn                        wvsat=9.4407860e-04
+ pvsat=1.5724812e-10+dpvsatn                         ua=8.405689e-10
+ lua=-2.328776e-17         wua=3.323681e-17          pua=-1.096815e-23
+ ub=1.219954e-18           lub=-8.349997e-26         wub=-1.638484e-25
+ pub=1.528061e-32          uc=2.174414e-10           luc=-1.060862e-17
+ wuc=-2.493871e-17         puc=1.532718e-24          rdsw=102.9
+ prwb=0                    prwg=0                    wr=1
+ u0=4.7356230e-02          lu0=3.3321140e-10         wu0=7.0259580e-11
+ pu0=8.2061830e-18         a0=1.163095               la0=1.217857e-08
+ wa0=2.122024e-08          pa0=-7.00268e-15          keta=-0.001
+ a1=0                      a2=0.99                   ags=1.423844
+ lags=-5.736857e-08        wags=-2.307085e-08        pags=7.613379e-15
+ b0=0                      b1=0                      voff=-0.1041251
+ lvoff=-1.300342e-08       wvoff=-2.17458e-09        pvoff=1.387317e-15
+ nfactor=1.288803          lnfactor=6.095963e-08     wnfactor=-1.03213e-07
+ pnfactor=1.062059e-14     cit=0                     cdsc=0
+ cdscb=0                   cdscd=0                   eta0=0.0008440161
+ leta0=4.037982e-10        weta0=1.434869e-12        peta0=-3.822031e-18
+ etab=-0.002130606         letab=-4.518999e-10       wetab=-1.850606e-11
+ petab=6.106991e-18        dsub=0                    pclm=0.3585052
+ lpclm=1.09005e-07         wpclm=4.284785e-08        ppclm=1.263441e-15+dppclmn
+ pdiblc1=0                 pdiblc2=0.005364868       lpdiblc2=-2.14062e-11
+ wpdiblc2=6.219454e-10     ppdiblc2=2.245796e-17     pdiblcb=0
+ drout=0                   pscbe1=1.8e+08            pscbe2=5e-08
+ pvag=0                    delta=0.01                kt1=-0.1890473
+ lkt1=2.403242e-09         wkt1=2.126591e-09         pkt1=-3.669215e-16
+ kt2=-0.02                 at=40422.62               lat=-0.0007994639
+ wat=-0.003118006          pat=4.596919e-10          ute=-1.577388
+ lute=9.03799e-09          wute=3.701206e-10         pute=-1.221397e-16
+ ua1=1.528207e-09          lua1=-6.754351e-17        wua1=1.068044e-16
+ pua1=-1.760166e-24        ub1=-2.801067e-18         lub1=1.051756e-25
+ wub1=-2.146773e-25        pub1=1.056997e-32         uc1=-4.953533e-10
+ luc1=3.736971e-17         wuc1=3.315467e-17         puc1=-6.23301e-24
+ kt1l=0                    prt=0                     alpha0=0
+ alpha1=0.009179           beta0=6.415               cj=cjn
+ mj=0.4528                 pb=0.7956                 cjsw=cjswn
+ mjsw=0.2323               pbsw=0.7956               cjswg=cjswgn
+ mjswg=0.4087              pbswg=0.7956              tcj=0.0009067
+ tcjsw=0.0002781           tcjswg=0.0002781          tpb=0.001427
+ tpbsw=0.001427            tpbswg=0.001427           js=8.00e-7
+ jsw=1.55e-12              cgdo=cgon                 cgso=cgon
+ cgbo=0                    capmod=3                  nqsmod=0
+ xpart=1                   cf=0                      tlev=1
+ tlevc=1                   xti=3                     n=1
+ hdif=hdifn                ldif=8e-08                rsh=rshn
+ rs=0                      rd=0                      dlc=1.72e-8
+ cgdl=cgln                 cgsl=cgln                 wwc=-4.5e-2
+ dwc=0                     noia=7.0e+18              noib=2.5e+4
+ noic=1.0e-13              em=4.1e+7                 ef=1.009
+ noimod=2                  sa0=0.35e-6               sb0=0.35e-6
+ kvsat=0.4                 wlod=0.5e-6               tku0=0.03
+ ku0=-0.62e-7              llodku0=1                 wlodku0=1
+ lku0=2.0e-7               wku0=0.7e-6               pku0=-0.5e-13
+ kvth0=5.2e-9              stk2=2.5e-9               steta0=-1.1e-10
+ lkvth0=-1.0e-8            wkvth0=2.2e-6             pkvth0=-5e-14
+ llodvth=1.0               wlodvth=1                 lodk2=1
+ lodeta0=2                 minr=1e-3                 imax=0.01
+ imelt=0.01
//
     }
ends nch_mis
//   // **************************************************************
//                                                              *
//                1.2V PMOS DEVICES MODEL                       *
//                                                              *
// **************************************************************
//

// *********************************
//        Mismatch   model         *
// *********************************

inline subckt pch_mis ( d g s b )
parameters l=1u w=1u multi=1 factor=1 sa=0.35e-6 sb=0.35e-6 ad=2 * hdifp
+ / factor * w as=2 * hdifp / factor * w pd=2 * (2 * hdifp / factor + w) ps=2 *
+ (2 * hdifp / factor + w) nrd=hdifp / factor / w nrs=hdifp / factor / w temp1=parp1
+ temp2=parp2 fac1=0.778 * temp1 + 0.629 * temp2 fac2=0.778 * temp1 - 0.629 * temp2
+ lef=l - 2.0e-8 wef=w + 1.5e-8 geo_fac=1 / sqrt(multi * lef * wef * 1e12) vthmisp=0.002585
+ * geo_fac * fac1 dlmisp=0.001932 * geo_fac * lef * fac2 dwmisp= - 0.001932 * geo_fac
+ * wef * fac2 toxmisp=0.001932 * geo_fac * toxp * fac2
pch_mis ( d g s b ) pch w=w l=l ad=ad as=as pd=pd ps=ps nrd=nrd nrs=nrs m=multi sa=sa
+ sb=sb
model pch bsim3v3  {
     1: type=p
+ lmin=8.00e-07-(dxl+dlmisp)                          lmax=2.1e-05
+ wmin=1.0005e-05-(dxw+dwmisp)                        wmax=0.0009001
+ tnom=25                   version=3.24              tox=(toxp+toxmisp)
+ toxm=(toxp+toxmisp)       xj=2.1e-07                nch=7.3e+17
+ lln=1                     lwn=1                     wln=1
+ wwn=-1                    lint=4e-09                ll=0
+ lw=0                      lwl=0                     wint=-6.5e-09
+ wl=0                      ww=0                      wwl=0
+ mobmod=1                  binunit=2                 xl=-2.0e-08+(dxl+dlmisp)
+ xw=1.5e-08+(dxw+dwmisp)   dwg=0                     dwb=0
+ vth0=-0.2932273+(dvthp+vthmisp)                     lvth0=-2.066847e-08+dlvthp
+ pvth0=0+dpvthp            k1=0.4394179              lk1=8.3678e-09
+ k2=-0.001+dk2p            lk2=0+dlk2p               k3=0
+ dvt0=0                    dvt1=0                    dvt2=0
+ dvt0w=0                   dvt1w=0                   dvt2w=0
+ nlx=0                     w0=0                      k3b=0
+ vfb=-1.031548             vsat=80000                pvsat=0+dpvsatp
+ lvsat=0+dlvsatp           ua=2.530576e-09           lua=-4.183904e-16
+ ub=-7.355376e-19          lub=1.031064e-25          uc=-1.865951e-10
+ luc=8.367809e-18          rdsw=445                  prwb=0
+ prwg=0                    wr=1                      u0=0.0139415
+ a0=1.312587               la0=-1.255171e-07         keta=-0.001
+ a1=0                      a2=0.99                   ags=0.3466435
+ lags=3.347123e-08         b0=0                      b1=0
+ voff=-0.1248322           lvoff=-1.673565e-09       nfactor=0.6832174
+ lnfactor=1.673561e-07     cit=0                     cdsc=0
+ cdscb=0                   cdscd=0                   eta0=0.0003741305
+ leta0=1.255171e-09        etab=-0.0001              dsub=0
+ pclm=0.77                 pdiblc1=0                 pdiblc2=0.0001
+ pdiblcb=0                 drout=0                   pscbe1=4.24e+08
+ pscbe2=1e-07              pvag=0                    delta=0.005
+ kt1=-0.1874826            lkt1=-2.510342e-08        kt2=0.01
+ at=103000                 ute=-1                    ua1=1.995804e-09
+ lua1=4.183904e-17         ub1=-3.364265e-18         lub1=1.422528e-25
+ uc1=-3.044239e-10         luc1=-2.568917e-17        kt1l=0
+ prt=0                     alpha0=0                  alpha1=0.001435
+ beta0=9.351               cj=cjp                    mj=0.4234
+ pb=0.9                    cjsw=cjswp                mjsw=0.1716
+ pbsw=0.9                  cjswg=cjswgp              mjswg=0.4413
+ pbswg=0.9                 tcj=0.000887              tcjsw=0.000298
+ tcjswg=0.000298           tpb=0.001643              tpbsw=0.001643
+ tpbswg=0.001643           js=1.80e-7                jsw=8.055e-13
+ cgdo=cgop                 cgso=cgop                 cgbo=0
+ capmod=3                  nqsmod=0                  xpart=1
+ cf=0                      tlev=1                    tlevc=1
+ xti=3                     n=1                       hdif=hdifp
+ ldif=8e-08                rsh=rshp                  rs=0
+ rd=0                      dlc=1.20e-8               wvth0=0+dwvthp
+ cgdl=cglp                 cgsl=cglp                 wwc=-4e-2
+ dwc=0                     noia=1.0e+19              noib=1.0e+3
+ noic=1.0e-11              em=1.0e+8                 ef=1.107
+ noimod=2                  sa0=0.35e-6               sb0=0.35e-6
+ kvsat=-0.6                wlod=0.3e-6               tku0=0.50
+ ku0=1.14e-7               llodku0=1                 wlodku0=1
+ lku0=6e-8                 wku0=3.0e-7               pku0=1e-14
+ kvth0=-2.3e-9             stk2=0e-9                 steta0=0
+ lkvth0=1e-8               wkvth0=2.5e-7             pkvth0=4e-14
+ llodvth=1                 wlodvth=1                 lodk2=1
+ lodeta0=1                 minr=1e-3                 imax=0.01
+ imelt=0.01

     2: type=p
+ lmin=3.50e-07-(dxl+dlmisp)                          lmax=8.00e-07-(dxl+dlmisp)
+ wmin=1.0005e-05-(dxw+dwmisp)                        wmax=0.0009001
+ tnom=25                   version=3.24              tox=(toxp+toxmisp)
+ toxm=(toxp+toxmisp)       xj=2.1e-07                nch=7.3e+17
+ lln=1                     lwn=1                     wln=1
+ wwn=-1                    lint=4e-09                ll=0
+ lw=0                      lwl=0                     wint=-6.5e-09
+ wl=0                      ww=0                      wwl=0
+ mobmod=1                  binunit=2                 xl=-2.0e-08+(dxl+dlmisp)
+ xw=1.5e-08+(dxw+dwmisp)   dwg=0                     dwb=0
+ vth0=-0.3068838+(dvthp+vthmisp)                     lvth0=-1.012566e-08+dlvthp
+ pvth0=0+dpvthp            k1=0.450257               k2=-0.001+dk2p
+ lk2=0+dlk2p               k3=0                      dvt0=0
+ dvt1=0                    dvt2=0                    dvt0w=0
+ dvt1w=0                   dvt2w=0                   nlx=0
+ w0=0                      k3b=0                     vfb=-1.013218
+ vsat=80000                ua=2.060176e-09           pvsat=0+dpvsatp
+ lvsat=0+dlvsatp           lua=-5.52409e-17          ub=-4.803356e-19
+ lub=-9.390952e-26         uc=-1.75756e-10           rdsw=445
+ prwb=0                    prwg=0                    wr=1
+ u0=0.0139415              a0=1.257333               la0=-8.286134e-08
+ keta=-0.001               a1=0                      a2=0.99
+ ags=0.3828444             lags=5.524101e-09         b0=0
+ b1=0                      voff=-0.1262845           lvoff=-5.524101e-10
+ nfactor=0.9               cit=0                     cdsc=0
+ cdscb=0                   cdscd=0                   eta0=0.001642222
+ leta0=2.762044e-10        etab=-0.0001              dsub=0
+ pclm=0.77                 pdiblc1=0                 pdiblc2=0.0001
+ pdiblcb=0                 drout=0                   pscbe1=4.24e+08
+ pscbe2=1e-07              pvag=0                    delta=0.005
+ kt1=-0.2343111            lkt1=1.104818e-08         kt2=0.01
+ at=155235.6               lat=-0.04032586           ute=-1.143111
+ lute=1.104818e-07         ua1=2.193111e-09          lua1=-1.104818e-16
+ ub1=-4.095911e-18         lub1=7.070835e-25         uc1=-3.017075e-10
+ luc1=-2.778616e-17        kt1l=0                    prt=0
+ alpha0=0                  alpha1=0.001435           beta0=9.351
+ cj=cjp                    mj=0.4234                 pb=0.9
+ cjsw=cjswp                mjsw=0.1716               pbsw=0.9
+ cjswg=cjswgp              mjswg=0.4413              pbswg=0.9
+ tcj=0.000887              tcjsw=0.000298            tcjswg=0.000298
+ tpb=0.001643              tpbsw=0.001643            tpbswg=0.001643
+ js=1.80e-7                jsw=8.055e-13             cgdo=cgop
+ cgso=cgop                 cgbo=0                    capmod=3
+ nqsmod=0                  xpart=1                   cf=0
+ tlev=1                    tlevc=1                   xti=3
+ n=1                       hdif=hdifp                ldif=8e-08
+ rsh=rshp                  rs=0                      rd=0
+ dlc=1.20e-8               wvth0=0+dwvthp            cgdl=cglp
+ cgsl=cglp                 wwc=-4e-2                 dwc=0
+ noia=1.0e+19              noib=1.0e+3               noic=1.0e-11
+ em=1.0e+8                 ef=1.107                  noimod=2
+ sa0=0.35e-6               sb0=0.35e-6               kvsat=-0.6
+ wlod=0.3e-6               tku0=0.50                 ku0=1.14e-7
+ llodku0=1                 wlodku0=1                 lku0=6e-8
+ wku0=3.0e-7               pku0=1e-14                kvth0=-2.3e-9
+ stk2=0e-9                 steta0=0                  lkvth0=1e-8
+ wkvth0=2.5e-7             pkvth0=4e-14              llodvth=1
+ wlodvth=1                 lodk2=1                   lodeta0=1
+ minr=1e-3                 imax=0.01                 imelt=0.01

     3: type=p
+ lmin=1.30e-07             lmax=3.50e-07-(dxl+dlmisp)
+ wmin=1.0005e-05-(dxw+dwmisp)                        wmax=0.0009001
+ tnom=25                   version=3.24              tox=(toxp+toxmisp)
+ toxm=(toxp+toxmisp)       xj=2.1e-07                nch=7.3e+17
+ lln=1                     lwn=1                     wln=1
+ wwn=-1                    lint=4e-09                ll=0
+ lw=0                      lwl=0                     wint=-6.5e-09
+ wl=0                      ww=0                      wwl=0
+ mobmod=1                  binunit=2                 xl=-2.0e-08+(dxl+dlmisp)
+ xw=1.5e-08+(dxw+dwmisp)   dwg=0                     dwb=0
+ vth0=-0.2995375+(dvthp+vthmisp)                     lvth0=-1.2491168e-08+dlvthp
+ pvth0=0+dpvthp            k1=0.4363479              lk1=4.478727e-09
+ k2=-0.001+dk2p            lk2=0+dlk2p               k3=0
+ dvt0=0                    dvt1=0                    dvt2=0
+ dvt0w=0                   dvt1w=0                   dvt2w=0
+ nlx=0                     w0=0                      k3b=0
+ vfb=-0.9703192            vsat=7.5641820e+04        pvsat=0+dpvsatp
+ lvsat=1.4033344e-03+dlvsatp                         ua=1.999253e-09
+ lua=-3.562378e-17         ub=-6.570817e-19          lub=-3.699726e-26
+ uc=-1.75756e-10           rdsw=445                  prwb=0
+ prwg=0                    wr=1                      u0=0.0139415
+ a0=1                      keta=-0.001               a1=0
+ a2=0.99                   ags=0.4                   b0=0
+ b1=0                      voff=-0.1154818           lvoff=-4.030853e-09
+ nfactor=0.8072727         lnfactor=2.985818e-08     cit=-3.5236360e-04
+ lcit=1.1346109e-10        cdsc=0                    cdscb=0
+ cdscd=0                   eta0=1.8181870e-04        leta0=7.4645450e-10
+ etab=0.001476364          letab=-5.075891e-10       dsub=0
+ pclm=0.6633636            lpclm=3.433691e-08        pdiblc1=0
+ pdiblc2=-0.0003172727     lpdiblc2=1.343618e-10     pdiblcb=0
+ drout=0                   pscbe1=4.24e+08           pscbe2=1e-07
+ pvag=0                    delta=0.005               kt1=-0.1907273
+ lkt1=-2.985817e-09        kt2=0.01                  at=37881.82
+ lat=-0.002537945          ute=-0.8                  ua1=1.757273e-09
+ lua1=2.985817e-17         ub1=-1.649636e-18         lub1=-8.061709e-26
+ uc1=-4.113209e-10         luc1=7.50933e-18          kt1l=0
+ prt=0                     alpha0=0                  alpha1=0.001435
+ beta0=9.351               cj=cjp                    mj=0.4234
+ pb=0.9                    cjsw=cjswp                mjsw=0.1716
+ pbsw=0.9                  cjswg=cjswgp              mjswg=0.4413
+ pbswg=0.9                 tcj=0.000887              tcjsw=0.000298
+ tcjswg=0.000298           tpb=0.001643              tpbsw=0.001643
+ tpbswg=0.001643           js=1.80e-7                jsw=8.055e-13
+ cgdo=cgop                 cgso=cgop                 cgbo=0
+ capmod=3                  nqsmod=0                  xpart=1
+ cf=0                      tlev=1                    tlevc=1
+ xti=3                     n=1                       hdif=hdifp
+ ldif=8e-08                rsh=rshp                  rs=0
+ rd=0                      dlc=1.20e-8               wvth0=0+dwvthp
+ cgdl=cglp                 cgsl=cglp                 wwc=-4e-2
+ dwc=0                     noia=1.0e+19              noib=1.0e+3
+ noic=1.0e-11              em=1.0e+8                 ef=1.107
+ noimod=2                  sa0=0.35e-6               sb0=0.35e-6
+ kvsat=-0.6                wlod=0.3e-6               tku0=0.50
+ ku0=1.14e-7               llodku0=1                 wlodku0=1
+ lku0=6e-8                 wku0=3.0e-7               pku0=1e-14
+ kvth0=-2.3e-9             stk2=0e-9                 steta0=0
+ lkvth0=1e-8               wkvth0=2.5e-7             pkvth0=4e-14
+ llodvth=1                 wlodvth=1                 lodk2=1
+ lodeta0=1                 minr=1e-3                 imax=0.01
+ imelt=0.01

     4: type=p
+ lmin=8.00e-07-(dxl+dlmisp)                          lmax=2.1e-05
+ wmin=1.205e-06-(dxw+dwmisp)                         wmax=1.0005e-05-(dxw+dwmisp)
+ tnom=25                   version=3.24              tox=(toxp+toxmisp)
+ toxm=(toxp+toxmisp)       xj=2.1e-07                nch=7.3e+17
+ lln=1                     lwn=1                     wln=1
+ wwn=-1                    lint=4e-09                ll=0
+ lw=0                      lwl=0                     wint=-6.5e-09
+ wl=0                      ww=0                      wwl=0
+ mobmod=1                  binunit=2                 xl=-2.0e-08+(dxl+dlmisp)
+ xw=1.5e-08+(dxw+dwmisp)   dwg=0                     dwb=0
+ vth0=-0.2946285+(dvthp+vthmisp)                     lvth0=-2.066847e-08+dlvthp
+ pvth0=0+dpvthp            wvth0=1.405763e-08+dwvthp k1=0.4393003
+ lk1=9.540242e-09          wk1=1.179614e-09          pk1=-1.176312e-14
+ k2=-0.001+dk2p            lk2=0+dlk2p               k3=0
+ dvt0=0                    dvt1=0                    dvt2=0
+ dvt0w=0                   dvt1w=0                   dvt2w=0
+ nlx=0                     w0=0                      k3b=0
+ vfb=-1.031958             vsat=80000                pvsat=0+dpvsatp
+ lvsat=0+dlvsatp           ua=2.530576e-09           lua=-4.183904e-16
+ ub=-7.365039e-19          lub=9.877072e-26          wub=9.695372e-27
+ pub=4.35001e-32           uc=-1.881138e-10          luc=9.540252e-18
+ wuc=1.523722e-17          puc=-1.176313e-23         rdsw=445
+ prwb=0                    prwg=0                    wr=1
+ u0=0.0141423              lu0=1.172443e-11          wu0=-2.014606e-09
+ pu0=-1.176313e-16         a0=1.312587               la0=-1.255171e-07
+ keta=-0.001               a1=0                      a2=0.99
+ ags=0.3461732             lags=3.8161e-08           wags=4.718462e-09
+ pags=-4.705251e-14        b0=0                      b1=0
+ voff=-0.1240611           lvoff=-2.377031e-09       wvoff=-7.736563e-09
+ pvoff=7.057875e-15        nfactor=0.6756238         lnfactor=1.732184e-07
+ wnfactor=7.618609e-08     pnfactor=-5.881567e-14    cit=0
+ cdsc=0                    cdscb=0                   cdscd=0
+ eta0=0.0003741306         leta0=1.255171e-09        etab=-0.0001
+ dsub=0                    pclm=0.77                 pdiblc1=0
+ pdiblc2=0.0001            pdiblcb=0                 drout=0
+ pscbe1=4.24e+08           pscbe2=1e-07              pvag=0
+ delta=0.005               kt1=-0.1872475            lkt1=-2.744831e-08
+ wkt1=-2.359228e-09        pkt1=2.352626e-14         kt2=0.01
+ at=103000                 ute=-0.9976485            lute=-2.344887e-08
+ wute=-2.359231e-08        pute=2.352626e-13         ua1=1.969202e-09
+ lua1=1.370039e-17         wua1=2.668989e-16         pua1=2.823152e-22
+ ub1=-3.264863e-18         lub1=8.714795e-26         wub1=-9.973013e-25
+ pub1=5.528672e-31         uc1=-2.993632e-10         luc1=-3.284108e-17
+ wuc1=-5.077419e-17        puc1=7.175508e-23         kt1l=0
+ prt=0                     alpha0=0                  alpha1=0.001435
+ beta0=9.351               cj=cjp                    mj=0.4234
+ pb=0.9                    cjsw=cjswp                mjsw=0.1716
+ pbsw=0.9                  cjswg=cjswgp              mjswg=0.4413
+ pbswg=0.9                 tcj=0.000887              tcjsw=0.000298
+ tcjswg=0.000298           tpb=0.001643              tpbsw=0.001643
+ tpbswg=0.001643           js=1.80e-7                jsw=8.055e-13
+ cgdo=cgop                 cgso=cgop                 cgbo=0
+ capmod=3                  nqsmod=0                  xpart=1
+ cf=0                      tlev=1                    tlevc=1
+ xti=3                     n=1                       hdif=hdifp
+ ldif=8e-08                rsh=rshp                  rs=0
+ rd=0                      dlc=1.20e-8               cgdl=cglp
+ cgsl=cglp                 wwc=-4e-2                 dwc=0
+ noia=1.0e+19              noib=1.0e+3               noic=1.0e-11
+ em=1.0e+8                 ef=1.107                  noimod=2
+ sa0=0.35e-6               sb0=0.35e-6               kvsat=-0.6
+ wlod=0.3e-6               tku0=0.50                 ku0=1.14e-7
+ llodku0=1                 wlodku0=1                 lku0=6e-8
+ wku0=3.0e-7               pku0=1e-14                kvth0=-2.3e-9
+ stk2=0e-9                 steta0=0                  lkvth0=1e-8
+ wkvth0=2.5e-7             pkvth0=4e-14              llodvth=1
+ wlodvth=1                 lodk2=1                   lodeta0=1
+ minr=1e-3                 imax=0.01                 imelt=0.01

     5: type=p
+ lmin=3.50e-07-(dxl+dlmisp)                          lmax=8.00e-07-(dxl+dlmisp)
+ wmin=1.205e-06-(dxw+dwmisp)                         wmax=1.0005e-05-(dxw+dwmisp)
+ tnom=25                   version=3.24              tox=(toxp+toxmisp)
+ toxm=(toxp+toxmisp)       xj=2.1e-07                nch=7.3e+17
+ lln=1                     lwn=1                     wln=1
+ wwn=-1                    lint=4e-09                ll=0
+ lw=0                      lwl=0                     wint=-6.5e-09
+ wl=0                      ww=0                      wwl=0
+ mobmod=1                  binunit=2                 xl=-2.0e-08+(dxl+dlmisp)
+ xw=1.5e-08+(dxw+dwmisp)   dwg=0                     dwb=0
+ vth0=-0.3084855+(dvthp+vthmisp)                     lvth0=-9.970861e-09+dlvthp
+ wvth0=1.606939e-08+dwvthp pvth0=-1.553112e-15+dpvthp
+ k1=0.4526607              lk1=-7.739997e-10         wk1=-2.411658e-08
+ pk1=7.765538e-15          k2=-0.001+dk2p            lk2=0+dlk2p
+ k3=0                      dvt0=0                    dvt1=0
+ dvt2=0                    dvt0w=0                   dvt1w=0
+ dvt2w=0                   nlx=0                     w0=0
+ k3b=0                     vfb=-1.021218             vsat=80000
+ ua=2.070201e-09           lua=-6.298091e-17         pvsat=0+dpvsatp
+ lvsat=0+dlvsatp           wua=-1.0059e-16           pua=7.765547e-23
+ ub=-4.846101e-19          lub=-9.569127e-26         wub=4.288687e-26
+ pub=1.787626e-32          uc=-1.75756e-10           rdsw=445
+ prwb=0                    prwg=0                    wr=1
+ u0=0.01417167             lu0=-1.095212e-11         wu0=-2.309313e-09
+ pu0=1.098825e-16          a0=1.257333               la0=-8.286133e-08
+ keta=-0.001               a1=0                      a2=0.99
+ ags=0.3924593             lags=2.428099e-09         wags=-9.646639e-08
+ pags=3.106218e-14         b0=0                      b1=0
+ voff=-0.1264246           lvoff=-5.524101e-10       wvoff=1.405763e-09
+ nfactor=0.9               cit=0                     cdsc=0
+ cdscb=0                   cdscd=0                   eta0=0.001642222
+ leta0=2.762044e-10        etab=-0.0001              dsub=0
+ pclm=0.77                 pdiblc1=0                 pdiblc2=0.0001
+ pdiblcb=0                 drout=0                   pscbe1=4.24e+08
+ pscbe2=1e-07              pvag=0                    delta=0.005
+ kt1=-0.2401212            lkt1=1.337018e-08         wkt1=5.829218e-08
+ pkt1=-2.329663e-14        kt2=0.01                  at=155235.6
+ lat=-0.04032585           ute=-1.191186             lute=1.259618e-07
+ wute=4.82332e-07          pute=-1.553109e-13        ua1=2.115021e-09
+ lua1=-9.887172e-17        wua1=7.834772e-16         pua1=-1.164833e-22
+ ub1=-4.107992e-18         lub1=7.380436e-25         wub1=1.212076e-25
+ pub1=-3.106218e-31        uc1=-3.000959e-10         luc1=-3.227537e-17
+ wuc1=-1.616938e-17        puc1=4.504016e-23         kt1l=0
+ prt=0                     alpha0=0                  alpha1=0.001435
+ beta0=9.351               cj=cjp                    mj=0.4234
+ pb=0.9                    cjsw=cjswp                mjsw=0.1716
+ pbsw=0.9                  cjswg=cjswgp              mjswg=0.4413
+ pbswg=0.9                 tcj=0.000887              tcjsw=0.000298
+ tcjswg=0.000298           tpb=0.001643              tpbsw=0.001643
+ tpbswg=0.001643           js=1.80e-7                jsw=8.055e-13
+ cgdo=cgop                 cgso=cgop                 cgbo=0
+ capmod=3                  nqsmod=0                  xpart=1
+ cf=0                      tlev=1                    tlevc=1
+ xti=3                     n=1                       hdif=hdifp
+ ldif=8e-08                rsh=rshp                  rs=0
+ rd=0                      dlc=1.20e-8               cgdl=cglp
+ cgsl=cglp                 wwc=-4e-2                 dwc=0
+ noia=1.0e+19              noib=1.0e+3               noic=1.0e-11
+ em=1.0e+8                 ef=1.107                  noimod=2
+ sa0=0.35e-6               sb0=0.35e-6               kvsat=-0.6
+ wlod=0.3e-6               tku0=0.50                 ku0=1.14e-7
+ llodku0=1                 wlodku0=1                 lku0=6e-8
+ wku0=3.0e-7               pku0=1e-14                kvth0=-2.3e-9
+ stk2=0e-9                 steta0=0                  lkvth0=1e-8
+ wkvth0=2.5e-7             pkvth0=4e-14              llodvth=1
+ wlodvth=1                 lodk2=1                   lodeta0=1
+ minr=1e-3                 imax=0.01                 imelt=0.01

     6: type=p
+ lmin=1.30e-07             lmax=3.50e-07-(dxl+dlmisp)
+ wmin=1.205e-06-(dxw+dwmisp)                         wmax=1.0005e-05-(dxw+dwmisp)
+ tnom=25                   version=3.24              tox=(toxp+toxmisp)
+ toxm=(toxp+toxmisp)       xj=2.1e-07                nch=7.3e+17
+ lln=1                     lwn=1                     wln=1
+ wwn=-1                    lint=4e-09                ll=0
+ lw=0                      lwl=0                     wint=-6.5e-09
+ wl=0                      ww=0                      wwl=0
+ mobmod=1                  binunit=2                 xl=-2.0e-08+(dxl+dlmisp)
+ xw=1.5e-08+(dxw+dwmisp)   dwg=0                     dwb=0
+ vth0=-0.3007786+(dvthp+vthmisp)                     lvth0=-1.2452491e-08+dlvthp
+ wvth0=1.2451168e-08+dwvthp                          pvth0=-3.8804420e-16+dpvthp
+ k1=0.4343991              lk1=5.106258e-09          wk1=1.955284e-08
+ pk1=-6.296016e-15         k2=-0.001+dk2p            lk2=0+dlk2p
+ k3=0                      dvt0=0                    dvt1=0
+ dvt2=0                    dvt0w=0                   dvt1w=0
+ dvt2w=0                   nlx=0                     w0=0
+ k3b=0                     vfb=-0.9415483            vsat=7.5100910e+04
+ lvsat=1.5775075e-03+dlvsatp                         wvsat=5.4269470e-03
+ pvsat=-1.7474771e-09+dpvsatp                        ua=1.97713e-09
+ lua=-3.3012e-17           wua=2.219549e-16          pua=-2.6204e-23
+ ub=-6.506528e-19          lub=-4.222554e-26         wub=-6.450149e-26
+ pub=5.245532e-32          uc=-1.75756e-10           rdsw=445
+ prwb=0                    prwg=0                    wr=1
+ u0=0.01419055             lu0=-1.703087e-11         wu0=-2.498718e-09
+ pu0=1.708708e-16          a0=1                      keta=-0.001
+ a1=0                      a2=0.99                   ags=0.4
+ b0=0                      b1=0                      voff=-0.1158204
+ lvoff=-3.966937e-09       wvoff=3.397306e-09        pvoff=-6.412771e-16
+ nfactor=0.8082265         lnfactor=2.955105e-08     wnfactor=-9.569868e-09
+ pnfactor=3.081497e-15     cit=-4.0173460e-04        lcit=1.2935854e-10
+ wcit=4.9533890e-10        pcit=-1.5949910e-16       cdsc=0
+ cdscb=0                   cdscd=0                   eta0=1.5685277e-04
+ leta0=7.5449350e-10       weta0=2.5048039e-10       peta0=-8.0654780e-17
+ etab=0.001460148          letab=-5.023678e-10       wetab=1.626878e-10
+ petab=-5.238544e-17       dsub=0                    pclm=0.6714336
+ lpclm=3.173837e-08        wpclm=-8.096643e-08       ppclm=2.607119e-14
+ pdiblc1=0                 pdiblc2=-0.0003129804     lpdiblc2=1.329797e-10
+ wpdiblc2=-4.306437e-11    ppdiblc2=1.386674e-17     pdiblcb=0
+ drout=0                   pscbe1=4.24e+08           pscbe2=1e-07
+ pvag=0                    delta=0.005               kt1=-0.1887242
+ lkt1=-3.179637e-09        wkt1=-2.00967e-08         pkt1=1.944595e-15
+ kt2=0.01                  at=37800.74               lat=-0.002511839
+ wat=0.0008134381          pat=-2.619272e-10         ute=-0.8
+ ua1=1.691787e-09          lua1=3.740971e-17         wua1=6.570216e-16
+ pua1=-7.576462e-23        ub1=-1.550013e-18         lub1=-8.562571e-26
+ wub1=-9.995162e-25        pub1=5.025138e-32         uc1=-4.330339e-10
+ luc1=1.053065e-17         wuc1=2.178463e-16         puc1=-3.031291e-23
+ kt1l=0                    prt=0                     alpha0=0
+ alpha1=0.001435           beta0=9.351               cj=cjp
+ mj=0.4234                 pb=0.9                    cjsw=cjswp
+ mjsw=0.1716               pbsw=0.9                  cjswg=cjswgp
+ mjswg=0.4413              pbswg=0.9                 tcj=0.000887
+ tcjsw=0.000298            tcjswg=0.000298           tpb=0.001643
+ tpbsw=0.001643            tpbswg=0.001643           js=1.80e-7
+ jsw=8.055e-13             cgdo=cgop                 cgso=cgop
+ cgbo=0                    capmod=3                  nqsmod=0
+ xpart=1                   cf=0                      tlev=1
+ tlevc=1                   xti=3                     n=1
+ hdif=hdifp                ldif=8e-08                rsh=rshp
+ rs=0                      rd=0                      dlc=1.20e-8
+ cgdl=cglp                 cgsl=cglp                 wwc=-4e-2
+ dwc=0                     noia=1.0e+19              noib=1.0e+3
+ noic=1.0e-11              em=1.0e+8                 ef=1.107
+ noimod=2                  sa0=0.35e-6               sb0=0.35e-6
+ kvsat=-0.6                wlod=0.3e-6               tku0=0.50
+ ku0=1.14e-7               llodku0=1                 wlodku0=1
+ lku0=6e-8                 wku0=3.0e-7               pku0=1e-14
+ kvth0=-2.3e-9             stk2=0e-9                 steta0=0
+ lkvth0=1e-8               wkvth0=2.5e-7             pkvth0=4e-14
+ llodvth=1                 wlodvth=1                 lodk2=1
+ lodeta0=1                 minr=1e-3                 imax=0.01
+ imelt=0.01

     7: type=p
+ lmin=8.00e-07-(dxl+dlmisp)                          lmax=2.1e-05
+ wmin=5.85e-07-(dxw+dwmisp)                          wmax=1.205e-06-(dxw+dwmisp)
+ tnom=25                   version=3.24              tox=(toxp+toxmisp)
+ toxm=(toxp+toxmisp)       xj=2.1e-07                nch=7.3e+17
+ lln=1                     lwn=1                     wln=1
+ wwn=-1                    lint=4e-09                ll=0
+ lw=0                      lwl=0                     wint=-6.5e-09
+ wl=0                      ww=0                      wwl=0
+ mobmod=1                  binunit=2                 xl=-2.0e-08+(dxl+dlmisp)
+ xw=1.5e-08+(dxw+dwmisp)   dwg=0                     dwb=0
+ vth0=-0.2969828+(dvthp+vthmisp)                     lvth0=-1.4629e-08+dlvthp
+ wvth0=1.696048e-08+dwvthp pvth0=-7.446704e-15+dpvthp
+ k1=0.4711628              lk1=-1.240999e-08         wk1=-3.810682e-08
+ pk1=1.530152e-14          k2=-0.001+dk2p            lk2=0+dlk2p
+ k3=0                      dvt0=0                    dvt1=0
+ dvt2=0                    dvt0w=0                   dvt1w=0
+ dvt2w=0                   nlx=0                     w0=0
+ k3b=0                     vfb=-1.023573             vsat=7.9751100e+04
+ lvsat=2.4820000e-03+dlvsatp                         wvsat=3.0688976e-04
+ pvsat=-3.0603062e-09+dpvsatp                        ua=2.530576e-09
+ lua=-4.183904e-16         ub=-7.175091e-19          lub=1.216406e-25
+ wub=-1.372522e-26         pub=1.530152e-32          uc=-1.75756e-10
+ rdsw=445                  prwb=0                    prwg=0
+ wr=1                      u0=1.2917879e-02          lu0=5.1613850e-10
+ wu0=-5.0489850e-10        pu0=-7.3957400e-16        a0=1.312587
+ la0=-1.255171e-07         keta=-0.001               a1=0
+ a2=0.99                   ags=0.35                  b0=0
+ b1=0                      voff=-0.1306675           lvoff=6.656445e-09
+ wvoff=4.091857e-10        pvoff=-4.080401e-15       nfactor=0.737413
+ lnfactor=1.255171e-07     cit=0                     cdsc=0
+ cdscb=0                   cdscd=0                   eta0=0.0003741305
+ leta0=1.255171e-09        etab=-0.0001              dsub=0
+ pclm=0.77                 pdiblc1=0                 pdiblc2=0.0001
+ pdiblcb=0                 drout=0                   pscbe1=4.24e+08
+ pscbe2=1e-07              pvag=0                    delta=0.005
+ kt1=-0.1891609            lkt1=-8.367812e-09        kt2=0.01
+ at=103000                 ute=-1.016783             lute=1.673561e-07
+ ua1=2.3319e-09            lua1=8.54893e-16          wua1=-1.803072e-16
+ pua1=-7.548755e-22        ub1=-4.149071e-18         lub1=-9.323311e-26
+ wub1=9.29261e-26          pub1=7.752772e-31         uc1=-3.108813e-10
+ luc1=2.535445e-17         wuc1=-3.657238e-17        kt1l=0
+ prt=0                     alpha0=0                  alpha1=0.001435
+ beta0=9.351               cj=cjp                    mj=0.4234
+ pb=0.9                    cjsw=cjswp                mjsw=0.1716
+ pbsw=0.9                  cjswg=cjswgp              mjswg=0.4413
+ pbswg=0.9                 tcj=0.000887              tcjsw=0.000298
+ tcjswg=0.000298           tpb=0.001643              tpbsw=0.001643
+ tpbswg=0.001643           js=1.80e-7                jsw=8.055e-13
+ cgdo=cgop                 cgso=cgop                 cgbo=0
+ capmod=3                  nqsmod=0                  xpart=1
+ cf=0                      tlev=1                    tlevc=1
+ xti=3                     n=1                       hdif=hdifp
+ ldif=8e-08                rsh=rshp                  rs=0
+ rd=0                      dlc=1.20e-8               cgdl=cglp
+ cgsl=cglp                 wwc=-4e-2                 dwc=0
+ noia=1.0e+19              noib=1.0e+3               noic=1.0e-11
+ em=1.0e+8                 ef=1.107                  noimod=2
+ sa0=0.35e-6               sb0=0.35e-6               kvsat=-0.6
+ wlod=0.3e-6               tku0=0.50                 ku0=1.14e-7
+ llodku0=1                 wlodku0=1                 lku0=6e-8
+ wku0=3.0e-7               pku0=1e-14                kvth0=-2.3e-9
+ stk2=0e-9                 steta0=0                  lkvth0=1e-8
+ wkvth0=2.5e-7             pkvth0=4e-14              llodvth=1
+ wlodvth=1                 lodk2=1                   lodeta0=1
+ minr=1e-3                 imax=0.01                 imelt=0.01

     8: type=p
+ lmin=3.50e-07-(dxl+dlmisp)                          lmax=8.00e-07-(dxl+dlmisp)
+ wmin=5.85e-07-(dxw+dwmisp)                          wmax=1.205e-06-(dxw+dwmisp)
+ tnom=25                   version=3.24              tox=(toxp+toxmisp)
+ toxm=(toxp+toxmisp)       xj=2.1e-07                nch=7.3e+17
+ lln=1                     lwn=1                     wln=1
+ wwn=-1                    lint=4e-09                ll=0
+ lw=0                      lwl=0                     wint=-6.5e-09
+ wl=0                      ww=0                      wwl=0
+ mobmod=1                  binunit=2                 xl=-2.0e-08+(dxl+dlmisp)
+ xw=1.5e-08+(dxw+dwmisp)   dwg=0                     dwb=0
+ vth0=-0.3049012+(dvthp+vthmisp)                     lvth0=-8.516014e-09+dlvthp
+ wvth0=1.16499e-08+dwvthp  pvth0=-3.346938e-15+dpvthp
+ k1=0.4443947              lk1=8.254944e-09          wk1=-1.392461e-08
+ pk1=-3.367149e-15         k2=-0.001+dk2p            lk2=0+dlk2p
+ k3=0                      dvt0=0                    dvt1=0
+ dvt2=0                    dvt0w=0                   dvt1w=0
+ dvt2w=0                   nlx=0                     w0=0
+ k3b=0                     vfb=-1.003068             vsat=8.5088560e+04
+ lvsat=-1.6385169e-03+dlvsatp                        wvsat=-6.2741950e-03
+ pvsat=2.0202910e-09+dpvsatp                         ua=1.995695e-09
+ lua=-5.461724e-18         wua=-8.723193e-18         pua=6.734304e-24
+ ub=-2.515979e-19          lub=-2.380428e-25         wub=-2.444172e-25
+ pub=1.933957e-31          uc=-1.75756e-10           rdsw=445
+ prwb=0                    prwg=0                    wr=1
+ u0=1.3768193e-02          lu0=-1.4030341e-10        wu0=-1.8118242e-09
+ pu0=2.6937265e-16         a0=1.257333               la0=-8.286133e-08
+ keta=-0.001               a1=0                      a2=0.99
+ ags=0.3142222             lags=2.762046e-08         b0=0
+ b1=0                      voff=-0.124867            lvoff=2.178457e-09
+ wvoff=-5.147034e-10       pvoff=-3.367159e-15       nfactor=0.9
+ cit=0                     cdsc=0                    cdscb=0
+ cdscd=0                   eta0=0.001642222          leta0=2.762044e-10
+ etab=-0.0001              dsub=0                    pclm=0.77
+ pdiblc1=0                 pdiblc2=0.0001            pdiblcb=0
+ drout=0                   pscbe1=4.24e+08           pscbe2=1e-07
+ pvag=0                    delta=0.005               kt1=-0.1999192
+ lkt1=-6.23589e-11         wkt1=8.723196e-09         pkt1=-6.734307e-15
+ kt2=0.01                  at=155235.6               lat=-0.04032585
+ ute=-0.8                  ua1=4.715561e-09          lua1=-9.852931e-16
+ wua1=-2.422988e-15        pua1=9.76474e-22          ub1=-6.668221e-18
+ lub1=1.851551e-24         wub1=3.277969e-24         pub1=-1.683576e-30
+ uc1=-3.243699e-10         luc1=3.57677e-17          wuc1=1.376045e-17
+ puc1=-3.885694e-23        kt1l=0                    prt=0
+ alpha0=0                  alpha1=0.001435           beta0=9.351
+ cj=cjp                    mj=0.4234                 pb=0.9
+ cjsw=cjswp                mjsw=0.1716               pbsw=0.9
+ cjswg=cjswgp              mjswg=0.4413              pbswg=0.9
+ tcj=0.000887              tcjsw=0.000298            tcjswg=0.000298
+ tpb=0.001643              tpbsw=0.001643            tpbswg=0.001643
+ js=1.80e-7                jsw=8.055e-13             cgdo=cgop
+ cgso=cgop                 cgbo=0                    capmod=3
+ nqsmod=0                  xpart=1                   cf=0
+ tlev=1                    tlevc=1                   xti=3
+ n=1                       hdif=hdifp                ldif=8e-08
+ rsh=rshp                  rs=0                      rd=0
+ dlc=1.20e-8               cgdl=cglp                 cgsl=cglp
+ wwc=-4e-2                 dwc=0                     noia=1.0e+19
+ noib=1.0e+3               noic=1.0e-11              em=1.0e+8
+ ef=1.107                  noimod=2                  sa0=0.35e-6
+ sb0=0.35e-6               kvsat=-0.6                wlod=0.3e-6
+ tku0=0.50                 ku0=1.14e-7               llodku0=1
+ wlodku0=1                 lku0=6e-8                 wku0=3.0e-7
+ pku0=1e-14                kvth0=-2.3e-9             stk2=0e-9
+ steta0=0                  lkvth0=1e-8               wkvth0=2.5e-7
+ pkvth0=4e-14              llodvth=1                 wlodvth=1
+ lodk2=1                   lodeta0=1                 minr=1e-3
+ imax=0.01                 imelt=0.01

     9: type=p
+ lmin=1.30e-07             lmax=3.50e-07-(dxl+dlmisp)
+ wmin=5.85e-07-(dxw+dwmisp)                          wmax=1.205e-06-(dxw+dwmisp)
+ tnom=25                   version=3.24              tox=(toxp+toxmisp)
+ toxm=(toxp+toxmisp)       xj=2.1e-07                nch=7.3e+17
+ lln=1                     lwn=1                     wln=1
+ wwn=-1                    lint=4e-09                ll=0
+ lw=0                      lwl=0                     wint=-6.5e-09
+ wl=0                      ww=0                      wwl=0
+ mobmod=1                  binunit=2                 xl=-2.0e-08+(dxl+dlmisp)
+ xw=1.5e-08+(dxw+dwmisp)   dwg=0                     dwb=0
+ vth0=-0.2904834+(dvthp+vthmisp)                     lvth0=-1.315855e-08+dlvthp
+ wvth0=-2.428481e-10+dwvthp                          pvth0=4.825279e-16+dpvthp
+ k1=0.4872531              lk1=-5.545465e-09         wk1=-4.561625e-08
+ pk1=6.837558e-15          k2=-0.001+dk2p            lk2=0+dlk2p
+ k3=0                      dvt0=0                    dvt1=0
+ dvt2=0                    dvt0w=0                   dvt1w=0
+ dvt2w=0                   nlx=0                     w0=0
+ k3b=0                     vfb=-0.9594337            vsat=7.8026160e+04
+ lvsat=6.3557680e-04+dlvsatp                         wvsat=1.8201134e-03
+ pvsat=-5.8607660e-10+dpvsatp                        ua=2.142335e-09
+ lua=-5.267981e-17         wua=1.825783e-17          pua=-1.953588e-24
+ ub=-9.879987e-19          lub=-9.217233e-28         wub=3.514461e-25
+ pub=1.527712e-33          uc=-1.48693e-10           luc=-8.714301e-18
+ wuc=-3.336873e-17         puc=1.074473e-23          rdsw=445
+ prwb=0                    prwg=0                    wr=1
+ u0=1.2659749e-02          lu0=2.1661563e-10         wu0=-6.1124070e-10
+ pu0=-1.1721530e-16        a0=1                      keta=-0.001
+ a1=0                      a2=0.99                   ags=0.4
+ b0=0                      b1=0                      voff=-0.1046588
+ lvoff=-4.328589e-09       wvoff=-1.036501e-08       pvoff=-1.953594e-16
+ nfactor=0.800465          lnfactor=3.205024e-08     cit=0
+ cdsc=0                    cdscb=0                   cdscd=0
+ eta0=-3.364374e-05        leta0=8.158335e-10        weta0=4.853635e-10
+ peta0=-1.562871e-16       etab=0.001346065          letab=-4.65633e-10
+ wetab=3.033523e-10        petab=-9.767944e-17       dsub=0
+ pclm=0.5565619            lpclm=6.872708e-08        wpclm=6.067044e-08
+ ppclm=-1.953589e-14       pdiblc1=0                 pdiblc2=-0.0006923457
+ lpdiblc2=2.551354e-10     wpdiblc2=4.246931e-10     ppdiblc2=-1.367512e-16
+ pdiblcb=0                 drout=0                   pscbe1=4.24e+08
+ pscbe2=1e-07              pvag=0                    delta=0.005
+ kt1=-0.185295             lkt1=-4.771351e-09        wkt1=-2.432489e-08
+ pkt1=3.907179e-15         kt2=0.01                  at=38460.46
+ lat=-0.00272427           ute=-0.8                  ua1=1.435063e-09
+ lua1=7.102744e-17         wua1=9.735622e-16         pua1=-1.172153e-22
+ ub1=-3.063422e-19         lub1=-1.969745e-25        wub1=-2.532963e-24
+ pub1=1.875445e-31         uc1=-2.545728e-10         luc1=1.329303e-17
+ wuc1=-2.19609e-18         puc1=-3.371893e-23        kt1l=0
+ prt=0                     alpha0=0                  alpha1=0.001435
+ beta0=9.351               cj=cjp                    mj=0.4234
+ pb=0.9                    cjsw=cjswp                mjsw=0.1716
+ pbsw=0.9                  cjswg=cjswgp              mjswg=0.4413
+ pbswg=0.9                 tcj=0.000887              tcjsw=0.000298
+ tcjswg=0.000298           tpb=0.001643              tpbsw=0.001643
+ tpbswg=0.001643           js=1.80e-7                jsw=8.055e-13
+ cgdo=cgop                 cgso=cgop                 cgbo=0
+ capmod=3                  nqsmod=0                  xpart=1
+ cf=0                      tlev=1                    tlevc=1
+ xti=3                     n=1                       hdif=hdifp
+ ldif=8e-08                rsh=rshp                  rs=0
+ rd=0                      dlc=1.20e-8               cgdl=cglp
+ cgsl=cglp                 wwc=-4e-2                 dwc=0
+ noia=1.0e+19              noib=1.0e+3               noic=1.0e-11
+ em=1.0e+8                 ef=1.107                  noimod=2
+ sa0=0.35e-6               sb0=0.35e-6               kvsat=-0.6
+ wlod=0.3e-6               tku0=0.50                 ku0=1.14e-7
+ llodku0=1                 wlodku0=1                 lku0=6e-8
+ wku0=3.0e-7               pku0=1e-14                kvth0=-2.3e-9
+ stk2=0e-9                 steta0=0                  lkvth0=1e-8
+ wkvth0=2.5e-7             pkvth0=4e-14              llodvth=1
+ wlodvth=1                 lodk2=1                   lodeta0=1
+ minr=1e-3                 imax=0.01                 imelt=0.01

     10: type=p
+ lmin=8.00e-07-(dxl+dlmisp)                          lmax=2.1e-05
+ wmin=1.50e-07             wmax=5.85e-07-(dxw+dwmisp)
+ tnom=25                   version=3.24              tox=(toxp+toxmisp)
+ toxm=(toxp+toxmisp)       xj=2.1e-07                nch=7.3e+17
+ lln=1                     lwn=1                     wln=1
+ wwn=-1                    lint=4e-09                ll=0
+ lw=0                      lwl=0                     wint=-6.5e-09
+ wl=0                      ww=0                      wwl=0
+ mobmod=1                  binunit=2                 xl=-2.0e-08+(dxl+dlmisp)
+ xw=1.5e-08+(dxw+dwmisp)   dwg=0                     dwb=0
+ vth0=-0.2798276+(dvthp+vthmisp)                     lvth0=-3.129704e-08+dlvthp
+ wvth0=6.444338e-09+dwvthp pvth0=2.77081e-15+dpvthp  k1=0.4469916
+ lk1=1.015345e-08          wk1=-2.32899e-08          pk1=1.470128e-15
+ k2=-0.001+dk2p            lk2=0+dlk2p               k3=0
+ dvt0=0                    dvt1=0                    dvt2=0
+ dvt0w=0                   dvt1w=0                   dvt2w=0
+ nlx=0                     w0=0                      k3b=0
+ vfb=-0.9818085            vsat=8.0251740e+04        pvsat=0+dpvsatp
+ lvsat=-2.5103423e-03+dlvsatp                        ua=2.527534e-09
+ lua=-3.880463e-16         wua=1.865315e-18          pua=-1.860093e-23
+ ub=-4.750965e-19          lub=4.64211e-26           wub=-1.623242e-25
+ pub=6.14111e-32           uc=-1.75756e-10           rdsw=445
+ prwb=0                    prwg=0                    wr=1
+ u0=1.2096630e-02          lu0=-7.1431280e-10        wu0=-1.4734067e-12
+ pu0=1.4692774e-17         a0=1.312587               la0=-1.255171e-07
+ keta=-0.001               a1=0                      a2=0.99
+ ags=0.35                  b0=0                      b1=0
+ voff=-0.128429            lvoff=-4.371794e-09       wvoff=-9.630188e-10
+ pvoff=2.67991e-15         nfactor=0.737413          lnfactor=1.255171e-07
+ cit=0                     cdsc=0                    cdscb=0
+ cdscd=0                   eta0=0.0003741306         leta0=1.255171e-09
+ etab=-0.0001              dsub=0                    pclm=0.77
+ pdiblc1=0                 pdiblc2=0.0001            pdiblcb=0
+ drout=0                   pscbe1=4.24e+08           pscbe2=1e-07
+ pvag=0                    delta=0.005               kt1=-0.1930813
+ lkt1=-6.920771e-09        wkt1=2.403198e-09         pkt1=-8.870365e-16
+ kt2=0.01                  at=103000                 ute=-1.016783
+ lute=1.673561e-07         ua1=2.048204e-09          lua1=-6.689221e-16
+ wua1=-6.401409e-18        pua1=1.792233e-22         ub1=-4.325127e-18
+ lub1=1.803517e-24         wub1=2.008491e-25         pub1=-3.874307e-31
+ uc1=-3.768008e-10         luc1=4.635038e-17         wuc1=3.836331e-18
+ puc1=-1.287051e-23        kt1l=0                    prt=0
+ alpha0=0                  alpha1=0.001435           beta0=9.351
+ cj=cjp                    mj=0.4234                 pb=0.9
+ cjsw=cjswp                mjsw=0.1716               pbsw=0.9
+ cjswg=cjswgp              mjswg=0.4413              pbswg=0.9
+ tcj=0.000887              tcjsw=0.000298            tcjswg=0.000298
+ tpb=0.001643              tpbsw=0.001643            tpbswg=0.001643
+ js=1.80e-7                jsw=8.055e-13             cgdo=cgop
+ cgso=cgop                 cgbo=0                    capmod=3
+ nqsmod=0                  xpart=1                   cf=0
+ tlev=1                    tlevc=1                   xti=3
+ n=1                       hdif=hdifp                ldif=8e-08
+ rsh=rshp                  rs=0                      rd=0
+ dlc=1.20e-8               cgdl=cglp                 cgsl=cglp
+ wwc=-4e-2                 dwc=0                     noia=1.0e+19
+ noib=1.0e+3               noic=1.0e-11              em=1.0e+8
+ ef=1.107                  noimod=2                  sa0=0.35e-6
+ sb0=0.35e-6               kvsat=-0.6                wlod=0.3e-6
+ tku0=0.50                 ku0=1.14e-7               llodku0=1
+ wlodku0=1                 lku0=6e-8                 wku0=3.0e-7
+ pku0=1e-14                kvth0=-2.3e-9             stk2=0e-9
+ steta0=0                  lkvth0=1e-8               wkvth0=2.5e-7
+ pkvth0=4e-14              llodvth=1                 wlodvth=1
+ lodk2=1                   lodeta0=1                 minr=1e-3
+ imax=0.01                 imelt=0.01

     11: type=p
+ lmin=3.50e-07-(dxl+dlmisp)                          lmax=8.00e-07-(dxl+dlmisp)
+ wmin=1.50e-07             wmax=5.85e-07-(dxw+dwmisp)
+ tnom=25                   version=3.24              tox=(toxp+toxmisp)
+ toxm=(toxp+toxmisp)       xj=2.1e-07                nch=7.3e+17
+ lln=1                     lwn=1                     wln=1
+ wwn=-1                    lint=4e-09                ll=0
+ lw=0                      lwl=0                     wint=-6.5e-09
+ wl=0                      ww=0                      wwl=0
+ mobmod=1                  binunit=2                 xl=-2.0e-08+(dxl+dlmisp)
+ xw=1.5e-08+(dxw+dwmisp)   dwg=0                     dwb=0
+ vth0=-0.3039332+(dvthp+vthmisp)                     lvth0=-1.26875e-08+dlvthp
+ wvth0=1.105655e-08+dwvthp pvth0=-7.898166e-16+dpvthp
+ k1=0.4581052              lk1=1.573731e-09          wk1=-2.232916e-08
+ pk1=7.28435e-16           k2=-0.001+dk2p            lk2=0+dlk2p
+ k3=0                      dvt0=0                    dvt1=0
+ dvt2=0                    dvt0w=0                   dvt1w=0
+ dvt2w=0                   nlx=0                     w0=0
+ k3b=0                     vfb=-0.9606453            vsat=7.3974930e+04
+ lvsat=2.3353568e-03+dlvsatp                         wvsat=5.3846300e-04
+ pvsat=-4.1569350e-10+dpvsatp                        ua=2.014799e-09
+ lua=7.784523e-18          wua=-2.043428e-17         pua=-1.385645e-24
+ ub=-5.357826e-19          lub=9.327074e-26          wub=-7.021202e-26
+ pub=-9.699508e-33         uc=-1.75756e-10           rdsw=445
+ prwb=0                    prwg=0                    wr=1
+ u0=1.0734105e-02          lu0=3.3755760e-10         wu0=4.8071810e-11
+ pu0=-2.3556135e-17        a0=1.257333               la0=-8.286133e-08
+ keta=-0.001               a1=0                      a2=0.99
+ ags=0.3142222             lags=2.762046e-08         b0=0
+ b1=0                      voff=-0.1324338           lvoff=-1.280073e-09
+ wvoff=4.123756e-09        pvoff=-1.24708e-15        nfactor=0.9
+ cit=0                     cdsc=0                    cdscb=0
+ cdscd=0                   eta0=0.001642222          leta0=2.762044e-10
+ etab=-0.0001              dsub=0                    pclm=0.77
+ pdiblc1=0                 pdiblc2=0.0001            pdiblcb=0
+ drout=0                   pscbe1=4.24e+08           pscbe2=1e-07
+ pvag=0                    delta=0.005               kt1=-0.1848069
+ lkt1=-1.330861e-08        wkt1=-5.406888e-10        pkt1=1.385644e-15
+ kt2=0.01                  at=155235.6               lat=-0.04032585
+ ute=-0.8                  ua1=1.310912e-10          lua1=8.110887e-16
+ wua1=3.87292e-16          pua1=-1.24708e-22         ub1=-4.491228e-19
+ lub1=-1.188759e-24        wub1=-5.343381e-25        pub1=1.801338e-31
+ uc1=-2.573048e-10         luc1=-4.590057e-17        wuc1=-2.735048e-17
+ puc1=1.120571e-23         kt1l=0                    prt=0
+ alpha0=0                  alpha1=0.001435           beta0=9.351
+ cj=cjp                    mj=0.4234                 pb=0.9
+ cjsw=cjswp                mjsw=0.1716               pbsw=0.9
+ cjswg=cjswgp              mjswg=0.4413              pbswg=0.9
+ tcj=0.000887              tcjsw=0.000298            tcjswg=0.000298
+ tpb=0.001643              tpbsw=0.001643            tpbswg=0.001643
+ js=1.80e-7                jsw=8.055e-13             cgdo=cgop
+ cgso=cgop                 cgbo=0                    capmod=3
+ nqsmod=0                  xpart=1                   cf=0
+ tlev=1                    tlevc=1                   xti=3
+ n=1                       hdif=hdifp                ldif=8e-08
+ rsh=rshp                  rs=0                      rd=0
+ dlc=1.20e-8               cgdl=cglp                 cgsl=cglp
+ wwc=-4e-2                 dwc=0                     noia=1.0e+19
+ noib=1.0e+3               noic=1.0e-11              em=1.0e+8
+ ef=1.107                  noimod=2                  sa0=0.35e-6
+ sb0=0.35e-6               kvsat=-0.6                wlod=0.3e-6
+ tku0=0.50                 ku0=1.14e-7               llodku0=1
+ wlodku0=1                 lku0=6e-8                 wku0=3.0e-7
+ pku0=1e-14                kvth0=-2.3e-9             stk2=0e-9
+ steta0=0                  lkvth0=1e-8               wkvth0=2.5e-7
+ pkvth0=4e-14              llodvth=1                 wlodvth=1
+ lodk2=1                   lodeta0=1                 minr=1e-3
+ imax=0.01                 imelt=0.01

     12: type=p
+ lmin=1.30e-07             lmax=3.50e-07-(dxl+dlmisp)
+ wmin=1.50e-07             wmax=5.85e-07-(dxw+dwmisp)
+ tnom=25                   version=3.24              tox=(toxp+toxmisp)
+ toxm=(toxp+toxmisp)       xj=2.1e-07                nch=7.3e+17
+ lln=1                     lwn=1                     wln=1
+ wwn=-1                    lint=4e-09                ll=0
+ lw=0                      lwl=0                     wint=-6.5e-09
+ wl=0                      ww=0                      wwl=0
+ mobmod=1                  binunit=2                 xl=-2.0e-08+(dxl+dlmisp)
+ xw=1.5e-08+(dxw+dwmisp)   dwg=0                     dwb=0
+ vth0=-0.3048250+(dvthp+vthmisp)                     lvth0=-1.2400367e-08+dlvthp
+ wvth0=8.5485470e-09+dwvthp                          pvth0=1.7760218e-17+dpvthp
+ k1=0.4427917              lk1=6.504686e-09          wk1=-1.83614e-08
+ pk1=-5.491839e-16         k2=-0.001+dk2p            lk2=0+dlk2p
+ k3=0                      dvt0=0                    dvt1=0
+ dvt2=0                    dvt0w=0                   dvt1w=0
+ dvt2w=0                   nlx=0                     w0=0
+ k3b=0                     vfb=-0.9194162            vsat=8.1796750e+04
+ lvsat=-1.8327007e-04+dlvsatp                        wvsat=-4.9125760e-04
+ pvsat=-8.4123390e-11+dpvsatp                        ua=2.236433e-09
+ lua=-6.358157e-17         wua=-3.942444e-17         pua=4.729189e-24
+ ub=-1.957686e-19          lub=-1.621375e-26         wub=-1.34191e-25
+ pub=1.090173e-32          uc=-2.152362e-10          luc=1.271263e-17
+ wuc=7.422278e-18          puc=-2.389974e-24         rdsw=445
+ prwb=0                    prwg=0                    wr=1
+ u0=1.1699615e-02          lu0=2.6663165e-11         wu0=-2.2678760e-11
+ pu0=-7.7444550e-19        a0=1                      keta=-0.001
+ a1=0                      a2=0.99                   ags=0.4
+ b0=0                      b1=0                      voff=-0.1196788
+ lvoff=-5.387188e-09       wvoff=-1.157738e-09       pvoff=4.535614e-16
+ nfactor=0.7974537         lnfactor=3.30199e-08      wnfactor=1.845967e-09
+ pnfactor=-5.944019e-16    cit=0                     cdsc=0
+ cdscb=0                   cdscd=0                   eta0=0.0008490036
+ leta0=5.316207e-10        weta0=-5.569997e-11       peta0=1.793541e-17
+ etab=0.002002198          letab=-6.769076e-10       wetab=-9.885673e-11
+ petab=3.183187e-17        dsub=0                    pclm=0.6500209
+ lpclm=3.863327e-08        wpclm=3.380071e-09        ppclm=-1.088382e-15
+ pdiblc1=0                 pdiblc2=0.0001410173      lpdiblc2=-1.32076e-11
+ wpdiblc2=-8.615851e-11    ppdiblc2=2.774305e-17     pdiblcb=0
+ drout=0                   pscbe1=4.24e+08           pscbe2=1e-07
+ pvag=0                    delta=0.005               kt1=-0.2279583
+ lkt1=5.861558e-10         wkt1=1.827687e-09         pkt1=6.230266e-16
+ kt2=0.01                  at=38101.16               lat=-0.002608573
+ wat=0.0002202548          pat=-7.092206e-11         ute=-0.8
+ ua1=3.024294e-09          lua1=-1.205227e-16        wua1=-6.363516e-19
+ pua1=2.049077e-25         ub1=-4.582381e-18         lub1=1.421507e-25
+ wub1=8.824908e-26         pub1=-2.033927e-32        uc1=-2.43311e-10
+ luc1=-5.040653e-17        wuc1=-9.099546e-18        puc1=5.328908e-24
+ kt1l=0                    prt=0                     alpha0=0
+ alpha1=0.001435           beta0=9.351               cj=cjp
+ mj=0.4234                 pb=0.9                    cjsw=cjswp
+ mjsw=0.1716               pbsw=0.9                  cjswg=cjswgp
+ mjswg=0.4413              pbswg=0.9                 tcj=0.000887
+ tcjsw=0.000298            tcjswg=0.000298           tpb=0.001643
+ tpbsw=0.001643            tpbswg=0.001643           js=1.80e-7
+ jsw=8.055e-13             cgdo=cgop                 cgso=cgop
+ cgbo=0                    capmod=3                  nqsmod=0
+ xpart=1                   cf=0                      tlev=1
+ tlevc=1                   xti=3                     n=1
+ hdif=hdifp                ldif=8e-08                rsh=rshp
+ rs=0                      rd=0                      dlc=1.20e-8
+ cgdl=cglp                 cgsl=cglp                 wwc=-4e-2
+ dwc=0                     noia=1.0e+19              noib=1.0e+3
+ noic=1.0e-11              em=1.0e+8                 ef=1.107
+ noimod=2                  sa0=0.35e-6               sb0=0.35e-6
+ kvsat=-0.6                wlod=0.3e-6               tku0=0.50
+ ku0=1.14e-7               llodku0=1                 wlodku0=1
+ lku0=6e-8                 wku0=3.0e-7               pku0=1e-14
+ kvth0=-2.3e-9             stk2=0e-9                 steta0=0
+ lkvth0=1e-8               wkvth0=2.5e-7             pkvth0=4e-14
+ llodvth=1                 wlodvth=1                 lodk2=1
+ lodeta0=1                 minr=1e-3                 imax=0.01
+ imelt=0.01
//
     }
ends pch_mis

endsection mos
//
//
//  *************************************************************
//                                                              *
//               2.5V NORMAL DEVICES MODEL                      *
//                                                              *
//  *************************************************************
//
section mos_25
//
//  ********************************
//        Mismatch   model         *
//  ********************************
inline subckt nch_25_mis ( d g s b )
parameters l=1u w=1u factor=1 multi=1 sa=0.35u sb=0.35u ad=2 * hdifn_25 / factor *
+ w as=2 * hdifn_25 / factor * w pd=2 * (2 * hdifn_25 / factor + w) ps=2 * (2 * hdifn_25
+ / factor + w) nrd=hdifn_25 / factor / w nrs=hdifn_25 / factor / w temp1=parn1_25
+ temp2=parn2_25 fac1=0.427 * temp1 + 0.904 * temp2 fac2=0.427 * temp1 - 0.904 *
+ temp2 lef=l - 4.0e-8 wef=w + 1.0e-8 geo_fac=1 / sqrt(multi * lef * wef * 1e12)
+ vthmis=0.006243 * geo_fac * fac1 dlmis=0.002279 * geo_fac * lef * fac2 dwmis=
+ - 0.002279 * geo_fac * wef * fac2 toxmis=0.002279 * geo_fac * toxn_25 * fac2
nch_25_mis ( d g s b ) nch_25 w=w l=l ad=ad as=as pd=pd ps=ps nrd=nrd nrs=nrs m=multi sa=sa
+ sb=sb
model nch_25 bsim3v3  {
     1: type=n
+ lmin=1.20e-06-(dxl_25+dlmis)                        lmax=2.10e-05
+ wmin=1.001e-05-(dxw_25+dwmis)                       wmax=0.0009001
+ tnom=25                   version=3.24              tox=(toxn_25+toxmis)
+ toxm=(toxn_25+toxmis)     xj=1.9e-07                nch=3.28e+17
+ lln=1                     lwn=1                     wln=1
+ wwn=-1                    lint=3.1e-08              wint=1.95e-08
+ mobmod=1                  binunit=2                 xl=-4e-08+(dxl_25+dlmis)
+ xw=1e-8+(dxw_25+dwmis)    dwg=0                     dwb=0
+ ldif=8e-08                hdif=hdifn_25             rsh=6.6
+ rd=0                      rs=0                      vth0=0.5462298+(dvthn_25+vthmis)
+ lvth0=3.791434e-08        wvth0=5.574453e-08        pvth0=-3.6853e-14
+ k1=0.55801                lk1=-2.344909e-09         wk1=4.097137e-08
+ pk1=-4.498656e-14         k2=-0.001893228           lk2=-8.895973e-09
+ wk2=-9.171656e-09         pk2=1.007047e-14          k3=0
+ dvt0=0                    dvt1=0                    dvt2=0
+ dvt0w=0                   dvt1w=0                   dvt2w=0
+ nlx=0                     w0=0                      k3b=0
+ vfb=-0.8166977            vsat=101225.9             lvsat=-0.01232605
+ wvsat=9.056558e-05        pvsat=-9.944839e-11       ua=-6.255406e-10
+ lua=-1.94116e-16          wua=-1.460773e-16         pua=2.331054e-21
+ ub=2.037894e-18           lub=-5.933173e-26         wub=-1.27836e-24
+ pub=-3.920999e-31         uc=6.14423e-11            luc=-9.532507e-18
+ wuc=-9.63961e-17          puc=1.150034e-22          rdsw=325.9
+ prwb=0                    prwg=0                    wr=1
+ u0=0.03828657             lu0=-5.822331e-09         wu0=-1.807987e-08
+ pu0=4.028212e-14          a0=0.5340004              la0=-1.048441e-07
+ wa0=2.945578e-07          pa0=-3.234229e-13         keta=0.009165752
+ lketa=-2.935073e-08       wketa=-5.500693e-08       pketa=6.03976e-14
+ a1=0                      a2=0.99                   ags=0.02
+ b0=0                      b1=0                      voff=-0.115974
+ lvoff=1.674896e-09        wvoff=-1.086672e-07       pvoff=5.845006e-14
+ nfactor=1                 cit=0.0002238203          lcit=-1.013128e-10
+ wcit=-1.5565e-09          pcit=1.709037e-15         cdsc=0
+ cdscb=0                   cdscd=0                   eta0=5e-05
+ etab=-5e-05               dsub=0                    pclm=0.7
+ pdiblc1=1e-06             pdiblc2=0.0005096363      lpdiblc2=4.930418e-09
+ wpdiblc2=-3.626117e-11    ppdiblc2=3.981404e-17     pdiblcb=0.01
+ drout=0                   pscbe1=1.816114e+08       lpscbe1=184.8907
+ wpscbe1=-1.359819         ppscbe1=1.493218e-06      pscbe2=1e-06
+ pvag=0                    delta=0.01                alpha0=0
+ alpha1=0.7997             beta0=14.401              kt1=-0.290201
+ lkt1=1.016254e-08         wkt1=-1.98575e-08         pkt1=-2.38813e-14
+ kt2=-0.02944941           lkt2=2.289216e-09         wkt2=-3.879695e-10
+ pkt2=-5.869811e-15        at=10000                  ute=-1.584248
+ lute=1.529864e-07         wute=3.570072e-07         pute=-6.114151e-13
+ ua1=1.743e-09             ub1=-2.376207e-18         lub1=3.369821e-25
+ wub1=4.239915e-25         pub1=-7.625448e-31        uc1=-6.18781e-11
+ luc1=2.893467e-17         wuc1=-2.601357e-17        puc1=-3.302829e-23
+ kt1l=0                    prt=0                     cj=cjn_25
+ mj=0.3193271              pb=0.7249372              cjsw=cjswn_25
+ mjsw=0.01                 pbsw=0.7249372            cjswg=cjswgn_25
+ mjswg=0.01                pbswg=0.7249372           tpb=0.001816363
+ tpbsw=0.001816363         tpbswg=0.001816363        tcj=0.001010853
+ tcjsw=9.297595e-05        tcjswg=9.297595e-05       js=4.03e-7
+ jsw=1.8e-12               n=1                       xti=3
+ cgdo=cgon_25              cgso=cgon_25              capmod=3
+ nqsmod=0                  xpart=1                   cf=0
+ tlev=1                    tlevc=1                   dlc=4.01e-8
+ cgbo=0                    cgdl=cgln_25              cgsl=cgln_25
+ wwc=-1.22e-2              dwc=0                     noia=8.0e+19
+ noib=2.5e+4               noic=1.0e-13              em=1.1e+7
+ ef=0.872                  noimod=2                  sa0=0.35e-6
+ sb0=0.35e-6               kvsat=0.35                wlod=0.3e-6
+ tku0=0.03                 ku0=-5.95e-8              llodku0=1
+ wlodku0=1                 lku0=1.493e-7             wku0=3.5e-7
+ pku0=0                    kvth0=7.2e-9              stk2=0
+ steta0=-1.1e-10           lkvth0=-5e-8              wkvth0=5e-6
+ pkvth0=0                  llodvth=1.0               wlodvth=1
+ lodk2=1                   lodeta0=2                 minr=1e-3
+ imax=0.01                 imelt=0.01

     2: type=n
+ lmin=5.0e-07-(dxl_25+dlmis)                         lmax=1.20e-06-(dxl_25+dlmis)
+ wmin=1.001e-05-(dxw_25+dwmis)                       wmax=0.0009001
+ tnom=25                   version=3.24              tox=(toxn_25+toxmis)
+ toxm=(toxn_25+toxmis)     xj=1.9e-07                nch=3.28e+17
+ lln=1                     lwn=1                     wln=1
+ wwn=-1                    lint=3.1e-08              wint=1.95e-08
+ mobmod=1                  binunit=2                 xl=-4e-08+(dxl_25+dlmis)
+ xw=1e-8+(dxw_25+dwmis)    dwg=0                     dwb=0
+ ldif=8e-08                hdif=hdifn_25             rsh=6.6
+ rd=0                      rs=0                      vth0=0.561313+(dvthn_25+vthmis)
+ lvth0=2.135296e-08        wvth0=-2.290768e-09       pvth0=2.686979e-14
+ k1=0.5219827              lk1=3.721306e-08          wk1=-7.733095e-08
+ pk1=8.490937e-14          k2=0.01126943             lk2=-2.334857e-08
+ wk2=3.635663e-08          pk2=-3.991962e-14         k3=0
+ dvt0=0                    dvt1=0                    dvt2=0
+ dvt0w=0                   dvt1w=0                   dvt2w=0
+ nlx=0                     w0=0                      k3b=0
+ vfb=-0.8468292            vsat=92842.86             lvsat=-0.003121457
+ ua=-8.70128e-10           lua=7.444107e-17          wua=3.140157e-15
+ pua=-1.277231e-21         ub=1.974071e-18           lub=1.074604e-26
+ wub=-1.367533e-24         pub=-2.941878e-31         uc=3.571922e-11
+ luc=1.871144e-17          wuc=1.115946e-16          puc=-1.133703e-22
+ rdsw=325.9                prwb=0                    prwg=0
+ wr=1                      u0=0.03137542             lu0=1.766108e-09
+ wu0=3.564368e-08          pu0=-1.870634e-14         a0=0.3326174
+ la0=1.162744e-07          wa0=4.858207e-07          pa0=-5.334296e-13
+ keta=-0.0137679           lketa=-4.169581e-09       wketa=-1.893171e-08
+ pketa=2.078702e-14        a1=0                      a2=0.99
+ ags=0.04274286            lags=-2.497166e-08        b0=0
+ b1=0                      voff=-0.1191335           lvoff=5.144074e-09
+ wvoff=-3.20723e-08        pvoff=-2.565111e-14       nfactor=1
+ cit=0.000113169           lcit=2.01824e-11          wcit=-5.469469e-10
+ pcit=6.005477e-16         cdsc=0                    cdscb=0
+ cdscd=0                   eta0=-0.000490143         leta0=5.930769e-10
+ etab=0.000490143          letab=-5.930769e-10       dsub=0
+ pclm=0.6147142            lpclm=9.364378e-08        pdiblc1=1e-06
+ pdiblc2=0.004999998       pdiblcb=0.01              drout=0
+ pscbe1=3.5e+08            pscbe2=1e-06              pvag=0
+ delta=0.01                alpha0=0                  alpha1=0.7997
+ beta0=14.401              kt1=-0.2855672            lkt1=5.074688e-09
+ wkt1=-6.871637e-08        pkt1=2.976575e-14         kt2=-0.02733552
+ lkt2=-3.183875e-11        wkt2=-1.475411e-08        pkt2=9.904213e-15
+ at=10000                  ute=-1.464582             lute=2.159387e-08
+ wute=-6.202247e-07        pute=4.615853e-13         ua1=1.743e-09
+ ub1=-2.218245e-18         lub1=1.635397e-25         wub1=-9.4581e-25
+ pub1=7.414972e-31         uc1=-5.649232e-11         luc1=2.302109e-17
+ wuc1=-1.068542e-16        puc1=5.573478e-23         kt1l=0
+ prt=0                     cj=cjn_25                 mj=0.3193271
+ pb=0.7249372              cjsw=cjswn_25             mjsw=0.01
+ pbsw=0.7249372            cjswg=cjswgn_25           mjswg=0.01
+ pbswg=0.7249372           tpb=0.001816363           tpbsw=0.001816363
+ tpbswg=0.001816363        tcj=0.001010853           tcjsw=9.297595e-05
+ tcjswg=9.297595e-05       js=4.03e-7                jsw=1.8e-12
+ n=1                       xti=3                     cgdo=cgon_25
+ cgso=cgon_25              capmod=3                  nqsmod=0
+ xpart=1                   cf=0                      tlev=1
+ tlevc=1                   dlc=4.01e-8               cgbo=0
+ cgdl=cgln_25              cgsl=cgln_25              wwc=-1.22e-2
+ dwc=0                     noia=8.0e+19              noib=2.5e+4
+ noic=1.0e-13              em=1.1e+7                 ef=0.872
+ noimod=2                  sa0=0.35e-6               sb0=0.35e-6
+ kvsat=0.35                wlod=0.3e-6               tku0=0.03
+ ku0=-5.95e-8              llodku0=1                 wlodku0=1
+ lku0=1.493e-7             wku0=3.5e-7               pku0=0
+ kvth0=7.2e-9              stk2=0                    steta0=-1.1e-10
+ lkvth0=-5e-8              wkvth0=5e-6               pkvth0=0
+ llodvth=1.0               wlodvth=1                 lodk2=1
+ lodeta0=2                 minr=1e-3                 imax=0.01
+ imelt=0.01

     3: type=n
+ lmin=2.8e-07              lmax=5e-07-(dxl_25+dlmis) wmin=1.001e-05-(dxw_25+dwmis)
+ wmax=0.0009001            tnom=25                   version=3.24
+ tox=(toxn_25+toxmis)      toxm=(toxn_25+toxmis)     xj=1.9e-07
+ nch=3.28e+17              lln=1                     lwn=1
+ wln=1                     wwn=-1                    lint=3.1e-08
+ wint=1.95e-08             mobmod=1                  binunit=2
+ xl=-4e-08+(dxl_25+dlmis)  xw=1e-8+(dxw_25+dwmis)    dwg=0
+ dwb=0                     ldif=8e-08                hdif=hdifn_25
+ rsh=6.6                   rd=0                      rs=0
+ vth0=0.6685686+(dvthn_25+vthmis)                    lvth0=-2.133475e-08
+ wvth0=1.128612e-07        pvth0=-1.896067e-14       k1=0.805287
+ lk1=-7.554204e-08         wk1=2.35355e-07           pk1=-3.953965e-14
+ k2=-0.03438999            lk2=-5.176121e-09         wk2=-1.106507e-07
+ pk2=1.858932e-14          k3=0                      dvt0=0
+ dvt1=0                    dvt2=0                    dvt0w=0
+ dvt1w=0                   dvt2w=0                   nlx=0
+ w0=0                      k3b=0                     vfb=-0.6704064
+ vsat=86095.65             lvsat=-0.0004360696       ua=-6.959174e-10
+ lua=5.105241e-18          wua=-1.193429e-16         pua=2.00496e-23
+ ub=2.465556e-18           lub=-1.84865e-25          wub=-3.645505e-24
+ pub=6.124448e-31          uc=1.473028e-10           luc=-2.569881e-17
+ wuc=-2.998074e-16         puc=5.036765e-23          rdsw=325.9
+ prwb=0                    prwg=0                    wr=1
+ u0=0.03742776             lu0=-6.427248e-10         wu0=-1.965285e-08
+ pu0=3.301679e-15          a0=0.4442892              la0=7.182904e-08
+ wa0=-1.478578e-06         pa0=2.484012e-13          keta=-0.06427277
+ lketa=1.593136e-08        wketa=5.761829e-08        pketa=-9.679875e-15
+ a1=0                      a2=0.99                   ags=-0.02000001
+ b0=0                      b1=0                      voff=-0.08663055
+ lvoff=-7.792102e-09       wvoff=-1.670256e-07       pvoff=2.80603e-14
+ nfactor=1                 cit=-4.457351e-05         lcit=8.29639e-11
+ wcit=1.664621e-09         pcit=-2.796563e-16        cdsc=0
+ cdscb=0                   cdscd=0                   eta0=-0.000424348
+ leta0=5.668905e-10        etab=-0.0001488371        letab=-3.387628e-10
+ dsub=0                    pclm=0.7403224            lpclm=4.365171e-08
+ pdiblc1=1e-06             pdiblc2=-0.03330233       lpdiblc2=1.524433e-08
+ pdiblcb=0.01              drout=0                   pscbe1=3.5e+08
+ pscbe2=1e-06              pvag=0                    delta=0.01
+ alpha0=0                  alpha1=0.7997             beta0=14.401
+ kt1=-0.3097389            lkt1=1.469501e-08         wkt1=1.050708e-08
+ pkt1=-1.765189e-15        kt2=-0.03610081           lkt2=3.45675e-09
+ wkt2=1.753077e-08         pkt2=-2.945169e-15        at=1488.371
+ lat=0.003387628           ute=-1.434012             lute=9.426986e-09
+ wute=9.336343e-07         pute=-1.568506e-13        ua1=1.844129e-09
+ lua1=-4.024927e-17        ub1=-2.42138e-18          lub1=2.443874e-25
+ wub1=1.587238e-24         pub1=-2.666561e-31        uc1=-1.317202e-11
+ luc1=5.779609e-18         wuc1=5.742081e-17         puc1=-9.646697e-24
+ kt1l=0                    prt=0                     cj=cjn_25
+ mj=0.3193271              pb=0.7249372              cjsw=cjswn_25
+ mjsw=0.01                 pbsw=0.7249372            cjswg=cjswgn_25
+ mjswg=0.01                pbswg=0.7249372           tpb=0.001816363
+ tpbsw=0.001816363         tpbswg=0.001816363        tcj=0.001010853
+ tcjsw=9.297595e-05        tcjswg=9.297595e-05       js=4.03e-7
+ jsw=1.8e-12               n=1                       xti=3
+ cgdo=cgon_25              cgso=cgon_25              capmod=3
+ nqsmod=0                  xpart=1                   cf=0
+ tlev=1                    tlevc=1                   dlc=4.01e-8
+ cgbo=0                    cgdl=cgln_25              cgsl=cgln_25
+ wwc=-1.22e-2              dwc=0                     noia=8.0e+19
+ noib=2.5e+4               noic=1.0e-13              em=1.1e+7
+ ef=0.872                  noimod=2                  sa0=0.35e-6
+ sb0=0.35e-6               kvsat=0.35                wlod=0.3e-6
+ tku0=0.03                 ku0=-5.95e-8              llodku0=1
+ wlodku0=1                 lku0=1.493e-7             wku0=3.5e-7
+ pku0=0                    kvth0=7.2e-9              stk2=0
+ steta0=-1.1e-10           lkvth0=-5e-8              wkvth0=5e-6
+ pkvth0=0                  llodvth=1.0               wlodvth=1
+ lodk2=1                   lodeta0=2                 minr=1e-3
+ imax=0.01                 imelt=0.01

     4: type=n
+ lmin=1.2e-06-(dxl_25+dlmis)                         lmax=2.1e-05
+ wmin=1.21e-06-(dxw_25+dwmis)                        wmax=1.001e-05-(dxw_25+dwmis)
+ tnom=25                   version=3.24              tox=(toxn_25+toxmis)
+ toxm=(toxn_25+toxmis)     xj=1.9e-07                nch=3.28e+17
+ lln=1                     lwn=1                     wln=1
+ wwn=-1                    lint=3.1e-08              wint=1.95e-08
+ mobmod=1                  binunit=2                 xl=-4e-08+(dxl_25+dlmis)
+ xw=1e-8+(dxw_25+dwmis)    dwg=0                     dwb=0
+ ldif=8e-08                hdif=hdifn_25             rsh=6.6
+ rd=0                      rs=0                      vth0=0.5535434+(dvthn_25+vthmis)
+ lvth0=3.392514e-08        wvth0=-1.725304e-08       pvth0=2.963216e-15
+ k1=0.5586147              lk1=-7.350993e-10         wk1=3.493632e-08
+ pk1=-6.105405e-14         k2=-0.001357819           lk2=-9.651671e-09
+ wk2=-1.451557e-08         pk2=1.761309e-14          k3=0
+ dvt0=0                    dvt1=0                    dvt2=0
+ dvt0w=0                   dvt1w=0                   dvt2w=0
+ nlx=0                     w0=0                      k3b=0
+ vfb=-0.8130998            vsat=101235.7             lvsat=-0.01233681
+ wvsat=-7.266502e-06       pvsat=7.979299e-12        ua=-6.48368e-10
+ lua=4.723421e-17          wua=8.176306e-17          pua=-7.786219e-23
+ ub=1.962333e-18           lub=-9.439127e-26         wub=-5.241816e-25
+ pub=-4.217057e-32         uc=5.326088e-11           luc=4.488363e-18
+ wuc=-1.47373e-17          puc=-2.493888e-23         rdsw=325.9
+ prwb=0                    prwg=0                    wr=1
+ u0=0.03724615             lu0=-1.646063e-09         wu0=-7.695495e-09
+ pu0=-1.401211e-15         a0=0.5562392              la0=-1.219706e-07
+ wa0=7.259207e-08          pa0=-1.524827e-13         keta=0.002464927
+ lketa=-2.203729e-08       wketa=1.187401e-08        pketa=-1.259785e-14
+ a1=0                      a2=0.99                   ags=0.01933995
+ lags=6.619002e-09         wags=6.587982e-09         pags=-6.606424e-14
+ b0=0                      b1=0                      voff=-0.1246474
+ lvoff=8.253139e-09        wvoff=-2.209775e-08       pvoff=-7.207374e-15
+ nfactor=1                 cit=8.058136e-05          lcit=2.084676e-11
+ wcit=-1.268319e-10        pcit=4.897627e-16         cdsc=0
+ cdscb=0                   cdscd=0                   eta0=5e-05
+ etab=-5e-05               dsub=0                    pclm=0.7
+ pdiblc1=1e-06             pdiblc2=0.0005057121      lpdiblc2=4.934727e-09
+ wpdiblc2=2.908552e-12     ppdiblc2=-3.192458e-18    pdiblcb=0.01
+ drout=0                   pscbe1=1.814642e+08       lpscbe1=185.0523
+ wpscbe1=0.1090885         ppscbe1=-1.197768e-07     pscbe2=1e-06
+ pvag=0                    delta=0.01                alpha0=0
+ alpha1=0.7997             beta0=14.401              kt1=-0.2923405
+ lkt1=9.905668e-09         wkt1=1.49724e-09          pkt1=-2.13175e-14
+ kt2=-0.02969708           lkt2=2.050367e-09         wkt2=2.084077e-09
+ pkt2=-3.48586e-15         at=10000                  ute=-1.576062
+ lute=8.089091e-08         wute=2.75305e-07          pute=1.081697e-13
+ ua1=1.743e-09             ub1=-2.368329e-18         lub1=2.40139e-25
+ wub1=3.453572e-25         pub1=2.04046e-31          uc1=-6.301321e-11
+ luc1=2.399741e-17         wuc1=-1.468404e-17        puc1=1.625053e-23
+ kt1l=0                    prt=0                     cj=cjn_25
+ mj=0.3193271              pb=0.7249372              cjsw=cjswn_25
+ mjsw=0.01                 pbsw=0.7249372            cjswg=cjswgn_25
+ mjswg=0.01                pbswg=0.7249372           tpb=0.001816363
+ tpbsw=0.001816363         tpbswg=0.001816363        tcj=0.001010853
+ tcjsw=9.297595e-05        tcjswg=9.297595e-05       js=4.03e-7
+ jsw=1.8e-12               n=1                       xti=3
+ cgdo=cgon_25              cgso=cgon_25              capmod=3
+ nqsmod=0                  xpart=1                   cf=0
+ tlev=1                    tlevc=1                   dlc=4.01e-8
+ cgbo=0                    cgdl=cgln_25              cgsl=cgln_25
+ wwc=-1.22e-2              dwc=0                     noia=8.0e+19
+ noib=2.5e+4               noic=1.0e-13              em=1.1e+7
+ ef=0.872                  noimod=2                  sa0=0.35e-6
+ sb0=0.35e-6               kvsat=0.35                wlod=0.3e-6
+ tku0=0.03                 ku0=-5.95e-8              llodku0=1
+ wlodku0=1                 lku0=1.493e-7             wku0=3.5e-7
+ pku0=0                    kvth0=7.2e-9              stk2=0
+ steta0=-1.1e-10           lkvth0=-5e-8              wkvth0=5e-6
+ pkvth0=0                  llodvth=1.0               wlodvth=1
+ lodk2=1                   lodeta0=2                 minr=1e-3
+ imax=0.01                 imelt=0.01

     5: type=n
+ lmin=5.0e-07-(dxl_25+dlmis)                         lmax=1.2e-06-(dxl_25+dlmis)
+ wmin=1.21e-06-(dxw_25+dwmis)                        wmax=1.001e-05-(dxw_25+dwmis)
+ tnom=25                   version=3.24              tox=(toxn_25+toxmis)
+ toxm=(toxn_25+toxmis)     xj=1.9e-07                nch=3.28e+17
+ lln=1                     lwn=1                     wln=1
+ wwn=-1                    lint=3.1e-08              wint=1.95e-08
+ mobmod=1                  binunit=2                 xl=-4e-08+(dxl_25+dlmis)
+ xw=1e-8+(dxw_25+dwmis)    dwg=0                     dwb=0
+ ldif=8e-08                hdif=hdifn_25             rsh=6.6
+ rd=0                      rs=0                      vth0=0.5627995+(dvthn_25+vthmis)
+ lvth0=2.376209e-08        wvth0=-1.712651e-08       pvth0=2.824284e-15
+ k1=0.513768               lk1=4.850651e-08          wk1=4.65992e-09
+ pk1=-2.781055e-14         k2=0.01553639             lk2=-2.820151e-08
+ wk2=-6.231849e-09         pk2=8.517568e-15          k3=0
+ dvt0=0                    dvt1=0                    dvt2=0
+ dvt0w=0                   dvt1w=0                   dvt2w=0
+ nlx=0                     w0=0                      k3b=0
+ vfb=-0.8086806            vsat=92842.86             lvsat=-0.003121457
+ ua=-5.53023e-10           lua=-5.74546e-17          wua=-2.486846e-17
+ pua=3.921921e-23          ub=1.894186e-18           lub=-1.956657e-26
+ wub=-5.702043e-25         pub=8.362437e-33          uc=5.059609e-11
+ luc=7.414306e-18          wuc=-3.689143e-17         puc=-6.13656e-25
+ rdsw=325.9                prwb=0                    prwg=0
+ wr=1                      u0=0.0358885              lu0=-1.553587e-10
+ wu0=-9.401353e-09         pu0=4.718194e-16          a0=0.3811871
+ la0=7.02366e-08           wa0=1.047213e-09          pa0=-7.392643e-14
+ keta=-0.01589304          lketa=-1.880237e-09       wketa=2.279359e-09
+ pketa=-2.062926e-15       a1=0                      a2=0.99
+ ags=0.05421544            lags=-3.167428e-08        wags=-1.145078e-07
+ pags=6.689886e-14         b0=0                      b1=0
+ voff=-0.1206563           lvoff=3.870888e-09        wvoff=-1.687365e-08
+ pvoff=-1.294344e-14       nfactor=1                 cit=4.16665e-05
+ lcit=6.357527e-11         wcit=1.667193e-10         pcit=1.674434e-16
+ cdsc=0                    cdscb=0                   cdscd=0
+ eta0=-0.000490143         leta0=5.930769e-10        etab=0.000490143
+ letab=-5.930769e-10       dsub=0                    pclm=0.6147214
+ lpclm=9.36359e-08         wpclm=-7.15767e-11        ppclm=7.860325e-17
+ pdiblc1=1e-06             pdiblc2=0.004999998       pdiblcb=0.01
+ drout=0                   pscbe1=3.5e+08            pscbe2=1e-06
+ pvag=0                    delta=0.01                alpha0=0
+ alpha1=0.7997             beta0=14.401              kt1=-0.290602
+ lkt1=7.996759e-09         wkt1=-1.846457e-08        pkt1=6.005647e-16
+ kt2=-0.02877119           lkt2=1.033734e-09         wkt2=-4.246612e-10
+ pkt2=-7.312654e-16        at=10000                  ute=-1.569641
+ lute=7.384119e-08         wute=4.283696e-07         pute=-5.989518e-14
+ ua1=1.743e-09             ub1=-2.379152e-18         lub1=2.52023e-25
+ wub1=6.602026e-25         pub1=-1.416541e-31        uc1=-6.753693e-11
+ luc1=2.896446e-17         wuc1=3.382023e-18         puc1=-3.586004e-24
+ kt1l=0                    prt=0                     cj=cjn_25
+ mj=0.3193271              pb=0.7249372              cjsw=cjswn_25
+ mjsw=0.01                 pbsw=0.7249372            cjswg=cjswgn_25
+ mjswg=0.01                pbswg=0.7249372           tpb=0.001816363
+ tpbsw=0.001816363         tpbswg=0.001816363        tcj=0.001010853
+ tcjsw=9.297595e-05        tcjswg=9.297595e-05       js=4.03e-7
+ jsw=1.8e-12               n=1                       xti=3
+ cgdo=cgon_25              cgso=cgon_25              capmod=3
+ nqsmod=0                  xpart=1                   cf=0
+ tlev=1                    tlevc=1                   dlc=4.01e-8
+ cgbo=0                    cgdl=cgln_25              cgsl=cgln_25
+ wwc=-1.22e-2              dwc=0                     noia=8.0e+19
+ noib=2.5e+4               noic=1.0e-13              em=1.1e+7
+ ef=0.872                  noimod=2                  sa0=0.35e-6
+ sb0=0.35e-6               kvsat=0.35                wlod=0.3e-6
+ tku0=0.03                 ku0=-5.95e-8              llodku0=1
+ wlodku0=1                 lku0=1.493e-7             wku0=3.5e-7
+ pku0=0                    kvth0=7.2e-9              stk2=0
+ steta0=-1.1e-10           lkvth0=-5e-8              wkvth0=5e-6
+ pkvth0=0                  llodvth=1.0               wlodvth=1
+ lodk2=1                   lodeta0=2                 minr=1e-3
+ imax=0.01                 imelt=0.01

     6: type=n
+ lmin=2.8e-07              lmax=5.0e-07-(dxl_25+dlmis)
+ wmin=1.21e-06-(dxw_25+dwmis)                        wmax=1.001e-05-(dxw_25+dwmis)
+ tnom=25                   version=3.24              tox=(toxn_25+toxmis)
+ toxm=(toxn_25+toxmis)     xj=1.9e-07                nch=3.28e+17
+ lln=1                     lwn=1                     wln=1
+ wwn=-1                    lint=3.1e-08              wint=1.95e-08
+ mobmod=1                  binunit=2                 xl=-4e-08+(dxl_25+dlmis)
+ xw=1e-8+(dxw_25+dwmis)    dwg=0                     dwb=0
+ ldif=8e-08                hdif=hdifn_25             rsh=6.6
+ rd=0                      rs=0                      vth0=0.6844962+(dvthn_25+vthmis)
+ lvth0=-2.467325e-08       wvth0=-4.611279e-08       pvth0=1.436083e-14
+ k1=0.8531682              lk1=-8.657477e-08         wk1=-2.425473e-07
+ pk1=7.057792e-14          k2=-0.05141579            lk2=-1.554543e-09
+ wk2=5.928379e-08          pk2=-1.755766e-14         k3=0
+ dvt0=0                    dvt1=0                    dvt2=0
+ dvt0w=0                   dvt1w=0                   dvt2w=0
+ nlx=0                     w0=0                      k3b=0
+ vfb=-0.7652686            vsat=8.6448090e+04        lvsat=-5.7633940e-04
+ wvsat=-1.7101926e-03      pvsat=6.8065680e-10       ua=-7.156305e-10
+ lua=7.263201e-18          wua=7.741344e-17          pua=-1.48899e-24
+ ub=2.17854e-18            lub=-1.327395e-25         wub=-7.808022e-25
+ pub=9.218037e-32          uc=1.243654e-10           luc=-2.194589e-17
+ wuc=-7.08698e-17          puc=1.290974e-23          rdsw=325.9
+ prwb=0                    prwg=0                    wr=1
+ u0=0.03633325             lu0=-3.323704e-10         wu0=-8.728519e-09
+ pu0=2.04032e-16           a0=0.2551618              la0=1.203947e-07
+ wa0=4.091018e-07          pa0=-2.363322e-13         keta=-0.06037572
+ lketa=1.582387e-08        wketa=1.872172e-08        pketa=-8.606989e-15
+ a1=0                      a2=0.99                   ags=-0.02971154
+ lags=1.728653e-09         wags=9.693079e-08         pags=-1.725368e-14
+ b0=0                      b1=0                      voff=-0.09485205
+ lvoff=-6.399188e-09       wvoff=-8.496678e-08       pvoff=1.415763e-14
+ nfactor=1                 cit=1.87189e-05           lcit=7.270839e-11
+ wcit=1.032899e-09         pcit=-1.772961e-16        cdsc=0
+ cdscb=0                   cdscd=0                   eta0=-4.4818090e-04
+ leta0=5.7637610e-10       weta0=-2.1118445e-09      peta0=8.4051400e-16
+ etab=-0.0001431909        letab=-3.410101e-10       wetab=-5.635467e-11
+ petab=2.242921e-17        dsub=0                    pclm=0.7395863
+ lpclm=4.393965e-08        wpclm=7.346791e-09        ppclm=-2.87391e-15
+ pdiblc1=1e-06             pdiblc2=-0.03464225       lpdiblc2=1.577762e-08
+ wpdiblc2=1.337371e-08     ppdiblc2=-5.322741e-15    pdiblcb=0.01
+ drout=0                   pscbe1=3.5e+08            pscbe2=1e-06
+ pvag=0                    delta=0.01                alpha0=0
+ alpha1=0.7997             beta0=14.401              kt1=-0.3076753
+ lkt1=1.479193e-08         wkt1=-1.008979e-08        pkt1=-2.732598e-15
+ kt2=-0.03407931           lkt2=3.146365e-09         wkt2=-2.645907e-09
+ pkt2=1.527902e-16         at=1431.908               lat=0.0034101
+ wat=0.0005635483          pat=-2.242926e-10         ute=-1.371134
+ lute=-5.164809e-09        wute=3.060447e-07         pute=-1.120987e-14
+ ua1=1.833928e-09          lua1=-3.618919e-17        wua1=1.018181e-16
+ pua1=-4.052361e-23        ub1=-2.309933e-18         lub1=2.244739e-25
+ wub1=4.74888e-25          pub1=-6.789896e-32        uc1=-7.1775e-12
+ luc1=4.941405e-18         wuc1=-2.410485e-18        puc1=-1.280585e-24
+ kt1l=0                    prt=0                     cj=cjn_25
+ mj=0.3193271              pb=0.7249372              cjsw=cjswn_25
+ mjsw=0.01                 pbsw=0.7249372            cjswg=cjswgn_25
+ mjswg=0.01                pbswg=0.7249372           tpb=0.001816363
+ tpbsw=0.001816363         tpbswg=0.001816363        tcj=0.001010853
+ tcjsw=9.297595e-05        tcjswg=9.297595e-05       js=4.03e-7
+ jsw=1.8e-12               n=1                       xti=3
+ cgdo=cgon_25              cgso=cgon_25              capmod=3
+ nqsmod=0                  xpart=1                   cf=0
+ tlev=1                    tlevc=1                   dlc=4.01e-8
+ cgbo=0                    cgdl=cgln_25              cgsl=cgln_25
+ wwc=-1.22e-2              dwc=0                     noia=8.0e+19
+ noib=2.5e+4               noic=1.0e-13              em=1.1e+7
+ ef=0.872                  noimod=2                  sa0=0.35e-6
+ sb0=0.35e-6               kvsat=0.35                wlod=0.3e-6
+ tku0=0.03                 ku0=-5.95e-8              llodku0=1
+ wlodku0=1                 lku0=1.493e-7             wku0=3.5e-7
+ pku0=0                    kvth0=7.2e-9              stk2=0
+ steta0=-1.1e-10           lkvth0=-5e-8              wkvth0=5e-6
+ pkvth0=0                  llodvth=1.0               wlodvth=1
+ lodk2=1                   lodeta0=2                 minr=1e-3
+ imax=0.01                 imelt=0.01

     7: type=n
+ lmin=1.2e-06-(dxl_25+dlmis)                         lmax=2.1e-05
+ wmin=6.0e-07-(dxw_25+dwmis)                         wmax=1.21e-06-(dxw_25+dwmis)
+ tnom=25                   version=3.24              tox=(toxn_25+toxmis)
+ toxm=(toxn_25+toxmis)     xj=1.9e-07                nch=3.28e+17
+ lln=1                     lwn=1                     wln=1
+ wwn=-1                    lint=3.1e-08              wint=1.95e-08
+ mobmod=1                  binunit=2                 xl=-4e-08+(dxl_25+dlmis)
+ xw=1e-8+(dxw_25+dwmis)    dwg=0                     dwb=0
+ ldif=8e-08                hdif=hdifn_25             rsh=6.6
+ rd=0                      rs=0                      vth0=0.5541502+(dvthn_25+vthmis)
+ lvth0=4.4826290e-08       wvth0=-1.7969525e-08      pvth0=-9.9110500e-15
+ k1=0.6238807              lk1=-1.208121e-07         wk1=-4.214282e-08
+ pk1=8.075687e-14          k2=-0.02331892            lk2=3.289958e-08
+ wk2=1.14205e-08           pk2=-3.263994e-14         k3=0
+ dvt0=0                    dvt1=0                    dvt2=0
+ dvt0w=0                   dvt1w=0                   dvt2w=0
+ nlx=0                     w0=0                      k3b=0
+ vfb=-0.8647492            vsat=1.0171881e+05        lvsat=-1.7184015e-02
+ wvsat=-5.7781140e-04      pvsat=5.7325310e-09       ua=-6.746027e-10
+ lua=9.58011e-17           wua=1.127462e-16          pua=-1.352197e-22
+ ub=1.73611e-18            lub=-3.433537e-25         wub=-2.570126e-25
+ pub=2.518541e-31          uc=6.394864e-11           luc=-4.265159e-17
+ wuc=-2.735956e-17         puc=3.073341e-23          rdsw=325.9
+ prwb=0                    prwg=0                    wr=1
+ u0=3.2068890e-02          lu0=-4.7598300e-09        wu0=-1.5811429e-09
+ pu0=2.2761478e-15         a0=0.5679296              la0=-1.597854e-07
+ wa0=5.878569e-08          pa0=-1.078234e-13         keta=0.01175419
+ lketa=-3.394948e-08       wketa=9.03391e-10         pketa=1.470456e-15
+ a1=0                      a2=0.99                   ags=0.02952203
+ lags=-9.548719e-08        wags=-5.437074e-09        pags=5.452318e-14
+ b0=0                      b1=0                      voff=-0.1361137
+ lvoff=2.764377e-09        wvoff=-8.556083e-09       pvoff=-7.251459e-16
+ nfactor=1                 cit=-9.979836e-06         lcit=2.149484e-10
+ wcit=-1.987914e-11        pcit=2.605285e-16         cdsc=0
+ cdscb=0                   cdscd=0                   eta0=5e-05
+ etab=-5e-05               dsub=0                    pclm=0.7
+ pdiblc1=1e-06             pdiblc2=0.0005045947      lpdiblc2=4.935956e-09
+ wpdiblc2=4.228449e-12     ppdiblc2=-4.644269e-18    pdiblcb=0.01
+ drout=0                   pscbe1=1.814223e+08       lpscbe1=185.0983
+ wpscbe1=0.1585543         ppscbe1=-1.740868e-07     pscbe2=1e-06
+ pvag=0                    delta=0.01                alpha0=0
+ alpha1=0.7997             beta0=14.401              kt1=-0.287591
+ lkt1=-2.829119e-08        wkt1=-4.111954e-09        pkt1=2.379299e-14
+ kt2=-0.02678708           lkt2=-4.477435e-09        wkt2=-1.352642e-09
+ pkt2=4.223475e-15         at=10000                  ute=-1.494996
+ lute=3.580508e-07         wute=1.795666e-07         pute=-2.191562e-13
+ ua1=1.743e-09             ub1=-2.24558e-18          lub1=6.945156e-25
+ wub1=2.003911e-25         pub1=-3.325729e-31        uc1=-8.067581e-11
+ luc1=5.252251e-17         wuc1=6.175502e-18         puc1=-1.743761e-23
+ kt1l=0                    prt=0                     cj=cjn_25
+ mj=0.3193271              pb=0.7249372              cjsw=cjswn_25
+ mjsw=0.01                 pbsw=0.7249372            cjswg=cjswgn_25
+ mjswg=0.01                pbswg=0.7249372           tpb=0.001816363
+ tpbsw=0.001816363         tpbswg=0.001816363        tcj=0.001010853
+ tcjsw=9.297595e-05        tcjswg=9.297595e-05       js=4.03e-7
+ jsw=1.8e-12               n=1                       xti=3
+ cgdo=cgon_25              cgso=cgon_25              capmod=3
+ nqsmod=0                  xpart=1                   cf=0
+ tlev=1                    tlevc=1                   dlc=4.01e-8
+ cgbo=0                    cgdl=cgln_25              cgsl=cgln_25
+ wwc=-1.22e-2              dwc=0                     noia=8.0e+19
+ noib=2.5e+4               noic=1.0e-13              em=1.1e+7
+ ef=0.872                  noimod=2                  sa0=0.35e-6
+ sb0=0.35e-6               kvsat=0.35                wlod=0.3e-6
+ tku0=0.03                 ku0=-5.95e-8              llodku0=1
+ wlodku0=1                 lku0=1.493e-7             wku0=3.5e-7
+ pku0=0                    kvth0=7.2e-9              stk2=0
+ steta0=-1.1e-10           lkvth0=-5e-8              wkvth0=5e-6
+ pkvth0=0                  llodvth=1.0               wlodvth=1
+ lodk2=1                   lodeta0=2                 minr=1e-3
+ imax=0.01                 imelt=0.01

     8: type=n
+ lmin=5.0e-07-(dxl_25+dlmis)                         lmax=1.2e-06-(dxl_25+dlmis)
+ wmin=6.0e-07-(dxw_25+dwmis)                         wmax=1.21e-06-(dxw_25+dwmis)
+ tnom=25                   version=3.24              tox=(toxn_25+toxmis)
+ toxm=(toxn_25+toxmis)     xj=1.9e-07                nch=3.28e+17
+ lln=1                     lwn=1                     wln=1
+ wwn=-1                    lint=3.1e-08              wint=1.95e-08
+ mobmod=1                  binunit=2                 xl=-4e-08+(dxl_25+dlmis)
+ xw=1e-8+(dxw_25+dwmis)    dwg=0                     dwb=0
+ ldif=8e-08                hdif=hdifn_25             rsh=6.6
+ rd=0                      rs=0                      vth0=0.5682745+(dvthn_25+vthmis)
+ lvth0=2.9317764e-08       wvth0=-2.3592545e-08      pvth0=-3.7369730e-15
+ k1=0.517328               lk1=-3.817216e-09         wk1=4.556238e-10
+ pk1=3.398377e-14          k2=0.01651492             lk2=-1.083799e-08
+ wk2=-7.3875e-09           pk2=-1.198874e-14         k3=0
+ dvt0=0                    dvt1=0                    dvt2=0
+ dvt0w=0                   dvt1w=0                   dvt2w=0
+ nlx=0                     w0=0                      k3b=0
+ vfb=-0.912801             vsat=8.9337160e+04        lvsat=-3.5889600e-03
+ wvsat=4.1402310e-03       pvsat=5.5212010e-10       ua=-5.283277e-10
+ lua=-6.480883e-17         wua=-5.403362e-17         pua=4.790457e-23
+ ub=1.288412e-18           lub=1.482181e-25          wub=1.452145e-25
+ pub=-1.897913e-31         uc=6.589195e-12           luc=2.032909e-17
+ wuc=1.508072e-17          puc=-1.586602e-23         rdsw=325.9
+ prwb=0                    prwg=0                    wr=1
+ u0=2.6922315e-02          lu0=8.9110440e-10         wu0=1.1877108e-09
+ pu0=-7.6405360e-16        a0=0.409158               la0=1.454578e-08
+ wa0=-3.19865e-08          pa0=-8.155571e-15         keta=-0.01566437
+ lketa=-3.843909e-09       wketa=2.009296e-09        pketa=2.561715e-16
+ a1=0                      a2=0.99                   ags=-0.1227631
+ lags=7.172186e-08         wags=9.45039e-08          pags=-5.521201e-14
+ b0=0                      b1=0                      voff=-0.1204382
+ lvoff=-1.444727e-08       wvoff=-1.713118e-08       pvoff=8.690311e-15
+ nfactor=1                 cit=-0.0001547657         lcit=3.739234e-10
+ wcit=3.987058e-10         pcit=-1.990778e-16        cdsc=0
+ cdscb=0                   cdscd=0                   eta0=-0.000490143
+ leta0=5.930769e-10        etab=0.000490143          letab=-5.930769e-10
+ dsub=0                    pclm=0.6155033            lpclm=9.277744e-08
+ wpclm=-9.949611e-10       ppclm=1.092453e-15        pdiblc1=1e-06
+ pdiblc2=0.005000001       pdiblcb=0.01              drout=0
+ pscbe1=3.5e+08            pscbe2=1e-06              pvag=0
+ delta=0.01                alpha0=0                  alpha1=0.7997
+ beta0=14.401              kt1=-0.3264761            lkt1=1.440468e-08
+ wkt1=2.390278e-08         pkt1=-6.967189e-15        kt2=-0.03246339
+ lkt2=1.755159e-09         wkt2=3.935832e-09         pkt2=-1.583269e-15
+ at=10000                  ute=-1.186555             lute=1.938267e-08
+ wute=-2.405503e-08        pute=4.420327e-15         ua1=1.580022e-09
+ lua1=1.789501e-16         wua1=1.924773e-16         pua1=-2.113401e-22
+ ub1=-1.468904e-18         lub1=-1.582742e-25        wub1=-4.148e-25
+ pub1=3.429068e-31         uc1=-4.470879e-11         luc1=1.303072e-17
+ wuc1=-2.357801e-17        puc1=1.523175e-23         kt1l=0
+ prt=0                     cj=cjn_25                 mj=0.3193271
+ pb=0.7249372              cjsw=cjswn_25             mjsw=0.01
+ pbsw=0.7249372            cjswg=cjswgn_25           mjswg=0.01
+ pbswg=0.7249372           tpb=0.001816363           tpbsw=0.001816363
+ tpbswg=0.001816363        tcj=0.001010853           tcjsw=9.297595e-05
+ tcjswg=9.297595e-05       js=4.03e-7                jsw=1.8e-12
+ n=1                       xti=3                     cgdo=cgon_25
+ cgso=cgon_25              capmod=3                  nqsmod=0
+ xpart=1                   cf=0                      tlev=1
+ tlevc=1                   dlc=4.01e-8               cgbo=0
+ cgdl=cgln_25              cgsl=cgln_25              wwc=-1.22e-2
+ dwc=0                     noia=8.0e+19              noib=2.5e+4
+ noic=1.0e-13              em=1.1e+7                 ef=0.872
+ noimod=2                  sa0=0.35e-6               sb0=0.35e-6
+ kvsat=0.35                wlod=0.3e-6               tku0=0.03
+ ku0=-5.95e-8              llodku0=1                 wlodku0=1
+ lku0=1.493e-7             wku0=3.5e-7               pku0=0
+ kvth0=7.2e-9              stk2=0                    steta0=-1.1e-10
+ lkvth0=-5e-8              wkvth0=5e-6               pkvth0=0
+ llodvth=1.0               wlodvth=1                 lodk2=1
+ lodeta0=2                 minr=1e-3                 imax=0.01
+ imelt=0.01

     9: type=n
+ lmin=2.8e-07              lmax=5.0e-07-(dxl_25+dlmis)
+ wmin=6.0e-07-(dxw_25+dwmis)                         wmax=1.21e-06-(dxw_25+dwmis)
+ tnom=25                   version=3.24              tox=(toxn_25+toxmis)
+ toxm=(toxn_25+toxmis)     xj=1.9e-07                nch=3.28e+17
+ lln=1                     lwn=1                     wln=1
+ wwn=-1                    lint=3.1e-08              wint=1.95e-08
+ mobmod=1                  binunit=2                 xl=-4e-08+(dxl_25+dlmis)
+ xw=1e-8+(dxw_25+dwmis)    dwg=0                     dwb=0
+ ldif=8e-08                hdif=hdifn_25             rsh=6.6
+ rd=0                      rs=0                      vth0=0.6727744+(dvthn_25+vthmis)
+ lvth0=-1.2273222e-08      wvth0=-3.2269360e-08      pvth0=-2.8360204e-16
+ k1=0.506862               lk1=3.482065e-10          wk1=1.664402e-07
+ pk1=-3.20781e-14          k2=0.05711861             lk2=-2.699826e-08
+ wk2=-6.889533e-08         pk2=1.249137e-14          k3=0
+ dvt0=0                    dvt1=0                    dvt2=0
+ dvt0w=0                   dvt1w=0                   dvt2w=0
+ nlx=0                     w0=0                      k3b=0
+ vfb=-0.7772112            vsat=8.0319670e+04        wvsat=5.5274680e-03
+ ua=-7.495025e-10          lua=2.321874e-17          wua=1.174163e-16
+ pua=-2.033249e-23         ub=1.881401e-18           lub=-8.779129e-26
+ wub=-4.298805e-25         pub=3.90965e-32           uc=9.905966e-11
+ luc=-1.647415e-17         wuc=-4.098369e-17         puc=6.447613e-24
+ rdsw=325.9                prwb=0                    prwg=0
+ wr=1                      u0=2.9573904e-02          lu0=-1.6422901e-10
+ wu0=-7.4573300e-10        pu0=5.4570510e-18         a0=0.6412702
+ la0=-7.783486e-08         wa0=-4.689214e-08         pa0=-2.223132e-15
+ keta=-0.04961912          lketa=9.670079e-09        wketa=6.018185e-09
+ pketa=-1.339365e-15       a1=0                      a2=0.99
+ ags=0.1503953             lags=-3.699515e-08        wags=-1.157753e-07
+ pags=2.847913e-14         b0=0                      b1=0
+ voff=-0.1895237           lvoff=1.304875e-08        wvoff=2.684043e-08
+ pvoff=-8.810388e-15       nfactor=1                 cit=0.0008311252
+ lcit=-1.846116e-11        wcit=7.344712e-11         pcit=-6.962485e-17
+ cdsc=0                    cdscb=0                   cdscd=0
+ eta0=-0.002236364         leta0=1.288073e-09        etab=-0.0001909085
+ letab=-3.220184e-10       dsub=0                    pclm=0.7887304
+ lpclm=2.383302e-08        wpclm=-5.069236e-08       ppclm=2.087202e-14
+ pdiblc1=1e-06             pdiblc2=-0.01574455       lpdiblc2=8.256332e-09
+ wpdiblc2=-8.944461e-09    ppdiblc2=3.559895e-15     pdiblcb=0.01
+ drout=0                   pscbe1=3.5e+08            pscbe2=1e-06
+ pvag=0                    delta=0.01                alpha0=0
+ alpha1=0.7997             beta0=14.401              kt1=-0.3208798
+ lkt1=1.217738e-08         wkt1=5.504833e-09         pkt1=3.551922e-16
+ kt2=-0.03856365           lkt2=4.18306e-09          wkt2=2.650097e-09
+ pkt2=-1.071547e-15        at=1909.088               lat=0.003220183
+ ute=-1.093895             lute=-1.74962e-08         wute=-2.137455e-08
+ pute=3.353496e-15         ua1=2.370475e-09          lua1=-1.356501e-16
+ wua1=-5.318439e-16        pua1=7.693971e-23         ub1=-2.511816e-18
+ lub1=2.568048e-25         wub1=7.133122e-25         pub1=-1.060818e-31
+ uc1=-2.860716e-11         luc1=6.622267e-18         wuc1=2.289795e-17
+ puc1=-3.265684e-24        kt1l=0                    prt=0
+ cj=cjn_25                 mj=0.3193271              pb=0.7249372
+ cjsw=cjswn_25             mjsw=0.01                 pbsw=0.7249372
+ cjswg=cjswgn_25           mjswg=0.01                pbswg=0.7249372
+ tpb=0.001816363           tpbsw=0.001816363         tpbswg=0.001816363
+ tcj=0.001010853           tcjsw=9.297595e-05        tcjswg=9.297595e-05
+ js=4.03e-7                jsw=1.8e-12               n=1
+ xti=3                     cgdo=cgon_25              cgso=cgon_25
+ capmod=3                  nqsmod=0                  xpart=1
+ cf=0                      tlev=1                    tlevc=1
+ dlc=4.01e-8               cgbo=0                    cgdl=cgln_25
+ cgsl=cgln_25              wwc=-1.22e-2              dwc=0
+ noia=8.0e+19              noib=2.5e+4               noic=1.0e-13
+ em=1.1e+7                 ef=0.872                  noimod=2
+ sa0=0.35e-6               sb0=0.35e-6               kvsat=0.35
+ wlod=0.3e-6               tku0=0.03                 ku0=-5.95e-8
+ llodku0=1                 wlodku0=1                 lku0=1.493e-7
+ wku0=3.5e-7               pku0=0                    kvth0=7.2e-9
+ stk2=0                    steta0=-1.1e-10           lkvth0=-5e-8
+ wkvth0=5e-6               pkvth0=0                  llodvth=1.0
+ wlodvth=1                 lodk2=1                   lodeta0=2
+ minr=1e-3                 imax=0.01                 imelt=0.01

     10: type=n
+ lmin=1.2e-06-(dxl_25+dlmis)                         lmax=2.1e-05
+ wmin=1.5e-07              wmax=6.0e-07-(dxw_25+dwmis)
+ tnom=25                   version=3.24              tox=(toxn_25+toxmis)
+ toxm=(toxn_25+toxmis)     xj=1.9e-07                nch=3.28e+17
+ lln=1                     lwn=1                     wln=1
+ wwn=-1                    lint=3.1e-08              wint=1.95e-08
+ mobmod=1                  binunit=2                 xl=-4e-08+(dxl_25+dlmis)
+ xw=1e-8+(dxw_25+dwmis)    dwg=0                     dwb=0
+ ldif=8e-08                hdif=hdifn_25             rsh=6.6
+ rd=0                      rs=0                      vth0=0.5422315+(dvthn_25+vthmis)
+ lvth0=3.1714840e-08       wvth0=-1.1163966e-08      pvth0=-2.4244101e-15
+ k1=0.5479347              lk1=3.78316e-08           wk1=1.222366e-09
+ pk1=-9.828678e-15         k2=0.005827645            lk2=-2.890513e-08
+ wk2=-5.222191e-09         pk2=2.650552e-15          k3=0
+ dvt0=0                    dvt1=0                    dvt2=0
+ dvt0w=0                   dvt1w=0                   dvt2w=0
+ nlx=0                     w0=0                      k3b=0
+ vfb=-0.909018             vsat=1.0088023e+05        lvsat=-8.8966530e-03
+ wvsat=-9.8984170e-05      pvsat=1.0004452e-09       ua=-5.019348e-10
+ lua=-1.028488e-16         wua=1.415291e-17          pua=-2.179062e-23
+ ub=1.259826e-18           lub=5.625312e-26          wub=1.494562e-26
+ pub=2.367857e-32          uc=1.171129e-11           luc=1.227163e-17
+ wuc=2.467972e-18          puc=-6.277545e-25         rdsw=325.9
+ prwb=0                    prwg=0                    wr=1
+ u0=2.7484521e-02          lu0=5.7991870e-10         wu0=1.0365279e-09
+ pu0=-7.7284900e-16        a0=0.719522               la0=-3.474643e-07
+ wa0=-2.777356e-08         pa0=-6.588075e-16         keta=0.01854084
+ lketa=-3.251736e-08       wketa=-2.971792e-09       pketa=6.527143e-16
+ a1=0                      a2=0.99                   ags=0.02000002
+ b0=0                      b1=0                      voff=-0.1554637
+ lvoff=-6.93599e-10        wvoff=2.49282e-09         pvoff=1.249359e-15
+ nfactor=1                 cit=-6.461236e-05         lcit=8.206671e-10
+ wcit=1.131603e-11         pcit=-8.533693e-17        cdsc=0
+ cdscb=0                   cdscd=0                   eta0=5e-05
+ etab=-5e-05               dsub=0                    pclm=0.7
+ pdiblc1=1e-06             pdiblc2=0.0007116703      lpdiblc2=2.908376e-09
+ wpdiblc2=-1.140118e-10    ppdiblc2=1.153104e-15     pdiblcb=0.01
+ drout=0                   pscbe1=1.817012e+08       lpscbe1=184.7988
+ ppscbe1=-3.076762e-09     pscbe2=1e-06              pvag=0
+ delta=0.01                alpha0=0                  alpha1=0.7997
+ beta0=14.401              kt1=-0.3046467            lkt1=1.85551e-08
+ wkt1=5.626874e-09         pkt1=-2.956242e-15        kt2=-0.03127436
+ lkt2=4.907518e-09         wkt2=1.209594e-09         pkt2=-1.135333e-15
+ at=10000                  ute=-1.21389              lute=6.427178e-09
+ wute=1.905479e-08         pute=-1.837907e-14        ua1=1.743e-09
+ ub1=-1.899235e-18         lub1=1.875644e-25         wub1=2.62803e-27
+ pub1=-4.310363e-32        uc1=-7.342586e-11         luc1=2.391715e-17
+ wuc1=2.03578e-18          puc1=-1.103955e-24        kt1l=0
+ prt=0                     cj=cjn_25                 mj=0.3193271
+ pb=0.7249372              cjsw=cjswn_25             mjsw=0.01
+ pbsw=0.7249372            cjswg=cjswgn_25           mjswg=0.01
+ pbswg=0.7249372           tpb=0.001816363           tpbsw=0.001816363
+ tpbswg=0.001816363        tcj=0.001010853           tcjsw=9.297595e-05
+ tcjswg=9.297595e-05       js=4.03e-7                jsw=1.8e-12
+ n=1                       xti=3                     cgdo=cgon_25
+ cgso=cgon_25              capmod=3                  nqsmod=0
+ xpart=1                   cf=0                      tlev=1
+ tlevc=1                   dlc=4.01e-8               cgbo=0
+ cgdl=cgln_25              cgsl=cgln_25              wwc=-1.22e-2
+ dwc=0                     noia=8.0e+19              noib=2.5e+4
+ noic=1.0e-13              em=1.1e+7                 ef=0.872
+ noimod=2                  sa0=0.35e-6               sb0=0.35e-6
+ kvsat=0.35                wlod=0.3e-6               tku0=0.03
+ ku0=-5.95e-8              llodku0=1                 wlodku0=1
+ lku0=1.493e-7             wku0=3.5e-7               pku0=0
+ kvth0=7.2e-9              stk2=0                    steta0=-1.1e-10
+ lkvth0=-5e-8              wkvth0=5e-6               pkvth0=0
+ llodvth=1.0               wlodvth=1                 lodk2=1
+ lodeta0=2                 minr=1e-3                 imax=0.01
+ imelt=0.01

     11: type=n
+ lmin=5.0e-07-(dxl_25+dlmis)                         lmax=1.20e-06-(dxl_25+dlmis)
+ wmin=1.5e-07              wmax=6.0e-07-(dxw_25+dwmis)
+ tnom=25                   version=3.24              tox=(toxn_25+toxmis)
+ toxm=(toxn_25+toxmis)     xj=1.9e-07                nch=3.28e+17
+ lln=1                     lwn=1                     wln=1
+ wwn=-1                    lint=3.1e-08              wint=1.95e-08
+ mobmod=1                  binunit=2                 xl=-4e-08+(dxl_25+dlmis)
+ xw=1e-8+(dxw_25+dwmis)    dwg=0                     dwb=0
+ ldif=8e-08                hdif=hdifn_25             rsh=6.6
+ rd=0                      rs=0                      vth0=0.5417253+(dvthn_25+vthmis)
+ lvth0=3.2270560e-08       wvth0=-8.4329900e-09      pvth0=-5.4230210e-15
+ k1=0.5188512              lk1=6.976528e-08          wk1=-4.141004e-10
+ pk1=-8.031837e-15         k2=0.01219333             lk2=-3.589466e-08
+ wk2=-4.919882e-09         pk2=2.318618e-15          k3=0
+ dvt0=0                    dvt1=0                    dvt2=0
+ dvt0w=0                   dvt1w=0                   dvt2w=0
+ nlx=0                     w0=0                      k3b=0
+ vfb=-0.9318906            vsat=9.5862160e+04        lvsat=-3.3867960e-03
+ wvsat=4.1445850e-04       pvsat=4.3668510e-10       ua=-6.218908e-10
+ lua=2.886285e-17          wua=-6.090707e-19         pua=-5.58197e-24
+ ub=1.495336e-18           lub=-2.02337e-25          wub=2.706116e-26
+ pub=1.037571e-32          uc=2.93016e-11            luc=-7.042535e-18
+ wuc=2.111928e-18          puc=-2.368185e-25         rdsw=325.9
+ prwb=0                    prwg=0                    wr=1
+ u0=2.9326258e-02          lu0=-1.4423063e-09        wu0=-1.8494141e-10
+ pu0=5.6832430e-16         a0=0.410676               la0=-8.35134e-09
+ wa0=-3.285325e-08         pa0=4.918691e-15          keta=-0.005220399
+ lketa=-6.427524e-09       wketa=-3.954217e-09       pketa=1.731417e-15
+ a1=0                      a2=0.99                   ags=0.05020038
+ lags=-3.316003e-08        wags=-4.258256e-09        pags=4.675565e-15
+ b0=0                      b1=0                      voff=-0.1544699
+ lvoff=-1.784848e-09       wvoff=2.300918e-09        pvoff=1.460067e-15
+ nfactor=1                 cit=0.0006517879          lcit=3.405972e-11
+ wcit=-6.183635e-11        pcit=-5.015623e-18        cdsc=0
+ cdscb=0                   cdscd=0                   eta0=-0.0003037047
+ leta0=3.883675e-10        weta0=-1.064564e-10       peta0=1.168891e-16
+ etab=0.000490143          letab=-5.930769e-10       dsub=0
+ pclm=0.6142834            lpclm=9.411686e-08        wpclm=-2.983971e-10
+ ppclm=3.276399e-16        pdiblc1=1e-06             pdiblc2=0.003360465
+ wpdiblc2=9.361742e-10     pdiblcb=0.01              drout=0
+ pscbe1=3.500095e+08       ppscbe1=2.169026e-09      pscbe2=1e-06
+ pvag=0                    delta=0.01                alpha0=0
+ alpha1=0.7997             beta0=14.401              kt1=-0.2880923
+ lkt1=3.783602e-10         wkt1=1.985635e-09         pkt1=1.041839e-15
+ kt2=-0.02560025           lkt2=-1.322649e-09        wkt2=1.69774e-11
+ pkt2=1.741595e-16         at=10000                  ute=-1.251221
+ lute=4.741641e-08         wute=1.286888e-08         pute=-1.158695e-14
+ ua1=1.974202e-09          lua1=-2.538594e-16        wua1=-3.259943e-17
+ pua1=3.579417e-23         ub1=-2.260109e-18         lub1=5.838046e-25
+ wub1=3.697838e-26         pub1=-8.082031e-32        uc1=-9.803292e-11
+ luc1=5.093571e-17         wuc1=6.870073e-18         puc1=-6.412009e-24
+ kt1l=0                    prt=0                     cj=cjn_25
+ mj=0.3193271              pb=0.7249372              cjsw=cjswn_25
+ mjsw=0.01                 pbsw=0.7249372            cjswg=cjswgn_25
+ mjswg=0.01                pbswg=0.7249372           tpb=0.001816363
+ tpbsw=0.001816363         tpbswg=0.001816363        tcj=0.001010853
+ tcjsw=9.297595e-05        tcjswg=9.297595e-05       js=4.03e-7
+ jsw=1.8e-12               n=1                       xti=3
+ cgdo=cgon_25              cgso=cgon_25              capmod=3
+ nqsmod=0                  xpart=1                   cf=0
+ tlev=1                    tlevc=1                   dlc=4.01e-8
+ cgbo=0                    cgdl=cgln_25              cgsl=cgln_25
+ wwc=-1.22e-2              dwc=0                     noia=8.0e+19
+ noib=2.5e+4               noic=1.0e-13              em=1.1e+7
+ ef=0.872                  noimod=2                  sa0=0.35e-6
+ sb0=0.35e-6               kvsat=0.35                wlod=0.3e-6
+ tku0=0.03                 ku0=-5.95e-8              llodku0=1
+ wlodku0=1                 lku0=1.493e-7             wku0=3.5e-7
+ pku0=0                    kvth0=7.2e-9              stk2=0
+ steta0=-1.1e-10           lkvth0=-5e-8              wkvth0=5e-6
+ pkvth0=0                  llodvth=1.0               wlodvth=1
+ lodk2=1                   lodeta0=2                 minr=1e-3
+ imax=0.01                 imelt=0.01

     12: type=n
+ lmin=2.8e-07              lmax=5.0e-07-(dxl_25+dlmis)
+ wmin=1.5e-07              wmax=6.0e-07-(dxw_25+dwmis)
+ tnom=25                   version=3.24              tox=(toxn_25+toxmis)
+ toxm=(toxn_25+toxmis)     xj=1.9e-07                nch=3.28e+17
+ lln=1                     lwn=1                     wln=1
+ wwn=-1                    lint=3.1e-08              wint=1.95e-08
+ mobmod=1                  binunit=2                 xl=-4e-08+(dxl_25+dlmis)
+ xw=1e-8+(dxw_25+dwmis)    dwg=0                     dwb=0
+ ldif=8e-08                hdif=hdifn_25             rsh=6.6
+ rd=0                      rs=0                      vth0=0.6596250+(dvthn_25+vthmis)
+ lvth0=-1.4653499e-08      wvth0=-2.4761023e-08      pvth0=1.0755358e-15
+ k1=0.8684869              lk1=-6.938973e-08         wk1=-4.004752e-08
+ pk1=7.742263e-15          k2=-0.06783327            lk2=-4.044069e-09
+ wk2=2.4522e-09            pk2=-6.154713e-16         k3=0
+ dvt0=0                    dvt1=0                    dvt2=0
+ dvt0w=0                   dvt1w=0                   dvt2w=0
+ nlx=0                     w0=0                      k3b=0
+ vfb=-0.9503278            vsat=8.7299730e+04        lvsat=2.1045111e-05
+ wvsat=1.5418500e-03       pvsat=-1.2016753e-11      ua=-5.249773e-10
+ lua=-9.708697e-18         wua=-1.07876e-17          pua=-1.530916e-24
+ ub=9.176741e-19           lub=2.757234e-26          wub=1.204075e-25
+ pub=-2.677613e-32         uc=1.904671e-11           luc=-2.961089e-18
+ wuc=4.703706e-18          puc=-1.268346e-24         rdsw=325.9
+ prwb=0                    prwg=0                    wr=1
+ u0=2.5628585e-02          lu0=2.9365850e-11         wu0=1.5070432e-09
+ pu0=-1.0508559e-16        a0=0.6062471              la0=-8.618863e-08
+ wa0=-2.68939e-08          pa0=2.546869e-15          keta=-0.04630484
+ lketa=9.92408e-09         wketa=4.125726e-09        pketa=-1.4844e-15
+ a1=0                      a2=0.99                   ags=-0.07609219
+ lags=1.710441e-08         wags=1.3549e-08           pags=-2.411722e-15
+ b0=0                      b1=0                      voff=-0.1508045
+ lvoff=-3.243679e-09       wvoff=4.731763e-09        pvoff=4.925908e-16
+ nfactor=1                 cit=0.001160922           lcit=-1.685757e-10
+ wcit=-1.148669e-10        pcit=1.609052e-17         cdsc=0
+ cdscb=0                   cdscd=0                   eta0=-0.003146469
+ leta0=1.519788e-09        weta0=5.196694e-10        peta0=-1.323089e-16
+ etab=7.439798e-05         letab=-4.276103e-10       wetab=-1.514901e-10
+ petab=6.029304e-17        dsub=0                    pclm=0.7668545
+ lpclm=3.339355e-08        wpclm=-3.820119e-08       ppclm=1.541295e-14
+ pdiblc1=1e-06             pdiblc2=-0.04019715       lpdiblc2=1.733593e-08
+ wpdiblc2=5.017971e-09     ppdiblc2=-1.624555e-15    pdiblcb=0.01
+ drout=0                   pscbe1=3.5e+08            pscbe2=1e-06
+ pvag=0                    delta=0.01                alpha0=0
+ alpha1=0.7997             beta0=14.401              kt1=-0.3202
+ lkt1=1.315721e-08         wkt1=5.116618e-09         pkt1=-2.042924e-16
+ kt2=-0.03602254           lkt2=2.82542e-09          wkt2=1.199123e-09
+ pkt2=-2.963344e-16        at=1651.169               lat=0.003322834
+ wat=0.000147272           pat=-5.861422e-11         ute=-1.124059
+ lute=-3.193976e-09        wute=-4.15091e-09         pute=-4.813071e-15
+ ua1=1.180961e-09          lua1=6.185042e-17         wua1=1.473686e-16
+ pua1=-3.583308e-23        ub1=-5.926962e-19         lub1=-7.982564e-26
+ wub1=-3.825053e-25        pub1=8.613416e-32         uc1=4.570387e-11
+ luc1=-6.271527e-18        wuc1=-1.953365e-17        puc1=4.096673e-24
+ kt1l=0                    prt=0                     cj=cjn_25
+ mj=0.3193271              pb=0.7249372              cjsw=cjswn_25
+ mjsw=0.01                 pbsw=0.7249372            cjswg=cjswgn_25
+ mjswg=0.01                pbswg=0.7249372           tpb=0.001816363
+ tpbsw=0.001816363         tpbswg=0.001816363        tcj=0.001010853
+ tcjsw=9.297595e-05        tcjswg=9.297595e-05       js=4.03e-7
+ jsw=1.8e-12               n=1                       xti=3
+ cgdo=cgon_25              cgso=cgon_25              capmod=3
+ nqsmod=0                  xpart=1                   cf=0
+ tlev=1                    tlevc=1                   dlc=4.01e-8
+ cgbo=0                    cgdl=cgln_25              cgsl=cgln_25
+ wwc=-1.22e-2              dwc=0                     noia=8.0e+19
+ noib=2.5e+4               noic=1.0e-13              em=1.1e+7
+ ef=0.872                  noimod=2                  sa0=0.35e-6
+ sb0=0.35e-6               kvsat=0.35                wlod=0.3e-6
+ tku0=0.03                 ku0=-5.95e-8              llodku0=1
+ wlodku0=1                 lku0=1.493e-7             wku0=3.5e-7
+ pku0=0                    kvth0=7.2e-9              stk2=0
+ steta0=-1.1e-10           lkvth0=-5e-8              wkvth0=5e-6
+ pkvth0=0                  llodvth=1.0               wlodvth=1
+ lodk2=1                   lodeta0=2                 minr=1e-3
+ imax=0.01                 imelt=0.01
//
//  *************************************************************
//                                                              *
//              2.5V PMOS DEVICES MODEL                         *
//                                                              *
//  *************************************************************
//
     }
ends nch_25_mis

//  ********************************
//        Mismatch   model         *
//  ********************************
inline subckt pch_25_mis ( d g s b )
parameters l=1u w=1u factor=1 multi=1 sa=0.35u sb=0.35u ad=2 * hdifp_25 / factor *
+ w as=2 * hdifp_25 / factor * w pd=2 * (2 * hdifp_25 / factor + w) ps=2 * (2 * hdifp_25
+ / factor + w) nrd=hdifp_25 / factor / w nrs=hdifp_25 / factor / w temp1=parp1_25
+ temp2=parp2_25 fac1=0.887 * temp1 + 0.461 * temp2 fac2=0.887 * temp1 - 0.461 *
+ temp2 lef=l - 4.0e-8 wef=w + 1.0e-8 geo_fac=1 / sqrt(multi * lef * wef * 1e12)
+ vthmis=0.003463 * geo_fac * fac1 dlmis=0.002070 * geo_fac * lef * fac2 dwmis=
+ - 0.002070 * geo_fac * wef * fac2 toxmis=0.002070 * geo_fac * toxp_25 * fac2
pch_25_mis ( d g s b ) pch_25 w=w l=l ad=ad as=as pd=pd ps=ps nrd=nrd nrs=nrs m=multi sa=sa
+ sb=sb
model pch_25 bsim3v3  {
     1: type=p
+ lmin=1.21e-06-(dxl_25+dlmis)                        lmax=2.1e-05
+ wmin=1.001e-05-(dxw_25+dwmis)                       wmax=0.0009001
+ tnom=25                   version=3.24              tox=(toxp_25+toxmis)
+ toxm=(toxp_25+toxmis)     xj=2.1e-07                nch=7.22e+17
+ lln=1                     lwn=1                     wln=1
+ wwn=-1                    lint=4.4e-08              wint=5e-09
+ mobmod=1                  binunit=2                 xl=-4e-08+(dxl_25+dlmis)
+ xw=1e-8+(dxw_25+dwmis)    dwg=0                     dwb=0
+ ldif=8e-08                hdif=hdifp_25             rsh=7.2
+ rd=0                      rs=0                      vth0=-0.592658+(dvthp_25+vthmis)
+ lvth0=-1.055122e-08       wvth0=1.561465e-08        pvth0=1.575669e-14
+ k1=0.8641071              lk1=1.793378e-08          wk1=-9.128735e-08
+ pk1=-1.293998e-13         k2=-0.02934441            lk2=-6.656386e-09
+ wk2=4.882645e-09          pk2=2.74645e-14           k3=0
+ dvt0=0                    dvt1=0                    dvt2=0
+ dvt0w=0                   dvt1w=0                   dvt2w=0
+ nlx=0                     w0=0                      k3b=0
+ vfb=-1.14392              vsat=153630.9             lvsat=-0.03638859
+ ua=1.306378e-09           lua=-6.524579e-16         wua=-1.073666e-15
+ pua=1.595408e-21          ub=2.727538e-19           lub=8.028553e-25
+ wub=1.092813e-24          pub=3.625076e-31          uc=-9.835018e-11
+ luc=9.673812e-17          wuc=2.717682e-17          puc=-4.093868e-23
+ rdsw=784.6                prwb=0                    prwg=0
+ wr=1                      u0=0.01238799             lu0=3.924454e-11
+ wu0=-3.809757e-09         pu0=4.142064e-15          a0=0.7676753
+ la0=-1.51543e-07          wa0=-4.307646e-07         pa0=-2.065499e-13
+ keta=0.003813325          lketa=-2.161789e-08       wketa=-2.881522e-08
+ pketa=-3.63145e-14        a1=0                      a2=0.99
+ ags=0.02                  b0=0                      b1=0
+ voff=-0.09809562          lvoff=-2.072911e-09       wvoff=-5.213407e-08
+ pvoff=-2.903061e-14       nfactor=1                 cit=2.096417e-05
+ lcit=-1.079015e-12        wcit=-1.040074e-10        pcit=8.365094e-17
+ cdsc=0                    cdscb=0                   cdscd=0
+ eta0=5e-05                etab=-5e-05               dsub=0
+ pclm=0.7                  pdiblc1=1e-06             pdiblc2=0.0001
+ pdiblcb=0.01              drout=0                   pscbe1=1.818456e+08
+ lpscbe1=181.943           pscbe2=5e-07              pvag=0
+ delta=0.01                alpha0=0                  alpha1=1.0857
+ beta0=23.74               kt1=-0.2672082            lkt1=-9.184623e-09
+ wkt1=-1.072133e-07        pkt1=1.315602e-14         kt2=-0.02844408
+ lkt2=7.33378e-10          wkt2=1.810166e-08         pkt2=-2.137926e-14
+ at=-50000                 ute=-0.8395534            lute=-1.640363e-08
+ wute=9.212293e-07         pute=-5.374068e-13        ua1=1.752e-09
+ ub1=-2.360212e-18         lub1=3.389896e-25         wub1=2.957343e-24
+ pub1=-2.832312e-30        uc1=3.524049e-12          luc1=-1.171839e-17
+ wuc1=1.352376e-16         puc1=4.739483e-23         kt1l=0
+ prt=0                     cj=cjp_25                 mj=0.3952264
+ pb=0.854899               cjsw=cjswp_25             mjsw=0.0450429
+ pbsw=0.854899             cjswg=cjswgp_25           mjswg=0.0450429
+ pbswg=0.854899            tpb=0.001603538           tpbsw=0.001603538
+ tpbswg=0.001603538        tcj=0.0009016089          tcjsw=0.0001793034
+ tcjswg=0.0001793034       js=2.0e-7                 jsw=1.36e-12
+ n=1                       xti=3                     cgdo=cgop_25
+ cgso=cgop_25              capmod=3                  nqsmod=0
+ xpart=1                   cf=0                      tlev=1
+ tlevc=1                   dlc=3.90e-8               cgbo=0
+ cgdl=cglp_25              cgsl=cglp_25              wwc=-1.20e-2
+ dwc=0                     noia=5.0e+19              noib=4.0e+3
+ noic=8.0e-12              em=4.1e+7                 ef=1.152
+ noimod=2                  sa0=0.35e-6               sb0=0.35e-6
+ kvsat=-1                  wlod=0.3e-6               tku0=0.03
+ ku0=8.5e-08               llodku0=1                 wlodku0=1
+ lku0=8.0e-09              wku0=6.0e-07              pku0=0
+ kvth0=1.0e-09             stk2=0                    steta0=-3e-10
+ lkvth0=-1.0e-10           wkvth0=0                  pkvth0=0
+ llodvth=1                 wlodvth=1                 lodk2=1
+ lodeta0=1                 minr=1e-3                 imax=0.01
+ imelt=0.01

     2: type=p
+ lmin=5.0e-07-(dxl_25+dlmis)                         lmax=1.21e-06-(dxl_25+dlmis)
+ wmin=1.001e-05-(dxw_25+dwmis)                       wmax=0.0009001
+ tnom=25                   version=3.24              tox=(toxp_25+toxmis)
+ toxm=(toxp_25+toxmis)     xj=2.1e-07                nch=7.22e+17
+ lln=1                     lwn=1                     wln=1
+ wwn=-1                    lint=4.4e-08              wint=5e-09
+ mobmod=1                  binunit=2                 xl=-4e-08+(dxl_25+dlmis)
+ xw=1e-8+(dxw_25+dwmis)    dwg=0                     dwb=0
+ ldif=8e-08                hdif=hdifp_25             rsh=7.2
+ rd=0                      rs=0                      vth0=-0.611469+(dvthp_25+vthmis)
+ lvth0=9.802192e-09        wvth0=1.308355e-08        pvth0=1.849535e-14
+ k1=0.8710226              lk1=1.045122e-08          wk1=-3.438209e-07
+ pk1=1.438415e-13          k2=-0.02763058            lk2=-8.510749e-09
+ wk2=6.998036e-08          pk2=-4.297124e-14         k3=0
+ dvt0=0                    dvt1=0                    dvt2=0
+ dvt0w=0                   dvt1w=0                   dvt2w=0
+ nlx=0                     w0=0                      k3b=0
+ vfb=-1.206446             vsat=124656.7             lvsat=-0.005038549
+ wvsat=0.05827999          pvsat=-6.305896e-08       ua=1.046701e-09
+ lua=-3.714873e-16         wua=-4.068017e-16         pua=8.738602e-22
+ ub=7.067158e-19           lub=3.333084e-25          wub=3.837701e-24
+ pub=-2.607462e-30         uc=-4.644377e-11          luc=4.057539e-17
+ wuc=1.226846e-16          puc=-1.442781e-22         rdsw=784.6
+ prwb=0                    prwg=0                    wr=1
+ u0=0.01329371             lu0=-9.407475e-10         wu0=1.638803e-09
+ pu0=-1.753279e-15         a0=0.5676079              la0=6.492977e-08
+ wa0=-6.150402e-07         pa0=-7.16353e-15          keta=-0.007487313
+ lketa=-9.390594e-09       wketa=-1.055999e-07       pketa=4.676653e-14
+ a1=0                      a2=0.99                   ags=0.02
+ b0=0                      b1=0                      voff=-0.1058675
+ lvoff=6.336205e-09        wvoff=-9.207594e-08       pvoff=1.418649e-14
+ nfactor=1                 cit=2.032099e-05          lcit=-3.830841e-13
+ wcit=-4.465096e-12        pcit=-2.405385e-17        cdsc=0
+ cdscb=0                   cdscd=0                   eta0=-8.098595e-05
+ leta0=1.417268e-10        etab=8.098595e-05         letab=-1.417268e-10
+ dsub=0                    pclm=0.6741349            lpclm=2.798603e-08
+ wpclm=-3.321953e-08       ppclm=3.594356e-14        pdiblc1=1e-06
+ pdiblc2=-0.0003715494     lpdiblc2=5.102165e-10     pdiblcb=0.01
+ drout=0                   pscbe1=3.5e+08            pscbe2=5e-07
+ pvag=0                    delta=0.01                alpha0=0
+ alpha1=1.0857             beta0=23.74               kt1=-0.2727011
+ lkt1=-3.241333e-09        wkt1=-1.937851e-07        pkt1=1.068268e-13
+ kt2=-0.02877774           lkt2=1.094401e-09         wkt2=-4.380376e-09
+ pkt2=2.946302e-15         at=-50000                 ute=-0.8358768
+ lute=-2.038169e-08        wute=4.007488e-07         pute=2.575322e-14
+ ua1=1.752e-09             ub1=-2.01657e-18          lub1=-3.283118e-26
+ wub1=4.298972e-25         pub1=-9.761699e-32        uc1=-1.267933e-12
+ luc1=-6.533462e-18        wuc1=2.523737e-16         puc1=-7.934643e-23
+ kt1l=0                    prt=0                     cj=cjp_25
+ mj=0.3952264              pb=0.854899               cjsw=cjswp_25
+ mjsw=0.0450429            pbsw=0.854899             cjswg=cjswgp_25
+ mjswg=0.0450429           pbswg=0.854899            tpb=0.001603538
+ tpbsw=0.001603538         tpbswg=0.001603538        tcj=0.0009016089
+ tcjsw=0.0001793034        tcjswg=0.0001793034       js=2.0e-7
+ jsw=1.36e-12              n=1                       xti=3
+ cgdo=cgop_25              cgso=cgop_25              capmod=3
+ nqsmod=0                  xpart=1                   cf=0
+ tlev=1                    tlevc=1                   dlc=3.90e-8
+ cgbo=0                    cgdl=cglp_25              cgsl=cglp_25
+ wwc=-1.20e-2              dwc=0                     noia=5.0e+19
+ noib=4.0e+3               noic=8.0e-12              em=4.1e+7
+ ef=1.152                  noimod=2                  sa0=0.35e-6
+ sb0=0.35e-6               kvsat=-1                  wlod=0.3e-6
+ tku0=0.03                 ku0=8.5e-08               llodku0=1
+ wlodku0=1                 lku0=8.0e-09              wku0=6.0e-07
+ pku0=0                    kvth0=1.0e-09             stk2=0
+ steta0=-3e-10             lkvth0=-1.0e-10           wkvth0=0
+ pkvth0=0                  llodvth=1                 wlodvth=1
+ lodk2=1                   lodeta0=1                 minr=1e-3
+ imax=0.01                 imelt=0.01

     3: type=p
+ lmin=2.8e-07              lmax=5.0e-07-(dxl_25+dlmis)
+ wmin=1.001e-05-(dxw_25+dwmis)                       wmax=0.0009001
+ tnom=25                   version=3.24              tox=(toxp_25+toxmis)
+ toxm=(toxp_25+toxmis)     xj=2.1e-07                nch=7.22e+17
+ lln=1                     lwn=1                     wln=1
+ wwn=-1                    lint=4.4e-08              wint=5e-09
+ mobmod=1                  binunit=2                 xl=-4e-08+(dxl_25+dlmis)
+ xw=1e-8+(dxw_25+dwmis)    dwg=0                     dwb=0
+ ldif=8e-08                hdif=hdifp_25             rsh=7.2
+ rd=0                      rs=0                      vth0=-0.6284454+(dvthp_25+vthmis)
+ lvth0=1.6117434e-08       wvth0=-1.0891628e-07      pvth0=6.3879290e-14
+ k1=0.7489086              lk1=5.587764e-08          wk1=1.334465e-07
+ pk1=-3.370194e-14         k2=0.05316933             lk2=-3.856831e-08
+ wk2=-9.384368e-08         pk2=1.797131e-14          k3=0
+ dvt0=0                    dvt1=0                    dvt2=0
+ dvt0w=0                   dvt1w=0                   dvt2w=0
+ nlx=0                     w0=0                      k3b=0
+ vfb=-1.495219             vsat=118875.6             lvsat=-0.002887961
+ wvsat=-0.1889443          pvsat=2.890847e-08        ua=6.619991e-11
+ lua=-6.740967e-18         wua=3.007804e-15          pua=-3.963729e-22
+ ub=1.578969e-18           lub=8.830356e-27          wub=-4.495365e-24
+ pub=4.924388e-31          uc=8.285272e-11           luc=-7.522903e-18
+ wuc=-3.996817e-16         puc=5.004216e-23          rdsw=784.6
+ prwb=0                    prwg=0                    wr=1
+ u0=0.011449               lu0=-2.545132e-10         wu0=-1.235081e-09
+ pu0=-6.841936e-16         a0=0.5632573              la0=6.654819e-08
+ wa0=-2.654111e-07         pa0=-1.372255e-13         keta=-0.05200238
+ lketa=7.169009e-09        wketa=3.575234e-08        pketa=-5.816519e-15
+ a1=0                      a2=0.99                   ags=0.02
+ b0=0                      b1=0                      voff=-0.08734847
+ lvoff=-5.528529e-10       wvoff=-1.308841e-07       pvoff=2.862312e-14
+ nfactor=1                 cit=1.408297e-05          lcit=1.937458e-12
+ wcit=5.14631e-10          pcit=-2.171576e-16        cdsc=0
+ cdscb=0                   cdscd=0                   eta0=-1.0353073e-03
+ leta0=4.9673430e-10       weta0=1.4765083e-08       peta0=-5.4926110e-15
+ etab=0.001586302          letab=-7.017043e-10       dsub=0
+ pclm=0.6094105            lpclm=5.206348e-08        wpclm=8.637496e-08
+ ppclm=-8.545629e-15       pdiblc1=1e-06             pdiblc2=-0.005287672
+ lpdiblc2=2.339014e-09     pdiblcb=0.01              drout=0
+ pscbe1=3.5e+08            pscbe2=5e-07              pvag=0
+ delta=0.01                alpha0=0                  alpha1=1.0857
+ beta0=23.74               kt1=-0.2832858            lkt1=6.96172e-10
+ wkt1=6.857672e-07         pkt1=-2.203667e-13        kt2=-0.02031674
+ lkt2=-2.053089e-09        wkt2=1.694691e-08         pkt2=-4.987448e-15
+ at=-50000                 ute=-0.8439304            lute=-1.738578e-08
+ wute=8.030051e-07         pute=-1.238861e-13        ua1=1.752e-09
+ ub1=-2.179324e-18         lub1=2.771347e-26         wub1=5.107105e-25
+ pub1=-1.276796e-31        uc1=-4.301871e-11         luc1=8.997827e-18
+ wuc1=7.733619e-17         puc1=-1.423249e-23        kt1l=0
+ prt=0                     cj=cjp_25                 mj=0.3952264
+ pb=0.854899               cjsw=cjswp_25             mjsw=0.0450429
+ pbsw=0.854899             cjswg=cjswgp_25           mjswg=0.0450429
+ pbswg=0.854899            tpb=0.001603538           tpbsw=0.001603538
+ tpbswg=0.001603538        tcj=0.0009016089          tcjsw=0.0001793034
+ tcjswg=0.0001793034       js=2.0e-7                 jsw=1.36e-12
+ n=1                       xti=3                     cgdo=cgop_25
+ cgso=cgop_25              capmod=3                  nqsmod=0
+ xpart=1                   cf=0                      tlev=1
+ tlevc=1                   dlc=3.90e-8               cgbo=0
+ cgdl=cglp_25              cgsl=cglp_25              wwc=-1.20e-2
+ dwc=0                     noia=5.0e+19              noib=4.0e+3
+ noic=8.0e-12              em=4.1e+7                 ef=1.152
+ noimod=2                  sa0=0.35e-6               sb0=0.35e-6
+ kvsat=-1                  wlod=0.3e-6               tku0=0.03
+ ku0=8.5e-08               llodku0=1                 wlodku0=1
+ lku0=8.0e-09              wku0=6.0e-07              pku0=0
+ kvth0=1.0e-09             stk2=0                    steta0=-3e-10
+ lkvth0=-1.0e-10           wkvth0=0                  pkvth0=0
+ llodvth=1                 wlodvth=1                 lodk2=1
+ lodeta0=1                 minr=1e-3                 imax=0.01
+ imelt=0.01

     4: type=p
+ lmin=1.21e-06-(dxl_25+dlmis)                        lmax=2.1e-05
+ wmin=1.21e-06-(dxw_25+dwmis)                        wmax=1.001e-05-(dxw_25+dwmis)
+ tnom=25                   version=3.24              tox=(toxp_25+toxmis)
+ toxm=(toxp_25+toxmis)     xj=2.1e-07                nch=7.22e+17
+ lln=1                     lwn=1                     wln=1
+ wwn=-1                    lint=4.4e-08              wint=5e-09
+ mobmod=1                  binunit=2                 xl=-4e-08+(dxl_25+dlmis)
+ xw=1e-8+(dxw_25+dwmis)    dwg=0                     dwb=0
+ ldif=8e-08                hdif=hdifp_25             rsh=7.2
+ rd=0                      rs=0                      vth0=-0.5922534+(dvthp_25+vthmis)
+ lvth0=-9.883339e-09       wvth0=1.1564e-08          pvth0=9.071176e-15
+ k1=0.8575256              lk1=7.085931e-09          wk1=-2.540683e-08
+ pk1=-2.081279e-14         k2=-0.02769539            lk2=-4.377368e-09
+ wk2=-1.162411e-08         pk2=4.651531e-15          k3=0
+ dvt0=0                    dvt1=0                    dvt2=0
+ dvt0w=0                   dvt1w=0                   dvt2w=0
+ nlx=0                     w0=0                      k3b=0
+ vfb=-1.127317             vsat=153796.5             lvsat=-0.03805559
+ wvsat=-0.001658336        pvsat=1.668667e-08        ua=1.147473e-09
+ lua=-4.318336e-16         wua=5.169694e-16          pua=-6.130409e-22
+ ub=4.268081e-19           lub=8.35886e-25           wub=-4.492706e-25
+ pub=3.187007e-32          uc=-8.933044e-11          luc=9.463186e-17
+ wuc=-6.311084e-17         puc=-1.985492e-23         rdsw=784.6
+ prwb=0                    prwg=0                    wr=1
+ u0=0.01206673             lu0=7.395418e-10          wu0=-5.939101e-10
+ pu0=-2.867913e-15         a0=0.7233278              la0=-1.808745e-07
+ wa0=1.315347e-08          pa0=8.705841e-14          keta=0.00107581
+ lketa=-2.662966e-08       wketa=-1.412713e-09       pketa=1.385335e-14
+ a1=0                      a2=0.99                   ags=0.02
+ b0=0                      b1=0                      voff=-0.1011136
+ lvoff=-6.524667e-09       wvoff=-2.192446e-08       pvoff=1.553147e-14
+ nfactor=1                 cit=1.048439e-05          lcit=8.311773e-12
+ wcit=8.952415e-13         pcit=-1.035085e-17        cdsc=0
+ cdscb=0                   cdscd=0                   eta0=5e-05
+ etab=-5e-05               dsub=0                    pclm=0.7
+ pdiblc1=1e-06             pdiblc2=0.0001            pdiblcb=0.01
+ drout=0                   pscbe1=1.818512e+08       lpscbe1=181.937
+ wpscbe1=-0.05602397       ppscbe1=6.060409e-08      pscbe2=5e-07
+ pvag=0                    delta=0.01                alpha0=0
+ alpha1=1.0857             beta0=23.74               kt1=-0.2807457
+ lkt1=-1.005078e-08        wkt1=2.829763e-08         pkt1=2.182622e-14
+ kt2=-0.02625579           lkt2=-1.664142e-09        wkt2=-3.803102e-09
+ pkt2=2.619913e-15         at=-50000                 ute=-0.7465684
+ lute=-8.281842e-08        wute=-9.550956e-09        pute=1.274053e-13
+ ua1=1.752e-09             ub1=-2.026951e-18         lub1=4.385948e-26
+ wub1=-3.786033e-25        pub1=1.2194e-31           uc1=1.347552e-11
+ luc1=-4.228754e-18        wuc1=3.56234e-17          puc1=-2.757639e-23
+ kt1l=0                    prt=0                     cj=cjp_25
+ mj=0.3952264              pb=0.854899               cjsw=cjswp_25
+ mjsw=0.0450429            pbsw=0.854899             cjswg=cjswgp_25
+ mjswg=0.0450429           pbswg=0.854899            tpb=0.001603538
+ tpbsw=0.001603538         tpbswg=0.001603538        tcj=0.0009016089
+ tcjsw=0.0001793034        tcjswg=0.0001793034       js=2.0e-7
+ jsw=1.36e-12              n=1                       xti=3
+ cgdo=cgop_25              cgso=cgop_25              capmod=3
+ nqsmod=0                  xpart=1                   cf=0
+ tlev=1                    tlevc=1                   dlc=3.90e-8
+ cgbo=0                    cgdl=cglp_25              cgsl=cglp_25
+ wwc=-1.20e-2              dwc=0                     noia=5.0e+19
+ noib=4.0e+3               noic=8.0e-12              em=4.1e+7
+ ef=1.152                  noimod=2                  sa0=0.35e-6
+ sb0=0.35e-6               kvsat=-1                  wlod=0.3e-6
+ tku0=0.03                 ku0=8.5e-08               llodku0=1
+ wlodku0=1                 lku0=8.0e-09              wku0=6.0e-07
+ pku0=0                    kvth0=1.0e-09             stk2=0
+ steta0=-3e-10             lkvth0=-1.0e-10           wkvth0=0
+ pkvth0=0                  llodvth=1                 wlodvth=1
+ lodk2=1                   lodeta0=1                 minr=1e-3
+ imax=0.01                 imelt=0.01

     5: type=p
+ lmin=5.0e-07-(dxl_25+dlmis)                         lmax=1.21e-06-(dxl_25+dlmis)
+ wmin=1.21e-06-(dxw_25+dwmis)                        wmax=1.001e-05-(dxw_25+dwmis)
+ tnom=25                   version=3.24              tox=(toxp_25+toxmis)
+ toxm=(toxp_25+toxmis)     xj=2.1e-07                nch=7.22e+17
+ lln=1                     lwn=1                     wln=1
+ wwn=-1                    lint=4.4e-08              wint=5e-09
+ mobmod=1                  binunit=2                 xl=-4e-08+(dxl_25+dlmis)
+ xw=1e-8+(dxw_25+dwmis)    dwg=0                     dwb=0
+ ldif=8e-08                hdif=hdifp_25             rsh=7.2
+ rd=0                      rs=0                      vth0=-0.6129133+(dvthp_25+vthmis)
+ lvth0=1.247063e-08        wvth0=2.754078e-08        pvth0=-8.215706e-15
+ k1=0.8429049              lk1=2.290554e-08          wk1=-6.236289e-08
+ pk1=1.917367e-14          k2=-0.02060185            lk2=-1.205258e-08
+ wk2=-3.77261e-10          pk2=-7.517555e-15         k3=0
+ dvt0=0                    dvt1=0                    dvt2=0
+ dvt0w=0                   dvt1w=0                   dvt2w=0
+ nlx=0                     w0=0                      k3b=0
+ vfb=-1.202873             vsat=129103.9             lvsat=-0.01133815
+ wvsat=0.01376372          ua=1.015496e-09           lua=-2.890341e-16
+ wua=-9.443952e-17         pua=4.850352e-23          ub=1.167577e-18
+ lub=3.437394e-26          wub=-7.755197e-25         pub=3.848716e-31
+ uc=-2.296296e-11          luc=2.282225e-17          wuc=-1.123583e-16
+ puc=3.343085e-23          rdsw=784.6                prwb=0
+ prwg=0                    wr=1                      u0=0.01386882
+ lu0=-1.210321e-09         wu0=-4.118001e-09         pu0=9.451544e-16
+ a0=0.4799562              la0=8.245356e-08          wa0=2.623542e-07
+ pa0=-1.825767e-13         keta=-0.02015385          lketa=-3.659164e-09
+ wketa=2.119212e-08        pketa=-1.060508e-14       a1=0
+ a2=0.99                   ags=0.02                  b0=0
+ b1=0                      voff=-0.1149526           lvoff=8.449195e-09
+ wvoff=-1.133325e-09       pvoff=-6.964544e-15       nfactor=1
+ cit=2.131856e-05          lcit=-3.410794e-12        wcit=-1.445077e-11
+ pcit=6.253531e-18         cdsc=0                    cdscb=0
+ cdscd=0                   eta0=-8.098591e-05        leta0=1.417268e-10
+ etab=8.098591e-05         letab=-1.417268e-10       dsub=0
+ pclm=0.6708455            lpclm=3.154515e-08        wpclm=-2.92759e-10
+ ppclm=3.167668e-16        pdiblc1=1e-06             pdiblc2=-0.0003715492
+ lpdiblc2=5.102164e-10     pdiblcb=0.01              drout=0
+ pscbe1=3.5e+08            pscbe2=5e-07              pvag=0
+ delta=0.01                alpha0=0                  alpha1=1.0857
+ beta0=23.74               kt1=-0.2989441            lkt1=9.639789e-09
+ wkt1=6.890713e-08         pkt1=-2.211326e-14        kt2=-0.02924375
+ lkt2=1.568834e-09         wkt2=2.844058e-10         pkt2=-1.802771e-15
+ at=-50000                 ute=-0.8074903            lute=-1.690082e-08
+ wute=1.166002e-07         pute=-9.090245e-15        ua1=1.752e-09
+ ub1=-1.944364e-18         lub1=-4.54994e-26         wub1=-2.928843e-25
+ pub1=2.919198e-32         uc1=2.44614e-11           luc1=-1.611548e-17
+ wuc1=-5.176931e-18        puc1=1.656957e-23         kt1l=0
+ prt=0                     cj=cjp_25                 mj=0.3952264
+ pb=0.854899               cjsw=cjswp_25             mjsw=0.0450429
+ pbsw=0.854899             cjswg=cjswgp_25           mjswg=0.0450429
+ pbswg=0.854899            tpb=0.001603538           tpbsw=0.001603538
+ tpbswg=0.001603538        tcj=0.0009016089          tcjsw=0.0001793034
+ tcjswg=0.0001793034       js=2.0e-7                 jsw=1.36e-12
+ n=1                       xti=3                     cgdo=cgop_25
+ cgso=cgop_25              capmod=3                  nqsmod=0
+ xpart=1                   cf=0                      tlev=1
+ tlevc=1                   dlc=3.90e-8               cgbo=0
+ cgdl=cglp_25              cgsl=cglp_25              wwc=-1.20e-2
+ dwc=0                     noia=5.0e+19              noib=4.0e+3
+ noic=8.0e-12              em=4.1e+7                 ef=1.152
+ noimod=2                  sa0=0.35e-6               sb0=0.35e-6
+ kvsat=-1                  wlod=0.3e-6               tku0=0.03
+ ku0=8.5e-08               llodku0=1                 wlodku0=1
+ lku0=8.0e-09              wku0=6.0e-07              pku0=0
+ kvth0=1.0e-09             stk2=0                    steta0=-3e-10
+ lkvth0=-1.0e-10           wkvth0=0                  pkvth0=0
+ llodvth=1                 wlodvth=1                 lodk2=1
+ lodeta0=1                 minr=1e-3                 imax=0.01
+ imelt=0.01

     6: type=p
+ lmin=2.8e-07              lmax=5.0e-07-(dxl_25+dlmis)
+ wmin=1.21e-06-(dxw_25+dwmis)                        wmax=1.001e-05-(dxw_25+dwmis)
+ tnom=25                   version=3.24              tox=(toxp_25+toxmis)
+ toxm=(toxp_25+toxmis)     xj=2.1e-07                nch=7.22e+17
+ lln=1                     lwn=1                     wln=1
+ wwn=-1                    lint=4.4e-08              wint=5e-09
+ mobmod=1                  binunit=2                 xl=-4e-08+(dxl_25+dlmis)
+ xw=1e-8+(dxw_25+dwmis)    dwg=0                     dwb=0
+ ldif=8e-08                hdif=hdifp_25             rsh=7.2
+ rd=0                      rs=0                      vth0=-0.64129175+(dvthp_25+vthmis)
+ lvth0=2.3027418e-08       wvth0=1.9674751e-08       pvth0=-5.2895013e-15
+ k1=0.7562134              lk1=5.515479e-08          wk1=6.032497e-08
+ pk1=-2.646622e-14         k2=0.0499368              lk2=-3.829295e-08
+ wk2=-6.148596e-08         pk2=1.521488e-14          k3=0
+ dvt0=0                    dvt1=0                    dvt2=0
+ dvt0w=0                   dvt1w=0                   dvt2w=0
+ nlx=0                     w0=0                      k3b=0
+ vfb=-1.400653             vsat=98625.01             wvsat=0.01376373
+ ua=3.604407e-10           lua=-4.535359e-17         wua=6.245323e-17
+ pua=-9.8606e-24           ub=1.114336e-18           lub=5.417961e-26
+ wub=1.556058e-25          pub=3.849286e-32          uc=4.846232e-11
+ luc=-3.747956e-18         wuc=-5.543386e-17         puc=1.225494e-23
+ rdsw=784.6                prwb=0                    prwg=0
+ wr=1                      u0=0.01144613             lu0=-3.090805e-10
+ wu0=-1.206365e-09         pu0=-1.379744e-16         a0=0.5519273
+ la0=5.56803e-08           wa0=-1.519973e-07         pa0=-2.843797e-14
+ keta=-0.04863737          lketa=6.936704e-09        wketa=2.068658e-09
+ pketa=-3.491148e-15       a1=0                      a2=0.99
+ ags=0.02                  b0=0                      b1=0
+ voff=-0.0989763           lvoff=2.506003e-09        wvoff=-1.448955e-08
+ pvoff=-1.99603e-15        nfactor=1                 cit=7.246053e-05
+ lcit=-2.243561e-11        wcit=-6.972834e-11        pcit=2.681678e-17
+ cdsc=0                    cdscb=0                   cdscd=0
+ eta0=6.2043840e-04        leta0=-1.1920305e-10      weta0=-1.8089307e-09
+ peta0=6.7292220e-16       etab=0.001636668          letab=-7.204406e-10
+ wetab=-5.041685e-10       petab=1.875508e-16        dsub=0
+ pclm=0.6178901            lpclm=5.124457e-08        wpclm=1.495026e-09
+ ppclm=-3.482891e-16       pdiblc1=1e-06             pdiblc2=-0.005677225
+ lpdiblc2=2.483928e-09     wpdiblc2=3.899443e-09     ppdiblc2=-1.450593e-15
+ pdiblcb=0.01              drout=0                   pscbe1=3.5e+08
+ pscbe2=5e-07              pvag=0                    delta=0.01
+ alpha0=0                  alpha1=1.0857             beta0=23.74
+ kt1=-0.2076636            lkt1=-2.431654e-08        wkt1=-7.121064e-08
+ pkt1=3.001055e-14         kt2=-0.01723043           lkt2=-2.900122e-09
+ wkt2=-1.394708e-08        pkt2=3.491342e-15         at=-50000
+ ute=-0.763168             lute=-3.338875e-08        wute=-5.426509e-09
+ pute=3.63037e-14          ua1=1.752e-09             ub1=-2.122632e-18
+ lub1=2.081626e-26         wub1=-5.678085e-26        pub1=-5.863848e-32
+ uc1=-4.384848e-11         luc1=9.295796e-18         wuc1=8.56422e-17
+ puc1=-1.721515e-23        kt1l=0                    prt=0
+ cj=cjp_25                 mj=0.3952264              pb=0.854899
+ cjsw=cjswp_25             mjsw=0.0450429            pbsw=0.854899
+ cjswg=cjswgp_25           mjswg=0.0450429           pbswg=0.854899
+ tpb=0.001603538           tpbsw=0.001603538         tpbswg=0.001603538
+ tcj=0.0009016089          tcjsw=0.0001793034        tcjswg=0.0001793034
+ js=2.0e-7                 jsw=1.36e-12              n=1
+ xti=3                     cgdo=cgop_25              cgso=cgop_25
+ capmod=3                  nqsmod=0                  xpart=1
+ cf=0                      tlev=1                    tlevc=1
+ dlc=3.90e-8               cgbo=0                    cgdl=cglp_25
+ cgsl=cglp_25              wwc=-1.20e-2              dwc=0
+ noia=5.0e+19              noib=4.0e+3               noic=8.0e-12
+ em=4.1e+7                 ef=1.152                  noimod=2
+ sa0=0.35e-6               sb0=0.35e-6               kvsat=-1
+ wlod=0.3e-6               tku0=0.03                 ku0=8.5e-08
+ llodku0=1                 wlodku0=1                 lku0=8.0e-09
+ wku0=6.0e-07              pku0=0                    kvth0=1.0e-09
+ stk2=0                    steta0=-3e-10             lkvth0=-1.0e-10
+ wkvth0=0                  pkvth0=0                  llodvth=1
+ wlodvth=1                 lodk2=1                   lodeta0=1
+ minr=1e-3                 imax=0.01                 imelt=0.01

     7: type=p
+ lmin=1.21e-06-(dxl_25+dlmis)                        lmax=2.1e-05
+ wmin=6.0e-07-(dxw_25+dwmis)                         wmax=1.21e-06-(dxw_25+dwmis)
+ tnom=25                   version=3.24              tox=(toxp_25+toxmis)
+ toxm=(toxp_25+toxmis)     xj=2.1e-07                nch=7.22e+17
+ lln=1                     lwn=1                     wln=1
+ wwn=-1                    lint=4.4e-08              wint=5e-09
+ mobmod=1                  binunit=2                 xl=-4e-08+(dxl_25+dlmis)
+ xw=1e-8+(dxw_25+dwmis)    dwg=0                     dwb=0
+ ldif=8e-08                hdif=hdifp_25             rsh=7.2
+ rd=0                      rs=0                      vth0=-0.5992672+(dvthp_25+vthmis)
+ lvth0=-7.1468280e-09      wvth0=2.0050809e-08       pvth0=5.7599960e-15
+ k1=0.8393803              lk1=7.818752e-08          wk1=-3.450927e-09
+ pk1=-1.068457e-13         k2=-0.0232941             lk2=-2.852199e-08
+ wk2=-1.694966e-08         pk2=3.386652e-14          k3=0
+ dvt0=0                    dvt1=0                    dvt2=0
+ dvt0w=0                   dvt1w=0                   dvt2w=0
+ nlx=0                     w0=0                      k3b=0
+ vfb=-1.06531              vsat=1.5151247e+05        lvsat=-1.4868828e-02
+ wvsat=1.1053857e-03       pvsat=-1.1369312e-08      ua=1.593407e-09
+ lua=-1.699494e-15         wua=-2.26105e-17          pua=9.208276e-22
+ ub=8.789761e-20           lub=1.438693e-24          wub=-3.91891e-26
+ pub=-6.975265e-31         uc=-1.184087e-10          luc=1.21185e-16
+ wuc=-2.792616e-17         puc=-5.198425e-23         rdsw=784.6
+ prwb=0                    prwg=0                    wr=1
+ u0=1.2091756e-02          lu0=-2.2600737e-09        wu0=-6.2419320e-10
+ pu0=7.6162230e-16         a0=0.7575957              la0=-1.613768e-07
+ wa0=-2.831067e-08         pa0=6.346613e-14          keta=-0.008150994
+ lketa=-7.12548e-09        wketa=9.75172e-09         pketa=-9.746704e-15
+ a1=0                      a2=0.99                   ags=0.02
+ b0=0                      b1=0                      voff=-0.1091749
+ lvoff=1.926894e-08        wvoff=-1.21703e-08        pvoff=-1.56788e-14
+ nfactor=1                 cit=1.028907e-05          lcit=-3.700675e-12
+ wcit=1.131583e-12         pcit=4.184211e-18         cdsc=0
+ cdscb=0                   cdscd=0                   eta0=5e-05
+ etab=-5e-05               dsub=0                    pclm=0.7
+ pdiblc1=1e-06             pdiblc2=0.0001            pdiblcb=0.01
+ drout=0                   pscbe1=1.816656e+08       lpscbe1=182.1378
+ wpscbe1=0.1686224         ppscbe1=-1.824365e-07     pscbe2=5e-07
+ pvag=0                    delta=0.01                alpha0=0
+ alpha1=1.0857             beta0=23.74               kt1=-0.2650141
+ lkt1=3.060901e-08         wkt1=9.262272e-09         pkt1=-2.737213e-14
+ kt2=-0.02659608           lkt2=-9.365801e-10        wkt2=-3.391348e-09
+ pkt2=1.739564e-15         at=-50000                 ute=-0.7751827
+ lute=-3.3878e-08          wute=2.507235e-08         pute=6.818743e-14
+ ua1=1.752e-09             ub1=-2.199571e-18         lub1=1.941438e-25
+ wub1=-1.697329e-25        pub1=-5.990399e-32        uc1=2.047029e-11
+ luc1=-7.065085e-17        wuc1=2.715974e-17         puc1=5.279434e-23
+ kt1l=0                    prt=0                     cj=cjp_25
+ mj=0.3952264              pb=0.854899               cjsw=cjswp_25
+ mjsw=0.0450429            pbsw=0.854899             cjswg=cjswgp_25
+ mjswg=0.0450429           pbswg=0.854899            tpb=0.001603538
+ tpbsw=0.001603538         tpbswg=0.001603538        tcj=0.0009016089
+ tcjsw=0.0001793034        tcjswg=0.0001793034       js=2.0e-7
+ jsw=1.36e-12              n=1                       xti=3
+ cgdo=cgop_25              cgso=cgop_25              capmod=3
+ nqsmod=0                  xpart=1                   cf=0
+ tlev=1                    tlevc=1                   dlc=3.90e-8
+ cgbo=0                    cgdl=cglp_25              cgsl=cglp_25
+ wwc=-1.20e-2              dwc=0                     noia=5.0e+19
+ noib=4.0e+3               noic=8.0e-12              em=4.1e+7
+ ef=1.152                  noimod=2                  sa0=0.35e-6
+ sb0=0.35e-6               kvsat=-1                  wlod=0.3e-6
+ tku0=0.03                 ku0=8.5e-08               llodku0=1
+ wlodku0=1                 lku0=8.0e-09              wku0=6.0e-07
+ pku0=0                    kvth0=1.0e-09             stk2=0
+ steta0=-3e-10             lkvth0=-1.0e-10           wkvth0=0
+ pkvth0=0                  llodvth=1                 wlodvth=1
+ lodk2=1                   lodeta0=1                 minr=1e-3
+ imax=0.01                 imelt=0.01

     8: type=p
+ lmin=5.0e-07-(dxl_25+dlmis)                         lmax=1.21e-06-(dxl_25+dlmis)
+ wmin=6.0e-07-(dxw_25+dwmis)                         wmax=1.21e-06-(dxw_25+dwmis)
+ tnom=25                   version=3.24              tox=(toxp_25+toxmis)
+ toxm=(toxp_25+toxmis)     xj=2.1e-07                nch=7.22e+17
+ lln=1                     lwn=1                     wln=1
+ wwn=-1                    lint=4.4e-08              wint=5e-09
+ mobmod=1                  binunit=2                 xl=-4e-08+(dxl_25+dlmis)
+ xw=1e-8+(dxw_25+dwmis)    dwg=0                     dwb=0
+ ldif=8e-08                hdif=hdifp_25             rsh=7.2
+ rd=0                      rs=0                      vth0=-0.6085479+(dvthp_25+vthmis)
+ lvth0=2.8947529e-09       wvth0=2.2258657e-08       pvth0=3.3711050e-15
+ k1=0.8795801              lk1=3.469126e-08          wk1=-1.067399e-07
+ pk1=4.912946e-15          k2=-0.03444811            lk2=-1.645334e-08
+ wk2=1.637671e-08          pk2=-2.192623e-15         k3=0
+ dvt0=0                    dvt1=0                    dvt2=0
+ dvt0w=0                   dvt1w=0                   dvt2w=0
+ nlx=0                     w0=0                      k3b=0
+ vfb=-1.151843             vsat=1.4974394e+05        lvsat=-1.2955281e-02
+ wvsat=-1.1210743e-02      pvsat=1.9567394e-09       ua=1.370687e-10
+ lua=-1.237355e-16         wua=9.684573e-16          pua=-1.515078e-22
+ ub=1.175233e-18           lub=2.621967e-25          wub=-7.847829e-25
+ pub=1.09206e-31           uc=-4.802621e-11          luc=4.503118e-17
+ wuc=-8.203179e-17         puc=6.558037e-24          rdsw=784.6
+ prwb=0                    prwg=0                    wr=1
+ u0=1.0040139e-02          lu0=-4.0224790e-11        wu0=5.1470170e-10
+ pu0=-4.7066220e-16        a0=0.6512433              la0=-4.630351e-08
+ wa0=5.509672e-08          pa0=-2.678067e-14         keta=-0.0006901813
+ lketa=-1.519808e-08       wketa=-2.35892e-09        pketa=3.357009e-15
+ a1=0                      a2=0.99                   ags=0.02
+ b0=0                      b1=0                      voff=-0.09068604
+ lvoff=-7.359535e-10       wvoff=-3.049589e-08       pvoff=4.149486e-15
+ nfactor=1                 cit=1.585603e-06          lcit=5.716471e-12
+ wcit=9.426105e-12         pcit=-4.790461e-18        cdsc=0
+ cdscb=0                   cdscd=0                   eta0=-8.098595e-05
+ leta0=1.417268e-10        etab=8.098595e-05         letab=-1.417268e-10
+ dsub=0                    pclm=0.6707457            lpclm=3.165309e-08
+ wpclm=-1.7205e-10         ppclm=1.861598e-16        pdiblc1=1e-06
+ pdiblc2=-0.0003715493     lpdiblc2=5.102163e-10     pdiblcb=0.01
+ drout=0                   pscbe1=3.5e+08            pscbe2=5e-07
+ pvag=0                    delta=0.01                alpha0=0
+ alpha1=1.0857             beta0=23.74               kt1=-0.2293664
+ lkt1=-7.96175e-09         wkt1=-1.528183e-08        pkt1=-8.153993e-16
+ kt2=-0.02929149           lkt2=1.979855e-09         wkt2=3.421735e-10
+ pkt2=-2.300107e-15        at=-50000                 ute=-0.786118
+ lute=-2.204596e-08        wute=9.073968e-08         pute=-2.864625e-15
+ ua1=1.752e-09             ub1=-2.144477e-18         lub1=1.345319e-25
+ wub1=-5.074789e-26        pub1=-1.886458e-31        uc1=-5.920235e-11
+ luc1=1.555495e-17         wuc1=9.605621e-17         puc1=-2.175166e-23
+ kt1l=0                    prt=0                     cj=cjp_25
+ mj=0.3952264              pb=0.854899               cjsw=cjswp_25
+ mjsw=0.0450429            pbsw=0.854899             cjswg=cjswgp_25
+ mjswg=0.0450429           pbswg=0.854899            tpb=0.001603538
+ tpbsw=0.001603538         tpbswg=0.001603538        tcj=0.0009016089
+ tcjsw=0.0001793034        tcjswg=0.0001793034       js=2.0e-7
+ jsw=1.36e-12              n=1                       xti=3
+ cgdo=cgop_25              cgso=cgop_25              capmod=3
+ nqsmod=0                  xpart=1                   cf=0
+ tlev=1                    tlevc=1                   dlc=3.90e-8
+ cgbo=0                    cgdl=cglp_25              cgsl=cglp_25
+ wwc=-1.20e-2              dwc=0                     noia=5.0e+19
+ noib=4.0e+3               noic=8.0e-12              em=4.1e+7
+ ef=1.152                  noimod=2                  sa0=0.35e-6
+ sb0=0.35e-6               kvsat=-1                  wlod=0.3e-6
+ tku0=0.03                 ku0=8.5e-08               llodku0=1
+ wlodku0=1                 lku0=8.0e-09              wku0=6.0e-07
+ pku0=0                    kvth0=1.0e-09             stk2=0
+ steta0=-3e-10             lkvth0=-1.0e-10           wkvth0=0
+ pkvth0=0                  llodvth=1                 wlodvth=1
+ lodk2=1                   lodeta0=1                 minr=1e-3
+ imax=0.01                 imelt=0.01

     9: type=p
+ lmin=2.8e-07              lmax=5.0e-07-(dxl_25+dlmis)
+ wmin=6.0e-07-(dxw_25+dwmis)                         wmax=1.21e-06-(dxw_25+dwmis)
+ tnom=25                   version=3.24              tox=(toxp_25+toxmis)
+ toxm=(toxp_25+toxmis)     xj=2.1e-07                nch=7.22e+17
+ lln=1                     lwn=1                     wln=1
+ wwn=-1                    lint=4.4e-08              wint=5e-09
+ mobmod=1                  binunit=2                 xl=-4e-08+(dxl_25+dlmis)
+ xw=1e-8+(dxw_25+dwmis)    dwg=0                     dwb=0
+ ldif=8e-08                hdif=hdifp_25             rsh=7.2
+ rd=0                      rs=0                      vth0=-0.6618531+(dvthp_25+vthmis)
+ lvth0=2.3456141e-08       wvth0=4.4553986e-08       pvth0=-5.8082559e-15
+ k1=0.8808538              lk1=3.421746e-08          wk1=-9.048988e-08
+ pk1=-1.132059e-15         k2=-0.006057074           lk2=-2.70148e-08
+ wk2=6.266628e-09          pk2=1.568326e-15          k3=0
+ dvt0=0                    dvt1=0                    dvt2=0
+ dvt0w=0                   dvt1w=0                   dvt2w=0
+ nlx=0                     w0=0                      k3b=0
+ vfb=-1.324404             vsat=1.1491786e+05        wvsat=-5.9506270e-03
+ ua=-8.698593e-11          lua=-4.038723e-17         wua=6.038394e-16
+ pua=-1.586989e-23         ub=1.78987e-18            lub=3.355171e-26
+ wub=-6.617899e-25         pub=6.345261e-32          uc=7.120311e-11
+ luc=6.778718e-19          wuc=-8.295021e-17         puc=6.899692e-24
+ rdsw=784.6                prwb=0                    prwg=0
+ wr=1                      u0=1.1040227e-02          lu0=-4.1225770e-10
+ wu0=-7.1522370e-10        pu0=-1.3130011e-17        a0=0.1588304
+ la0=1.368741e-07          wa0=3.236498e-07          pa0=-1.266824e-13
+ keta=-0.06285268          lketa=7.92637e-09         wketa=1.926918e-08
+ pketa=-4.688643e-15       a1=0                      a2=0.99
+ ags=0.02                  b0=0                      b1=0
+ voff=-0.09780298          lvoff=1.911548e-09        wvoff=-1.590926e-08
+ pvoff=-1.276739e-15       nfactor=1                 cit=1.980478e-05
+ lcit=-1.061061e-12        wcit=-6.014867e-12        pcit=9.535804e-19
+ cdsc=0                    cdscb=0                   cdscd=0
+ eta0=-0.0009974771        leta0=4.826614e-10        weta0=1.48747e-10
+ peta0=-5.53338e-17        etab=0.001379087          letab=-6.246204e-10
+ wetab=-1.924957e-10       petab=7.16084e-17         dsub=0
+ pclm=0.6065102            lpclm=5.554868e-08        wpclm=1.526458e-08
+ ppclm=-5.556266e-15       pdiblc1=1e-06             pdiblc2=-0.002816108
+ lpdiblc2=1.419592e-09     wpdiblc2=4.374904e-10     ppdiblc2=-1.627465e-16
+ pdiblcb=0.01              drout=0                   pscbe1=3.5e+08
+ pscbe2=5e-07              pvag=0                    delta=0.01
+ alpha0=0                  alpha1=1.0857             beta0=23.74
+ kt1=-0.2405469            lkt1=-3.802616e-09        wkt1=-3.14219e-08
+ pkt1=5.188704e-15         kt2=-0.02485369           lkt2=3.289922e-10
+ wkt2=-4.722938e-09        pkt2=-4.158854e-16        at=-50000
+ ute=-0.8233667            lute=-8.189443e-09        wute=6.741398e-08
+ pute=5.812532e-15         ua1=1.752e-09             ub1=-1.763057e-18
+ lub1=-7.356183e-27        wub1=-4.918662e-25        pub1=-2.454983e-32
+ uc1=-1.931131e-11         luc1=7.154812e-19         wuc1=5.595222e-17
+ puc1=-6.83297e-24         kt1l=0                    prt=0
+ cj=cjp_25                 mj=0.3952264              pb=0.854899
+ cjsw=cjswp_25             mjsw=0.0450429            pbsw=0.854899
+ cjswg=cjswgp_25           mjswg=0.0450429           pbswg=0.854899
+ tpb=0.001603538           tpbsw=0.001603538         tpbswg=0.001603538
+ tcj=0.0009016089          tcjsw=0.0001793034        tcjswg=0.0001793034
+ js=2.0e-7                 jsw=1.36e-12              n=1
+ xti=3                     cgdo=cgop_25              cgso=cgop_25
+ capmod=3                  nqsmod=0                  xpart=1
+ cf=0                      tlev=1                    tlevc=1
+ dlc=3.90e-8               cgbo=0                    cgdl=cglp_25
+ cgsl=cglp_25              wwc=-1.20e-2              dwc=0
+ noia=5.0e+19              noib=4.0e+3               noic=8.0e-12
+ em=4.1e+7                 ef=1.152                  noimod=2
+ sa0=0.35e-6               sb0=0.35e-6               kvsat=-1
+ wlod=0.3e-6               tku0=0.03                 ku0=8.5e-08
+ llodku0=1                 wlodku0=1                 lku0=8.0e-09
+ wku0=6.0e-07              pku0=0                    kvth0=1.0e-09
+ stk2=0                    steta0=-3e-10             lkvth0=-1.0e-10
+ wkvth0=0                  pkvth0=0                  llodvth=1
+ wlodvth=1                 lodk2=1                   lodeta0=1
+ minr=1e-3                 imax=0.01                 imelt=0.01

     10: type=p
+ lmin=1.21e-06-(dxl_25+dlmis)                        lmax=2.1e-05
+ wmin=1.5e-07              wmax=6.0e-07-(dxw_25+dwmis)
+ tnom=25                   version=3.24              tox=(toxp_25+toxmis)
+ toxm=(toxp_25+toxmis)     xj=2.1e-07                nch=7.22e+17
+ lln=1                     lwn=1                     wln=1
+ wwn=-1                    lint=4.4e-08              wint=5e-09
+ mobmod=1                  binunit=2                 xl=-4e-08+(dxl_25+dlmis)
+ xw=1e-8+(dxw_25+dwmis)    dwg=0                     dwb=0
+ ldif=8e-08                hdif=hdifp_25             rsh=7.2
+ rd=0                      rs=0                      vth0=-0.5822442+(dvthp_25+vthmis)
+ lvth0=-1.3901569e-08      wvth0=9.8369660e-09       pvth0=9.8128400e-15
+ k1=0.8588101              lk1=-1.478419e-07         wk1=-1.510885e-08
+ pk1=2.87719e-14           k2=-0.04672182            lk2=4.641428e-08
+ wk2=-2.893036e-09         pk2=-1.109524e-14         k3=0
+ dvt0=0                    dvt1=0                    dvt2=0
+ dvt0w=0                   dvt1w=0                   dvt2w=0
+ nlx=0                     w0=0                      k3b=0
+ vfb=-1.229329             vsat=1.5388923e+05        lvsat=-3.9194710e-02
+ wvsat=-3.2067080e-04      pvsat=3.2262190e-09       ua=1.821198e-09
+ lua=-3.390816e-16         wua=-1.592852e-16         pua=1.045803e-22
+ ub=1.202239e-20           lub=3.826391e-25          wub=6.3361e-27
+ pub=-6.389405e-32         uc=-1.786856e-10          luc=4.024007e-17
+ wuc=8.239978e-18          puc=-3.417275e-24         rdsw=784.6
+ prwb=0                    prwg=0                    wr=1
+ u0=1.1218031e-02          lu0=-6.5310430e-10        wu0=-9.9958720e-11
+ pu0=-2.0255927e-16        a0=0.7173448              la0=-1.817097e-08
+ wa0=-4.160105e-09         pa0=-2.245737e-14         keta=0.01096282
+ lketa=-2.374728e-08       wketa=-1.716568e-09       pketa=2.263752e-16
+ a1=0                      a2=0.99                   ags=0.02
+ b0=0                      b1=0                      voff=-0.1297886
+ lvoff=-1.65654e-08        wvoff=1.979572e-10        pvoff=5.821803e-15
+ nfactor=1                 cit=1.137104e-05          lcit=4.013152e-12
+ wcit=4.823971e-13         pcit=-4.440848e-19        cdsc=0
+ cdscb=0                   cdscd=0                   eta0=5e-05
+ etab=-5e-05               dsub=0                    pclm=0.7
+ pdiblc1=1e-06             pdiblc2=0.0001            pdiblcb=0.01
+ drout=0                   pscbe1=1.819284e+08       lpscbe1=181.8536
+ wpscbe1=0.01095944        ppscbe1=-1.186081e-08     pscbe2=5e-07
+ pvag=0                    delta=0.01                alpha0=0
+ alpha1=1.0857             beta0=23.74               kt1=-0.2577438
+ lkt1=-2.52964e-08         wkt1=4.900084e-09         pkt1=6.17112e-15
+ kt2=-0.03612149           lkt2=6.632142e-09         wkt2=2.323896e-09
+ pkt2=-2.801668e-15        at=-50000                 ute=-0.7377433
+ lute=1.389509e-07         wute=2.608704e-09         pute=-3.550993e-14
+ ua1=1.752e-09             ub1=-2.531863e-18         lub1=3.099194e-25
+ wub1=2.964251e-26         pub1=-1.293694e-31        uc1=8.485323e-11
+ luc1=3.375146e-17         wuc1=-1.147003e-17        puc1=-9.847045e-24
+ kt1l=0                    prt=0                     cj=cjp_25
+ mj=0.3952264              pb=0.854899               cjsw=cjswp_25
+ mjsw=0.0450429            pbsw=0.854899             cjswg=cjswgp_25
+ mjswg=0.0450429           pbswg=0.854899            tpb=0.001603538
+ tpbsw=0.001603538         tpbswg=0.001603538        tcj=0.0009016089
+ tcjsw=0.0001793034        tcjswg=0.0001793034       js=2.0e-7
+ jsw=1.36e-12              n=1                       xti=3
+ cgdo=cgop_25              cgso=cgop_25              capmod=3
+ nqsmod=0                  xpart=1                   cf=0
+ tlev=1                    tlevc=1                   dlc=3.90e-8
+ cgbo=0                    cgdl=cglp_25              cgsl=cglp_25
+ wwc=-1.20e-2              dwc=0                     noia=5.0e+19
+ noib=4.0e+3               noic=8.0e-12              em=4.1e+7
+ ef=1.152                  noimod=2                  sa0=0.35e-6
+ sb0=0.35e-6               kvsat=-1                  wlod=0.3e-6
+ tku0=0.03                 ku0=8.5e-08               llodku0=1
+ wlodku0=1                 lku0=8.0e-09              wku0=6.0e-07
+ pku0=0                    kvth0=1.0e-09             stk2=0
+ steta0=-3e-10             lkvth0=-1.0e-10           wkvth0=0
+ pkvth0=0                  llodvth=1                 wlodvth=1
+ lodk2=1                   lodeta0=1                 minr=1e-3
+ imax=0.01                 imelt=0.01

     11: type=p
+ lmin=5.0e-07-(dxl_25+dlmis)                         lmax=1.21e-06-(dxl_25+dlmis)
+ wmin=1.5e-07              wmax=6.0e-07-(dxw_25+dwmis)
+ tnom=25                   version=3.24              tox=(toxp_25+toxmis)
+ toxm=(toxp_25+toxmis)     xj=2.1e-07                nch=7.22e+17
+ lln=1                     lwn=1                     wln=1
+ wwn=-1                    lint=4.4e-08              wint=5e-09
+ mobmod=1                  binunit=2                 xl=-4e-08+(dxl_25+dlmis)
+ xw=1e-8+(dxw_25+dwmis)    dwg=0                     dwb=0
+ ldif=8e-08                hdif=hdifp_25             rsh=7.2
+ rd=0                      rs=0                      vth0=-0.6059947+(dvthp_25+vthmis)
+ lvth0=1.1796470e-08       wvth0=2.0726768e-08       pvth0=-1.9699253e-15
+ k1=0.6738556              lk1=5.227895e-08          wk1=1.669482e-08
+ pk1=-5.639661e-15         k2=0.01812115             lk2=-2.374582e-08
+ wk2=-1.516484e-08         pk2=2.182861e-15          k3=0
+ dvt0=0                    dvt1=0                    dvt2=0
+ dvt0w=0                   dvt1w=0                   dvt2w=0
+ nlx=0                     w0=0                      k3b=0
+ vfb=-1.244404             vsat=1.2695915e+05        lvsat=-1.0056363e-02
+ wvsat=2.4601333e-03       pvsat=2.1738845e-10       ua=1.939733e-09
+ lua=-4.673357e-16         wua=-1.131411e-16         pua=5.465237e-23
+ ub=-1.526672e-19          lub=5.608332e-25          wub=1.195696e-26
+ pub=-6.997582e-32         uc=-2.026721e-10          luc=6.619349e-17
+ wuc=1.075575e-17          puc=-6.139345e-24         rdsw=784.6
+ prwb=0                    prwg=0                    wr=1
+ u0=1.1691454e-02          lu0=-1.1653492e-09        wu0=-4.7608780e-10
+ pu0=2.0441236e-16         a0=0.8292131              la0=-1.392126e-07
+ wa0=-5.168518e-08         pa0=2.896476e-14          keta=-0.0008486817
+ lketa=-1.096723e-08       wketa=-2.263821e-09       pketa=8.185024e-16
+ a1=0                      a2=0.99                   ags=0.02
+ b0=0                      b1=0                      voff=-0.152226
+ lvoff=7.711882e-09        wvoff=6.428103e-09        pvoff=-9.192155e-16
+ nfactor=1                 cit=1.691091e-05          lcit=-1.980986e-12
+ wcit=2.309198e-13         pcit=-1.719862e-19        cdsc=0
+ cdscb=0                   cdscd=0                   eta0=-8.098591e-05
+ leta0=1.417268e-10        etab=8.098591e-05         letab=-1.417268e-10
+ dsub=0                    pclm=0.6692098            lpclm=3.331502e-08
+ wpclm=7.495375e-10        ppclm=-8.110006e-16       pdiblc1=1e-06
+ pdiblc2=-0.0003715494     lpdiblc2=5.102165e-10     pdiblcb=0.01
+ drout=0                   pscbe1=3.5e+08            pscbe2=5e-07
+ pvag=0                    delta=0.01                alpha0=0
+ alpha1=1.0857             beta0=23.74               kt1=-0.27201
+ lkt1=-9.860273e-09        wkt1=1.030434e-08         pkt1=3.237147e-16
+ kt2=-0.02761026           lkt2=-2.577006e-09        wkt2=-6.665638e-10
+ pkt2=4.340095e-16         at=-50000                 ute=-0.5643566
+ lute=-4.86535e-08         wute=-4.23172e-08         pute=1.30999e-14
+ ua1=1.752e-09             ub1=-1.985564e-18         lub1=-2.811768e-25
+ wub1=-1.460956e-25        pub1=6.077933e-32         uc1=1.382096e-10
+ luc1=-2.398011e-17        wuc1=-2.239094e-17        puc1=1.969378e-24
+ kt1l=0                    prt=0                     cj=cjp_25
+ mj=0.3952264              pb=0.854899               cjsw=cjswp_25
+ mjsw=0.0450429            pbsw=0.854899             cjswg=cjswgp_25
+ mjswg=0.0450429           pbswg=0.854899            tpb=0.001603538
+ tpbsw=0.001603538         tpbswg=0.001603538        tcj=0.0009016089
+ tcjsw=0.0001793034        tcjswg=0.0001793034       js=2.0e-7
+ jsw=1.36e-12              n=1                       xti=3
+ cgdo=cgop_25              cgso=cgop_25              capmod=3
+ nqsmod=0                  xpart=1                   cf=0
+ tlev=1                    tlevc=1                   dlc=3.90e-8
+ cgbo=0                    cgdl=cglp_25              cgsl=cglp_25
+ wwc=-1.20e-2              dwc=0                     noia=5.0e+19
+ noib=4.0e+3               noic=8.0e-12              em=4.1e+7
+ ef=1.152                  noimod=2                  sa0=0.35e-6
+ sb0=0.35e-6               kvsat=-1                  wlod=0.3e-6
+ tku0=0.03                 ku0=8.5e-08               llodku0=1
+ wlodku0=1                 lku0=8.0e-09              wku0=6.0e-07
+ pku0=0                    kvth0=1.0e-09             stk2=0
+ steta0=-3e-10             lkvth0=-1.0e-10           wkvth0=0
+ pkvth0=0                  llodvth=1                 wlodvth=1
+ lodk2=1                   lodeta0=1                 minr=1e-3
+ imax=0.01                 imelt=0.01

     12: type=p
+ lmin=2.8e-07              lmax=5.0e-07-(dxl_25+dlmis)
+ wmin=1.5e-07              wmax=6.0e-07-(dxw_25+dwmis)
+ tnom=25                   version=3.24              tox=(toxp_25+toxmis)
+ toxm=(toxp_25+toxmis)     xj=2.1e-07                nch=7.22e+17
+ lln=1                     lwn=1                     wln=1
+ wwn=-1                    lint=4.4e-08              wint=5e-09
+ mobmod=1                  binunit=2                 xl=-4e-08+(dxl_25+dlmis)
+ xw=1e-8+(dxw_25+dwmis)    dwg=0                     dwb=0
+ ldif=8e-08                hdif=hdifp_25             rsh=7.2
+ rd=0                      rs=0                      vth0=-0.61217043+(dvthp_25+vthmis)
+ lvth0=1.3349838e-08       wvth0=1.4744382e-08       pvth0=2.5552593e-16
+ k1=0.7259418              lk1=3.290288e-08          wk1=2.457303e-09
+ pk1=-3.433049e-16         k2=0.02400170             lk2=-2.593338e-08
+ wk2=-1.176864e-08         pk2=9.194731e-16          k3=0
+ dvt0=0                    dvt1=0                    dvt2=0
+ dvt0w=0                   dvt1w=0                   dvt2w=0
+ nlx=0                     w0=0                      k3b=0
+ vfb=-1.439723             vsat=9.9611800e+04        lvsat=1.1685117e-04
+ wvsat=3.2330090e-03       pvsat=-7.0121480e-11      ua=9.700846e-10
+ lua=-1.066267e-16         wua=-3.040293e-17         pua=2.387378e-23
+ ub=8.979358e-19           lub=1.700088e-25          wub=-1.266295e-25
+ pub=-1.842165e-32         uc=-5.274278e-11          luc=1.041977e-17
+ wuc=-8.582675e-18         puc=1.054551e-24          rdsw=784.6
+ prwb=0                    prwg=0                    wr=1
+ u0=9.8469040e-03          lu0=-4.7917640e-10        wu0=7.7022720e-13
+ pu0=2.7021186e-17         a0=0.6900988              la0=-8.746201e-08
+ wa0=4.888815e-09          pa0=7.919232e-15          keta=-0.02848965
+ lketa=-6.847915e-10       wketa=-1.348636e-09       pketa=4.780536e-16
+ a1=0                      a2=0.99                   ags=0.02
+ b0=0                      b1=0                      voff=-0.1339684
+ lvoff=9.200603e-10        wvoff=5.790014e-09        pvoff=-6.818463e-16
+ nfactor=1                 cit=1.105695e-05          lcit=1.966859e-13
+ wcit=-7.661731e-13        pcit=1.989324e-19         cdsc=0
+ cdscb=0                   cdscd=0                   eta0=-0.000701363
+ leta0=3.72507e-10         weta0=-2.89215e-11        peta0=1.07588e-17
+ etab=0.0009958814         letab=-4.820678e-10       wetab=3.742779e-11
+ petab=-1.392315e-17       dsub=0                    pclm=0.6395858
+ lpclm=4.433514e-08        wpclm=-4.580718e-09       ppclm=1.171856e-15
+ pdiblc1=1e-06             pdiblc2=-0.001945184      lpdiblc2=1.095609e-09
+ wpdiblc2=-8.506322e-11    ppdiblc2=3.164351e-17     pdiblcb=0.01
+ drout=0                   pscbe1=3.5e+08            pscbe2=5e-07
+ pvag=0                    delta=0.01                alpha0=0
+ alpha1=1.0857             beta0=23.74               kt1=-0.3210307
+ lkt1=8.375411e-09         wkt1=1.686839e-08         pkt1=-2.118113e-15
+ kt2=-0.03151336           lkt2=-1.125054e-09        wkt2=-7.271351e-10
+ pkt2=4.56542e-16          at=-50000                 ute=-0.6865135
+ lute=-3.211138e-09        wute=-1.469798e-08        pute=2.82555e-15
+ ua1=1.752e-09             ub1=-2.588637e-18         lub1=-5.683356e-26
+ wub1=3.481583e-27         pub1=5.136597e-33         uc1=1.077026e-10
+ luc1=-1.263152e-17        wuc1=-2.025615e-17        puc1=1.175233e-24
+ kt1l=0                    prt=0                     cj=cjp_25
+ mj=0.3952264              pb=0.854899               cjsw=cjswp_25
+ mjsw=0.0450429            pbsw=0.854899             cjswg=cjswgp_25
+ mjswg=0.0450429           pbswg=0.854899            tpb=0.001603538
+ tpbsw=0.001603538         tpbswg=0.001603538        tcj=0.0009016089
+ tcjsw=0.0001793034        tcjswg=0.0001793034       js=2.0e-7
+ jsw=1.36e-12              n=1                       xti=3
+ cgdo=cgop_25              cgso=cgop_25              capmod=3
+ nqsmod=0                  xpart=1                   cf=0
+ tlev=1                    tlevc=1                   dlc=3.90e-8
+ cgbo=0                    cgdl=cglp_25              cgsl=cglp_25
+ wwc=-1.20e-2              dwc=0                     noia=5.0e+19
+ noib=4.0e+3               noic=8.0e-12              em=4.1e+7
+ ef=1.152                  noimod=2                  sa0=0.35e-6
+ sb0=0.35e-6               kvsat=-1                  wlod=0.3e-6
+ tku0=0.03                 ku0=8.5e-08               llodku0=1
+ wlodku0=1                 lku0=8.0e-09              wku0=6.0e-07
+ pku0=0                    kvth0=1.0e-09             stk2=0
+ steta0=-3e-10             lkvth0=-1.0e-10           wkvth0=0
+ pkvth0=0                  llodvth=1                 wlodvth=1
+ lodk2=1                   lodeta0=1                 minr=1e-3
+ imax=0.01                 imelt=0.01
//
//
     }
ends pch_25_mis

// **************************************************************
//                                                              *
//              2.5V NMOS DEVICES MODEL                         *
//                                                              *
// **************************************************************
model nch_25 bsim3v3  {
     1: type=n
+ lmin=1.20e-06-dxl_25      lmax=2.10e-05             wmin=1.001e-05-dxw_25
+ wmax=0.0009001            tnom=25                   version=3.24
+ tox=toxn_25               toxm=toxn_25              xj=1.9e-07
+ nch=3.28e+17              lln=1                     lwn=1
+ wln=1                     wwn=-1                    lint=3.1e-08
+ wint=1.95e-08             mobmod=1                  binunit=2
+ xl=-4e-08+dxl_25          xw=1e-8+dxw_25            dwg=0
+ dwb=0                     ldif=8e-08                hdif=hdifn_25
+ rsh=6.6                   rd=0                      rs=0
+ vth0=0.5462298+dvthn_25   lvth0=3.791434e-08+dlvthn_25
+ wvth0=5.574453e-08+dwvthn_25                        pvth0=-3.6853e-14+dpvthn_25
+ k1=0.55801                lk1=-2.344909e-09         wk1=4.097137e-08
+ pk1=-4.498656e-14         k2=-0.001893228+dk2n_25   lk2=-8.895973e-09+dlk2n_25
+ wk2=-9.171656e-09         pk2=1.007047e-14          k3=0
+ dvt0=0                    dvt1=0                    dvt2=0
+ dvt0w=0                   dvt1w=0                   dvt2w=0
+ nlx=0                     w0=0                      k3b=0
+ vfb=-0.8166977            vsat=101225.9             lvsat=-0.01232605+dlvsatn_25
+ wvsat=9.056558e-05        pvsat=-9.944839e-11       ua=-6.255406e-10
+ lua=-1.94116e-16          wua=-1.460773e-16         pua=2.331054e-21
+ ub=2.037894e-18           lub=-5.933173e-26         wub=-1.27836e-24
+ pub=-3.920999e-31         uc=6.14423e-11            luc=-9.532507e-18
+ wuc=-9.63961e-17          puc=1.150034e-22          rdsw=325.9
+ prwb=0                    prwg=0                    wr=1
+ u0=0.03828657             lu0=-5.822331e-09         wu0=-1.807987e-08
+ pu0=4.028212e-14          a0=0.5340004              la0=-1.048441e-07
+ wa0=2.945578e-07          pa0=-3.234229e-13         keta=0.009165752
+ lketa=-2.935073e-08       wketa=-5.500693e-08       pketa=6.03976e-14
+ a1=0                      a2=0.99                   ags=0.02
+ b0=0                      b1=0                      voff=-0.115974
+ lvoff=1.674896e-09        wvoff=-1.086672e-07       pvoff=5.845006e-14
+ nfactor=1                 cit=0.0002238203          lcit=-1.013128e-10
+ wcit=-1.5565e-09          pcit=1.709037e-15         cdsc=0
+ cdscb=0                   cdscd=0                   eta0=5e-05
+ etab=-5e-05               dsub=0                    pclm=0.7
+ pdiblc1=1e-06             pdiblc2=0.0005096363      lpdiblc2=4.930418e-09
+ wpdiblc2=-3.626117e-11    ppdiblc2=3.981404e-17     pdiblcb=0.01
+ drout=0                   pscbe1=1.816114e+08       lpscbe1=184.8907
+ wpscbe1=-1.359819         ppscbe1=1.493218e-06      pscbe2=1e-06
+ pvag=0                    delta=0.01                alpha0=0
+ alpha1=0.7997             beta0=14.401              kt1=-0.290201
+ lkt1=1.016254e-08         wkt1=-1.98575e-08         pkt1=-2.38813e-14
+ kt2=-0.02944941           lkt2=2.289216e-09         wkt2=-3.879695e-10
+ pkt2=-5.869811e-15        at=10000                  ute=-1.584248
+ lute=1.529864e-07         wute=3.570072e-07         pute=-6.114151e-13
+ ua1=1.743e-09             ub1=-2.376207e-18         lub1=3.369821e-25
+ wub1=4.239915e-25         pub1=-7.625448e-31        uc1=-6.18781e-11
+ luc1=2.893467e-17         wuc1=-2.601357e-17        puc1=-3.302829e-23
+ kt1l=0                    prt=0                     cj=cjn_25
+ mj=0.3193271              pb=0.7249372              cjsw=cjswn_25
+ mjsw=0.01                 pbsw=0.7249372            cjswg=cjswgn_25
+ mjswg=0.01                pbswg=0.7249372           tpb=0.001816363
+ tpbsw=0.001816363         tpbswg=0.001816363        tcj=0.001010853
+ tcjsw=9.297595e-05        tcjswg=9.297595e-05       js=4.03e-7
+ jsw=1.8e-12               n=1                       xti=3
+ cgdo=cgon_25              cgso=cgon_25              capmod=3
+ nqsmod=0                  xpart=1                   cf=0
+ tlev=1                    tlevc=1                   dlc=4.01e-8
+ cgbo=0                    cgdl=cgln_25              cgsl=cgln_25
+ wwc=-1.22e-2              dwc=0                     noia=8.0e+19
+ noib=2.5e+4               noic=1.0e-13              em=1.1e+7
+ ef=0.872                  noimod=2                  sa0=0.35e-6
+ sb0=0.35e-6               kvsat=0.35                wlod=0.3e-6
+ tku0=0.03                 ku0=-5.95e-8              llodku0=1
+ wlodku0=1                 lku0=1.493e-7             wku0=3.5e-7
+ pku0=0                    kvth0=7.2e-9              stk2=0
+ steta0=-1.1e-10           lkvth0=-5e-8              wkvth0=5e-6
+ pkvth0=0                  llodvth=1.0               wlodvth=1
+ lodk2=1                   lodeta0=2                 minr=1e-3
+ imax=0.01                 imelt=0.01

     2: type=n
+ lmin=5.0e-07-dxl_25       lmax=1.20e-06-dxl_25      wmin=1.001e-05-dxw_25
+ wmax=0.0009001            tnom=25                   version=3.24
+ tox=toxn_25               toxm=toxn_25              xj=1.9e-07
+ nch=3.28e+17              lln=1                     lwn=1
+ wln=1                     wwn=-1                    lint=3.1e-08
+ wint=1.95e-08             mobmod=1                  binunit=2
+ xl=-4e-08+dxl_25          xw=1e-8+dxw_25            dwg=0
+ dwb=0                     ldif=8e-08                hdif=hdifn_25
+ rsh=6.6                   rd=0                      rs=0
+ vth0=0.561313+dvthn_25    lvth0=2.135296e-08+dlvthn_25
+ wvth0=-2.290768e-09+dwvthn_25                       pvth0=2.686979e-14+dpvthn_25
+ k1=0.5219827              lk1=3.721306e-08          wk1=-7.733095e-08
+ pk1=8.490937e-14          k2=0.01126943+dk2n_25     lk2=-2.334857e-08+dlk2n_25
+ wk2=3.635663e-08          pk2=-3.991962e-14         k3=0
+ dvt0=0                    dvt1=0                    dvt2=0
+ dvt0w=0                   dvt1w=0                   dvt2w=0
+ nlx=0                     w0=0                      k3b=0
+ vfb=-0.8468292            vsat=92842.86             lvsat=-0.003121457+dlvsatn_25
+ ua=-8.70128e-10           lua=7.444107e-17          wua=3.140157e-15
+ pua=-1.277231e-21         ub=1.974071e-18           lub=1.074604e-26
+ wub=-1.367533e-24         pub=-2.941878e-31         uc=3.571922e-11
+ luc=1.871144e-17          wuc=1.115946e-16          puc=-1.133703e-22
+ rdsw=325.9                prwb=0                    prwg=0
+ wr=1                      u0=0.03137542             lu0=1.766108e-09
+ wu0=3.564368e-08          pu0=-1.870634e-14         a0=0.3326174
+ la0=1.162744e-07          wa0=4.858207e-07          pa0=-5.334296e-13
+ keta=-0.0137679           lketa=-4.169581e-09       wketa=-1.893171e-08
+ pketa=2.078702e-14        a1=0                      a2=0.99
+ ags=0.04274286            lags=-2.497166e-08        b0=0
+ b1=0                      voff=-0.1191335           lvoff=5.144074e-09
+ wvoff=-3.20723e-08        pvoff=-2.565111e-14       nfactor=1
+ cit=0.000113169           lcit=2.01824e-11          wcit=-5.469469e-10
+ pcit=6.005477e-16         cdsc=0                    cdscb=0
+ cdscd=0                   eta0=-0.000490143         leta0=5.930769e-10
+ etab=0.000490143          letab=-5.930769e-10       dsub=0
+ pclm=0.6147142            lpclm=9.364378e-08        pdiblc1=1e-06
+ pdiblc2=0.004999998       pdiblcb=0.01              drout=0
+ pscbe1=3.5e+08            pscbe2=1e-06              pvag=0
+ delta=0.01                alpha0=0                  alpha1=0.7997
+ beta0=14.401              kt1=-0.2855672            lkt1=5.074688e-09
+ wkt1=-6.871637e-08        pkt1=2.976575e-14         kt2=-0.02733552
+ lkt2=-3.183875e-11        wkt2=-1.475411e-08        pkt2=9.904213e-15
+ at=10000                  ute=-1.464582             lute=2.159387e-08
+ wute=-6.202247e-07        pute=4.615853e-13         ua1=1.743e-09
+ ub1=-2.218245e-18         lub1=1.635397e-25         wub1=-9.4581e-25
+ pub1=7.414972e-31         uc1=-5.649232e-11         luc1=2.302109e-17
+ wuc1=-1.068542e-16        puc1=5.573478e-23         kt1l=0
+ prt=0                     cj=cjn_25                 mj=0.3193271
+ pb=0.7249372              cjsw=cjswn_25             mjsw=0.01
+ pbsw=0.7249372            cjswg=cjswgn_25           mjswg=0.01
+ pbswg=0.7249372           tpb=0.001816363           tpbsw=0.001816363
+ tpbswg=0.001816363        tcj=0.001010853           tcjsw=9.297595e-05
+ tcjswg=9.297595e-05       js=4.03e-7                jsw=1.8e-12
+ n=1                       xti=3                     cgdo=cgon_25
+ cgso=cgon_25              capmod=3                  nqsmod=0
+ xpart=1                   cf=0                      tlev=1
+ tlevc=1                   dlc=4.01e-8               cgbo=0
+ cgdl=cgln_25              cgsl=cgln_25              wwc=-1.22e-2
+ dwc=0                     noia=8.0e+19              noib=2.5e+4
+ noic=1.0e-13              em=1.1e+7                 ef=0.872
+ noimod=2                  sa0=0.35e-6               sb0=0.35e-6
+ kvsat=0.35                wlod=0.3e-6               tku0=0.03
+ ku0=-5.95e-8              llodku0=1                 wlodku0=1
+ lku0=1.493e-7             wku0=3.5e-7               pku0=0
+ kvth0=7.2e-9              stk2=0                    steta0=-1.1e-10
+ lkvth0=-5e-8              wkvth0=5e-6               pkvth0=0
+ llodvth=1.0               wlodvth=1                 lodk2=1
+ lodeta0=2                 minr=1e-3                 imax=0.01
+ imelt=0.01

     3: type=n
+ lmin=2.8e-07              lmax=5e-07-dxl_25         wmin=1.001e-05-dxw_25
+ wmax=0.0009001            tnom=25                   version=3.24
+ tox=toxn_25               toxm=toxn_25              xj=1.9e-07
+ nch=3.28e+17              lln=1                     lwn=1
+ wln=1                     wwn=-1                    lint=3.1e-08
+ wint=1.95e-08             mobmod=1                  binunit=2
+ xl=-4e-08+dxl_25          xw=1e-8+dxw_25            dwg=0
+ dwb=0                     ldif=8e-08                hdif=hdifn_25
+ rsh=6.6                   rd=0                      rs=0
+ vth0=0.6685686+dvthn_25   lvth0=-2.133475e-08+dlvthn_25
+ wvth0=1.128612e-07+dwvthn_25                        pvth0=-1.896067e-14+dpvthn_25
+ k1=0.805287               lk1=-7.554204e-08         wk1=2.35355e-07
+ pk1=-3.953965e-14         k2=-0.03438999+dk2n_25    lk2=-5.176121e-09+dlk2n_25
+ wk2=-1.106507e-07         pk2=1.858932e-14          k3=0
+ dvt0=0                    dvt1=0                    dvt2=0
+ dvt0w=0                   dvt1w=0                   dvt2w=0
+ nlx=0                     w0=0                      k3b=0
+ vfb=-0.6704064            vsat=86095.65             lvsat=-0.0004360696+dlvsatn_25
+ ua=-6.959174e-10          lua=5.105241e-18          wua=-1.193429e-16
+ pua=2.00496e-23           ub=2.465556e-18           lub=-1.84865e-25
+ wub=-3.645505e-24         pub=6.124448e-31          uc=1.473028e-10
+ luc=-2.569881e-17         wuc=-2.998074e-16         puc=5.036765e-23
+ rdsw=325.9                prwb=0                    prwg=0
+ wr=1                      u0=0.03742776             lu0=-6.427248e-10
+ wu0=-1.965285e-08         pu0=3.301679e-15          a0=0.4442892
+ la0=7.182904e-08          wa0=-1.478578e-06         pa0=2.484012e-13
+ keta=-0.06427277          lketa=1.593136e-08        wketa=5.761829e-08
+ pketa=-9.679875e-15       a1=0                      a2=0.99
+ ags=-0.02000001           b0=0                      b1=0
+ voff=-0.08663055          lvoff=-7.792102e-09       wvoff=-1.670256e-07
+ pvoff=2.80603e-14         nfactor=1                 cit=-4.457351e-05
+ lcit=8.29639e-11          wcit=1.664621e-09         pcit=-2.796563e-16
+ cdsc=0                    cdscb=0                   cdscd=0
+ eta0=-0.000424348         leta0=5.668905e-10        etab=-0.0001488371
+ letab=-3.387628e-10       dsub=0                    pclm=0.7403224
+ lpclm=4.365171e-08        pdiblc1=1e-06             pdiblc2=-0.03330233
+ lpdiblc2=1.524433e-08     pdiblcb=0.01              drout=0
+ pscbe1=3.5e+08            pscbe2=1e-06              pvag=0
+ delta=0.01                alpha0=0                  alpha1=0.7997
+ beta0=14.401              kt1=-0.3097389            lkt1=1.469501e-08
+ wkt1=1.050708e-08         pkt1=-1.765189e-15        kt2=-0.03610081
+ lkt2=3.45675e-09          wkt2=1.753077e-08         pkt2=-2.945169e-15
+ at=1488.371               lat=0.003387628           ute=-1.434012
+ lute=9.426986e-09         wute=9.336343e-07         pute=-1.568506e-13
+ ua1=1.844129e-09          lua1=-4.024927e-17        ub1=-2.42138e-18
+ lub1=2.443874e-25         wub1=1.587238e-24         pub1=-2.666561e-31
+ uc1=-1.317202e-11         luc1=5.779609e-18         wuc1=5.742081e-17
+ puc1=-9.646697e-24        kt1l=0                    prt=0
+ cj=cjn_25                 mj=0.3193271              pb=0.7249372
+ cjsw=cjswn_25             mjsw=0.01                 pbsw=0.7249372
+ cjswg=cjswgn_25           mjswg=0.01                pbswg=0.7249372
+ tpb=0.001816363           tpbsw=0.001816363         tpbswg=0.001816363
+ tcj=0.001010853           tcjsw=9.297595e-05        tcjswg=9.297595e-05
+ js=4.03e-7                jsw=1.8e-12               n=1
+ xti=3                     cgdo=cgon_25              cgso=cgon_25
+ capmod=3                  nqsmod=0                  xpart=1
+ cf=0                      tlev=1                    tlevc=1
+ dlc=4.01e-8               cgbo=0                    cgdl=cgln_25
+ cgsl=cgln_25              wwc=-1.22e-2              dwc=0
+ noia=8.0e+19              noib=2.5e+4               noic=1.0e-13
+ em=1.1e+7                 ef=0.872                  noimod=2
+ sa0=0.35e-6               sb0=0.35e-6               kvsat=0.35
+ wlod=0.3e-6               tku0=0.03                 ku0=-5.95e-8
+ llodku0=1                 wlodku0=1                 lku0=1.493e-7
+ wku0=3.5e-7               pku0=0                    kvth0=7.2e-9
+ stk2=0                    steta0=-1.1e-10           lkvth0=-5e-8
+ wkvth0=5e-6               pkvth0=0                  llodvth=1.0
+ wlodvth=1                 lodk2=1                   lodeta0=2
+ minr=1e-3                 imax=0.01                 imelt=0.01

     4: type=n
+ lmin=1.2e-06-dxl_25       lmax=2.1e-05              wmin=1.21e-06-dxw_25
+ wmax=1.001e-05-dxw_25     tnom=25                   version=3.24
+ tox=toxn_25               toxm=toxn_25              xj=1.9e-07
+ nch=3.28e+17              lln=1                     lwn=1
+ wln=1                     wwn=-1                    lint=3.1e-08
+ wint=1.95e-08             mobmod=1                  binunit=2
+ xl=-4e-08+dxl_25          xw=1e-8+dxw_25            dwg=0
+ dwb=0                     ldif=8e-08                hdif=hdifn_25
+ rsh=6.6                   rd=0                      rs=0
+ vth0=0.5535434+dvthn_25   lvth0=3.392514e-08+dlvthn_25
+ wvth0=-1.725304e-08+dwvthn_25                       pvth0=2.963216e-15+dpvthn_25
+ k1=0.5586147              lk1=-7.350993e-10         wk1=3.493632e-08
+ pk1=-6.105405e-14         k2=-0.001357819+dk2n_25   lk2=-9.651671e-09+dlk2n_25
+ wk2=-1.451557e-08         pk2=1.761309e-14          k3=0
+ dvt0=0                    dvt1=0                    dvt2=0
+ dvt0w=0                   dvt1w=0                   dvt2w=0
+ nlx=0                     w0=0                      k3b=0
+ vfb=-0.8130998            vsat=101235.7             lvsat=-0.01233681+dlvsatn_25
+ wvsat=-7.266502e-06       pvsat=7.979299e-12        ua=-6.48368e-10
+ lua=4.723421e-17          wua=8.176306e-17          pua=-7.786219e-23
+ ub=1.962333e-18           lub=-9.439127e-26         wub=-5.241816e-25
+ pub=-4.217057e-32         uc=5.326088e-11           luc=4.488363e-18
+ wuc=-1.47373e-17          puc=-2.493888e-23         rdsw=325.9
+ prwb=0                    prwg=0                    wr=1
+ u0=0.03724615             lu0=-1.646063e-09         wu0=-7.695495e-09
+ pu0=-1.401211e-15         a0=0.5562392              la0=-1.219706e-07
+ wa0=7.259207e-08          pa0=-1.524827e-13         keta=0.002464927
+ lketa=-2.203729e-08       wketa=1.187401e-08        pketa=-1.259785e-14
+ a1=0                      a2=0.99                   ags=0.01933995
+ lags=6.619002e-09         wags=6.587982e-09         pags=-6.606424e-14
+ b0=0                      b1=0                      voff=-0.1246474
+ lvoff=8.253139e-09        wvoff=-2.209775e-08       pvoff=-7.207374e-15
+ nfactor=1                 cit=8.058136e-05          lcit=2.084676e-11
+ wcit=-1.268319e-10        pcit=4.897627e-16         cdsc=0
+ cdscb=0                   cdscd=0                   eta0=5e-05
+ etab=-5e-05               dsub=0                    pclm=0.7
+ pdiblc1=1e-06             pdiblc2=0.0005057121      lpdiblc2=4.934727e-09
+ wpdiblc2=2.908552e-12     ppdiblc2=-3.192458e-18    pdiblcb=0.01
+ drout=0                   pscbe1=1.814642e+08       lpscbe1=185.0523
+ wpscbe1=0.1090885         ppscbe1=-1.197768e-07     pscbe2=1e-06
+ pvag=0                    delta=0.01                alpha0=0
+ alpha1=0.7997             beta0=14.401              kt1=-0.2923405
+ lkt1=9.905668e-09         wkt1=1.49724e-09          pkt1=-2.13175e-14
+ kt2=-0.02969708           lkt2=2.050367e-09         wkt2=2.084077e-09
+ pkt2=-3.48586e-15         at=10000                  ute=-1.576062
+ lute=8.089091e-08         wute=2.75305e-07          pute=1.081697e-13
+ ua1=1.743e-09             ub1=-2.368329e-18         lub1=2.40139e-25
+ wub1=3.453572e-25         pub1=2.04046e-31          uc1=-6.301321e-11
+ luc1=2.399741e-17         wuc1=-1.468404e-17        puc1=1.625053e-23
+ kt1l=0                    prt=0                     cj=cjn_25
+ mj=0.3193271              pb=0.7249372              cjsw=cjswn_25
+ mjsw=0.01                 pbsw=0.7249372            cjswg=cjswgn_25
+ mjswg=0.01                pbswg=0.7249372           tpb=0.001816363
+ tpbsw=0.001816363         tpbswg=0.001816363        tcj=0.001010853
+ tcjsw=9.297595e-05        tcjswg=9.297595e-05       js=4.03e-7
+ jsw=1.8e-12               n=1                       xti=3
+ cgdo=cgon_25              cgso=cgon_25              capmod=3
+ nqsmod=0                  xpart=1                   cf=0
+ tlev=1                    tlevc=1                   dlc=4.01e-8
+ cgbo=0                    cgdl=cgln_25              cgsl=cgln_25
+ wwc=-1.22e-2              dwc=0                     noia=8.0e+19
+ noib=2.5e+4               noic=1.0e-13              em=1.1e+7
+ ef=0.872                  noimod=2                  sa0=0.35e-6
+ sb0=0.35e-6               kvsat=0.35                wlod=0.3e-6
+ tku0=0.03                 ku0=-5.95e-8              llodku0=1
+ wlodku0=1                 lku0=1.493e-7             wku0=3.5e-7
+ pku0=0                    kvth0=7.2e-9              stk2=0
+ steta0=-1.1e-10           lkvth0=-5e-8              wkvth0=5e-6
+ pkvth0=0                  llodvth=1.0               wlodvth=1
+ lodk2=1                   lodeta0=2                 minr=1e-3
+ imax=0.01                 imelt=0.01

     5: type=n
+ lmin=5.0e-07-dxl_25       lmax=1.2e-06-dxl_25       wmin=1.21e-06-dxw_25
+ wmax=1.001e-05-dxw_25     tnom=25                   version=3.24
+ tox=toxn_25               toxm=toxn_25              xj=1.9e-07
+ nch=3.28e+17              lln=1                     lwn=1
+ wln=1                     wwn=-1                    lint=3.1e-08
+ wint=1.95e-08             mobmod=1                  binunit=2
+ xl=-4e-08+dxl_25          xw=1e-8+dxw_25            dwg=0
+ dwb=0                     ldif=8e-08                hdif=hdifn_25
+ rsh=6.6                   rd=0                      rs=0
+ vth0=0.5627995+dvthn_25   lvth0=2.376209e-08+dlvthn_25
+ wvth0=-1.712651e-08+dwvthn_25                       pvth0=2.824284e-15+dpvthn_25
+ k1=0.513768               lk1=4.850651e-08          wk1=4.65992e-09
+ pk1=-2.781055e-14         k2=0.01553639+dk2n_25     lk2=-2.820151e-08+dlk2n_25
+ wk2=-6.231849e-09         pk2=8.517568e-15          k3=0
+ dvt0=0                    dvt1=0                    dvt2=0
+ dvt0w=0                   dvt1w=0                   dvt2w=0
+ nlx=0                     w0=0                      k3b=0
+ vfb=-0.8086806            vsat=92842.86             lvsat=-0.003121457+dlvsatn_25
+ ua=-5.53023e-10           lua=-5.74546e-17          wua=-2.486846e-17
+ pua=3.921921e-23          ub=1.894186e-18           lub=-1.956657e-26
+ wub=-5.702043e-25         pub=8.362437e-33          uc=5.059609e-11
+ luc=7.414306e-18          wuc=-3.689143e-17         puc=-6.13656e-25
+ rdsw=325.9                prwb=0                    prwg=0
+ wr=1                      u0=0.0358885              lu0=-1.553587e-10
+ wu0=-9.401353e-09         pu0=4.718194e-16          a0=0.3811871
+ la0=7.02366e-08           wa0=1.047213e-09          pa0=-7.392643e-14
+ keta=-0.01589304          lketa=-1.880237e-09       wketa=2.279359e-09
+ pketa=-2.062926e-15       a1=0                      a2=0.99
+ ags=0.05421544            lags=-3.167428e-08        wags=-1.145078e-07
+ pags=6.689886e-14         b0=0                      b1=0
+ voff=-0.1206563           lvoff=3.870888e-09        wvoff=-1.687365e-08
+ pvoff=-1.294344e-14       nfactor=1                 cit=4.16665e-05
+ lcit=6.357527e-11         wcit=1.667193e-10         pcit=1.674434e-16
+ cdsc=0                    cdscb=0                   cdscd=0
+ eta0=-0.000490143         leta0=5.930769e-10        etab=0.000490143
+ letab=-5.930769e-10       dsub=0                    pclm=0.6147214
+ lpclm=9.36359e-08         wpclm=-7.15767e-11        ppclm=7.860325e-17
+ pdiblc1=1e-06             pdiblc2=0.004999998       pdiblcb=0.01
+ drout=0                   pscbe1=3.5e+08            pscbe2=1e-06
+ pvag=0                    delta=0.01                alpha0=0
+ alpha1=0.7997             beta0=14.401              kt1=-0.290602
+ lkt1=7.996759e-09         wkt1=-1.846457e-08        pkt1=6.005647e-16
+ kt2=-0.02877119           lkt2=1.033734e-09         wkt2=-4.246612e-10
+ pkt2=-7.312654e-16        at=10000                  ute=-1.569641
+ lute=7.384119e-08         wute=4.283696e-07         pute=-5.989518e-14
+ ua1=1.743e-09             ub1=-2.379152e-18         lub1=2.52023e-25
+ wub1=6.602026e-25         pub1=-1.416541e-31        uc1=-6.753693e-11
+ luc1=2.896446e-17         wuc1=3.382023e-18         puc1=-3.586004e-24
+ kt1l=0                    prt=0                     cj=cjn_25
+ mj=0.3193271              pb=0.7249372              cjsw=cjswn_25
+ mjsw=0.01                 pbsw=0.7249372            cjswg=cjswgn_25
+ mjswg=0.01                pbswg=0.7249372           tpb=0.001816363
+ tpbsw=0.001816363         tpbswg=0.001816363        tcj=0.001010853
+ tcjsw=9.297595e-05        tcjswg=9.297595e-05       js=4.03e-7
+ jsw=1.8e-12               n=1                       xti=3
+ cgdo=cgon_25              cgso=cgon_25              capmod=3
+ nqsmod=0                  xpart=1                   cf=0
+ tlev=1                    tlevc=1                   dlc=4.01e-8
+ cgbo=0                    cgdl=cgln_25              cgsl=cgln_25
+ wwc=-1.22e-2              dwc=0                     noia=8.0e+19
+ noib=2.5e+4               noic=1.0e-13              em=1.1e+7
+ ef=0.872                  noimod=2                  sa0=0.35e-6
+ sb0=0.35e-6               kvsat=0.35                wlod=0.3e-6
+ tku0=0.03                 ku0=-5.95e-8              llodku0=1
+ wlodku0=1                 lku0=1.493e-7             wku0=3.5e-7
+ pku0=0                    kvth0=7.2e-9              stk2=0
+ steta0=-1.1e-10           lkvth0=-5e-8              wkvth0=5e-6
+ pkvth0=0                  llodvth=1.0               wlodvth=1
+ lodk2=1                   lodeta0=2                 minr=1e-3
+ imax=0.01                 imelt=0.01

     6: type=n
+ lmin=2.8e-07              lmax=5.0e-07-dxl_25       wmin=1.21e-06-dxw_25
+ wmax=1.001e-05-dxw_25     tnom=25                   version=3.24
+ tox=toxn_25               toxm=toxn_25              xj=1.9e-07
+ nch=3.28e+17              lln=1                     lwn=1
+ wln=1                     wwn=-1                    lint=3.1e-08
+ wint=1.95e-08             mobmod=1                  binunit=2
+ xl=-4e-08+dxl_25          xw=1e-8+dxw_25            dwg=0
+ dwb=0                     ldif=8e-08                hdif=hdifn_25
+ rsh=6.6                   rd=0                      rs=0
+ vth0=0.6844962+dvthn_25   lvth0=-2.467325e-08+dlvthn_25
+ wvth0=-4.611279e-08+dwvthn_25                       pvth0=1.436083e-14+dpvthn_25
+ k1=0.8531682              lk1=-8.657477e-08         wk1=-2.425473e-07
+ pk1=7.057792e-14          k2=-0.05141579+dk2n_25    lk2=-1.554543e-09+dlk2n_25
+ wk2=5.928379e-08          pk2=-1.755766e-14         k3=0
+ dvt0=0                    dvt1=0                    dvt2=0
+ dvt0w=0                   dvt1w=0                   dvt2w=0
+ nlx=0                     w0=0                      k3b=0
+ vfb=-0.7652686            vsat=8.6448090e+04        lvsat=-5.7633940e-04+dlvsatn_25
+ wvsat=-1.7101926e-03      pvsat=6.8065680e-10       ua=-7.156305e-10
+ lua=7.263201e-18          wua=7.741344e-17          pua=-1.48899e-24
+ ub=2.17854e-18            lub=-1.327395e-25         wub=-7.808022e-25
+ pub=9.218037e-32          uc=1.243654e-10           luc=-2.194589e-17
+ wuc=-7.08698e-17          puc=1.290974e-23          rdsw=325.9
+ prwb=0                    prwg=0                    wr=1
+ u0=0.03633325             lu0=-3.323704e-10         wu0=-8.728519e-09
+ pu0=2.04032e-16           a0=0.2551618              la0=1.203947e-07
+ wa0=4.091018e-07          pa0=-2.363322e-13         keta=-0.06037572
+ lketa=1.582387e-08        wketa=1.872172e-08        pketa=-8.606989e-15
+ a1=0                      a2=0.99                   ags=-0.02971154
+ lags=1.728653e-09         wags=9.693079e-08         pags=-1.725368e-14
+ b0=0                      b1=0                      voff=-0.09485205
+ lvoff=-6.399188e-09       wvoff=-8.496678e-08       pvoff=1.415763e-14
+ nfactor=1                 cit=1.87189e-05           lcit=7.270839e-11
+ wcit=1.032899e-09         pcit=-1.772961e-16        cdsc=0
+ cdscb=0                   cdscd=0                   eta0=-4.4818090e-04
+ leta0=5.7637610e-10       weta0=-2.1118445e-09      peta0=8.4051400e-16
+ etab=-0.0001431909        letab=-3.410101e-10       wetab=-5.635467e-11
+ petab=2.242921e-17        dsub=0                    pclm=0.7395863
+ lpclm=4.393965e-08        wpclm=7.346791e-09        ppclm=-2.87391e-15
+ pdiblc1=1e-06             pdiblc2=-0.03464225       lpdiblc2=1.577762e-08
+ wpdiblc2=1.337371e-08     ppdiblc2=-5.322741e-15    pdiblcb=0.01
+ drout=0                   pscbe1=3.5e+08            pscbe2=1e-06
+ pvag=0                    delta=0.01                alpha0=0
+ alpha1=0.7997             beta0=14.401              kt1=-0.3076753
+ lkt1=1.479193e-08         wkt1=-1.008979e-08        pkt1=-2.732598e-15
+ kt2=-0.03407931           lkt2=3.146365e-09         wkt2=-2.645907e-09
+ pkt2=1.527902e-16         at=1431.908               lat=0.0034101
+ wat=0.0005635483          pat=-2.242926e-10         ute=-1.371134
+ lute=-5.164809e-09        wute=3.060447e-07         pute=-1.120987e-14
+ ua1=1.833928e-09          lua1=-3.618919e-17        wua1=1.018181e-16
+ pua1=-4.052361e-23        ub1=-2.309933e-18         lub1=2.244739e-25
+ wub1=4.74888e-25          pub1=-6.789896e-32        uc1=-7.1775e-12
+ luc1=4.941405e-18         wuc1=-2.410485e-18        puc1=-1.280585e-24
+ kt1l=0                    prt=0                     cj=cjn_25
+ mj=0.3193271              pb=0.7249372              cjsw=cjswn_25
+ mjsw=0.01                 pbsw=0.7249372            cjswg=cjswgn_25
+ mjswg=0.01                pbswg=0.7249372           tpb=0.001816363
+ tpbsw=0.001816363         tpbswg=0.001816363        tcj=0.001010853
+ tcjsw=9.297595e-05        tcjswg=9.297595e-05       js=4.03e-7
+ jsw=1.8e-12               n=1                       xti=3
+ cgdo=cgon_25              cgso=cgon_25              capmod=3
+ nqsmod=0                  xpart=1                   cf=0
+ tlev=1                    tlevc=1                   dlc=4.01e-8
+ cgbo=0                    cgdl=cgln_25              cgsl=cgln_25
+ wwc=-1.22e-2              dwc=0                     noia=8.0e+19
+ noib=2.5e+4               noic=1.0e-13              em=1.1e+7
+ ef=0.872                  noimod=2                  sa0=0.35e-6
+ sb0=0.35e-6               kvsat=0.35                wlod=0.3e-6
+ tku0=0.03                 ku0=-5.95e-8              llodku0=1
+ wlodku0=1                 lku0=1.493e-7             wku0=3.5e-7
+ pku0=0                    kvth0=7.2e-9              stk2=0
+ steta0=-1.1e-10           lkvth0=-5e-8              wkvth0=5e-6
+ pkvth0=0                  llodvth=1.0               wlodvth=1
+ lodk2=1                   lodeta0=2                 minr=1e-3
+ imax=0.01                 imelt=0.01

     7: type=n
+ lmin=1.2e-06-dxl_25       lmax=2.1e-05              wmin=6.0e-07-dxw_25
+ wmax=1.21e-06-dxw_25      tnom=25                   version=3.24
+ tox=toxn_25               toxm=toxn_25              xj=1.9e-07
+ nch=3.28e+17              lln=1                     lwn=1
+ wln=1                     wwn=-1                    lint=3.1e-08
+ wint=1.95e-08             mobmod=1                  binunit=2
+ xl=-4e-08+dxl_25          xw=1e-8+dxw_25            dwg=0
+ dwb=0                     ldif=8e-08                hdif=hdifn_25
+ rsh=6.6                   rd=0                      rs=0
+ vth0=0.5541502+dvthn_25   lvth0=4.4826290e-08+dlvthn_25
+ wvth0=-1.7969525e-08+dwvthn_25                      pvth0=-9.9110500e-15+dpvthn_25
+ k1=0.6238807              lk1=-1.208121e-07         wk1=-4.214282e-08
+ pk1=8.075687e-14          k2=-0.02331892+dk2n_25    lk2=3.289958e-08+dlk2n_25
+ wk2=1.14205e-08           pk2=-3.263994e-14         k3=0
+ dvt0=0                    dvt1=0                    dvt2=0
+ dvt0w=0                   dvt1w=0                   dvt2w=0
+ nlx=0                     w0=0                      k3b=0
+ vfb=-0.8647492            vsat=1.0171881e+05        lvsat=-1.7184015e-02+dlvsatn_25
+ wvsat=-5.7781140e-04      pvsat=5.7325310e-09       ua=-6.746027e-10
+ lua=9.58011e-17           wua=1.127462e-16          pua=-1.352197e-22
+ ub=1.73611e-18            lub=-3.433537e-25         wub=-2.570126e-25
+ pub=2.518541e-31          uc=6.394864e-11           luc=-4.265159e-17
+ wuc=-2.735956e-17         puc=3.073341e-23          rdsw=325.9
+ prwb=0                    prwg=0                    wr=1
+ u0=3.2068890e-02          lu0=-4.7598300e-09        wu0=-1.5811429e-09
+ pu0=2.2761478e-15         a0=0.5679296              la0=-1.597854e-07
+ wa0=5.878569e-08          pa0=-1.078234e-13         keta=0.01175419
+ lketa=-3.394948e-08       wketa=9.03391e-10         pketa=1.470456e-15
+ a1=0                      a2=0.99                   ags=0.02952203
+ lags=-9.548719e-08        wags=-5.437074e-09        pags=5.452318e-14
+ b0=0                      b1=0                      voff=-0.1361137
+ lvoff=2.764377e-09        wvoff=-8.556083e-09       pvoff=-7.251459e-16
+ nfactor=1                 cit=-9.979836e-06         lcit=2.149484e-10
+ wcit=-1.987914e-11        pcit=2.605285e-16         cdsc=0
+ cdscb=0                   cdscd=0                   eta0=5e-05
+ etab=-5e-05               dsub=0                    pclm=0.7
+ pdiblc1=1e-06             pdiblc2=0.0005045947      lpdiblc2=4.935956e-09
+ wpdiblc2=4.228449e-12     ppdiblc2=-4.644269e-18    pdiblcb=0.01
+ drout=0                   pscbe1=1.814223e+08       lpscbe1=185.0983
+ wpscbe1=0.1585543         ppscbe1=-1.740868e-07     pscbe2=1e-06
+ pvag=0                    delta=0.01                alpha0=0
+ alpha1=0.7997             beta0=14.401              kt1=-0.287591
+ lkt1=-2.829119e-08        wkt1=-4.111954e-09        pkt1=2.379299e-14
+ kt2=-0.02678708           lkt2=-4.477435e-09        wkt2=-1.352642e-09
+ pkt2=4.223475e-15         at=10000                  ute=-1.494996
+ lute=3.580508e-07         wute=1.795666e-07         pute=-2.191562e-13
+ ua1=1.743e-09             ub1=-2.24558e-18          lub1=6.945156e-25
+ wub1=2.003911e-25         pub1=-3.325729e-31        uc1=-8.067581e-11
+ luc1=5.252251e-17         wuc1=6.175502e-18         puc1=-1.743761e-23
+ kt1l=0                    prt=0                     cj=cjn_25
+ mj=0.3193271              pb=0.7249372              cjsw=cjswn_25
+ mjsw=0.01                 pbsw=0.7249372            cjswg=cjswgn_25
+ mjswg=0.01                pbswg=0.7249372           tpb=0.001816363
+ tpbsw=0.001816363         tpbswg=0.001816363        tcj=0.001010853
+ tcjsw=9.297595e-05        tcjswg=9.297595e-05       js=4.03e-7
+ jsw=1.8e-12               n=1                       xti=3
+ cgdo=cgon_25              cgso=cgon_25              capmod=3
+ nqsmod=0                  xpart=1                   cf=0
+ tlev=1                    tlevc=1                   dlc=4.01e-8
+ cgbo=0                    cgdl=cgln_25              cgsl=cgln_25
+ wwc=-1.22e-2              dwc=0                     noia=8.0e+19
+ noib=2.5e+4               noic=1.0e-13              em=1.1e+7
+ ef=0.872                  noimod=2                  sa0=0.35e-6
+ sb0=0.35e-6               kvsat=0.35                wlod=0.3e-6
+ tku0=0.03                 ku0=-5.95e-8              llodku0=1
+ wlodku0=1                 lku0=1.493e-7             wku0=3.5e-7
+ pku0=0                    kvth0=7.2e-9              stk2=0
+ steta0=-1.1e-10           lkvth0=-5e-8              wkvth0=5e-6
+ pkvth0=0                  llodvth=1.0               wlodvth=1
+ lodk2=1                   lodeta0=2                 minr=1e-3
+ imax=0.01                 imelt=0.01

     8: type=n
+ lmin=5.0e-07-dxl_25       lmax=1.2e-06-dxl_25       wmin=6.0e-07-dxw_25
+ wmax=1.21e-06-dxw_25      tnom=25                   version=3.24
+ tox=toxn_25               toxm=toxn_25              xj=1.9e-07
+ nch=3.28e+17              lln=1                     lwn=1
+ wln=1                     wwn=-1                    lint=3.1e-08
+ wint=1.95e-08             mobmod=1                  binunit=2
+ xl=-4e-08+dxl_25          xw=1e-8+dxw_25            dwg=0
+ dwb=0                     ldif=8e-08                hdif=hdifn_25
+ rsh=6.6                   rd=0                      rs=0
+ vth0=0.5682745+dvthn_25   lvth0=2.9317764e-08+dlvthn_25
+ wvth0=-2.3592545e-08+dwvthn_25                      pvth0=-3.7369730e-15+dpvthn_25
+ k1=0.517328               lk1=-3.817216e-09         wk1=4.556238e-10
+ pk1=3.398377e-14          k2=0.01651492+dk2n_25     lk2=-1.083799e-08+dlk2n_25
+ wk2=-7.3875e-09           pk2=-1.198874e-14         k3=0
+ dvt0=0                    dvt1=0                    dvt2=0
+ dvt0w=0                   dvt1w=0                   dvt2w=0
+ nlx=0                     w0=0                      k3b=0
+ vfb=-0.912801             vsat=8.9337160e+04        lvsat=-3.5889600e-03+dlvsatn_25
+ wvsat=4.1402310e-03       pvsat=5.5212010e-10       ua=-5.283277e-10
+ lua=-6.480883e-17         wua=-5.403362e-17         pua=4.790457e-23
+ ub=1.288412e-18           lub=1.482181e-25          wub=1.452145e-25
+ pub=-1.897913e-31         uc=6.589195e-12           luc=2.032909e-17
+ wuc=1.508072e-17          puc=-1.586602e-23         rdsw=325.9
+ prwb=0                    prwg=0                    wr=1
+ u0=2.6922315e-02          lu0=8.9110440e-10         wu0=1.1877108e-09
+ pu0=-7.6405360e-16        a0=0.409158               la0=1.454578e-08
+ wa0=-3.19865e-08          pa0=-8.155571e-15         keta=-0.01566437
+ lketa=-3.843909e-09       wketa=2.009296e-09        pketa=2.561715e-16
+ a1=0                      a2=0.99                   ags=-0.1227631
+ lags=7.172186e-08         wags=9.45039e-08          pags=-5.521201e-14
+ b0=0                      b1=0                      voff=-0.1204382
+ lvoff=-1.444727e-08       wvoff=-1.713118e-08       pvoff=8.690311e-15
+ nfactor=1                 cit=-0.0001547657         lcit=3.739234e-10
+ wcit=3.987058e-10         pcit=-1.990778e-16        cdsc=0
+ cdscb=0                   cdscd=0                   eta0=-0.000490143
+ leta0=5.930769e-10        etab=0.000490143          letab=-5.930769e-10
+ dsub=0                    pclm=0.6155033            lpclm=9.277744e-08
+ wpclm=-9.949611e-10       ppclm=1.092453e-15        pdiblc1=1e-06
+ pdiblc2=0.005000001       pdiblcb=0.01              drout=0
+ pscbe1=3.5e+08            pscbe2=1e-06              pvag=0
+ delta=0.01                alpha0=0                  alpha1=0.7997
+ beta0=14.401              kt1=-0.3264761            lkt1=1.440468e-08
+ wkt1=2.390278e-08         pkt1=-6.967189e-15        kt2=-0.03246339
+ lkt2=1.755159e-09         wkt2=3.935832e-09         pkt2=-1.583269e-15
+ at=10000                  ute=-1.186555             lute=1.938267e-08
+ wute=-2.405503e-08        pute=4.420327e-15         ua1=1.580022e-09
+ lua1=1.789501e-16         wua1=1.924773e-16         pua1=-2.113401e-22
+ ub1=-1.468904e-18         lub1=-1.582742e-25        wub1=-4.148e-25
+ pub1=3.429068e-31         uc1=-4.470879e-11         luc1=1.303072e-17
+ wuc1=-2.357801e-17        puc1=1.523175e-23         kt1l=0
+ prt=0                     cj=cjn_25                 mj=0.3193271
+ pb=0.7249372              cjsw=cjswn_25             mjsw=0.01
+ pbsw=0.7249372            cjswg=cjswgn_25           mjswg=0.01
+ pbswg=0.7249372           tpb=0.001816363           tpbsw=0.001816363
+ tpbswg=0.001816363        tcj=0.001010853           tcjsw=9.297595e-05
+ tcjswg=9.297595e-05       js=4.03e-7                jsw=1.8e-12
+ n=1                       xti=3                     cgdo=cgon_25
+ cgso=cgon_25              capmod=3                  nqsmod=0
+ xpart=1                   cf=0                      tlev=1
+ tlevc=1                   dlc=4.01e-8               cgbo=0
+ cgdl=cgln_25              cgsl=cgln_25              wwc=-1.22e-2
+ dwc=0                     noia=8.0e+19              noib=2.5e+4
+ noic=1.0e-13              em=1.1e+7                 ef=0.872
+ noimod=2                  sa0=0.35e-6               sb0=0.35e-6
+ kvsat=0.35                wlod=0.3e-6               tku0=0.03
+ ku0=-5.95e-8              llodku0=1                 wlodku0=1
+ lku0=1.493e-7             wku0=3.5e-7               pku0=0
+ kvth0=7.2e-9              stk2=0                    steta0=-1.1e-10
+ lkvth0=-5e-8              wkvth0=5e-6               pkvth0=0
+ llodvth=1.0               wlodvth=1                 lodk2=1
+ lodeta0=2                 minr=1e-3                 imax=0.01
+ imelt=0.01

     9: type=n
+ lmin=2.8e-07              lmax=5.0e-07-dxl_25       wmin=6.0e-07-dxw_25
+ wmax=1.21e-06-dxw_25      tnom=25                   version=3.24
+ tox=toxn_25               toxm=toxn_25              xj=1.9e-07
+ nch=3.28e+17              lln=1                     lwn=1
+ wln=1                     wwn=-1                    lint=3.1e-08
+ wint=1.95e-08             mobmod=1                  binunit=2
+ xl=-4e-08+dxl_25          xw=1e-8+dxw_25            dwg=0
+ dwb=0                     ldif=8e-08                hdif=hdifn_25
+ rsh=6.6                   rd=0                      rs=0
+ vth0=0.6727744+dvthn_25   lvth0=-1.2273222e-08+dlvthn_25
+ wvth0=-3.2269360e-08+dwvthn_25                      pvth0=-2.8360204e-16+dpvthn_25
+ k1=0.506862               lk1=3.482065e-10          wk1=1.664402e-07
+ pk1=-3.20781e-14          k2=0.05711861+dk2n_25     lk2=-2.699826e-08+dlk2n_25
+ wk2=-6.889533e-08         pk2=1.249137e-14          k3=0
+ dvt0=0                    dvt1=0                    dvt2=0
+ dvt0w=0                   dvt1w=0                   dvt2w=0
+ nlx=0                     w0=0                      k3b=0
+ vfb=-0.7772112            vsat=8.0319670e+04        wvsat=5.5274680e-03
+ ua=-7.495025e-10          lvsat=0+dlvsatn_25        lua=2.321874e-17
+ wua=1.174163e-16          pua=-2.033249e-23         ub=1.881401e-18
+ lub=-8.779129e-26         wub=-4.298805e-25         pub=3.90965e-32
+ uc=9.905966e-11           luc=-1.647415e-17         wuc=-4.098369e-17
+ puc=6.447613e-24          rdsw=325.9                prwb=0
+ prwg=0                    wr=1                      u0=2.9573904e-02
+ lu0=-1.6422901e-10        wu0=-7.4573300e-10        pu0=5.4570510e-18
+ a0=0.6412702              la0=-7.783486e-08         wa0=-4.689214e-08
+ pa0=-2.223132e-15         keta=-0.04961912          lketa=9.670079e-09
+ wketa=6.018185e-09        pketa=-1.339365e-15       a1=0
+ a2=0.99                   ags=0.1503953             lags=-3.699515e-08
+ wags=-1.157753e-07        pags=2.847913e-14         b0=0
+ b1=0                      voff=-0.1895237           lvoff=1.304875e-08
+ wvoff=2.684043e-08        pvoff=-8.810388e-15       nfactor=1
+ cit=0.0008311252          lcit=-1.846116e-11        wcit=7.344712e-11
+ pcit=-6.962485e-17        cdsc=0                    cdscb=0
+ cdscd=0                   eta0=-0.002236364         leta0=1.288073e-09
+ etab=-0.0001909085        letab=-3.220184e-10       dsub=0
+ pclm=0.7887304            lpclm=2.383302e-08        wpclm=-5.069236e-08
+ ppclm=2.087202e-14        pdiblc1=1e-06             pdiblc2=-0.01574455
+ lpdiblc2=8.256332e-09     wpdiblc2=-8.944461e-09    ppdiblc2=3.559895e-15
+ pdiblcb=0.01              drout=0                   pscbe1=3.5e+08
+ pscbe2=1e-06              pvag=0                    delta=0.01
+ alpha0=0                  alpha1=0.7997             beta0=14.401
+ kt1=-0.3208798            lkt1=1.217738e-08         wkt1=5.504833e-09
+ pkt1=3.551922e-16         kt2=-0.03856365           lkt2=4.18306e-09
+ wkt2=2.650097e-09         pkt2=-1.071547e-15        at=1909.088
+ lat=0.003220183           ute=-1.093895             lute=-1.74962e-08
+ wute=-2.137455e-08        pute=3.353496e-15         ua1=2.370475e-09
+ lua1=-1.356501e-16        wua1=-5.318439e-16        pua1=7.693971e-23
+ ub1=-2.511816e-18         lub1=2.568048e-25         wub1=7.133122e-25
+ pub1=-1.060818e-31        uc1=-2.860716e-11         luc1=6.622267e-18
+ wuc1=2.289795e-17         puc1=-3.265684e-24        kt1l=0
+ prt=0                     cj=cjn_25                 mj=0.3193271
+ pb=0.7249372              cjsw=cjswn_25             mjsw=0.01
+ pbsw=0.7249372            cjswg=cjswgn_25           mjswg=0.01
+ pbswg=0.7249372           tpb=0.001816363           tpbsw=0.001816363
+ tpbswg=0.001816363        tcj=0.001010853           tcjsw=9.297595e-05
+ tcjswg=9.297595e-05       js=4.03e-7                jsw=1.8e-12
+ n=1                       xti=3                     cgdo=cgon_25
+ cgso=cgon_25              capmod=3                  nqsmod=0
+ xpart=1                   cf=0                      tlev=1
+ tlevc=1                   dlc=4.01e-8               cgbo=0
+ cgdl=cgln_25              cgsl=cgln_25              wwc=-1.22e-2
+ dwc=0                     noia=8.0e+19              noib=2.5e+4
+ noic=1.0e-13              em=1.1e+7                 ef=0.872
+ noimod=2                  sa0=0.35e-6               sb0=0.35e-6
+ kvsat=0.35                wlod=0.3e-6               tku0=0.03
+ ku0=-5.95e-8              llodku0=1                 wlodku0=1
+ lku0=1.493e-7             wku0=3.5e-7               pku0=0
+ kvth0=7.2e-9              stk2=0                    steta0=-1.1e-10
+ lkvth0=-5e-8              wkvth0=5e-6               pkvth0=0
+ llodvth=1.0               wlodvth=1                 lodk2=1
+ lodeta0=2                 minr=1e-3                 imax=0.01
+ imelt=0.01

     10: type=n
+ lmin=1.2e-06-dxl_25       lmax=2.1e-05              wmin=1.5e-07
+ wmax=6.0e-07-dxw_25       tnom=25                   version=3.24
+ tox=toxn_25               toxm=toxn_25              xj=1.9e-07
+ nch=3.28e+17              lln=1                     lwn=1
+ wln=1                     wwn=-1                    lint=3.1e-08
+ wint=1.95e-08             mobmod=1                  binunit=2
+ xl=-4e-08+dxl_25          xw=1e-8+dxw_25            dwg=0
+ dwb=0                     ldif=8e-08                hdif=hdifn_25
+ rsh=6.6                   rd=0                      rs=0
+ vth0=0.5422315+dvthn_25   lvth0=3.1714840e-08+dlvthn_25
+ wvth0=-1.1163966e-08+dwvthn_25                      pvth0=-2.4244101e-15+dpvthn_25
+ k1=0.5479347              lk1=3.78316e-08           wk1=1.222366e-09
+ pk1=-9.828678e-15         k2=0.005827645+dk2n_25    lk2=-2.890513e-08+dlk2n_25
+ wk2=-5.222191e-09         pk2=2.650552e-15          k3=0
+ dvt0=0                    dvt1=0                    dvt2=0
+ dvt0w=0                   dvt1w=0                   dvt2w=0
+ nlx=0                     w0=0                      k3b=0
+ vfb=-0.909018             vsat=1.0088023e+05        lvsat=-8.8966530e-03+dlvsatn_25
+ wvsat=-9.8984170e-05      pvsat=1.0004452e-09       ua=-5.019348e-10
+ lua=-1.028488e-16         wua=1.415291e-17          pua=-2.179062e-23
+ ub=1.259826e-18           lub=5.625312e-26          wub=1.494562e-26
+ pub=2.367857e-32          uc=1.171129e-11           luc=1.227163e-17
+ wuc=2.467972e-18          puc=-6.277545e-25         rdsw=325.9
+ prwb=0                    prwg=0                    wr=1
+ u0=2.7484521e-02          lu0=5.7991870e-10         wu0=1.0365279e-09
+ pu0=-7.7284900e-16        a0=0.719522               la0=-3.474643e-07
+ wa0=-2.777356e-08         pa0=-6.588075e-16         keta=0.01854084
+ lketa=-3.251736e-08       wketa=-2.971792e-09       pketa=6.527143e-16
+ a1=0                      a2=0.99                   ags=0.02000002
+ b0=0                      b1=0                      voff=-0.1554637
+ lvoff=-6.93599e-10        wvoff=2.49282e-09         pvoff=1.249359e-15
+ nfactor=1                 cit=-6.461236e-05         lcit=8.206671e-10
+ wcit=1.131603e-11         pcit=-8.533693e-17        cdsc=0
+ cdscb=0                   cdscd=0                   eta0=5e-05
+ etab=-5e-05               dsub=0                    pclm=0.7
+ pdiblc1=1e-06             pdiblc2=0.0007116703      lpdiblc2=2.908376e-09
+ wpdiblc2=-1.140118e-10    ppdiblc2=1.153104e-15     pdiblcb=0.01
+ drout=0                   pscbe1=1.817012e+08       lpscbe1=184.7988
+ ppscbe1=-3.076762e-09     pscbe2=1e-06              pvag=0
+ delta=0.01                alpha0=0                  alpha1=0.7997
+ beta0=14.401              kt1=-0.3046467            lkt1=1.85551e-08
+ wkt1=5.626874e-09         pkt1=-2.956242e-15        kt2=-0.03127436
+ lkt2=4.907518e-09         wkt2=1.209594e-09         pkt2=-1.135333e-15
+ at=10000                  ute=-1.21389              lute=6.427178e-09
+ wute=1.905479e-08         pute=-1.837907e-14        ua1=1.743e-09
+ ub1=-1.899235e-18         lub1=1.875644e-25         wub1=2.62803e-27
+ pub1=-4.310363e-32        uc1=-7.342586e-11         luc1=2.391715e-17
+ wuc1=2.03578e-18          puc1=-1.103955e-24        kt1l=0
+ prt=0                     cj=cjn_25                 mj=0.3193271
+ pb=0.7249372              cjsw=cjswn_25             mjsw=0.01
+ pbsw=0.7249372            cjswg=cjswgn_25           mjswg=0.01
+ pbswg=0.7249372           tpb=0.001816363           tpbsw=0.001816363
+ tpbswg=0.001816363        tcj=0.001010853           tcjsw=9.297595e-05
+ tcjswg=9.297595e-05       js=4.03e-7                jsw=1.8e-12
+ n=1                       xti=3                     cgdo=cgon_25
+ cgso=cgon_25              capmod=3                  nqsmod=0
+ xpart=1                   cf=0                      tlev=1
+ tlevc=1                   dlc=4.01e-8               cgbo=0
+ cgdl=cgln_25              cgsl=cgln_25              wwc=-1.22e-2
+ dwc=0                     noia=8.0e+19              noib=2.5e+4
+ noic=1.0e-13              em=1.1e+7                 ef=0.872
+ noimod=2                  sa0=0.35e-6               sb0=0.35e-6
+ kvsat=0.35                wlod=0.3e-6               tku0=0.03
+ ku0=-5.95e-8              llodku0=1                 wlodku0=1
+ lku0=1.493e-7             wku0=3.5e-7               pku0=0
+ kvth0=7.2e-9              stk2=0                    steta0=-1.1e-10
+ lkvth0=-5e-8              wkvth0=5e-6               pkvth0=0
+ llodvth=1.0               wlodvth=1                 lodk2=1
+ lodeta0=2                 minr=1e-3                 imax=0.01
+ imelt=0.01

     11: type=n
+ lmin=5.0e-07-dxl_25       lmax=1.20e-06-dxl_25      wmin=1.5e-07
+ wmax=6.0e-07-dxw_25       tnom=25                   version=3.24
+ tox=toxn_25               toxm=toxn_25              xj=1.9e-07
+ nch=3.28e+17              lln=1                     lwn=1
+ wln=1                     wwn=-1                    lint=3.1e-08
+ wint=1.95e-08             mobmod=1                  binunit=2
+ xl=-4e-08+dxl_25          xw=1e-8+dxw_25            dwg=0
+ dwb=0                     ldif=8e-08                hdif=hdifn_25
+ rsh=6.6                   rd=0                      rs=0
+ vth0=0.5417253+dvthn_25   lvth0=3.2270560e-08+dlvthn_25
+ wvth0=-8.4329900e-09+dwvthn_25                      pvth0=-5.4230210e-15+dpvthn_25
+ k1=0.5188512              lk1=6.976528e-08          wk1=-4.141004e-10
+ pk1=-8.031837e-15         k2=0.01219333+dk2n_25     lk2=-3.589466e-08+dlk2n_25
+ wk2=-4.919882e-09         pk2=2.318618e-15          k3=0
+ dvt0=0                    dvt1=0                    dvt2=0
+ dvt0w=0                   dvt1w=0                   dvt2w=0
+ nlx=0                     w0=0                      k3b=0
+ vfb=-0.9318906            vsat=9.5862160e+04        lvsat=-3.3867960e-03+dlvsatn_25
+ wvsat=4.1445850e-04       pvsat=4.3668510e-10       ua=-6.218908e-10
+ lua=2.886285e-17          wua=-6.090707e-19         pua=-5.58197e-24
+ ub=1.495336e-18           lub=-2.02337e-25          wub=2.706116e-26
+ pub=1.037571e-32          uc=2.93016e-11            luc=-7.042535e-18
+ wuc=2.111928e-18          puc=-2.368185e-25         rdsw=325.9
+ prwb=0                    prwg=0                    wr=1
+ u0=2.9326258e-02          lu0=-1.4423063e-09        wu0=-1.8494141e-10
+ pu0=5.6832430e-16         a0=0.410676               la0=-8.35134e-09
+ wa0=-3.285325e-08         pa0=4.918691e-15          keta=-0.005220399
+ lketa=-6.427524e-09       wketa=-3.954217e-09       pketa=1.731417e-15
+ a1=0                      a2=0.99                   ags=0.05020038
+ lags=-3.316003e-08        wags=-4.258256e-09        pags=4.675565e-15
+ b0=0                      b1=0                      voff=-0.1544699
+ lvoff=-1.784848e-09       wvoff=2.300918e-09        pvoff=1.460067e-15
+ nfactor=1                 cit=0.0006517879          lcit=3.405972e-11
+ wcit=-6.183635e-11        pcit=-5.015623e-18        cdsc=0
+ cdscb=0                   cdscd=0                   eta0=-0.0003037047
+ leta0=3.883675e-10        weta0=-1.064564e-10       peta0=1.168891e-16
+ etab=0.000490143          letab=-5.930769e-10       dsub=0
+ pclm=0.6142834            lpclm=9.411686e-08        wpclm=-2.983971e-10
+ ppclm=3.276399e-16        pdiblc1=1e-06             pdiblc2=0.003360465
+ wpdiblc2=9.361742e-10     pdiblcb=0.01              drout=0
+ pscbe1=3.500095e+08       ppscbe1=2.169026e-09      pscbe2=1e-06
+ pvag=0                    delta=0.01                alpha0=0
+ alpha1=0.7997             beta0=14.401              kt1=-0.2880923
+ lkt1=3.783602e-10         wkt1=1.985635e-09         pkt1=1.041839e-15
+ kt2=-0.02560025           lkt2=-1.322649e-09        wkt2=1.69774e-11
+ pkt2=1.741595e-16         at=10000                  ute=-1.251221
+ lute=4.741641e-08         wute=1.286888e-08         pute=-1.158695e-14
+ ua1=1.974202e-09          lua1=-2.538594e-16        wua1=-3.259943e-17
+ pua1=3.579417e-23         ub1=-2.260109e-18         lub1=5.838046e-25
+ wub1=3.697838e-26         pub1=-8.082031e-32        uc1=-9.803292e-11
+ luc1=5.093571e-17         wuc1=6.870073e-18         puc1=-6.412009e-24
+ kt1l=0                    prt=0                     cj=cjn_25
+ mj=0.3193271              pb=0.7249372              cjsw=cjswn_25
+ mjsw=0.01                 pbsw=0.7249372            cjswg=cjswgn_25
+ mjswg=0.01                pbswg=0.7249372           tpb=0.001816363
+ tpbsw=0.001816363         tpbswg=0.001816363        tcj=0.001010853
+ tcjsw=9.297595e-05        tcjswg=9.297595e-05       js=4.03e-7
+ jsw=1.8e-12               n=1                       xti=3
+ cgdo=cgon_25              cgso=cgon_25              capmod=3
+ nqsmod=0                  xpart=1                   cf=0
+ tlev=1                    tlevc=1                   dlc=4.01e-8
+ cgbo=0                    cgdl=cgln_25              cgsl=cgln_25
+ wwc=-1.22e-2              dwc=0                     noia=8.0e+19
+ noib=2.5e+4               noic=1.0e-13              em=1.1e+7
+ ef=0.872                  noimod=2                  sa0=0.35e-6
+ sb0=0.35e-6               kvsat=0.35                wlod=0.3e-6
+ tku0=0.03                 ku0=-5.95e-8              llodku0=1
+ wlodku0=1                 lku0=1.493e-7             wku0=3.5e-7
+ pku0=0                    kvth0=7.2e-9              stk2=0
+ steta0=-1.1e-10           lkvth0=-5e-8              wkvth0=5e-6
+ pkvth0=0                  llodvth=1.0               wlodvth=1
+ lodk2=1                   lodeta0=2                 minr=1e-3
+ imax=0.01                 imelt=0.01

     12: type=n
+ lmin=2.8e-07              lmax=5.0e-07-dxl_25       wmin=1.5e-07
+ wmax=6.0e-07-dxw_25       tnom=25                   version=3.24
+ tox=toxn_25               toxm=toxn_25              xj=1.9e-07
+ nch=3.28e+17              lln=1                     lwn=1
+ wln=1                     wwn=-1                    lint=3.1e-08
+ wint=1.95e-08             mobmod=1                  binunit=2
+ xl=-4e-08+dxl_25          xw=1e-8+dxw_25            dwg=0
+ dwb=0                     ldif=8e-08                hdif=hdifn_25
+ rsh=6.6                   rd=0                      rs=0
+ vth0=0.6596250+dvthn_25   lvth0=-1.4653499e-08+dlvthn_25
+ wvth0=-2.4761023e-08+dwvthn_25                      pvth0=1.0755358e-15+dpvthn_25
+ k1=0.8684869              lk1=-6.938973e-08         wk1=-4.004752e-08
+ pk1=7.742263e-15          k2=-0.06783327+dk2n_25    lk2=-4.044069e-09+dlk2n_25
+ wk2=2.4522e-09            pk2=-6.154713e-16         k3=0
+ dvt0=0                    dvt1=0                    dvt2=0
+ dvt0w=0                   dvt1w=0                   dvt2w=0
+ nlx=0                     w0=0                      k3b=0
+ vfb=-0.9503278            vsat=8.7299730e+04        lvsat=2.1045111e-05+dlvsatn_25
+ wvsat=1.5418500e-03       pvsat=-1.2016753e-11      ua=-5.249773e-10
+ lua=-9.708697e-18         wua=-1.07876e-17          pua=-1.530916e-24
+ ub=9.176741e-19           lub=2.757234e-26          wub=1.204075e-25
+ pub=-2.677613e-32         uc=1.904671e-11           luc=-2.961089e-18
+ wuc=4.703706e-18          puc=-1.268346e-24         rdsw=325.9
+ prwb=0                    prwg=0                    wr=1
+ u0=2.5628585e-02          lu0=2.9365850e-11         wu0=1.5070432e-09
+ pu0=-1.0508559e-16        a0=0.6062471              la0=-8.618863e-08
+ wa0=-2.68939e-08          pa0=2.546869e-15          keta=-0.04630484
+ lketa=9.92408e-09         wketa=4.125726e-09        pketa=-1.4844e-15
+ a1=0                      a2=0.99                   ags=-0.07609219
+ lags=1.710441e-08         wags=1.3549e-08           pags=-2.411722e-15
+ b0=0                      b1=0                      voff=-0.1508045
+ lvoff=-3.243679e-09       wvoff=4.731763e-09        pvoff=4.925908e-16
+ nfactor=1                 cit=0.001160922           lcit=-1.685757e-10
+ wcit=-1.148669e-10        pcit=1.609052e-17         cdsc=0
+ cdscb=0                   cdscd=0                   eta0=-0.003146469
+ leta0=1.519788e-09        weta0=5.196694e-10        peta0=-1.323089e-16
+ etab=7.439798e-05         letab=-4.276103e-10       wetab=-1.514901e-10
+ petab=6.029304e-17        dsub=0                    pclm=0.7668545
+ lpclm=3.339355e-08        wpclm=-3.820119e-08       ppclm=1.541295e-14
+ pdiblc1=1e-06             pdiblc2=-0.04019715       lpdiblc2=1.733593e-08
+ wpdiblc2=5.017971e-09     ppdiblc2=-1.624555e-15    pdiblcb=0.01
+ drout=0                   pscbe1=3.5e+08            pscbe2=1e-06
+ pvag=0                    delta=0.01                alpha0=0
+ alpha1=0.7997             beta0=14.401              kt1=-0.3202
+ lkt1=1.315721e-08         wkt1=5.116618e-09         pkt1=-2.042924e-16
+ kt2=-0.03602254           lkt2=2.82542e-09          wkt2=1.199123e-09
+ pkt2=-2.963344e-16        at=1651.169               lat=0.003322834
+ wat=0.000147272           pat=-5.861422e-11         ute=-1.124059
+ lute=-3.193976e-09        wute=-4.15091e-09         pute=-4.813071e-15
+ ua1=1.180961e-09          lua1=6.185042e-17         wua1=1.473686e-16
+ pua1=-3.583308e-23        ub1=-5.926962e-19         lub1=-7.982564e-26
+ wub1=-3.825053e-25        pub1=8.613416e-32         uc1=4.570387e-11
+ luc1=-6.271527e-18        wuc1=-1.953365e-17        puc1=4.096673e-24
+ kt1l=0                    prt=0                     cj=cjn_25
+ mj=0.3193271              pb=0.7249372              cjsw=cjswn_25
+ mjsw=0.01                 pbsw=0.7249372            cjswg=cjswgn_25
+ mjswg=0.01                pbswg=0.7249372           tpb=0.001816363
+ tpbsw=0.001816363         tpbswg=0.001816363        tcj=0.001010853
+ tcjsw=9.297595e-05        tcjswg=9.297595e-05       js=4.03e-7
+ jsw=1.8e-12               n=1                       xti=3
+ cgdo=cgon_25              cgso=cgon_25              capmod=3
+ nqsmod=0                  xpart=1                   cf=0
+ tlev=1                    tlevc=1                   dlc=4.01e-8
+ cgbo=0                    cgdl=cgln_25              cgsl=cgln_25
+ wwc=-1.22e-2              dwc=0                     noia=8.0e+19
+ noib=2.5e+4               noic=1.0e-13              em=1.1e+7
+ ef=0.872                  noimod=2                  sa0=0.35e-6
+ sb0=0.35e-6               kvsat=0.35                wlod=0.3e-6
+ tku0=0.03                 ku0=-5.95e-8              llodku0=1
+ wlodku0=1                 lku0=1.493e-7             wku0=3.5e-7
+ pku0=0                    kvth0=7.2e-9              stk2=0
+ steta0=-1.1e-10           lkvth0=-5e-8              wkvth0=5e-6
+ pkvth0=0                  llodvth=1.0               wlodvth=1
+ lodk2=1                   lodeta0=2                 minr=1e-3
+ imax=0.01                 imelt=0.01
//
// **************************************************************
//                                                              *
//              2.5V PMOS DEVICES MODEL                         *
//                                                              *
// **************************************************************
//
     }
model pch_25 bsim3v3  {
     1: type=p
+ lmin=1.21e-06-dxl_25      lmax=2.1e-05              wmin=1.001e-05-dxw_25
+ wmax=0.0009001            tnom=25                   version=3.24
+ tox=toxp_25               toxm=toxp_25              xj=2.1e-07
+ nch=7.22e+17              lln=1                     lwn=1
+ wln=1                     wwn=-1                    lint=4.4e-08
+ wint=5e-09                mobmod=1                  binunit=2
+ xl=-4e-08+dxl_25          xw=1e-8+dxw_25            dwg=0
+ dwb=0                     ldif=8e-08                hdif=hdifp_25
+ rsh=7.2                   rd=0                      rs=0
+ vth0=-0.592658+dvthp_25   lvth0=-1.055122e-08+dlvthp_25
+ wvth0=1.561465e-08+dwvthp_25                        pvth0=1.575669e-14+dpvthp_25
+ k1=0.8641071              lk1=1.793378e-08          wk1=-9.128735e-08
+ pk1=-1.293998e-13         k2=-0.02934441+dk2p_25    lk2=-6.656386e-09+dlk2p_25
+ wk2=4.882645e-09          pk2=2.74645e-14           k3=0
+ dvt0=0                    dvt1=0                    dvt2=0
+ dvt0w=0                   dvt1w=0                   dvt2w=0
+ nlx=0                     w0=0                      k3b=0
+ vfb=-1.14392              vsat=153630.9             lvsat=-0.03638859+dlvsatp_25
+ ua=1.306378e-09           lua=-6.524579e-16         wua=-1.073666e-15
+ pua=1.595408e-21          ub=2.727538e-19           lub=8.028553e-25
+ wub=1.092813e-24          pub=3.625076e-31          uc=-9.835018e-11
+ luc=9.673812e-17          wuc=2.717682e-17          puc=-4.093868e-23
+ rdsw=784.6                prwb=0                    prwg=0
+ wr=1                      u0=0.01238799             lu0=3.924454e-11
+ wu0=-3.809757e-09         pu0=4.142064e-15          a0=0.7676753
+ la0=-1.51543e-07          wa0=-4.307646e-07         pa0=-2.065499e-13
+ keta=0.003813325          lketa=-2.161789e-08       wketa=-2.881522e-08
+ pketa=-3.63145e-14        a1=0                      a2=0.99
+ ags=0.02                  b0=0                      b1=0
+ voff=-0.09809562          lvoff=-2.072911e-09       wvoff=-5.213407e-08
+ pvoff=-2.903061e-14       nfactor=1                 cit=2.096417e-05
+ lcit=-1.079015e-12        wcit=-1.040074e-10        pcit=8.365094e-17
+ cdsc=0                    cdscb=0                   cdscd=0
+ eta0=5e-05                etab=-5e-05               dsub=0
+ pclm=0.7                  pdiblc1=1e-06             pdiblc2=0.0001
+ pdiblcb=0.01              drout=0                   pscbe1=1.818456e+08
+ lpscbe1=181.943           pscbe2=5e-07              pvag=0
+ delta=0.01                alpha0=0                  alpha1=1.0857
+ beta0=23.74               kt1=-0.2672082            lkt1=-9.184623e-09
+ wkt1=-1.072133e-07        pkt1=1.315602e-14         kt2=-0.02844408
+ lkt2=7.33378e-10          wkt2=1.810166e-08         pkt2=-2.137926e-14
+ at=-50000                 ute=-0.8395534            lute=-1.640363e-08
+ wute=9.212293e-07         pute=-5.374068e-13        ua1=1.752e-09
+ ub1=-2.360212e-18         lub1=3.389896e-25         wub1=2.957343e-24
+ pub1=-2.832312e-30        uc1=3.524049e-12          luc1=-1.171839e-17
+ wuc1=1.352376e-16         puc1=4.739483e-23         kt1l=0
+ prt=0                     cj=cjp_25                 mj=0.3952264
+ pb=0.854899               cjsw=cjswp_25             mjsw=0.0450429
+ pbsw=0.854899             cjswg=cjswgp_25           mjswg=0.0450429
+ pbswg=0.854899            tpb=0.001603538           tpbsw=0.001603538
+ tpbswg=0.001603538        tcj=0.0009016089          tcjsw=0.0001793034
+ tcjswg=0.0001793034       js=2.0e-7                 jsw=1.36e-12
+ n=1                       xti=3                     cgdo=cgop_25
+ cgso=cgop_25              capmod=3                  nqsmod=0
+ xpart=1                   cf=0                      tlev=1
+ tlevc=1                   dlc=3.90e-8               cgbo=0
+ cgdl=cglp_25              cgsl=cglp_25              wwc=-1.20e-2
+ dwc=0                     noia=5.0e+19              noib=4.0e+3
+ noic=8.0e-12              em=4.1e+7                 ef=1.152
+ noimod=2                  sa0=0.35e-6               sb0=0.35e-6
+ kvsat=-1                  wlod=0.3e-6               tku0=0.03
+ ku0=8.5e-08               llodku0=1                 wlodku0=1
+ lku0=8.0e-09              wku0=6.0e-07              pku0=0
+ kvth0=1.0e-09             stk2=0                    steta0=-3e-10
+ lkvth0=-1.0e-10           wkvth0=0                  pkvth0=0
+ llodvth=1                 wlodvth=1                 lodk2=1
+ lodeta0=1                 minr=1e-3                 imax=0.01
+ imelt=0.01

     2: type=p
+ lmin=5.0e-07-dxl_25       lmax=1.21e-06-dxl_25      wmin=1.001e-05-dxw_25
+ wmax=0.0009001            tnom=25                   version=3.24
+ tox=toxp_25               toxm=toxp_25              xj=2.1e-07
+ nch=7.22e+17              lln=1                     lwn=1
+ wln=1                     wwn=-1                    lint=4.4e-08
+ wint=5e-09                mobmod=1                  binunit=2
+ xl=-4e-08+dxl_25          xw=1e-8+dxw_25            dwg=0
+ dwb=0                     ldif=8e-08                hdif=hdifp_25
+ rsh=7.2                   rd=0                      rs=0
+ vth0=-0.611469+dvthp_25   lvth0=9.802192e-09+dlvthp_25
+ wvth0=1.308355e-08+dwvthp_25                        pvth0=1.849535e-14+dpvthp_25
+ k1=0.8710226              lk1=1.045122e-08          wk1=-3.438209e-07
+ pk1=1.438415e-13          k2=-0.02763058+dk2p_25    lk2=-8.510749e-09+dlk2p_25
+ wk2=6.998036e-08          pk2=-4.297124e-14         k3=0
+ dvt0=0                    dvt1=0                    dvt2=0
+ dvt0w=0                   dvt1w=0                   dvt2w=0
+ nlx=0                     w0=0                      k3b=0
+ vfb=-1.206446             vsat=124656.7             lvsat=-0.005038549+dlvsatp_25
+ wvsat=0.05827999          pvsat=-6.305896e-08       ua=1.046701e-09
+ lua=-3.714873e-16         wua=-4.068017e-16         pua=8.738602e-22
+ ub=7.067158e-19           lub=3.333084e-25          wub=3.837701e-24
+ pub=-2.607462e-30         uc=-4.644377e-11          luc=4.057539e-17
+ wuc=1.226846e-16          puc=-1.442781e-22         rdsw=784.6
+ prwb=0                    prwg=0                    wr=1
+ u0=0.01329371             lu0=-9.407475e-10         wu0=1.638803e-09
+ pu0=-1.753279e-15         a0=0.5676079              la0=6.492977e-08
+ wa0=-6.150402e-07         pa0=-7.16353e-15          keta=-0.007487313
+ lketa=-9.390594e-09       wketa=-1.055999e-07       pketa=4.676653e-14
+ a1=0                      a2=0.99                   ags=0.02
+ b0=0                      b1=0                      voff=-0.1058675
+ lvoff=6.336205e-09        wvoff=-9.207594e-08       pvoff=1.418649e-14
+ nfactor=1                 cit=2.032099e-05          lcit=-3.830841e-13
+ wcit=-4.465096e-12        pcit=-2.405385e-17        cdsc=0
+ cdscb=0                   cdscd=0                   eta0=-8.098595e-05
+ leta0=1.417268e-10        etab=8.098595e-05         letab=-1.417268e-10
+ dsub=0                    pclm=0.6741349            lpclm=2.798603e-08
+ wpclm=-3.321953e-08       ppclm=3.594356e-14        pdiblc1=1e-06
+ pdiblc2=-0.0003715494     lpdiblc2=5.102165e-10     pdiblcb=0.01
+ drout=0                   pscbe1=3.5e+08            pscbe2=5e-07
+ pvag=0                    delta=0.01                alpha0=0
+ alpha1=1.0857             beta0=23.74               kt1=-0.2727011
+ lkt1=-3.241333e-09        wkt1=-1.937851e-07        pkt1=1.068268e-13
+ kt2=-0.02877774           lkt2=1.094401e-09         wkt2=-4.380376e-09
+ pkt2=2.946302e-15         at=-50000                 ute=-0.8358768
+ lute=-2.038169e-08        wute=4.007488e-07         pute=2.575322e-14
+ ua1=1.752e-09             ub1=-2.01657e-18          lub1=-3.283118e-26
+ wub1=4.298972e-25         pub1=-9.761699e-32        uc1=-1.267933e-12
+ luc1=-6.533462e-18        wuc1=2.523737e-16         puc1=-7.934643e-23
+ kt1l=0                    prt=0                     cj=cjp_25
+ mj=0.3952264              pb=0.854899               cjsw=cjswp_25
+ mjsw=0.0450429            pbsw=0.854899             cjswg=cjswgp_25
+ mjswg=0.0450429           pbswg=0.854899            tpb=0.001603538
+ tpbsw=0.001603538         tpbswg=0.001603538        tcj=0.0009016089
+ tcjsw=0.0001793034        tcjswg=0.0001793034       js=2.0e-7
+ jsw=1.36e-12              n=1                       xti=3
+ cgdo=cgop_25              cgso=cgop_25              capmod=3
+ nqsmod=0                  xpart=1                   cf=0
+ tlev=1                    tlevc=1                   dlc=3.90e-8
+ cgbo=0                    cgdl=cglp_25              cgsl=cglp_25
+ wwc=-1.20e-2              dwc=0                     noia=5.0e+19
+ noib=4.0e+3               noic=8.0e-12              em=4.1e+7
+ ef=1.152                  noimod=2                  sa0=0.35e-6
+ sb0=0.35e-6               kvsat=-1                  wlod=0.3e-6
+ tku0=0.03                 ku0=8.5e-08               llodku0=1
+ wlodku0=1                 lku0=8.0e-09              wku0=6.0e-07
+ pku0=0                    kvth0=1.0e-09             stk2=0
+ steta0=-3e-10             lkvth0=-1.0e-10           wkvth0=0
+ pkvth0=0                  llodvth=1                 wlodvth=1
+ lodk2=1                   lodeta0=1                 minr=1e-3
+ imax=0.01                 imelt=0.01

     3: type=p
+ lmin=2.8e-07              lmax=5.0e-07-dxl_25       wmin=1.001e-05-dxw_25
+ wmax=0.0009001            tnom=25                   version=3.24
+ tox=toxp_25               toxm=toxp_25              xj=2.1e-07
+ nch=7.22e+17              lln=1                     lwn=1
+ wln=1                     wwn=-1                    lint=4.4e-08
+ wint=5e-09                mobmod=1                  binunit=2
+ xl=-4e-08+dxl_25          xw=1e-8+dxw_25            dwg=0
+ dwb=0                     ldif=8e-08                hdif=hdifp_25
+ rsh=7.2                   rd=0                      rs=0
+ vth0=-0.6284454+dvthp_25  lvth0=1.6117434e-08+dlvthp_25
+ wvth0=-1.0891628e-07+dwvthp_25                      pvth0=6.3879290e-14+dpvthp_25
+ k1=0.7489086              lk1=5.587764e-08          wk1=1.334465e-07
+ pk1=-3.370194e-14         k2=0.05316933+dk2p_25     lk2=-3.856831e-08+dlk2p_25
+ wk2=-9.384368e-08         pk2=1.797131e-14          k3=0
+ dvt0=0                    dvt1=0                    dvt2=0
+ dvt0w=0                   dvt1w=0                   dvt2w=0
+ nlx=0                     w0=0                      k3b=0
+ vfb=-1.495219             vsat=118875.6             lvsat=-0.002887961+dlvsatp_25
+ wvsat=-0.1889443          pvsat=2.890847e-08        ua=6.619991e-11
+ lua=-6.740967e-18         wua=3.007804e-15          pua=-3.963729e-22
+ ub=1.578969e-18           lub=8.830356e-27          wub=-4.495365e-24
+ pub=4.924388e-31          uc=8.285272e-11           luc=-7.522903e-18
+ wuc=-3.996817e-16         puc=5.004216e-23          rdsw=784.6
+ prwb=0                    prwg=0                    wr=1
+ u0=0.011449               lu0=-2.545132e-10         wu0=-1.235081e-09
+ pu0=-6.841936e-16         a0=0.5632573              la0=6.654819e-08
+ wa0=-2.654111e-07         pa0=-1.372255e-13         keta=-0.05200238
+ lketa=7.169009e-09        wketa=3.575234e-08        pketa=-5.816519e-15
+ a1=0                      a2=0.99                   ags=0.02
+ b0=0                      b1=0                      voff=-0.08734847
+ lvoff=-5.528529e-10       wvoff=-1.308841e-07       pvoff=2.862312e-14
+ nfactor=1                 cit=1.408297e-05          lcit=1.937458e-12
+ wcit=5.14631e-10          pcit=-2.171576e-16        cdsc=0
+ cdscb=0                   cdscd=0                   eta0=-1.0353073e-03
+ leta0=4.9673430e-10       weta0=1.4765083e-08       peta0=-5.4926110e-15
+ etab=0.001586302          letab=-7.017043e-10       dsub=0
+ pclm=0.6094105            lpclm=5.206348e-08        wpclm=8.637496e-08
+ ppclm=-8.545629e-15       pdiblc1=1e-06             pdiblc2=-0.005287672
+ lpdiblc2=2.339014e-09     pdiblcb=0.01              drout=0
+ pscbe1=3.5e+08            pscbe2=5e-07              pvag=0
+ delta=0.01                alpha0=0                  alpha1=1.0857
+ beta0=23.74               kt1=-0.2832858            lkt1=6.96172e-10
+ wkt1=6.857672e-07         pkt1=-2.203667e-13        kt2=-0.02031674
+ lkt2=-2.053089e-09        wkt2=1.694691e-08         pkt2=-4.987448e-15
+ at=-50000                 ute=-0.8439304            lute=-1.738578e-08
+ wute=8.030051e-07         pute=-1.238861e-13        ua1=1.752e-09
+ ub1=-2.179324e-18         lub1=2.771347e-26         wub1=5.107105e-25
+ pub1=-1.276796e-31        uc1=-4.301871e-11         luc1=8.997827e-18
+ wuc1=7.733619e-17         puc1=-1.423249e-23        kt1l=0
+ prt=0                     cj=cjp_25                 mj=0.3952264
+ pb=0.854899               cjsw=cjswp_25             mjsw=0.0450429
+ pbsw=0.854899             cjswg=cjswgp_25           mjswg=0.0450429
+ pbswg=0.854899            tpb=0.001603538           tpbsw=0.001603538
+ tpbswg=0.001603538        tcj=0.0009016089          tcjsw=0.0001793034
+ tcjswg=0.0001793034       js=2.0e-7                 jsw=1.36e-12
+ n=1                       xti=3                     cgdo=cgop_25
+ cgso=cgop_25              capmod=3                  nqsmod=0
+ xpart=1                   cf=0                      tlev=1
+ tlevc=1                   dlc=3.90e-8               cgbo=0
+ cgdl=cglp_25              cgsl=cglp_25              wwc=-1.20e-2
+ dwc=0                     noia=5.0e+19              noib=4.0e+3
+ noic=8.0e-12              em=4.1e+7                 ef=1.152
+ noimod=2                  sa0=0.35e-6               sb0=0.35e-6
+ kvsat=-1                  wlod=0.3e-6               tku0=0.03
+ ku0=8.5e-08               llodku0=1                 wlodku0=1
+ lku0=8.0e-09              wku0=6.0e-07              pku0=0
+ kvth0=1.0e-09             stk2=0                    steta0=-3e-10
+ lkvth0=-1.0e-10           wkvth0=0                  pkvth0=0
+ llodvth=1                 wlodvth=1                 lodk2=1
+ lodeta0=1                 minr=1e-3                 imax=0.01
+ imelt=0.01

     4: type=p
+ lmin=1.21e-06-dxl_25      lmax=2.1e-05              wmin=1.21e-06-dxw_25
+ wmax=1.001e-05-dxw_25     tnom=25                   version=3.24
+ tox=toxp_25               toxm=toxp_25              xj=2.1e-07
+ nch=7.22e+17              lln=1                     lwn=1
+ wln=1                     wwn=-1                    lint=4.4e-08
+ wint=5e-09                mobmod=1                  binunit=2
+ xl=-4e-08+dxl_25          xw=1e-8+dxw_25            dwg=0
+ dwb=0                     ldif=8e-08                hdif=hdifp_25
+ rsh=7.2                   rd=0                      rs=0
+ vth0=-0.5922534+dvthp_25  lvth0=-9.883339e-09+dlvthp_25
+ wvth0=1.1564e-08+dwvthp_25                          pvth0=9.071176e-15+dpvthp_25
+ k1=0.8575256              lk1=7.085931e-09          wk1=-2.540683e-08
+ pk1=-2.081279e-14         k2=-0.02769539+dk2p_25    lk2=-4.377368e-09+dlk2p_25
+ wk2=-1.162411e-08         pk2=4.651531e-15          k3=0
+ dvt0=0                    dvt1=0                    dvt2=0
+ dvt0w=0                   dvt1w=0                   dvt2w=0
+ nlx=0                     w0=0                      k3b=0
+ vfb=-1.127317             vsat=153796.5             lvsat=-0.03805559+dlvsatp_25
+ wvsat=-0.001658336        pvsat=1.668667e-08        ua=1.147473e-09
+ lua=-4.318336e-16         wua=5.169694e-16          pua=-6.130409e-22
+ ub=4.268081e-19           lub=8.35886e-25           wub=-4.492706e-25
+ pub=3.187007e-32          uc=-8.933044e-11          luc=9.463186e-17
+ wuc=-6.311084e-17         puc=-1.985492e-23         rdsw=784.6
+ prwb=0                    prwg=0                    wr=1
+ u0=0.01206673             lu0=7.395418e-10          wu0=-5.939101e-10
+ pu0=-2.867913e-15         a0=0.7233278              la0=-1.808745e-07
+ wa0=1.315347e-08          pa0=8.705841e-14          keta=0.00107581
+ lketa=-2.662966e-08       wketa=-1.412713e-09       pketa=1.385335e-14
+ a1=0                      a2=0.99                   ags=0.02
+ b0=0                      b1=0                      voff=-0.1011136
+ lvoff=-6.524667e-09       wvoff=-2.192446e-08       pvoff=1.553147e-14
+ nfactor=1                 cit=1.048439e-05          lcit=8.311773e-12
+ wcit=8.952415e-13         pcit=-1.035085e-17        cdsc=0
+ cdscb=0                   cdscd=0                   eta0=5e-05
+ etab=-5e-05               dsub=0                    pclm=0.7
+ pdiblc1=1e-06             pdiblc2=0.0001            pdiblcb=0.01
+ drout=0                   pscbe1=1.818512e+08       lpscbe1=181.937
+ wpscbe1=-0.05602397       ppscbe1=6.060409e-08      pscbe2=5e-07
+ pvag=0                    delta=0.01                alpha0=0
+ alpha1=1.0857             beta0=23.74               kt1=-0.2807457
+ lkt1=-1.005078e-08        wkt1=2.829763e-08         pkt1=2.182622e-14
+ kt2=-0.02625579           lkt2=-1.664142e-09        wkt2=-3.803102e-09
+ pkt2=2.619913e-15         at=-50000                 ute=-0.7465684
+ lute=-8.281842e-08        wute=-9.550956e-09        pute=1.274053e-13
+ ua1=1.752e-09             ub1=-2.026951e-18         lub1=4.385948e-26
+ wub1=-3.786033e-25        pub1=1.2194e-31           uc1=1.347552e-11
+ luc1=-4.228754e-18        wuc1=3.56234e-17          puc1=-2.757639e-23
+ kt1l=0                    prt=0                     cj=cjp_25
+ mj=0.3952264              pb=0.854899               cjsw=cjswp_25
+ mjsw=0.0450429            pbsw=0.854899             cjswg=cjswgp_25
+ mjswg=0.0450429           pbswg=0.854899            tpb=0.001603538
+ tpbsw=0.001603538         tpbswg=0.001603538        tcj=0.0009016089
+ tcjsw=0.0001793034        tcjswg=0.0001793034       js=2.0e-7
+ jsw=1.36e-12              n=1                       xti=3
+ cgdo=cgop_25              cgso=cgop_25              capmod=3
+ nqsmod=0                  xpart=1                   cf=0
+ tlev=1                    tlevc=1                   dlc=3.90e-8
+ cgbo=0                    cgdl=cglp_25              cgsl=cglp_25
+ wwc=-1.20e-2              dwc=0                     noia=5.0e+19
+ noib=4.0e+3               noic=8.0e-12              em=4.1e+7
+ ef=1.152                  noimod=2                  sa0=0.35e-6
+ sb0=0.35e-6               kvsat=-1                  wlod=0.3e-6
+ tku0=0.03                 ku0=8.5e-08               llodku0=1
+ wlodku0=1                 lku0=8.0e-09              wku0=6.0e-07
+ pku0=0                    kvth0=1.0e-09             stk2=0
+ steta0=-3e-10             lkvth0=-1.0e-10           wkvth0=0
+ pkvth0=0                  llodvth=1                 wlodvth=1
+ lodk2=1                   lodeta0=1                 minr=1e-3
+ imax=0.01                 imelt=0.01

     5: type=p
+ lmin=5.0e-07-dxl_25       lmax=1.21e-06-dxl_25      wmin=1.21e-06-dxw_25
+ wmax=1.001e-05-dxw_25     tnom=25                   version=3.24
+ tox=toxp_25               toxm=toxp_25              xj=2.1e-07
+ nch=7.22e+17              lln=1                     lwn=1
+ wln=1                     wwn=-1                    lint=4.4e-08
+ wint=5e-09                mobmod=1                  binunit=2
+ xl=-4e-08+dxl_25          xw=1e-8+dxw_25            dwg=0
+ dwb=0                     ldif=8e-08                hdif=hdifp_25
+ rsh=7.2                   rd=0                      rs=0
+ vth0=-0.6129133+dvthp_25  lvth0=1.247063e-08+dlvthp_25
+ wvth0=2.754078e-08+dwvthp_25                        pvth0=-8.215706e-15+dpvthp_25
+ k1=0.8429049              lk1=2.290554e-08          wk1=-6.236289e-08
+ pk1=1.917367e-14          k2=-0.02060185+dk2p_25    lk2=-1.205258e-08+dlk2p_25
+ wk2=-3.77261e-10          pk2=-7.517555e-15         k3=0
+ dvt0=0                    dvt1=0                    dvt2=0
+ dvt0w=0                   dvt1w=0                   dvt2w=0
+ nlx=0                     w0=0                      k3b=0
+ vfb=-1.202873             vsat=129103.9             lvsat=-0.01133815+dlvsatp_25
+ wvsat=0.01376372          ua=1.015496e-09           lua=-2.890341e-16
+ wua=-9.443952e-17         pua=4.850352e-23          ub=1.167577e-18
+ lub=3.437394e-26          wub=-7.755197e-25         pub=3.848716e-31
+ uc=-2.296296e-11          luc=2.282225e-17          wuc=-1.123583e-16
+ puc=3.343085e-23          rdsw=784.6                prwb=0
+ prwg=0                    wr=1                      u0=0.01386882
+ lu0=-1.210321e-09         wu0=-4.118001e-09         pu0=9.451544e-16
+ a0=0.4799562              la0=8.245356e-08          wa0=2.623542e-07
+ pa0=-1.825767e-13         keta=-0.02015385          lketa=-3.659164e-09
+ wketa=2.119212e-08        pketa=-1.060508e-14       a1=0
+ a2=0.99                   ags=0.02                  b0=0
+ b1=0                      voff=-0.1149526           lvoff=8.449195e-09
+ wvoff=-1.133325e-09       pvoff=-6.964544e-15       nfactor=1
+ cit=2.131856e-05          lcit=-3.410794e-12        wcit=-1.445077e-11
+ pcit=6.253531e-18         cdsc=0                    cdscb=0
+ cdscd=0                   eta0=-8.098591e-05        leta0=1.417268e-10
+ etab=8.098591e-05         letab=-1.417268e-10       dsub=0
+ pclm=0.6708455            lpclm=3.154515e-08        wpclm=-2.92759e-10
+ ppclm=3.167668e-16        pdiblc1=1e-06             pdiblc2=-0.0003715492
+ lpdiblc2=5.102164e-10     pdiblcb=0.01              drout=0
+ pscbe1=3.5e+08            pscbe2=5e-07              pvag=0
+ delta=0.01                alpha0=0                  alpha1=1.0857
+ beta0=23.74               kt1=-0.2989441            lkt1=9.639789e-09
+ wkt1=6.890713e-08         pkt1=-2.211326e-14        kt2=-0.02924375
+ lkt2=1.568834e-09         wkt2=2.844058e-10         pkt2=-1.802771e-15
+ at=-50000                 ute=-0.8074903            lute=-1.690082e-08
+ wute=1.166002e-07         pute=-9.090245e-15        ua1=1.752e-09
+ ub1=-1.944364e-18         lub1=-4.54994e-26         wub1=-2.928843e-25
+ pub1=2.919198e-32         uc1=2.44614e-11           luc1=-1.611548e-17
+ wuc1=-5.176931e-18        puc1=1.656957e-23         kt1l=0
+ prt=0                     cj=cjp_25                 mj=0.3952264
+ pb=0.854899               cjsw=cjswp_25             mjsw=0.0450429
+ pbsw=0.854899             cjswg=cjswgp_25           mjswg=0.0450429
+ pbswg=0.854899            tpb=0.001603538           tpbsw=0.001603538
+ tpbswg=0.001603538        tcj=0.0009016089          tcjsw=0.0001793034
+ tcjswg=0.0001793034       js=2.0e-7                 jsw=1.36e-12
+ n=1                       xti=3                     cgdo=cgop_25
+ cgso=cgop_25              capmod=3                  nqsmod=0
+ xpart=1                   cf=0                      tlev=1
+ tlevc=1                   dlc=3.90e-8               cgbo=0
+ cgdl=cglp_25              cgsl=cglp_25              wwc=-1.20e-2
+ dwc=0                     noia=5.0e+19              noib=4.0e+3
+ noic=8.0e-12              em=4.1e+7                 ef=1.152
+ noimod=2                  sa0=0.35e-6               sb0=0.35e-6
+ kvsat=-1                  wlod=0.3e-6               tku0=0.03
+ ku0=8.5e-08               llodku0=1                 wlodku0=1
+ lku0=8.0e-09              wku0=6.0e-07              pku0=0
+ kvth0=1.0e-09             stk2=0                    steta0=-3e-10
+ lkvth0=-1.0e-10           wkvth0=0                  pkvth0=0
+ llodvth=1                 wlodvth=1                 lodk2=1
+ lodeta0=1                 minr=1e-3                 imax=0.01
+ imelt=0.01

     6: type=p
+ lmin=2.8e-07              lmax=5.0e-07-dxl_25       wmin=1.21e-06-dxw_25
+ wmax=1.001e-05-dxw_25     tnom=25                   version=3.24
+ tox=toxp_25               toxm=toxp_25              xj=2.1e-07
+ nch=7.22e+17              lln=1                     lwn=1
+ wln=1                     wwn=-1                    lint=4.4e-08
+ wint=5e-09                mobmod=1                  binunit=2
+ xl=-4e-08+dxl_25          xw=1e-8+dxw_25            dwg=0
+ dwb=0                     ldif=8e-08                hdif=hdifp_25
+ rsh=7.2                   rd=0                      rs=0
+ vth0=-0.64129175+dvthp_25 lvth0=2.3027418e-08+dlvthp_25
+ wvth0=1.9674751e-08+dwvthp_25                       pvth0=-5.2895013e-15+dpvthp_25
+ k1=0.7562134              lk1=5.515479e-08          wk1=6.032497e-08
+ pk1=-2.646622e-14         k2=0.0499368+dk2p_25      lk2=-3.829295e-08+dlk2p_25
+ wk2=-6.148596e-08         pk2=1.521488e-14          k3=0
+ dvt0=0                    dvt1=0                    dvt2=0
+ dvt0w=0                   dvt1w=0                   dvt2w=0
+ nlx=0                     w0=0                      k3b=0
+ vfb=-1.400653             vsat=98625.01             wvsat=0.01376373
+ ua=3.604407e-10           lvsat=0+dlvsatp_25        lua=-4.535359e-17
+ wua=6.245323e-17          pua=-9.8606e-24           ub=1.114336e-18
+ lub=5.417961e-26          wub=1.556058e-25          pub=3.849286e-32
+ uc=4.846232e-11           luc=-3.747956e-18         wuc=-5.543386e-17
+ puc=1.225494e-23          rdsw=784.6                prwb=0
+ prwg=0                    wr=1                      u0=0.01144613
+ lu0=-3.090805e-10         wu0=-1.206365e-09         pu0=-1.379744e-16
+ a0=0.5519273              la0=5.56803e-08           wa0=-1.519973e-07
+ pa0=-2.843797e-14         keta=-0.04863737          lketa=6.936704e-09
+ wketa=2.068658e-09        pketa=-3.491148e-15       a1=0
+ a2=0.99                   ags=0.02                  b0=0
+ b1=0                      voff=-0.0989763           lvoff=2.506003e-09
+ wvoff=-1.448955e-08       pvoff=-1.99603e-15        nfactor=1
+ cit=7.246053e-05          lcit=-2.243561e-11        wcit=-6.972834e-11
+ pcit=2.681678e-17         cdsc=0                    cdscb=0
+ cdscd=0                   eta0=6.2043840e-04        leta0=-1.1920305e-10
+ weta0=-1.8089307e-09      peta0=6.7292220e-16       etab=0.001636668
+ letab=-7.204406e-10       wetab=-5.041685e-10       petab=1.875508e-16
+ dsub=0                    pclm=0.6178901            lpclm=5.124457e-08
+ wpclm=1.495026e-09        ppclm=-3.482891e-16       pdiblc1=1e-06
+ pdiblc2=-0.005677225      lpdiblc2=2.483928e-09     wpdiblc2=3.899443e-09
+ ppdiblc2=-1.450593e-15    pdiblcb=0.01              drout=0
+ pscbe1=3.5e+08            pscbe2=5e-07              pvag=0
+ delta=0.01                alpha0=0                  alpha1=1.0857
+ beta0=23.74               kt1=-0.2076636            lkt1=-2.431654e-08
+ wkt1=-7.121064e-08        pkt1=3.001055e-14         kt2=-0.01723043
+ lkt2=-2.900122e-09        wkt2=-1.394708e-08        pkt2=3.491342e-15
+ at=-50000                 ute=-0.763168             lute=-3.338875e-08
+ wute=-5.426509e-09        pute=3.63037e-14          ua1=1.752e-09
+ ub1=-2.122632e-18         lub1=2.081626e-26         wub1=-5.678085e-26
+ pub1=-5.863848e-32        uc1=-4.384848e-11         luc1=9.295796e-18
+ wuc1=8.56422e-17          puc1=-1.721515e-23        kt1l=0
+ prt=0                     cj=cjp_25                 mj=0.3952264
+ pb=0.854899               cjsw=cjswp_25             mjsw=0.0450429
+ pbsw=0.854899             cjswg=cjswgp_25           mjswg=0.0450429
+ pbswg=0.854899            tpb=0.001603538           tpbsw=0.001603538
+ tpbswg=0.001603538        tcj=0.0009016089          tcjsw=0.0001793034
+ tcjswg=0.0001793034       js=2.0e-7                 jsw=1.36e-12
+ n=1                       xti=3                     cgdo=cgop_25
+ cgso=cgop_25              capmod=3                  nqsmod=0
+ xpart=1                   cf=0                      tlev=1
+ tlevc=1                   dlc=3.90e-8               cgbo=0
+ cgdl=cglp_25              cgsl=cglp_25              wwc=-1.20e-2
+ dwc=0                     noia=5.0e+19              noib=4.0e+3
+ noic=8.0e-12              em=4.1e+7                 ef=1.152
+ noimod=2                  sa0=0.35e-6               sb0=0.35e-6
+ kvsat=-1                  wlod=0.3e-6               tku0=0.03
+ ku0=8.5e-08               llodku0=1                 wlodku0=1
+ lku0=8.0e-09              wku0=6.0e-07              pku0=0
+ kvth0=1.0e-09             stk2=0                    steta0=-3e-10
+ lkvth0=-1.0e-10           wkvth0=0                  pkvth0=0
+ llodvth=1                 wlodvth=1                 lodk2=1
+ lodeta0=1                 minr=1e-3                 imax=0.01
+ imelt=0.01

     7: type=p
+ lmin=1.21e-06-dxl_25      lmax=2.1e-05              wmin=6.0e-07-dxw_25
+ wmax=1.21e-06-dxw_25      tnom=25                   version=3.24
+ tox=toxp_25               toxm=toxp_25              xj=2.1e-07
+ nch=7.22e+17              lln=1                     lwn=1
+ wln=1                     wwn=-1                    lint=4.4e-08
+ wint=5e-09                mobmod=1                  binunit=2
+ xl=-4e-08+dxl_25          xw=1e-8+dxw_25            dwg=0
+ dwb=0                     ldif=8e-08                hdif=hdifp_25
+ rsh=7.2                   rd=0                      rs=0
+ vth0=-0.5992672+dvthp_25  lvth0=-7.1468280e-09+dlvthp_25
+ wvth0=2.0050809e-08+dwvthp_25                       pvth0=5.7599960e-15+dpvthp_25
+ k1=0.8393803              lk1=7.818752e-08          wk1=-3.450927e-09
+ pk1=-1.068457e-13         k2=-0.0232941+dk2p_25     lk2=-2.852199e-08+dlk2p_25
+ wk2=-1.694966e-08         pk2=3.386652e-14          k3=0
+ dvt0=0                    dvt1=0                    dvt2=0
+ dvt0w=0                   dvt1w=0                   dvt2w=0
+ nlx=0                     w0=0                      k3b=0
+ vfb=-1.06531              vsat=1.5151247e+05        lvsat=-1.4868828e-02+dlvsatp_25
+ wvsat=1.1053857e-03       pvsat=-1.1369312e-08      ua=1.593407e-09
+ lua=-1.699494e-15         wua=-2.26105e-17          pua=9.208276e-22
+ ub=8.789761e-20           lub=1.438693e-24          wub=-3.91891e-26
+ pub=-6.975265e-31         uc=-1.184087e-10          luc=1.21185e-16
+ wuc=-2.792616e-17         puc=-5.198425e-23         rdsw=784.6
+ prwb=0                    prwg=0                    wr=1
+ u0=1.2091756e-02          lu0=-2.2600737e-09        wu0=-6.2419320e-10
+ pu0=7.6162230e-16         a0=0.7575957              la0=-1.613768e-07
+ wa0=-2.831067e-08         pa0=6.346613e-14          keta=-0.008150994
+ lketa=-7.12548e-09        wketa=9.75172e-09         pketa=-9.746704e-15
+ a1=0                      a2=0.99                   ags=0.02
+ b0=0                      b1=0                      voff=-0.1091749
+ lvoff=1.926894e-08        wvoff=-1.21703e-08        pvoff=-1.56788e-14
+ nfactor=1                 cit=1.028907e-05          lcit=-3.700675e-12
+ wcit=1.131583e-12         pcit=4.184211e-18         cdsc=0
+ cdscb=0                   cdscd=0                   eta0=5e-05
+ etab=-5e-05               dsub=0                    pclm=0.7
+ pdiblc1=1e-06             pdiblc2=0.0001            pdiblcb=0.01
+ drout=0                   pscbe1=1.816656e+08       lpscbe1=182.1378
+ wpscbe1=0.1686224         ppscbe1=-1.824365e-07     pscbe2=5e-07
+ pvag=0                    delta=0.01                alpha0=0
+ alpha1=1.0857             beta0=23.74               kt1=-0.2650141
+ lkt1=3.060901e-08         wkt1=9.262272e-09         pkt1=-2.737213e-14
+ kt2=-0.02659608           lkt2=-9.365801e-10        wkt2=-3.391348e-09
+ pkt2=1.739564e-15         at=-50000                 ute=-0.7751827
+ lute=-3.3878e-08          wute=2.507235e-08         pute=6.818743e-14
+ ua1=1.752e-09             ub1=-2.199571e-18         lub1=1.941438e-25
+ wub1=-1.697329e-25        pub1=-5.990399e-32        uc1=2.047029e-11
+ luc1=-7.065085e-17        wuc1=2.715974e-17         puc1=5.279434e-23
+ kt1l=0                    prt=0                     cj=cjp_25
+ mj=0.3952264              pb=0.854899               cjsw=cjswp_25
+ mjsw=0.0450429            pbsw=0.854899             cjswg=cjswgp_25
+ mjswg=0.0450429           pbswg=0.854899            tpb=0.001603538
+ tpbsw=0.001603538         tpbswg=0.001603538        tcj=0.0009016089
+ tcjsw=0.0001793034        tcjswg=0.0001793034       js=2.0e-7
+ jsw=1.36e-12              n=1                       xti=3
+ cgdo=cgop_25              cgso=cgop_25              capmod=3
+ nqsmod=0                  xpart=1                   cf=0
+ tlev=1                    tlevc=1                   dlc=3.90e-8
+ cgbo=0                    cgdl=cglp_25              cgsl=cglp_25
+ wwc=-1.20e-2              dwc=0                     noia=5.0e+19
+ noib=4.0e+3               noic=8.0e-12              em=4.1e+7
+ ef=1.152                  noimod=2                  sa0=0.35e-6
+ sb0=0.35e-6               kvsat=-1                  wlod=0.3e-6
+ tku0=0.03                 ku0=8.5e-08               llodku0=1
+ wlodku0=1                 lku0=8.0e-09              wku0=6.0e-07
+ pku0=0                    kvth0=1.0e-09             stk2=0
+ steta0=-3e-10             lkvth0=-1.0e-10           wkvth0=0
+ pkvth0=0                  llodvth=1                 wlodvth=1
+ lodk2=1                   lodeta0=1                 minr=1e-3
+ imax=0.01                 imelt=0.01

     8: type=p
+ lmin=5.0e-07-dxl_25       lmax=1.21e-06-dxl_25      wmin=6.0e-07-dxw_25
+ wmax=1.21e-06-dxw_25      tnom=25                   version=3.24
+ tox=toxp_25               toxm=toxp_25              xj=2.1e-07
+ nch=7.22e+17              lln=1                     lwn=1
+ wln=1                     wwn=-1                    lint=4.4e-08
+ wint=5e-09                mobmod=1                  binunit=2
+ xl=-4e-08+dxl_25          xw=1e-8+dxw_25            dwg=0
+ dwb=0                     ldif=8e-08                hdif=hdifp_25
+ rsh=7.2                   rd=0                      rs=0
+ vth0=-0.6085479+dvthp_25  lvth0=2.8947529e-09+dlvthp_25
+ wvth0=2.2258657e-08+dwvthp_25                       pvth0=3.3711050e-15+dpvthp_25
+ k1=0.8795801              lk1=3.469126e-08          wk1=-1.067399e-07
+ pk1=4.912946e-15          k2=-0.03444811+dk2p_25    lk2=-1.645334e-08+dlk2p_25
+ wk2=1.637671e-08          pk2=-2.192623e-15         k3=0
+ dvt0=0                    dvt1=0                    dvt2=0
+ dvt0w=0                   dvt1w=0                   dvt2w=0
+ nlx=0                     w0=0                      k3b=0
+ vfb=-1.151843             vsat=1.4974394e+05        lvsat=-1.2955281e-02+dlvsatp_25
+ wvsat=-1.1210743e-02      pvsat=1.9567394e-09       ua=1.370687e-10
+ lua=-1.237355e-16         wua=9.684573e-16          pua=-1.515078e-22
+ ub=1.175233e-18           lub=2.621967e-25          wub=-7.847829e-25
+ pub=1.09206e-31           uc=-4.802621e-11          luc=4.503118e-17
+ wuc=-8.203179e-17         puc=6.558037e-24          rdsw=784.6
+ prwb=0                    prwg=0                    wr=1
+ u0=1.0040139e-02          lu0=-4.0224790e-11        wu0=5.1470170e-10
+ pu0=-4.7066220e-16        a0=0.6512433              la0=-4.630351e-08
+ wa0=5.509672e-08          pa0=-2.678067e-14         keta=-0.0006901813
+ lketa=-1.519808e-08       wketa=-2.35892e-09        pketa=3.357009e-15
+ a1=0                      a2=0.99                   ags=0.02
+ b0=0                      b1=0                      voff=-0.09068604
+ lvoff=-7.359535e-10       wvoff=-3.049589e-08       pvoff=4.149486e-15
+ nfactor=1                 cit=1.585603e-06          lcit=5.716471e-12
+ wcit=9.426105e-12         pcit=-4.790461e-18        cdsc=0
+ cdscb=0                   cdscd=0                   eta0=-8.098595e-05
+ leta0=1.417268e-10        etab=8.098595e-05         letab=-1.417268e-10
+ dsub=0                    pclm=0.6707457            lpclm=3.165309e-08
+ wpclm=-1.7205e-10         ppclm=1.861598e-16        pdiblc1=1e-06
+ pdiblc2=-0.0003715493     lpdiblc2=5.102163e-10     pdiblcb=0.01
+ drout=0                   pscbe1=3.5e+08            pscbe2=5e-07
+ pvag=0                    delta=0.01                alpha0=0
+ alpha1=1.0857             beta0=23.74               kt1=-0.2293664
+ lkt1=-7.96175e-09         wkt1=-1.528183e-08        pkt1=-8.153993e-16
+ kt2=-0.02929149           lkt2=1.979855e-09         wkt2=3.421735e-10
+ pkt2=-2.300107e-15        at=-50000                 ute=-0.786118
+ lute=-2.204596e-08        wute=9.073968e-08         pute=-2.864625e-15
+ ua1=1.752e-09             ub1=-2.144477e-18         lub1=1.345319e-25
+ wub1=-5.074789e-26        pub1=-1.886458e-31        uc1=-5.920235e-11
+ luc1=1.555495e-17         wuc1=9.605621e-17         puc1=-2.175166e-23
+ kt1l=0                    prt=0                     cj=cjp_25
+ mj=0.3952264              pb=0.854899               cjsw=cjswp_25
+ mjsw=0.0450429            pbsw=0.854899             cjswg=cjswgp_25
+ mjswg=0.0450429           pbswg=0.854899            tpb=0.001603538
+ tpbsw=0.001603538         tpbswg=0.001603538        tcj=0.0009016089
+ tcjsw=0.0001793034        tcjswg=0.0001793034       js=2.0e-7
+ jsw=1.36e-12              n=1                       xti=3
+ cgdo=cgop_25              cgso=cgop_25              capmod=3
+ nqsmod=0                  xpart=1                   cf=0
+ tlev=1                    tlevc=1                   dlc=3.90e-8
+ cgbo=0                    cgdl=cglp_25              cgsl=cglp_25
+ wwc=-1.20e-2              dwc=0                     noia=5.0e+19
+ noib=4.0e+3               noic=8.0e-12              em=4.1e+7
+ ef=1.152                  noimod=2                  sa0=0.35e-6
+ sb0=0.35e-6               kvsat=-1                  wlod=0.3e-6
+ tku0=0.03                 ku0=8.5e-08               llodku0=1
+ wlodku0=1                 lku0=8.0e-09              wku0=6.0e-07
+ pku0=0                    kvth0=1.0e-09             stk2=0
+ steta0=-3e-10             lkvth0=-1.0e-10           wkvth0=0
+ pkvth0=0                  llodvth=1                 wlodvth=1
+ lodk2=1                   lodeta0=1                 minr=1e-3
+ imax=0.01                 imelt=0.01

     9: type=p
+ lmin=2.8e-07              lmax=5.0e-07-dxl_25       wmin=6.0e-07-dxw_25
+ wmax=1.21e-06-dxw_25      tnom=25                   version=3.24
+ tox=toxp_25               toxm=toxp_25              xj=2.1e-07
+ nch=7.22e+17              lln=1                     lwn=1
+ wln=1                     wwn=-1                    lint=4.4e-08
+ wint=5e-09                mobmod=1                  binunit=2
+ xl=-4e-08+dxl_25          xw=1e-8+dxw_25            dwg=0
+ dwb=0                     ldif=8e-08                hdif=hdifp_25
+ rsh=7.2                   rd=0                      rs=0
+ vth0=-0.6618531+dvthp_25  lvth0=2.3456141e-08+dlvthp_25
+ wvth0=4.4553986e-08+dwvthp_25                       pvth0=-5.8082559e-15+dpvthp_25
+ k1=0.8808538              lk1=3.421746e-08          wk1=-9.048988e-08
+ pk1=-1.132059e-15         k2=-0.006057074+dk2p_25   lk2=-2.70148e-08+dlk2p_25
+ wk2=6.266628e-09          pk2=1.568326e-15          k3=0
+ dvt0=0                    dvt1=0                    dvt2=0
+ dvt0w=0                   dvt1w=0                   dvt2w=0
+ nlx=0                     w0=0                      k3b=0
+ vfb=-1.324404             vsat=1.1491786e+05        wvsat=-5.9506270e-03
+ ua=-8.698593e-11          lvsat=0+dlvsatp_25        lua=-4.038723e-17
+ wua=6.038394e-16          pua=-1.586989e-23         ub=1.78987e-18
+ lub=3.355171e-26          wub=-6.617899e-25         pub=6.345261e-32
+ uc=7.120311e-11           luc=6.778718e-19          wuc=-8.295021e-17
+ puc=6.899692e-24          rdsw=784.6                prwb=0
+ prwg=0                    wr=1                      u0=1.1040227e-02
+ lu0=-4.1225770e-10        wu0=-7.1522370e-10        pu0=-1.3130011e-17
+ a0=0.1588304              la0=1.368741e-07          wa0=3.236498e-07
+ pa0=-1.266824e-13         keta=-0.06285268          lketa=7.92637e-09
+ wketa=1.926918e-08        pketa=-4.688643e-15       a1=0
+ a2=0.99                   ags=0.02                  b0=0
+ b1=0                      voff=-0.09780298          lvoff=1.911548e-09
+ wvoff=-1.590926e-08       pvoff=-1.276739e-15       nfactor=1
+ cit=1.980478e-05          lcit=-1.061061e-12        wcit=-6.014867e-12
+ pcit=9.535804e-19         cdsc=0                    cdscb=0
+ cdscd=0                   eta0=-0.0009974771        leta0=4.826614e-10
+ weta0=1.48747e-10         peta0=-5.53338e-17        etab=0.001379087
+ letab=-6.246204e-10       wetab=-1.924957e-10       petab=7.16084e-17
+ dsub=0                    pclm=0.6065102            lpclm=5.554868e-08
+ wpclm=1.526458e-08        ppclm=-5.556266e-15       pdiblc1=1e-06
+ pdiblc2=-0.002816108      lpdiblc2=1.419592e-09     wpdiblc2=4.374904e-10
+ ppdiblc2=-1.627465e-16    pdiblcb=0.01              drout=0
+ pscbe1=3.5e+08            pscbe2=5e-07              pvag=0
+ delta=0.01                alpha0=0                  alpha1=1.0857
+ beta0=23.74               kt1=-0.2405469            lkt1=-3.802616e-09
+ wkt1=-3.14219e-08         pkt1=5.188704e-15         kt2=-0.02485369
+ lkt2=3.289922e-10         wkt2=-4.722938e-09        pkt2=-4.158854e-16
+ at=-50000                 ute=-0.8233667            lute=-8.189443e-09
+ wute=6.741398e-08         pute=5.812532e-15         ua1=1.752e-09
+ ub1=-1.763057e-18         lub1=-7.356183e-27        wub1=-4.918662e-25
+ pub1=-2.454983e-32        uc1=-1.931131e-11         luc1=7.154812e-19
+ wuc1=5.595222e-17         puc1=-6.83297e-24         kt1l=0
+ prt=0                     cj=cjp_25                 mj=0.3952264
+ pb=0.854899               cjsw=cjswp_25             mjsw=0.0450429
+ pbsw=0.854899             cjswg=cjswgp_25           mjswg=0.0450429
+ pbswg=0.854899            tpb=0.001603538           tpbsw=0.001603538
+ tpbswg=0.001603538        tcj=0.0009016089          tcjsw=0.0001793034
+ tcjswg=0.0001793034       js=2.0e-7                 jsw=1.36e-12
+ n=1                       xti=3                     cgdo=cgop_25
+ cgso=cgop_25              capmod=3                  nqsmod=0
+ xpart=1                   cf=0                      tlev=1
+ tlevc=1                   dlc=3.90e-8               cgbo=0
+ cgdl=cglp_25              cgsl=cglp_25              wwc=-1.20e-2
+ dwc=0                     noia=5.0e+19              noib=4.0e+3
+ noic=8.0e-12              em=4.1e+7                 ef=1.152
+ noimod=2                  sa0=0.35e-6               sb0=0.35e-6
+ kvsat=-1                  wlod=0.3e-6               tku0=0.03
+ ku0=8.5e-08               llodku0=1                 wlodku0=1
+ lku0=8.0e-09              wku0=6.0e-07              pku0=0
+ kvth0=1.0e-09             stk2=0                    steta0=-3e-10
+ lkvth0=-1.0e-10           wkvth0=0                  pkvth0=0
+ llodvth=1                 wlodvth=1                 lodk2=1
+ lodeta0=1                 minr=1e-3                 imax=0.01
+ imelt=0.01

     10: type=p
+ lmin=1.21e-06-dxl_25      lmax=2.1e-05              wmin=1.5e-07
+ wmax=6.0e-07-dxw_25       tnom=25                   version=3.24
+ tox=toxp_25               toxm=toxp_25              xj=2.1e-07
+ nch=7.22e+17              lln=1                     lwn=1
+ wln=1                     wwn=-1                    lint=4.4e-08
+ wint=5e-09                mobmod=1                  binunit=2
+ xl=-4e-08+dxl_25          xw=1e-8+dxw_25            dwg=0
+ dwb=0                     ldif=8e-08                hdif=hdifp_25
+ rsh=7.2                   rd=0                      rs=0
+ vth0=-0.5822442+dvthp_25  lvth0=-1.3901569e-08+dlvthp_25
+ wvth0=9.8369660e-09+dwvthp_25                       pvth0=9.8128400e-15+dpvthp_25
+ k1=0.8588101              lk1=-1.478419e-07         wk1=-1.510885e-08
+ pk1=2.87719e-14           k2=-0.04672182+dk2p_25    lk2=4.641428e-08+dlk2p_25
+ wk2=-2.893036e-09         pk2=-1.109524e-14         k3=0
+ dvt0=0                    dvt1=0                    dvt2=0
+ dvt0w=0                   dvt1w=0                   dvt2w=0
+ nlx=0                     w0=0                      k3b=0
+ vfb=-1.229329             vsat=1.5388923e+05        lvsat=-3.9194710e-02+dlvsatp_25
+ wvsat=-3.2067080e-04      pvsat=3.2262190e-09       ua=1.821198e-09
+ lua=-3.390816e-16         wua=-1.592852e-16         pua=1.045803e-22
+ ub=1.202239e-20           lub=3.826391e-25          wub=6.3361e-27
+ pub=-6.389405e-32         uc=-1.786856e-10          luc=4.024007e-17
+ wuc=8.239978e-18          puc=-3.417275e-24         rdsw=784.6
+ prwb=0                    prwg=0                    wr=1
+ u0=1.1218031e-02          lu0=-6.5310430e-10        wu0=-9.9958720e-11
+ pu0=-2.0255927e-16        a0=0.7173448              la0=-1.817097e-08
+ wa0=-4.160105e-09         pa0=-2.245737e-14         keta=0.01096282
+ lketa=-2.374728e-08       wketa=-1.716568e-09       pketa=2.263752e-16
+ a1=0                      a2=0.99                   ags=0.02
+ b0=0                      b1=0                      voff=-0.1297886
+ lvoff=-1.65654e-08        wvoff=1.979572e-10        pvoff=5.821803e-15
+ nfactor=1                 cit=1.137104e-05          lcit=4.013152e-12
+ wcit=4.823971e-13         pcit=-4.440848e-19        cdsc=0
+ cdscb=0                   cdscd=0                   eta0=5e-05
+ etab=-5e-05               dsub=0                    pclm=0.7
+ pdiblc1=1e-06             pdiblc2=0.0001            pdiblcb=0.01
+ drout=0                   pscbe1=1.819284e+08       lpscbe1=181.8536
+ wpscbe1=0.01095944        ppscbe1=-1.186081e-08     pscbe2=5e-07
+ pvag=0                    delta=0.01                alpha0=0
+ alpha1=1.0857             beta0=23.74               kt1=-0.2577438
+ lkt1=-2.52964e-08         wkt1=4.900084e-09         pkt1=6.17112e-15
+ kt2=-0.03612149           lkt2=6.632142e-09         wkt2=2.323896e-09
+ pkt2=-2.801668e-15        at=-50000                 ute=-0.7377433
+ lute=1.389509e-07         wute=2.608704e-09         pute=-3.550993e-14
+ ua1=1.752e-09             ub1=-2.531863e-18         lub1=3.099194e-25
+ wub1=2.964251e-26         pub1=-1.293694e-31        uc1=8.485323e-11
+ luc1=3.375146e-17         wuc1=-1.147003e-17        puc1=-9.847045e-24
+ kt1l=0                    prt=0                     cj=cjp_25
+ mj=0.3952264              pb=0.854899               cjsw=cjswp_25
+ mjsw=0.0450429            pbsw=0.854899             cjswg=cjswgp_25
+ mjswg=0.0450429           pbswg=0.854899            tpb=0.001603538
+ tpbsw=0.001603538         tpbswg=0.001603538        tcj=0.0009016089
+ tcjsw=0.0001793034        tcjswg=0.0001793034       js=2.0e-7
+ jsw=1.36e-12              n=1                       xti=3
+ cgdo=cgop_25              cgso=cgop_25              capmod=3
+ nqsmod=0                  xpart=1                   cf=0
+ tlev=1                    tlevc=1                   dlc=3.90e-8
+ cgbo=0                    cgdl=cglp_25              cgsl=cglp_25
+ wwc=-1.20e-2              dwc=0                     noia=5.0e+19
+ noib=4.0e+3               noic=8.0e-12              em=4.1e+7
+ ef=1.152                  noimod=2                  sa0=0.35e-6
+ sb0=0.35e-6               kvsat=-1                  wlod=0.3e-6
+ tku0=0.03                 ku0=8.5e-08               llodku0=1
+ wlodku0=1                 lku0=8.0e-09              wku0=6.0e-07
+ pku0=0                    kvth0=1.0e-09             stk2=0
+ steta0=-3e-10             lkvth0=-1.0e-10           wkvth0=0
+ pkvth0=0                  llodvth=1                 wlodvth=1
+ lodk2=1                   lodeta0=1                 minr=1e-3
+ imax=0.01                 imelt=0.01

     11: type=p
+ lmin=5.0e-07-dxl_25       lmax=1.21e-06-dxl_25      wmin=1.5e-07
+ wmax=6.0e-07-dxw_25       tnom=25                   version=3.24
+ tox=toxp_25               toxm=toxp_25              xj=2.1e-07
+ nch=7.22e+17              lln=1                     lwn=1
+ wln=1                     wwn=-1                    lint=4.4e-08
+ wint=5e-09                mobmod=1                  binunit=2
+ xl=-4e-08+dxl_25          xw=1e-8+dxw_25            dwg=0
+ dwb=0                     ldif=8e-08                hdif=hdifp_25
+ rsh=7.2                   rd=0                      rs=0
+ vth0=-0.6059947+dvthp_25  lvth0=1.1796470e-08+dlvthp_25
+ wvth0=2.0726768e-08+dwvthp_25                       pvth0=-1.9699253e-15+dpvthp_25
+ k1=0.6738556              lk1=5.227895e-08          wk1=1.669482e-08
+ pk1=-5.639661e-15         k2=0.01812115+dk2p_25     lk2=-2.374582e-08+dlk2p_25
+ wk2=-1.516484e-08         pk2=2.182861e-15          k3=0
+ dvt0=0                    dvt1=0                    dvt2=0
+ dvt0w=0                   dvt1w=0                   dvt2w=0
+ nlx=0                     w0=0                      k3b=0
+ vfb=-1.244404             vsat=1.2695915e+05        lvsat=-1.0056363e-02+dlvsatp_25
+ wvsat=2.4601333e-03       pvsat=2.1738845e-10       ua=1.939733e-09
+ lua=-4.673357e-16         wua=-1.131411e-16         pua=5.465237e-23
+ ub=-1.526672e-19          lub=5.608332e-25          wub=1.195696e-26
+ pub=-6.997582e-32         uc=-2.026721e-10          luc=6.619349e-17
+ wuc=1.075575e-17          puc=-6.139345e-24         rdsw=784.6
+ prwb=0                    prwg=0                    wr=1
+ u0=1.1691454e-02          lu0=-1.1653492e-09        wu0=-4.7608780e-10
+ pu0=2.0441236e-16         a0=0.8292131              la0=-1.392126e-07
+ wa0=-5.168518e-08         pa0=2.896476e-14          keta=-0.0008486817
+ lketa=-1.096723e-08       wketa=-2.263821e-09       pketa=8.185024e-16
+ a1=0                      a2=0.99                   ags=0.02
+ b0=0                      b1=0                      voff=-0.152226
+ lvoff=7.711882e-09        wvoff=6.428103e-09        pvoff=-9.192155e-16
+ nfactor=1                 cit=1.691091e-05          lcit=-1.980986e-12
+ wcit=2.309198e-13         pcit=-1.719862e-19        cdsc=0
+ cdscb=0                   cdscd=0                   eta0=-8.098591e-05
+ leta0=1.417268e-10        etab=8.098591e-05         letab=-1.417268e-10
+ dsub=0                    pclm=0.6692098            lpclm=3.331502e-08
+ wpclm=7.495375e-10        ppclm=-8.110006e-16       pdiblc1=1e-06
+ pdiblc2=-0.0003715494     lpdiblc2=5.102165e-10     pdiblcb=0.01
+ drout=0                   pscbe1=3.5e+08            pscbe2=5e-07
+ pvag=0                    delta=0.01                alpha0=0
+ alpha1=1.0857             beta0=23.74               kt1=-0.27201
+ lkt1=-9.860273e-09        wkt1=1.030434e-08         pkt1=3.237147e-16
+ kt2=-0.02761026           lkt2=-2.577006e-09        wkt2=-6.665638e-10
+ pkt2=4.340095e-16         at=-50000                 ute=-0.5643566
+ lute=-4.86535e-08         wute=-4.23172e-08         pute=1.30999e-14
+ ua1=1.752e-09             ub1=-1.985564e-18         lub1=-2.811768e-25
+ wub1=-1.460956e-25        pub1=6.077933e-32         uc1=1.382096e-10
+ luc1=-2.398011e-17        wuc1=-2.239094e-17        puc1=1.969378e-24
+ kt1l=0                    prt=0                     cj=cjp_25
+ mj=0.3952264              pb=0.854899               cjsw=cjswp_25
+ mjsw=0.0450429            pbsw=0.854899             cjswg=cjswgp_25
+ mjswg=0.0450429           pbswg=0.854899            tpb=0.001603538
+ tpbsw=0.001603538         tpbswg=0.001603538        tcj=0.0009016089
+ tcjsw=0.0001793034        tcjswg=0.0001793034       js=2.0e-7
+ jsw=1.36e-12              n=1                       xti=3
+ cgdo=cgop_25              cgso=cgop_25              capmod=3
+ nqsmod=0                  xpart=1                   cf=0
+ tlev=1                    tlevc=1                   dlc=3.90e-8
+ cgbo=0                    cgdl=cglp_25              cgsl=cglp_25
+ wwc=-1.20e-2              dwc=0                     noia=5.0e+19
+ noib=4.0e+3               noic=8.0e-12              em=4.1e+7
+ ef=1.152                  noimod=2                  sa0=0.35e-6
+ sb0=0.35e-6               kvsat=-1                  wlod=0.3e-6
+ tku0=0.03                 ku0=8.5e-08               llodku0=1
+ wlodku0=1                 lku0=8.0e-09              wku0=6.0e-07
+ pku0=0                    kvth0=1.0e-09             stk2=0
+ steta0=-3e-10             lkvth0=-1.0e-10           wkvth0=0
+ pkvth0=0                  llodvth=1                 wlodvth=1
+ lodk2=1                   lodeta0=1                 minr=1e-3
+ imax=0.01                 imelt=0.01

     12: type=p
+ lmin=2.8e-07              lmax=5.0e-07-dxl_25       wmin=1.5e-07
+ wmax=6.0e-07-dxw_25       tnom=25                   version=3.24
+ tox=toxp_25               toxm=toxp_25              xj=2.1e-07
+ nch=7.22e+17              lln=1                     lwn=1
+ wln=1                     wwn=-1                    lint=4.4e-08
+ wint=5e-09                mobmod=1                  binunit=2
+ xl=-4e-08+dxl_25          xw=1e-8+dxw_25            dwg=0
+ dwb=0                     ldif=8e-08                hdif=hdifp_25
+ rsh=7.2                   rd=0                      rs=0
+ vth0=-0.61217043+dvthp_25 lvth0=1.3349838e-08+dlvthp_25
+ wvth0=1.4744382e-08+dwvthp_25                       pvth0=2.5552593e-16+dpvthp_25
+ k1=0.7259418              lk1=3.290288e-08          wk1=2.457303e-09
+ pk1=-3.433049e-16         k2=0.02400170+dk2p_25     lk2=-2.593338e-08+dlk2p_25
+ wk2=-1.176864e-08         pk2=9.194731e-16          k3=0
+ dvt0=0                    dvt1=0                    dvt2=0
+ dvt0w=0                   dvt1w=0                   dvt2w=0
+ nlx=0                     w0=0                      k3b=0
+ vfb=-1.439723             vsat=9.9611800e+04        lvsat=1.1685117e-04+dlvsatp_25
+ wvsat=3.2330090e-03       pvsat=-7.0121480e-11      ua=9.700846e-10
+ lua=-1.066267e-16         wua=-3.040293e-17         pua=2.387378e-23
+ ub=8.979358e-19           lub=1.700088e-25          wub=-1.266295e-25
+ pub=-1.842165e-32         uc=-5.274278e-11          luc=1.041977e-17
+ wuc=-8.582675e-18         puc=1.054551e-24          rdsw=784.6
+ prwb=0                    prwg=0                    wr=1
+ u0=9.8469040e-03          lu0=-4.7917640e-10        wu0=7.7022720e-13
+ pu0=2.7021186e-17         a0=0.6900988              la0=-8.746201e-08
+ wa0=4.888815e-09          pa0=7.919232e-15          keta=-0.02848965
+ lketa=-6.847915e-10       wketa=-1.348636e-09       pketa=4.780536e-16
+ a1=0                      a2=0.99                   ags=0.02
+ b0=0                      b1=0                      voff=-0.1339684
+ lvoff=9.200603e-10        wvoff=5.790014e-09        pvoff=-6.818463e-16
+ nfactor=1                 cit=1.105695e-05          lcit=1.966859e-13
+ wcit=-7.661731e-13        pcit=1.989324e-19         cdsc=0
+ cdscb=0                   cdscd=0                   eta0=-0.000701363
+ leta0=3.72507e-10         weta0=-2.89215e-11        peta0=1.07588e-17
+ etab=0.0009958814         letab=-4.820678e-10       wetab=3.742779e-11
+ petab=-1.392315e-17       dsub=0                    pclm=0.6395858
+ lpclm=4.433514e-08        wpclm=-4.580718e-09       ppclm=1.171856e-15
+ pdiblc1=1e-06             pdiblc2=-0.001945184      lpdiblc2=1.095609e-09
+ wpdiblc2=-8.506322e-11    ppdiblc2=3.164351e-17     pdiblcb=0.01
+ drout=0                   pscbe1=3.5e+08            pscbe2=5e-07
+ pvag=0                    delta=0.01                alpha0=0
+ alpha1=1.0857             beta0=23.74               kt1=-0.3210307
+ lkt1=8.375411e-09         wkt1=1.686839e-08         pkt1=-2.118113e-15
+ kt2=-0.03151336           lkt2=-1.125054e-09        wkt2=-7.271351e-10
+ pkt2=4.56542e-16          at=-50000                 ute=-0.6865135
+ lute=-3.211138e-09        wute=-1.469798e-08        pute=2.82555e-15
+ ua1=1.752e-09             ub1=-2.588637e-18         lub1=-5.683356e-26
+ wub1=3.481583e-27         pub1=5.136597e-33         uc1=1.077026e-10
+ luc1=-1.263152e-17        wuc1=-2.025615e-17        puc1=1.175233e-24
+ kt1l=0                    prt=0                     cj=cjp_25
+ mj=0.3952264              pb=0.854899               cjsw=cjswp_25
+ mjsw=0.0450429            pbsw=0.854899             cjswg=cjswgp_25
+ mjswg=0.0450429           pbswg=0.854899            tpb=0.001603538
+ tpbsw=0.001603538         tpbswg=0.001603538        tcj=0.0009016089
+ tcjsw=0.0001793034        tcjswg=0.0001793034       js=2.0e-7
+ jsw=1.36e-12              n=1                       xti=3
+ cgdo=cgop_25              cgso=cgop_25              capmod=3
+ nqsmod=0                  xpart=1                   cf=0
+ tlev=1                    tlevc=1                   dlc=3.90e-8
+ cgbo=0                    cgdl=cglp_25              cgsl=cglp_25
+ wwc=-1.20e-2              dwc=0                     noia=5.0e+19
+ noib=4.0e+3               noic=8.0e-12              em=4.1e+7
+ ef=1.152                  noimod=2                  sa0=0.35e-6
+ sb0=0.35e-6               kvsat=-1                  wlod=0.3e-6
+ tku0=0.03                 ku0=8.5e-08               llodku0=1
+ wlodku0=1                 lku0=8.0e-09              wku0=6.0e-07
+ pku0=0                    kvth0=1.0e-09             stk2=0
+ steta0=-3e-10             lkvth0=-1.0e-10           wkvth0=0
+ pkvth0=0                  llodvth=1                 wlodvth=1
+ lodk2=1                   lodeta0=1                 minr=1e-3
+ imax=0.01                 imelt=0.01
//

     }
endsection mos_25
//
//
//  *************************************************************
//                                                              *
//             1.2V NATIVE NMOS DEVICES MODEL                   *
//                                                              *
//  *************************************************************
//
section mos_na
//
model nch_na bsim3v3  {
     1: type=n
+ lmin=5.9e-07-dxl_na       lmax=2.1e-05              wmin=1.5e-07
+ wmax=1.01e-04             tnom=25                   version=3.24
+ tox=toxn_na               toxm=toxn_na              xj=3.7e-07
+ nch=2.4766e+18            lln=-1                    lwn=1
+ wln=1                     wwn=1                     lint=1.39e-08
+ wint=5e-09                mobmod=2                  binunit=2
+ xl=-2e-08+dxl_na          xw=1e-08+dxw_na           dwg=0
+ dwb=0                     ldif=8e-08                hdif=hdifn_na
+ rsh=rshn_na               rd=0                      rs=0
+ vth0=0.05636426+dvthn_na  lvth0=4.392801e-08        wvth0=-1.33564e-08
+ pvth0=5.167447e-15        k1=0.522944               lk1=-6.617237e-09
+ wk1=-2.366986e-08         pk1=8.821118e-15          k2=-0.1576434
+ lk2=6.765601e-09          wk2=6.914849e-09          pk2=-2.852455e-15
+ k3=0                      dvt0=0                    dvt1=0
+ dvt2=0                    dvt0w=0                   dvt1w=0
+ dvt2w=0                   nlx=0                     w0=0
+ k3b=0                     vfb=-1.351028             vsat=106653
+ lvsat=-9.374221e-06       wvsat=0.003469265         pvsat=9.518828e-11
+ ua=1.864003e-09           lua=-8.933161e-16         wua=-3.69825e-17
+ pua=2.851796e-23          ub=7.997565e-19           lub=1.376869e-24
+ wub=-1.3647e-26           pub=-9.9332e-32           uc=-6.863009e-11
+ luc=-5.407888e-18         wuc=-1.802501e-17         puc=7.625091e-24
+ rdsw=120                  prwb=0                    prwg=0
+ wr=1                      u0=0.07375325             lu0=-1.351267e-08
+ wu0=-2.157281e-09         pu0=1.406486e-15          a0=-0.0528997
+ la0=3.634898e-08          wa0=-1.138098e-08         pa0=3.796219e-14
+ keta=-0.02985081          lketa=1.51673e-08         wketa=2.275424e-09
+ pketa=-2.291255e-16       a1=0                      a2=0.99
+ ags=0.02                  b0=0                      b1=0
+ voff=-0.0343072           lvoff=-6.737394e-09       wvoff=-1.504835e-10
+ pvoff=-3.072169e-16       nfactor=0.4961725         lnfactor=3.805425e-08
+ wnfactor=-2.102366e-09    pnfactor=2.090214e-14     cit=-0.0006883347
+ lcit=5.971137e-10         wcit=1.040892e-11         pcit=-2.097383e-16
+ cdsc=0                    cdscb=0                   cdscd=0
+ eta0=0.01085313           leta0=-3.435666e-09       weta0=-1.379368e-10
+ peta0=6.194969e-16        etab=-0.0002178037        letab=-1.893827e-09
+ wetab=2.747685e-10        petab=8.029687e-17        dsub=0
+ pclm=0.5928147            lpclm=5.639843e-08        wpclm=1.416969e-08
+ ppclm=9.501751e-15        pdiblc1=0                 pdiblc2=0.1000914
+ lpdiblc2=-9.082438e-10    wpdiblc2=-9.14072e-10     ppdiblc2=9.087888e-15
+ pdiblcb=0.03011739        lpdiblcb=-2.000112e-07    wpdiblcb=-3.138314e-09
+ ppdiblcb=3.120175e-14     drout=0                   pscbe1=3.018689e+08
+ lpscbe1=-18.58056         wpscbe1=-0.2915419        ppscbe1=2.898566e-06
+ pscbe2=1e-06              pvag=0                    delta=0.01
+ alpha0=0                  alpha1=0                  beta0=30
+ kt1=-0.2584956            lkt1=3.475441e-08         wkt1=5.453206e-10
+ pkt1=-5.421688e-15        kt2=-0.009929673          lkt2=-7.44595e-09
+ wkt2=-1.32745e-09         pkt2=1.128863e-15         at=-50000
+ ute=-1.602334             lute=7.750366e-08         wute=4.64693e-08
+ pute=-1.086806e-14        ua1=1.802969e-09          lua1=-5.266315e-16
+ wua1=-8.263214e-18        pua1=8.21545e-23          ub1=-2.808046e-18
+ lub1=2.324109e-25         wub1=3.646687e-27         pub1=-3.62561e-32
+ uc1=-8.068051e-12         luc1=-4.333939e-17        wuc1=-6.80025e-19
+ puc1=6.760945e-24         kt1l=0                    prt=0
+ cj=cjn_na                 mj=0.2892492              pb=0.6028805
+ cjsw=cjswn_na             mjsw=0.1                  pbsw=0.6028805
+ cjswg=cjswgn_na           mjswg=0.1                 pbswg=0.6028805
+ tcj=1.145466e-3           tcjsw=1.025488e-4         tcjswg=1.025488e-4
+ tpb=1.785442e-3           tpbsw=1.785442e-3         tpbswg=1.785442e-3
+ tlev=1                    tlevc=1                   js=9.0e-7
+ jsw=2.05e-11              n=1                       xti=3
+ cgdo=cgon_na              cgso=cgon_na              cgbo=0
+ capmod=3                  nqsmod=0                  xpart=1
+ cf=0                      vfbcv=-1                  acde=1
+ moin=15                   noff=1                    voffcv=0
+ dlc=1.435e-8              llc=-0.04                 minr=1e-60
+ noia=4.0e+19              noib=5.25e+3               noic=1.0e-14
+ em=1e+6                   ef=0.78                  noimod=2
+ imax=0.01                 imelt=0.01

     2: type=n
+ lmin=3e-07                lmax=5.9e-07-dxl_na       wmin=1.5e-07
+ wmax=1.01e-04             tnom=25                   version=3.24
+ tox=toxn_na               toxm=toxn_na              xj=3.7e-07
+ nch=2.4766e+18            lln=-1                    lwn=1
+ wln=1                     wwn=1                     lint=1.39e-08
+ wint=5e-09                mobmod=2                  binunit=2
+ xl=-2e-08+dxl_na          xw=1e-08+dxw_na           dwg=0
+ dwb=0                     ldif=8e-08                hdif=hdifn_na
+ rsh=rshn_na               rd=0                      rs=0
+ vth0=0.1154363+dvthn_na   lvth0=1.189916e-08        wvth0=-6.12623e-09
+ pvth0=1.247251e-15        k1=0.4961382              lk1=7.9169e-09
+ wk1=1.695015e-08          pk1=-1.320305e-14         k2=-0.1332177
+ lk2=-6.478012e-09         wk2=-4.789893e-09         pk2=3.493856e-15
+ k3=0                      dvt0=0                    dvt1=0
+ dvt2=0                    dvt0w=0                   dvt1w=0
+ dvt2w=0                   nlx=0                     w0=0
+ k3b=0                     vfb=-1.351028             vsat=106632.9
+ wvsat=0.003665582         pvsat=-1.125431e-11       ua=6.45231e-10
+ lua=-2.324978e-16         wua=7.588043e-17          pua=-3.267631e-23
+ ub=4.05903e-18            lub=-3.903092e-25         wub=-3.557173e-25
+ pub=8.613849e-32          uc=-8.136993e-11          luc=1.499655e-18
+ wuc=-8.485598e-18         puc=2.452821e-24          rdsw=120
+ prwb=0                    prwg=0                    wr=1
+ u0=0.05936552             lu0=-5.711642e-09         wu0=-6.881876e-10
+ pu0=6.099437e-16          a0=-0.7551197             la0=4.170926e-07
+ wa0=9.82619e-08           pa0=-2.148617e-14         keta=-0.005456419
+ lketa=1.940667e-09        wketa=1.577763e-09        pketa=1.49146e-16
+ a1=0                      a2=0.99                   ags=0.02
+ b0=0                      b1=0                      voff=-0.04110964
+ lvoff=-3.049114e-09       wvoff=9.388682e-09        pvoff=-5.479352e-15
+ nfactor=0.4872651         lnfactor=4.288384e-08     wnfactor=2.195143e-08
+ pnfactor=7.860176e-15     cit=0.0008963341          lcit=-2.620936e-10
+ wcit=-5.397399e-10        pcit=8.855241e-17         cdsc=0
+ cdscb=0                   cdscd=0                   eta0=0.005199886
+ leta0=-3.704788e-10       weta0=-1.200709e-10       peta0=6.098099e-16
+ etab=-0.006127054         letab=1.310168e-09        wetab=4.844721e-10
+ petab=-3.340442e-17       dsub=0                    pclm=0.696928
+ lpclm=-5.179621e-11       wpclm=3.06698e-08         ppclm=5.553882e-16
+ pdiblc1=0                 pdiblc2=0.09765319        lpdiblc2=4.137297e-10
+ wpdiblc2=2.346749e-08     ppdiblc2=-4.131796e-15    pdiblcb=-0.4288752
+ lpdiblcb=4.885457e-08     wpdiblcb=6.079949e-08     ppdiblcb=-3.465327e-15
+ drout=0                   pscbe1=3.034197e+07       lpscbe1=128.6413
+ wpscbe1=46.15688          ppscbe1=-2.228577e-05     pscbe2=1e-06
+ pvag=-0.6764673           lpvag=3.667805e-07        wpvag=-2.994415e-08
+ ppvag=1.623571e-14        delta=0.01                alpha0=0
+ alpha1=0                  beta0=30                  kt1=-0.212439
+ lkt1=9.782522e-09         wkt1=-2.076619e-08        pkt1=6.133414e-15
+ kt2=-0.02475368           lkt2=5.916286e-10         wkt2=-8.956322e-11
+ pkt2=4.576814e-16         at=-60612.51              lat=0.005754102
+ wat=-0.002775607          pat=1.504934e-09          ute=-1.383444
+ lute=-4.117802e-08        wute=5.11059e-08          pute=-1.338202e-14
+ ua1=8.192318e-10          lua1=6.750918e-18         wua1=2.678421e-16
+ pua1=-6.754977e-23        ub1=-2.469686e-18         lub1=4.895223e-26
+ wub1=-2.376907e-25        pub1=9.4597e-32           uc1=-7.849457e-11
+ luc1=-5.154138e-18        wuc1=4.514423e-18         puc1=3.944515e-24
+ kt1l=0                    prt=0                     cj=cjn_na
+ mj=0.2892492              pb=0.6028805              cjsw=cjswn_na
+ mjsw=0.1                  pbsw=0.6028805            cjswg=cjswgn_na
+ mjswg=0.1                 pbswg=0.6028805           tcj=1.145466e-3
+ tcjsw=1.025488e-4         tcjswg=1.025488e-4        tpb=1.785442e-3
+ tpbsw=1.785442e-3         tpbswg=1.785442e-3        tlev=1
+ tlevc=1                   js=9.0e-7                 jsw=2.05e-11
+ n=1                       xti=3                     cgdo=cgon_na
+ cgso=cgon_na              cgbo=0                    capmod=3
+ nqsmod=0                  xpart=1                   cf=0
+ vfbcv=-1                  acde=1                    moin=15
+ noff=1                    voffcv=0                  dlc=1.435e-8
+ llc=-0.04                 minr=1e-60                imax=0.01
+ noia=4.0e+19              noib=5.25e+3               noic=1.0e-14
+ em=1e+6                   ef=0.78                  noimod=2
+ imelt=0.01

     }
endsection mos_na
//
//
//  *************************************************************
//                                                              *
//               1.2V LOW Vt DEVICES MODEL                      *
//                                                              *
//  *************************************************************
//
section mos_lvt
//
// **************************************************************
//                                                              *
//               1.2V LOW Vt NMOS DEVICES MODEL                 *
//                                                              *
// **************************************************************
//
model nch_lvt bsim3v3  {
     1: type=n
+ lmin=4.7e-07-dxl_lvt      lmax=2.1e-05              wmin=1.0005e-05-dxw_lvt
+ wmax=0.0009001            tnom=25                   version=3.24
+ tox=toxn_lvt              toxm=toxn_lvt             xj=1.9e-07
+ nch=1.58e+18              lln=1                     lwn=1
+ wln=1                     wwn=-1                    lint=1.2e-09
+ ll=0                      lw=0                      lwl=0
+ wint=2.5e-09              wl=0                      ww=0
+ wwl=0                     mobmod=1                  binunit=2
+ xl=-2e-08+dxl_lvt         xw=1.5e-08+dxw_lvt        dwg=0
+ dwb=0                     ldif=8e-08                hdif=hdifn_lvt
+ rsh=rshn_lvt              rd=0                      rs=0
+ vth0=0.2186999+dvthn_lvt  pvth0=0+dpvthn_lvt        lvth0=2.831266e-08+dlvthn_lvt
+ wvth0=-6.677064e-09+dwvthn_lvt                      k1=0.3651984
+ lk1=5.989299e-08          k2=-0.007536892+dk2n_lvt  lk2=-2.467438e-08+dlk2n_lvt
+ k3=0                      dvt0=0                    dvt1=0
+ dvt2=0                    dvt0w=0                   dvt1w=0
+ dvt2w=0                   nlx=0                     w0=0
+ k3b=0                     vfb=-1.166902             vsat=117000
+ pvsat=0+dpvsatn_lvt       lvsat=0+dlvsatn_lvt       ua=6.983373e-12
+ lua=4.671626e-20          ub=2.666506e-18           lub=-5.214804e-26
+ uc=2.221286e-10           luc=-2.28941e-17          rdsw=155+drdswn_lvt
+ prwb=0                    prwg=0                    wr=1
+ u0=0.05187641             lu0=1.712371e-09          a0=2.066128
+ la0=-5.464872e-07         keta=0.0009319599         lketa=3.045488e-11
+ a1=0                      a2=1                      ags=0.8441848
+ lags=-1.48742e-08         b0=0                      b1=0
+ voff=-0.09914832          lvoff=-7.915079e-09       nfactor=0.07584696
+ lnfactor=3.72017e-09      cit=0.001715902           lcit=-1.593018e-10
+ cdsc=0                    cdscb=0                   cdscd=0
+ eta0=0.0003645229         leta0=2.844395e-10        etab=-0.0009029813
+ letab=3.404115e-10        dsub=0                    pclm=0.08541831
+ lpclm=4.198514e-08+dlpclmn_lvt                      pdiblc1=0
+ pdiblc2=0.00424947        lpdiblc2=4.296839e-09     pdiblcb=0.8747813
+ lpdiblcb=-4.788341e-07    drout=0                   pscbe1=7.522838e+08
+ pscbe2=1e-10              pvag=1e-20                delta=0.01
+ alpha0=0                  alpha1=0.013325           beta0=6.2486
+ kt1=-0.0910067            lkt1=-8.546768e-10        kt2=0.02
+ at=12065.23               lat=-2.342674e-06         ute=-1.522339
+ lute=7.601984e-08         ua1=1.116939e-10          lua1=1.423642e-17
+ ub1=1e-19                 uc1=4.73e-11              kt1l=0
+ prt=0                     cj=cjn_lvt                mj=0.3473
+ pb=0.6209                 cjsw=cjswn_lvt            mjsw=0.1679
+ pbsw=0.6209               cjswg=cjswgn_lvt          mjswg=0.5055
+ pbswg=0.6209              tcj=0.000976              tcjsw=0.000255
+ tcjswg=0.000255           tpb=0.001367              tpbsw=0.001367
+ tpbswg=0.001367           js=6e-07                  jsw=1e-11
+ n=1                       xti=3                     cgdo=cgon_lvt
+ cgso=cgon_lvt             capmod=3                  nqsmod=0
+ xpart=1                   cf=0                      tlev=1
+ tlevc=1                   dlc=1.80e-8               cgdl=cgln_lvt
+ cgsl=cgln_lvt             wwc=-0.041                dwc=0
+ noia=8.0e+18              noib=1.0e+4               noic=1.0e-13
+ em=4.1e+7                 ef=0.948                  noimod=2
+ sa0=0.35e-6               sb0=0.35e-6               kvsat=0.4
+ wlod=0.5e-6               tku0=0.03                 ku0=-0.62e-7
+ llodku0=1                 wlodku0=1                 lku0=1.8e-7
+ wku0=0.7e-6               pku0=-0.5e-13             kvth0=5.2e-9
+ stk2=2.5e-9               steta0=-1.1e-10           lkvth0=-1.0e-8
+ wkvth0=2.2e-6             pkvth0=-5e-14             llodvth=1.0
+ wlodvth=1                 lodk2=1                   lodeta0=2
+ minr=1e-3                 imax=0.01                 imelt=0.01

     2: type=n
+ lmin=1.6e-07-dxl_lvt      lmax=4.7e-07-dxl_lvt      wmin=1.0005e-05-dxw_lvt
+ wmax=0.0009001            tnom=25                   version=3.24
+ tox=toxn_lvt              toxm=toxn_lvt             xj=1.9e-07
+ nch=1.58e+18              lln=1                     lwn=1
+ wln=1                     wwn=-1                    lint=1.2e-09
+ ll=0                      lw=0                      lwl=0
+ wint=2.5e-09              wl=0                      ww=0
+ wwl=0                     mobmod=1                  binunit=2
+ xl=-2e-08+dxl_lvt         xw=1.5e-08+dxw_lvt        dwg=0
+ dwb=0                     ldif=8e-08                hdif=hdifn_lvt
+ rsh=rshn_lvt              rd=0                      rs=0
+ vth0=0.264771+dvthn_lvt   pvth0=0+dpvthn_lvt        lvth0=7.691254e-09+dlvthn_lvt
+ wvth0=-6.676732e-09+dwvthn_lvt                      k1=0.3585702
+ lk1=6.285978e-08          k2=-0.01235577+dk2n_lvt   lk2=-2.251745e-08+dlk2n_lvt
+ k3=0                      dvt0=0                    dvt1=0
+ dvt2=0                    dvt0w=0                   dvt1w=0
+ dvt2w=0                   nlx=0                     w0=0
+ k3b=0                     vfb=-1.438095             vsat=122541.3
+ pvsat=0+dpvsatn_lvt       lvsat=-0.00248028+dlvsatn_lvt
+ ua=7.150491e-12           lua=-2.80858e-20          ub=2.749742e-18
+ lub=-8.940448e-26         uc=1.733938e-10           luc=-1.080403e-18
+ rdsw=155+drdswn_lvt       prwb=0                    prwg=0
+ wr=1                      u0=0.05155703             lu0=1.855326e-09
+ a0=0.5631431              la0=1.262487e-07          keta=-0.01742242
+ lketa=8.245876e-09        a1=0                      a2=1
+ ags=1.126526              lags=-1.412499e-07        b0=0
+ b1=0                      voff=-0.1252335           lvoff=3.760631e-09
+ nfactor=0.01660566        lnfactor=3.023657e-08     cit=0.0002159791
+ lcit=5.120637e-10         cdsc=0                    cdscb=0
+ cdscd=0                   eta0=0.0009729683         leta0=1.209941e-11
+ etab=0.0008206542         letab=-4.310877e-10       dsub=0
+ pclm=-0.1423521           lpclm=1.439351e-07+dlpclmn_lvt
+ pdiblc1=0                 pdiblc2=0.006676776       lpdiblc2=3.210376e-09
+ pdiblcb=-0.1174393        lpdiblcb=-3.471618e-08    drout=0
+ pscbe1=7.522838e+08       pscbe2=1e-10              pvag=1.443871e-20
+ lpvag=-1.986766e-27       delta=0.01                alpha0=0
+ alpha1=0.013325           beta0=6.2486              kt1=-0.0851112
+ lkt1=-3.493499e-09        kt2=0.02                  at=16094.97
+ lat=-0.00180605           ute=-1.293248             lute=-2.652137e-08
+ ua1=1.36677e-11           lua1=5.811293e-17         ub1=1e-19
+ uc1=4.73e-11              kt1l=0                    prt=0
+ cj=cjn_lvt                mj=0.3473                 pb=0.6209
+ cjsw=cjswn_lvt            mjsw=0.1679               pbsw=0.6209
+ cjswg=cjswgn_lvt          mjswg=0.5055              pbswg=0.6209
+ tcj=0.000976              tcjsw=0.000255            tcjswg=0.000255
+ tpb=0.001367              tpbsw=0.001367            tpbswg=0.001367
+ js=6e-07                  jsw=1e-11                 n=1
+ xti=3                     cgdo=cgon_lvt             cgso=cgon_lvt
+ capmod=3                  nqsmod=0                  xpart=1
+ cf=0                      tlev=1                    tlevc=1
+ dlc=1.80e-8               cgdl=cgln_lvt             cgsl=cgln_lvt
+ wwc=-0.041                dwc=0                     noia=8.0e+18
+ noib=1.0e+4               noic=1.0e-13              em=4.1e+7
+ ef=0.948                  noimod=2                  sa0=0.35e-6
+ sb0=0.35e-6               kvsat=0.4                 wlod=0.5e-6
+ tku0=0.03                 ku0=-0.62e-7              llodku0=1
+ wlodku0=1                 lku0=1.8e-7               wku0=0.7e-6
+ pku0=-0.5e-13             kvth0=5.2e-9              stk2=2.5e-9
+ steta0=-1.1e-10           lkvth0=-1.0e-8            wkvth0=2.2e-6
+ pkvth0=-5e-14             llodvth=1.0               wlodvth=1
+ lodk2=1                   lodeta0=2                 minr=1e-3
+ imax=0.01                 imelt=0.01

     3: type=n
+ lmin=1.3e-07              lmax=1.6e-07-dxl_lvt      wmin=1.0005e-05-dxw_lvt
+ wmax=0.0009001            tnom=25                   version=3.24
+ tox=toxn_lvt              toxm=toxn_lvt             xj=1.9e-07
+ nch=1.58e+18              lln=1                     lwn=1
+ wln=1                     wwn=-1                    lint=1.2e-09
+ ll=0                      lw=0                      lwl=0
+ wint=2.5e-09              wl=0                      ww=0
+ wwl=0                     mobmod=1                  binunit=2
+ xl=-2e-08+dxl_lvt         xw=1.5e-08+dxw_lvt        dwg=0
+ dwb=0                     ldif=8e-08                hdif=hdifn_lvt
+ rsh=rshn_lvt              rd=0                      rs=0
+ vth0=0.2632801+dvthn_lvt  pvth0=0+dpvthn_lvt        lvth0=7.896404e-09+dlvthn_lvt
+ wvth0=-6.677188e-09+dwvthn_lvt                      k1=0.8154
+ k2=-0.176+dk2n_lvt        lk2=0+dlk2n_lvt           k3=0
+ dvt0=0                    dvt1=0                    dvt2=0
+ dvt0w=0                   dvt1w=0                   dvt2w=0
+ nlx=0                     w0=0                      k3b=0
+ vfb=-1.422095             vsat=104516               ua=7.561451e-12
+ lua=-8.463399e-20         pvsat=0+dpvsatn_lvt       lvsat=0+dlvsatn_lvt
+ ub=2.817333e-18           lub=-9.870508e-26         uc=1.417923e-10
+ luc=3.267964e-18          rdsw=155+drdswn_lvt       prwb=0
+ prwg=0                    wr=1                      u0=0.06011489
+ lu0=6.777658e-10          a0=-0.3932121             la0=2.578432e-07
+ keta=-0.003230288         lketa=6.293039e-09        a1=0
+ a2=1                      ags=0.1                   b0=0
+ b1=0                      voff=-0.1154606           lvoff=2.415891e-09
+ nfactor=0.2363482         cit=0.003937372           cdsc=0
+ cdscb=0                   cdscd=0                   eta0=-0.01241958
+ leta0=1.854914e-09        etab=0.01235386           letab=-2.018057e-09
+ dsub=0                    pclm=-0.05429043          lpclm=1.318179e-07+dlpclmn_lvt
+ pdiblc1=0                 pdiblc2=0.01691817        lpdiblc2=1.80116e-09
+ pdiblcb=-2.004314         lpdiblcb=2.249177e-07     drout=0
+ pscbe1=7.522838e+08       pscbe2=1e-10              pvag=0
+ delta=0.01                alpha0=0                  alpha1=0.013325
+ beta0=6.2486              kt1=0.1029066             lkt1=-2.936475e-08
+ kt2=0.02                  at=-58485.4               lat=0.008456209
+ ute=-2.140521             lute=9.006341e-08         ua1=-1.586879e-09
+ lua1=2.783482e-16         ub1=1e-19                 uc1=4.73e-11
+ kt1l=0                    prt=0                     cj=cjn_lvt
+ mj=0.3473                 pb=0.6209                 cjsw=cjswn_lvt
+ mjsw=0.1679               pbsw=0.6209               cjswg=cjswgn_lvt
+ mjswg=0.5055              pbswg=0.6209              tcj=0.000976
+ tcjsw=0.000255            tcjswg=0.000255           tpb=0.001367
+ tpbsw=0.001367            tpbswg=0.001367           js=6e-07
+ jsw=1e-11                 n=1                       xti=3
+ cgdo=cgon_lvt             cgso=cgon_lvt             capmod=3
+ nqsmod=0                  xpart=1                   cf=0
+ tlev=1                    tlevc=1                   dlc=1.80e-8
+ cgdl=cgln_lvt             cgsl=cgln_lvt             wwc=-0.041
+ dwc=0                     noia=8.0e+18              noib=1.0e+4
+ noic=1.0e-13              em=4.1e+7                 ef=0.948
+ noimod=2                  sa0=0.35e-6               sb0=0.35e-6
+ kvsat=0.4                 wlod=0.5e-6               tku0=0.03
+ ku0=-0.62e-7              llodku0=1                 wlodku0=1
+ lku0=1.8e-7               wku0=0.7e-6               pku0=-0.5e-13
+ kvth0=5.2e-9              stk2=2.5e-9               steta0=-1.1e-10
+ lkvth0=-1.0e-8            wkvth0=2.2e-6             pkvth0=-5e-14
+ llodvth=1.0               wlodvth=1                 lodk2=1
+ lodeta0=2                 minr=1e-3                 imax=0.01
+ imelt=0.01

     4: type=n
+ lmin=4.7e-07-dxl_lvt      lmax=2.1e-05              wmin=1.205e-06-dxw_lvt
+ wmax=1.0005e-05-dxw_lvt   tnom=25                   version=3.24
+ tox=toxn_lvt              toxm=toxn_lvt             xj=1.9e-07
+ nch=1.58e+18              lln=1                     lwn=1
+ wln=1                     wwn=-1                    lint=1.2e-09
+ ll=0                      lw=0                      lwl=0
+ wint=2.5e-09              wl=0                      ww=0
+ wwl=0                     mobmod=1                  binunit=2
+ xl=-2e-08+dxl_lvt         xw=1.5e-08+dxw_lvt        dwg=0
+ dwb=0                     ldif=8e-08                hdif=hdifn_lvt
+ rsh=rshn_lvt              rd=0                      rs=0
+ vth0=0.2185341+dvthn_lvt  lvth0=2.835675e-08+dlvthn_lvt
+ wvth0=-5.016240e-9+dwvthn_lvt                       pvth0=-4.4138970e-16+dpvthn_lvt
+ k1=0.3642492              lk1=6.554062e-08          wk1=9.50652e-09
+ pk1=-5.6561e-14           k2=-0.00646911+dk2n_lvt   lk2=-2.704726e-08+dlk2n_lvt
+ wk2=-1.069385e-08         pk2=2.376442e-14          k3=0
+ dvt0=0                    dvt1=0                    dvt2=0
+ dvt0w=0                   dvt1w=0                   dvt2w=0
+ nlx=0                     w0=0                      k3b=0
+ vfb=-1.088464             vsat=116963.9             lvsat=1.617243e-05+dlvsatn_lvt
+ wvsat=0.0003618565        pvsat=-1.619669e-10+dpvsatn_lvt
+ ua=6.97719e-12            lua=6.657756e-20          wua=6.191665e-20
+ pua=-1.989109e-25         ub=2.730763e-18           lub=-4.399068e-26
+ wub=-6.435365e-25         pub=-8.169596e-32         uc=2.327686e-10
+ luc=-2.361347e-17         wuc=-1.065595e-16         puc=7.204488e-24
+ rdsw=155+drdswn_lvt       prwb=0                    prwg=0
+ wr=1                      u0=0.05288545             lu0=1.84059e-09
+ wu0=-1.010546e-08         pu0=-1.284116e-15         a0=2.071429
+ la0=-5.37297e-07          wa0=-5.308889e-08         pa0=-9.204114e-14
+ keta=0.0009948396         lketa=-6.89348e-10        wketa=-6.297373e-10
+ pketa=7.208826e-15        a1=0                      a2=1
+ ags=0.8444371             lags=-9.922409e-09        wags=-2.526e-09
+ pags=-4.959223e-14        b0=0                      b1=0
+ voff=-0.09402448          lvoff=-8.121651e-09       wvoff=-5.131522e-08
+ pvoff=2.068805e-15        nfactor=0.07296902        lnfactor=6.369044e-09
+ wnfactor=2.882255e-08     pnfactor=-2.652847e-14    cit=0.001519322
+ lcit=-1.12563e-10         wcit=1.968752e-09         pcit=-4.680885e-16
+ cdsc=0                    cdscb=0                   cdscd=0
+ eta0=0.0003575815         leta0=2.875465e-10        weta0=6.951847e-11
+ peta0=-3.111644e-17       etab=-0.0006329031        letab=3.360514e-10
+ wetab=-2.704833e-09       petab=4.366639e-17        dsub=0
+ pclm=0.09043974           lpclm=5.019517e-08+dlpclmn_lvt
+ wpclm=-5.028955e-08       ppclm=-8.222338e-14       pdiblc1=0
+ pdiblc2=0.004287268       lpdiblc2=3.763847e-09     wpdiblc2=-3.785372e-10
+ ppdiblc2=5.337912e-15     pdiblcb=0.8519068         lpdiblcb=-4.696254e-07
+ wpdiblcb=2.290889e-07     ppdiblcb=-9.222537e-14    drout=0
+ pscbe1=7.522838e+08       pscbe2=1e-10              pvag=-0.0004142047
+ wpvag=4.148259e-09        delta=0.01                alpha0=0
+ alpha1=0.013325           beta0=6.2486              kt1=-0.09552659
+ lkt1=-9.726804e-10        wkt1=4.526676e-08         pkt1=1.181807e-15
+ kt2=0.02                  at=11942.14               lat=-2.666123e-06
+ wat=0.001232814           pat=3.239339e-12          ute=-1.594844
+ lute=8.651576e-08         wute=7.261371e-07         pute=-1.051166e-13
+ ua1=1.227562e-11          lua1=1.620201e-17         wua1=9.956736e-16
+ pua1=-1.968544e-23        ub1=1e-19                 uc1=4.73e-11
+ kt1l=0                    prt=0                     cj=cjn_lvt
+ mj=0.3473                 pb=0.6209                 cjsw=cjswn_lvt
+ mjsw=0.1679               pbsw=0.6209               cjswg=cjswgn_lvt
+ mjswg=0.5055              pbswg=0.6209              tcj=0.000976
+ tcjsw=0.000255            tcjswg=0.000255           tpb=0.001367
+ tpbsw=0.001367            tpbswg=0.001367           js=6e-07
+ jsw=1e-11                 n=1                       xti=3
+ cgdo=cgon_lvt             cgso=cgon_lvt             capmod=3
+ nqsmod=0                  xpart=1                   cf=0
+ tlev=1                    tlevc=1                   dlc=1.80e-8
+ cgdl=cgln_lvt             cgsl=cgln_lvt             wwc=-0.041
+ dwc=0                     noia=8.0e+18              noib=1.0e+4
+ noic=1.0e-13              em=4.1e+7                 ef=0.948
+ noimod=2                  sa0=0.35e-6               sb0=0.35e-6
+ kvsat=0.4                 wlod=0.5e-6               tku0=0.03
+ ku0=-0.62e-7              llodku0=1                 wlodku0=1
+ lku0=1.8e-7               wku0=0.7e-6               pku0=-0.5e-13
+ kvth0=5.2e-9              stk2=2.5e-9               steta0=-1.1e-10
+ lkvth0=-1.0e-8            wkvth0=2.2e-6             pkvth0=-5e-14
+ llodvth=1.0               wlodvth=1                 lodk2=1
+ lodeta0=2                 minr=1e-3                 imax=0.01
+ imelt=0.01

     5: type=n
+ lmin=1.6e-07-dxl_lvt      lmax=4.7e-07-dxl_lvt      wmin=1.205e-06-dxw_lvt
+ wmax=1.0005e-05-dxw_lvt   tnom=25                   version=3.24
+ tox=toxn_lvt              toxm=toxn_lvt             xj=1.9e-07
+ nch=1.58e+18              lln=1                     lwn=1
+ wln=1                     wwn=-1                    lint=1.2e-09
+ ll=0                      lw=0                      lwl=0
+ wint=2.5e-09              wl=0                      ww=0
+ wwl=0                     mobmod=1                  binunit=2
+ xl=-2e-08+dxl_lvt         xw=1.5e-08+dxw_lvt        dwg=0
+ dwb=0                     ldif=8e-08                hdif=hdifn_lvt
+ rsh=rshn_lvt              rd=0                      rs=0
+ vth0=0.2649697+dvthn_lvt  lvth0=7.572175e-09+dlvthn_lvt
+ wvth0=-8.666475e-09+dwvthn_lvt                      pvth0=1.192507e-15+dpvthn_lvt
+ k1=0.3687194              lk1=6.353976e-08          wk1=-1.016443e-07
+ pk1=-6.809914e-15         k2=-0.01681033+dk2n_lvt   lk2=-2.241853e-08+dlk2n_lvt
+ wk2=4.461251e-08          pk2=-9.907082e-16         k3=0
+ dvt0=0                    dvt1=0                    dvt2=0
+ dvt0w=0                   dvt1w=0                   dvt2w=0
+ nlx=0                     w0=0                      k3b=0
+ vfb=-1.32663              vsat=122570.9             lvsat=-0.002493556+dlvsatn_lvt
+ wvsat=-0.000297061        pvsat=1.329648e-10+dpvsatn_lvt
+ ua=7.205343e-12           lua=-3.554361e-20         wua=-5.493456e-19
+ pua=7.469005e-26          ub=2.836354e-18           lub=-9.125332e-26
+ wub=-8.674242e-25         pub=1.851615e-32          uc=1.802748e-10
+ luc=-1.172736e-19         wuc=-6.891378e-17         puc=-9.645743e-24
+ rdsw=155+drdswn_lvt       prwb=0                    prwg=0
+ wr=1                      u0=0.05259407             lu0=1.971013e-09
+ wu0=-1.038588e-08         pu0=-1.1586e-15           a0=0.5902705
+ la0=1.256694e-07          wa0=-2.716822e-07         pa0=5.801237e-15
+ keta=-0.01737404          lketa=7.532563e-09        wketa=-4.845435e-10
+ pketa=7.143837e-15        a1=0                      a2=1
+ ags=1.142863              lags=-1.43498e-07         wags=-1.636221e-07
+ pags=2.251441e-14         b0=0                      b1=0
+ voff=-0.1213025           lvoff=4.087997e-09        wvoff=-3.936844e-08
+ pvoff=-3.278571e-15       nfactor=0.01263903        lnfactor=3.337275e-08
+ wnfactor=3.972592e-08     pnfactor=-3.140882e-14    cit=3.506316e-05
+ lcit=5.517911e-10         wcit=1.811874e-09         pcit=-3.978703e-16
+ cdsc=0                    cdscb=0                   cdscd=0
+ eta0=0.0009716384         leta0=1.269465e-11        weta0=1.331856e-11
+ peta0=-5.961389e-18       etab=0.001213966          letab=-4.906071e-10
+ wetab=-3.939018e-09       petab=5.960877e-16        dsub=0
+ pclm=-0.1018935           lpclm=1.362835e-07+dlpclmn_lvt
+ wpclm=-4.05192e-07        ppclm=7.663094e-14        pdiblc1=0
+ pdiblc2=0.004702318       lpdiblc2=3.578069e-09     wpdiblc2=1.977417e-08
+ ppdiblc2=-3.682438e-15    pdiblcb=-0.1090316        lpdiblcb=-3.950938e-08
+ wpdiblcb=-8.420253e-08    ppdiblcb=4.80039e-14      drout=0
+ pscbe1=7.522838e+08       pscbe2=1e-10              pvag=-0.0004142047
+ wpvag=4.148259e-09        delta=0.01                alpha0=0
+ alpha1=0.013325           beta0=6.2486              kt1=-0.08971371
+ lkt1=-3.574525e-09        wkt1=4.609412e-08         pkt1=8.114817e-16
+ kt2=0.02                  at=16528.25               lat=-0.002055408
+ wat=-0.004339308          pat=2.497321e-09          ute=-1.334122
+ lute=-3.018312e-08        wute=4.093606e-07         pute=3.667249e-14
+ ua1=-9.097832e-11         lua1=6.241849e-17         wua1=1.04803e-15
+ pua1=-4.312016e-23        ub1=1e-19                 uc1=4.73e-11
+ kt1l=0                    prt=0                     cj=cjn_lvt
+ mj=0.3473                 pb=0.6209                 cjsw=cjswn_lvt
+ mjsw=0.1679               pbsw=0.6209               cjswg=cjswgn_lvt
+ mjswg=0.5055              pbswg=0.6209              tcj=0.000976
+ tcjsw=0.000255            tcjswg=0.000255           tpb=0.001367
+ tpbsw=0.001367            tpbswg=0.001367           js=6e-07
+ jsw=1e-11                 n=1                       xti=3
+ cgdo=cgon_lvt             cgso=cgon_lvt             capmod=3
+ nqsmod=0                  xpart=1                   cf=0
+ tlev=1                    tlevc=1                   dlc=1.80e-8
+ cgdl=cgln_lvt             cgsl=cgln_lvt             wwc=-0.041
+ dwc=0                     noia=8.0e+18              noib=1.0e+4
+ noic=1.0e-13              em=4.1e+7                 ef=0.948
+ noimod=2                  sa0=0.35e-6               sb0=0.35e-6
+ kvsat=0.4                 wlod=0.5e-6               tku0=0.03
+ ku0=-0.62e-7              llodku0=1                 wlodku0=1
+ lku0=1.8e-7               wku0=0.7e-6               pku0=-0.5e-13
+ kvth0=5.2e-9              stk2=2.5e-9               steta0=-1.1e-10
+ lkvth0=-1.0e-8            wkvth0=2.2e-6             pkvth0=-5e-14
+ llodvth=1.0               wlodvth=1                 lodk2=1
+ lodeta0=2                 minr=1e-3                 imax=0.01
+ imelt=0.01

     6: type=n
+ lmin=1.3e-07              lmax=1.6e-07-dxl_lvt      wmin=1.205e-06-dxw_lvt
+ wmax=1.0005e-05-dxw_lvt   tnom=25                   version=3.24
+ tox=toxn_lvt              toxm=toxn_lvt             xj=1.9e-07
+ nch=1.58e+18              lln=1                     lwn=1
+ wln=1                     wwn=-1                    lint=1.2e-09
+ ll=0                      lw=0                      lwl=0
+ wint=2.5e-09              wl=0                      ww=0
+ wwl=0                     mobmod=1                  binunit=2
+ xl=-2e-08+dxl_lvt         xw=1.5e-08+dxw_lvt        dwg=0
+ dwb=0                     ldif=8e-08                hdif=hdifn_lvt
+ rsh=rshn_lvt              rd=0                      rs=0
+ vth0=0.2626133+dvthn_lvt  pvth0=0+dpvthn_lvt        lvth0=7.896404e-09+dlvthn_lvt
+ wvth0=0+dwvthn_lvt        k1=0.7739359              lk1=7.781956e-09
+ wk1=4.152633e-07          pk1=-7.79364e-14          k2=-0.1606747+dk2n_lvt
+ lk2=-2.622784e-09+dlk2n_lvt                         wk2=-1.534829e-07
+ pk2=2.626722e-14          k3=0                      dvt0=0
+ dvt1=0                    dvt2=0                    dvt0w=0
+ dvt1w=0                   dvt2w=0                   nlx=0
+ w0=0                      k3b=0                     vfb=-1.18882
+ vsat=104209.5             lvsat=3.297975e-05+dlvsatn_lvt
+ wvsat=0.003069636         pvsat=-3.302928e-10+dpvsatn_lvt
+ ua=9.026951e-12           lua=-2.861971e-19         wua=-1.467702e-17
+ pua=2.018658e-24          ub=2.820647e-18           lub=-8.909198e-26
+ wub=-3.318362e-26         pub=-9.627535e-32         uc=1.251536e-10
+ luc=7.46741e-18           wuc=1.66637e-16           puc=-4.205753e-23
+ rdsw=155+drdswn_lvt       prwb=0                    prwg=0
+ wr=1                      u0=0.06570523             lu0=1.669163e-10
+ wu0=-5.598737e-08         pu0=5.116167e-15          a0=-0.03525737
+ la0=2.117421e-07          wa0=-3.584923e-06         pa0=4.617032e-13
+ keta=-0.000864153         lketa=5.260801e-09        wketa=-2.369715e-08
+ pketa=1.033789e-14        a1=0                      a2=1
+ ags=0.1                   b0=0                      b1=0
+ voff=-0.1088687           lvoff=2.377104e-09        wvoff=-6.601836e-08
+ pvoff=3.88457e-16         nfactor=0.2516509         lnfactor=4.847223e-10
+ wnfactor=-1.532561e-07    pnfactor=-4.8545e-15      cit=0.004012196
+ lcit=4.537603e-12         wcit=-7.493621e-10        pcit=-4.544417e-17
+ cdsc=0                    cdscb=0                   cdscd=0
+ eta0=-0.01282964          leta0=1.91175e-09         weta0=4.106691e-09
+ peta0=-5.692095e-16       etab=0.01268106           letab=-2.06848e-09
+ wetab=-3.276918e-09       petab=5.049828e-16        dsub=0
+ pclm=-0.1311391           lpclm=1.403077e-07+dlpclmn_lvt
+ wpclm=7.696391e-07        ppclm=-8.502582e-14       pdiblc1=0
+ pdiblc2=0.02998604        lpdiblc2=9.902933e-11     wpdiblc2=-1.308749e-07
+ ppdiblc2=1.704688e-14     pdiblcb=-2.125524         lpdiblcb=2.379599e-07
+ wpdiblcb=1.21392e-06      ppdiblcb=-1.306178e-13    drout=0
+ pscbe1=7.522838e+08       pscbe2=1e-10              pvag=-0.001899815
+ lpvag=2.044201e-10        wpvag=1.902667e-08        ppvag=-2.04727e-15
+ delta=0.01                alpha0=0                  alpha1=0.013325
+ beta0=6.2486              kt1=0.1110016             lkt1=-3.119295e-08
+ wkt1=-8.107108e-08        pkt1=1.830941e-14         kt2=0.02
+ at=-61115.25              lat=0.008628338           wat=0.02633794
+ pat=-1.723869e-09         ute=-2.298377             lute=1.024983e-07
+ wute=1.58093e-06          pute=-1.245354e-13        ua1=-1.918385e-09
+ lua1=3.138696e-16         wua1=3.320029e-15         pua1=-3.557472e-22
+ ub1=1e-19                 uc1=4.73e-11              kt1l=0
+ prt=0                     cj=cjn_lvt                mj=0.3473
+ pb=0.6209                 cjsw=cjswn_lvt            mjsw=0.1679
+ pbsw=0.6209               cjswg=cjswgn_lvt          mjswg=0.5055
+ pbswg=0.6209              tcj=0.000976              tcjsw=0.000255
+ tcjswg=0.000255           tpb=0.001367              tpbsw=0.001367
+ tpbswg=0.001367           js=6e-07                  jsw=1e-11
+ n=1                       xti=3                     cgdo=cgon_lvt
+ cgso=cgon_lvt             capmod=3                  nqsmod=0
+ xpart=1                   cf=0                      tlev=1
+ tlevc=1                   dlc=1.80e-8               cgdl=cgln_lvt
+ cgsl=cgln_lvt             wwc=-0.041                dwc=0
+ noia=8.0e+18              noib=1.0e+4               noic=1.0e-13
+ em=4.1e+7                 ef=0.948                  noimod=2
+ sa0=0.35e-6               sb0=0.35e-6               kvsat=0.4
+ wlod=0.5e-6               tku0=0.03                 ku0=-0.62e-7
+ llodku0=1                 wlodku0=1                 lku0=1.8e-7
+ wku0=0.7e-6               pku0=-0.5e-13             kvth0=5.2e-9
+ stk2=2.5e-9               steta0=-1.1e-10           lkvth0=-1.0e-8
+ wkvth0=2.2e-6             pkvth0=-5e-14             llodvth=1.0
+ wlodvth=1                 lodk2=1                   lodeta0=2
+ minr=1e-3                 imax=0.01                 imelt=0.01

     7: type=n
+ lmin=4.7e-07-dxl_lvt      lmax=2.1e-05              wmin=6.1e-07-dxw_lvt
+ wmax=1.205e-06-dxw_lvt    tnom=25                   version=3.24
+ tox=toxn_lvt              toxm=toxn_lvt             xj=1.9e-07
+ nch=1.58e+18              lln=1                     lwn=1
+ wln=1                     wwn=-1                    lint=1.2e-09
+ ll=0                      lw=0                      lwl=0
+ wint=2.5e-09              wl=0                      ww=0
+ wwl=0                     mobmod=1                  binunit=2
+ xl=-2e-08+dxl_lvt         xw=1.5e-08+dxw_lvt        dwg=0
+ dwb=0                     ldif=8e-08                hdif=hdifn_lvt
+ rsh=rshn_lvt              rd=0                      rs=0
+ vth0=0.2309822+dvthn_lvt  lvth0=3.4960950e-08+dlvthn_lvt
+ wvth0=-2.0140657e-08+dwvthn_lvt                     pvth0=-8.4654520e-15+dpvthn_lvt
+ k1=0.4092222              lk1=3.104279e-08          wk1=-4.513567e-08
+ pk1=-1.464614e-14         k2=-0.03038621+dk2n_lvt   lk2=-8.977733e-09+dlk2n_lvt
+ wk2=1.836542e-08          pk2=1.809949e-15          k3=0
+ dvt0=0                    dvt1=0                    dvt2=0
+ dvt0w=0                   dvt1w=0                   dvt2w=0
+ nlx=0                     w0=0                      k3b=0
+ vfb=-1.088464             vsat=1.2446090e+05        lvsat=-2.6865730e-03+dlvsatn_lvt
+ wvsat=-8.7469970e-03      pvsat=3.1218248e-09+dpvsatn_lvt
+ ua=1.038705e-11           lua=1.146289e-18          wua=-4.081064e-18
+ pua=-1.51076e-24          ub=2.337551e-18           lub=-8.71382e-26
+ wub=-1.657836e-25         pub=-2.927173e-32         uc=1.527568e-10
+ luc=-2.44413e-17          wuc=-9.345229e-18         puc=8.210295e-24
+ rdsw=155+drdswn_lvt       prwb=0                    prwg=0
+ wr=1                      u0=4.8247020e-02          lu0=1.6823193e-10
+ wu0=-4.4697750e-09        pu0=7.4780120e-16         a0=1.815234
+ la0=-7.307417e-07         wa0=2.581879e-07          pa0=1.429943e-13
+ keta=0.0003453363         lketa=6.558135e-09        wketa=1.59407e-10
+ pketa=-1.596866e-15       a1=0                      a2=1
+ ags=0.9397634             lags=-9.432971e-08        wags=-1.183476e-07
+ pags=5.296263e-14         b0=0                      b1=0
+ voff=-0.1476755           lvoff=-8.071907e-09       wvoff=1.387077e-08
+ pvoff=2.008365e-15        nfactor=-0.416532         lnfactor=1.098439e-07
+ wnfactor=6.235663e-07     pnfactor=-1.522504e-13    cit=0.006195111
+ lcit=-9.664304e-10        wcit=-3.712332e-09        pcit=5.693605e-16
+ cdsc=0                    cdscb=0                   cdscd=0
+ eta0=0.0002921318         leta0=3.168418e-10        weta0=1.490398e-10
+ peta0=-6.671022e-17       etab=-0.004936935         letab=2.091177e-09
+ wetab=2.524566e-09        petab=-2.088811e-15       dsub=0
+ pclm=0.004050262          lpclm=-9.025595e-08+dlpclmn_lvt
+ wpclm=5.467367e-08        ppclm=8.842474e-14        pdiblc1=0
+ pdiblc2=3.9430640e-03     lpdiblc2=8.4842490e-09    wpdiblc2=3.9669120e-11
+ ppdiblc2=-3.9737670e-16   pdiblcb=2.208723          lpdiblcb=-1.524748e-06
+ wpdiblcb=-1.419443e-06    ppdiblcb=1.189749e-12     drout=0
+ pscbe1=7.522838e+08       pscbe2=1e-10              pvag=0.003
+ delta=0.01                alpha0=0                  alpha1=0.013325
+ beta0=6.2486              kt1=-0.03860558           lkt1=4.675711e-10
+ wkt1=-2.389227e-08        pkt1=-5.680988e-16        kt2=0.02
+ at=22150.61               lat=0.000218606           wat=-0.01117048
+ pat=-2.656063e-10         ute=-0.9972               ua1=4.733778e-10
+ lua1=6.720521e-17         wua1=4.354344e-16         pua1=-8.165433e-23
+ ub1=1e-19                 uc1=4.73e-11              kt1l=0
+ prt=0                     cj=cjn_lvt                mj=0.3473
+ pb=0.6209                 cjsw=cjswn_lvt            mjsw=0.1679
+ pbsw=0.6209               cjswg=cjswgn_lvt          mjswg=0.5055
+ pbswg=0.6209              tcj=0.000976              tcjsw=0.000255
+ tcjswg=0.000255           tpb=0.001367              tpbsw=0.001367
+ tpbswg=0.001367           js=6e-07                  jsw=1e-11
+ n=1                       xti=3                     cgdo=cgon_lvt
+ cgso=cgon_lvt             capmod=3                  nqsmod=0
+ xpart=1                   cf=0                      tlev=1
+ tlevc=1                   dlc=1.80e-8               cgdl=cgln_lvt
+ cgsl=cgln_lvt             wwc=-0.041                dwc=0
+ noia=8.0e+18              noib=1.0e+4               noic=1.0e-13
+ em=4.1e+7                 ef=0.948                  noimod=2
+ sa0=0.35e-6               sb0=0.35e-6               kvsat=0.4
+ wlod=0.5e-6               tku0=0.03                 ku0=-0.62e-7
+ llodku0=1                 wlodku0=1                 lku0=1.8e-7
+ wku0=0.7e-6               pku0=-0.5e-13             kvth0=5.2e-9
+ stk2=2.5e-9               steta0=-1.1e-10           lkvth0=-1.0e-8
+ wkvth0=2.2e-6             pkvth0=-5e-14             llodvth=1.0
+ wlodvth=1                 lodk2=1                   lodeta0=2
+ minr=1e-3                 imax=0.01                 imelt=0.01

     8: type=n
+ lmin=1.6e-07-dxl_lvt      lmax=4.7e-07-dxl_lvt      wmin=6.1e-07-dxw_lvt
+ wmax=1.205e-06-dxw_lvt    tnom=25                   version=3.24
+ tox=toxn_lvt              toxm=toxn_lvt             xj=1.9e-07
+ nch=1.58e+18              lln=1                     lwn=1
+ wln=1                     wwn=-1                    lint=1.2e-09
+ ll=0                      lw=0                      lwl=0
+ wint=2.5e-09              wl=0                      ww=0
+ wwl=0                     mobmod=1                  binunit=2
+ xl=-2e-08+dxl_lvt         xw=1.5e-08+dxw_lvt        dwg=0
+ dwb=0                     ldif=8e-08                hdif=hdifn_lvt
+ rsh=rshn_lvt              rd=0                      rs=0
+ vth0=0.2986195+dvthn_lvt  lvth0=4.6864860e-09+dlvthn_lvt
+ wvth0=-4.9551010e-08+dwvthn_lvt                     pvth0=4.6986230e-15+dpvthn_lvt
+ k1=0.2714527              lk1=9.270845e-08          wk1=1.653488e-08
+ pk1=-4.224989e-14         k2=0.02756109+dk2n_lvt    lk2=-3.491494e-08+dlk2n_lvt
+ wk2=-9.29877e-09          pk2=1.419244e-14          k3=0
+ dvt0=0                    dvt1=0                    dvt2=0
+ dvt0w=0                   dvt1w=0                   dvt2w=0
+ nlx=0                     w0=0                      k3b=0
+ vfb=-1.120943             vsat=1.2942793e+05        lvsat=-4.9098170e-03+dlvsatn_lvt
+ wvsat=-8.6283580e-03      pvsat=3.0687224e-09+dpvsatn_lvt
+ ua=2.220885e-11           lua=-4.145151e-18         wua=-1.877861e-17
+ pua=5.067864e-24          ub=2.130279e-18           lub=5.636728e-27
+ wub=-9.542479e-27         pub=-9.920527e-32         uc=8.376679e-11
+ luc=6.438639e-18          wuc=4.834349e-17          puc=-1.761118e-23
+ rdsw=155+drdswn_lvt       prwb=0                    prwg=0
+ wr=1                      u0=4.5094720e-02          lu0=1.5792028e-09
+ wu0=-1.2741737e-09        pu0=-6.8255020e-16        a0=0.5462454
+ la0=-1.627426e-07         wa0=-2.181918e-07         pa0=3.562219e-13
+ keta=0.01049178           lketa=2.016584e-09        wketa=-3.434153e-08
+ pketa=1.384575e-14        a1=0                      a2=1
+ ags=1.008221              lags=-1.249712e-07        wags=-3.139239e-11
+ pags=4.317878e-18         b0=0                      b1=0
+ voff=-0.1879333           lvoff=9.947499e-09        wvoff=4.1588e-08
+ pvoff=-1.039787e-14       nfactor=-0.04475243       lnfactor=-5.656461e-08
+ wnfactor=1.094565e-07     pnfactor=7.78651e-14      cit=0.003013027
+ lcit=4.5787e-10           wcit=-1.806352e-09        pcit=-2.837562e-16
+ cdsc=0                    cdscb=0                   cdscd=0
+ eta0=0.001180698          leta0=-8.088033e-11       weta0=-2.406886e-10
+ peta0=1.077322e-16        etab=0.000514033          letab=-3.486762e-10
+ wetab=-3.0886e-09         petab=4.236417e-16        dsub=0
+ pclm=-0.709565            lpclm=2.291582e-07+dlpclmn_lvt
+ wpclm=3.331288e-07        ppclm=-3.621177e-14       pdiblc1=0
+ pdiblc2=0.02600801        lpdiblc2=-1.392024e-09    wpdiblc2=-6.112255e-09
+ ppdiblc2=2.356225e-15     pdiblcb=-1.602943         lpdiblcb=1.813533e-07
+ wpdiblcb=1.7309e-06       ppdiblcb=-2.203444e-13    drout=0
+ pscbe1=7.522838e+08       pscbe2=1e-10              pvag=0.003
+ delta=0.01                alpha0=0                  alpha1=0.013325
+ beta0=6.2486              kt1=-0.02430046           lkt1=-5.935405e-09
+ wkt1=-3.3383e-08          pkt1=3.679951e-15         kt2=0.02
+ at=22639.01               wat=-0.01176388           ute=-0.9972
+ ua1=5.006711e-10          lua1=5.498873e-17         wua1=3.291758e-16
+ pua1=-3.409301e-23        ub1=1e-19                 uc1=4.73e-11
+ kt1l=0                    prt=0                     cj=cjn_lvt
+ mj=0.3473                 pb=0.6209                 cjsw=cjswn_lvt
+ mjsw=0.1679               pbsw=0.6209               cjswg=cjswgn_lvt
+ mjswg=0.5055              pbswg=0.6209              tcj=0.000976
+ tcjsw=0.000255            tcjswg=0.000255           tpb=0.001367
+ tpbsw=0.001367            tpbswg=0.001367           js=6e-07
+ jsw=1e-11                 n=1                       xti=3
+ cgdo=cgon_lvt             cgso=cgon_lvt             capmod=3
+ nqsmod=0                  xpart=1                   cf=0
+ tlev=1                    tlevc=1                   dlc=1.80e-8
+ cgdl=cgln_lvt             cgsl=cgln_lvt             wwc=-0.041
+ dwc=0                     noia=8.0e+18              noib=1.0e+4
+ noic=1.0e-13              em=4.1e+7                 ef=0.948
+ noimod=2                  sa0=0.35e-6               sb0=0.35e-6
+ kvsat=0.4                 wlod=0.5e-6               tku0=0.03
+ ku0=-0.62e-7              llodku0=1                 wlodku0=1
+ lku0=1.8e-7               wku0=0.7e-6               pku0=-0.5e-13
+ kvth0=5.2e-9              stk2=2.5e-9               steta0=-1.1e-10
+ lkvth0=-1.0e-8            wkvth0=2.2e-6             pkvth0=-5e-14
+ llodvth=1.0               wlodvth=1                 lodk2=1
+ lodeta0=2                 minr=1e-3                 imax=0.01
+ imelt=0.01

     9: type=n
+ lmin=1.3e-07              lmax=1.6e-07-dxl_lvt      wmin=6.1e-07-dxw_lvt
+ wmax=1.205e-06-dxw_lvt    tnom=25                   version=3.24
+ tox=toxn_lvt              toxm=toxn_lvt             xj=1.9e-07
+ nch=1.58e+18              lln=1                     lwn=1
+ wln=1                     wwn=-1                    lint=1.2e-09
+ ll=0                      lw=0                      lwl=0
+ wint=2.5e-09              wl=0                      ww=0
+ wwl=0                     mobmod=1                  binunit=2
+ xl=-2e-08+dxl_lvt         xw=1.5e-08+dxw_lvt        dwg=0
+ dwb=0                     ldif=8e-08                hdif=hdifn_lvt
+ rsh=rshn_lvt              rd=0                      rs=0
+ vth0=0.3304819+dvthn_lvt  lvth0=3.0222150e-10+dlvthn_lvt
+ wvth0=-8.2459890e-08+dwvthn_lvt                     pvth0=9.2268840e-15+dpvthn_lvt
+ k1=2.717728               lk1=-2.43899e-07          wk1=-1.946443e-06
+ pk1=2.278559e-13          k2=-0.9038036+dk2n_lvt    lk2=9.324084e-08+dlk2n_lvt
+ wk2=7.494186e-07          pk2=-9.020708e-14         k3=0
+ dvt0=0                    dvt1=0                    dvt2=0
+ dvt0w=0                   dvt1w=0                   dvt2w=0
+ nlx=0                     w0=0                      k3b=0
+ vfb=-1.333006             vsat=9.6543140e+04        lvsat=-3.8486930e-04+dlvsatn_lvt
+ wvsat=1.2384001e-02       pvsat=1.7742183e-10+dpvsatn_lvt
+ ua=-8.074579e-11          lua=1.002141e-17          wua=9.439685e-17
+ pua=-1.050508e-23         ub=5.284533e-18           lub=-4.283886e-25
+ wub=-3.026805e-24         pub=3.1597e-31            uc=5.81177e-10
+ luc=-6.200502e-17         wuc=-3.874315e-16         puc=4.235146e-23
+ rdsw=155+drdswn_lvt       prwb=0                    prwg=0
+ wr=1                      u0=2.8186157e-02          lu0=3.9058210e-09
+ wu0=-1.0401711e-08        pu0=5.7339900e-16         a0=-10.73
+ la0=1.388869e-06          wa0=9.409187e-06          pa0=-9.685055e-13
+ keta=-0.1215333           lketa=2.018323e-08        wketa=1.229158e-07
+ pketa=-7.792859e-15       a1=0                      a2=1
+ ags=0.1                   b0=0                      b1=0
+ voff=-0.2175153           lvoff=1.401798e-08        wvoff=6.598727e-08
+ pvoff=-1.37552e-14        nfactor=0.08062168        lnfactor=-7.38161e-08
+ wnfactor=5.454456e-08     pnfactor=8.542098e-14     cit=0.006824558
+ lcit=-6.659656e-11        wcit=-4.166382e-09        pcit=4.098383e-17
+ cdsc=0                    cdscb=0                   cdscd=0
+ eta0=-0.0155203           leta0=2.217177e-09        weta0=7.375848e-09
+ peta0=-9.403032e-16       etab=0.01579505           letab=-2.451344e-09
+ wetab=-7.060414e-09       petab=9.701632e-16        dsub=0
+ pclm=1.074134             lpclm=-1.627879e-08+dlpclmn_lvt
+ wpclm=-6.947675e-07       ppclm=1.052268e-13        pdiblc1=0
+ pdiblc2=-0.09531967       lpdiblc2=1.530267e-08     wpdiblc2=2.137152e-08
+ ppdiblc2=-1.425543e-15    pdiblcb=-1.215765         lpdiblcb=1.280777e-07
+ wpdiblcb=1.085635e-07     ppdiblcb=2.88913e-15      drout=0
+ pscbe1=7.522838e+08       pscbe2=1e-10              pvag=0.0249721
+ lpvag=-3.023361e-09       wpvag=-1.36227e-08        ppvag=1.874483e-15
+ delta=0.01                alpha0=0                  alpha1=0.013325
+ beta0=6.2486              kt1=0.06933948            lkt1=-1.882026e-08
+ wkt1=-3.045165e-08        pkt1=3.276598e-15         kt2=0.02
+ at=-79362.54              lat=0.01403541            wat=0.04850839
+ pat=-8.293465e-09         ute=-0.9972               ua1=2.243216e-09
+ lua1=-1.847854e-16        wua1=-1.736315e-15        pua1=2.501186e-22
+ ub1=1e-19                 uc1=4.73e-11              kt1l=0
+ prt=0                     cj=cjn_lvt                mj=0.3473
+ pb=0.6209                 cjsw=cjswn_lvt            mjsw=0.1679
+ pbsw=0.6209               cjswg=cjswgn_lvt          mjswg=0.5055
+ pbswg=0.6209              tcj=0.000976              tcjsw=0.000255
+ tcjswg=0.000255           tpb=0.001367              tpbsw=0.001367
+ tpbswg=0.001367           js=6e-07                  jsw=1e-11
+ n=1                       xti=3                     cgdo=cgon_lvt
+ cgso=cgon_lvt             capmod=3                  nqsmod=0
+ xpart=1                   cf=0                      tlev=1
+ tlevc=1                   dlc=1.80e-8               cgdl=cgln_lvt
+ cgsl=cgln_lvt             wwc=-0.041                dwc=0
+ noia=8.0e+18              noib=1.0e+4               noic=1.0e-13
+ em=4.1e+7                 ef=0.948                  noimod=2
+ sa0=0.35e-6               sb0=0.35e-6               kvsat=0.4
+ wlod=0.5e-6               tku0=0.03                 ku0=-0.62e-7
+ llodku0=1                 wlodku0=1                 lku0=1.8e-7
+ wku0=0.7e-6               pku0=-0.5e-13             kvth0=5.2e-9
+ stk2=2.5e-9               steta0=-1.1e-10           lkvth0=-1.0e-8
+ wkvth0=2.2e-6             pkvth0=-5e-14             llodvth=1.0
+ wlodvth=1                 lodk2=1                   lodeta0=2
+ minr=1e-3                 imax=0.01                 imelt=0.01

     10: type=n
+ lmin=4.7e-07-dxl_lvt      lmax=2.1e-05              wmin=1.5e-07
+ wmax=6.1e-07-dxw_lvt      tnom=25                   version=3.24
+ tox=toxn_lvt              toxm=toxn_lvt             xj=1.9e-07
+ nch=1.58e+18              lln=1                     lwn=1
+ wln=1                     wwn=-1                    lint=1.2e-09
+ ll=0                      lw=0                      lwl=0
+ wint=2.5e-09              wl=0                      ww=0
+ wwl=0                     mobmod=1                  binunit=2
+ xl=-2e-08+dxl_lvt         xw=1.5e-08+dxw_lvt        dwg=0
+ dwb=0                     ldif=8e-08                hdif=hdifn_lvt
+ rsh=rshn_lvt              rd=0                      rs=0
+ vth0=0.2351561+dvthn_lvt  lvth0=1.7784442e-08+dlvthn_lvt
+ wvth0=-2.2728472e-08+dwvthn_lvt                     pvth0=2.1839764e-15+dpvthn_lvt
+ k1=0.4207048              lk1=-4.4961830e-08        wk1=-5.2254860e-08
+ pk1=3.2476730e-14         k2=-2.0899918e-02+dk2n_lvt
+ lk2=1.4056583e-08+dlk2n_lvt                         wk2=1.2483916e-08
+ pk2=-1.2471323e-14        k3=0                      dvt0=0
+ dvt1=0                    dvt2=0                    dvt0w=0
+ dvt1w=0                   dvt2w=0                   nlx=0
+ w0=0                      k3b=0                     vfb=-0.9656632
+ vsat=1.0801257e+05        lvsat=3.4117030e-03+dlvsatn_lvt
+ wvsat=1.4509674e-03       pvsat=-6.5910570e-10+dpvsatn_lvt
+ ua=4.7431240e-12          lua=-1.7107693e-18        wua=-5.8183020e-19
+ pua=2.6061711e-25         ub=2.1620185e-18          lub=-1.9656855e-25
+ wub=-5.6953480e-26        pub=3.8575060e-32         uc=1.5563596e-10
+ luc=-1.3859294e-17        wuc=-1.1130317e-17        puc=1.6494537e-24
+ rdsw=155+drdswn_lvt       prwb=0                    prwg=0
+ wr=1                      u0=4.3399560e-02          lu0=3.8742300e-10
+ wu0=-1.4643523e-09        pu0=6.1190400e-16         a0=1.7841951
+ la0=-2.5254255e-07        wa0=2.7743206e-07         pa0=-1.5348924e-13
+ keta=1.1451785e-02        lketa=-8.7363010e-10      wketa=-6.7265910e-09
+ pketa=3.0108227e-15       a1=0                      a2=1
+ ags=0.7623376             lags=-1.6909201e-08       wags=-8.3436330e-09
+ pags=4.9620110e-15        b0=0                      b1=0
+ voff=-0.1422990           lvoff=-1.5104732e-09      wvoff=1.0537338e-08
+ pvoff=-2.0597152e-15      nfactor=0.7132385         lnfactor=-1.6104107e-07
+ wnfactor=-7.6891430e-08   pnfactor=1.5698260e-14    cit=2.4552821e-04
+ lcit=-6.5138460e-11       wcit=-2.3590645e-11       pcit=1.0559176e-17
+ cdsc=0                    cdscb=0                   cdscd=0
+ eta0=6.0638770e-04        leta0=1.7542617e-10       weta0=-4.5798910e-11
+ peta0=2.0967528e-17       etab=-1.0165505e-03       letab=-1.2100637e-09
+ wetab=9.3927660e-11       petab=-4.2042110e-17      dsub=0
+ pclm=-7.1235970e-02       lpclm=9.1573170e-08+dlpclmn_lvt
+ wpclm=1.0135114e-07       ppclm=-2.4309334e-14      pdiblc1=0
+ pdiblc2=4.0447940e-03     lpdiblc2=7.4651840e-09    wpdiblc2=-2.3403286e-11
+ ppdiblc2=2.3444202e-16    pdiblcb=-0.3733662        lpdiblcb=5.2519860e-07
+ wpdiblcb=1.8145231e-07    ppdiblcb=-8.1218050e-14   drout=0
+ pscbe1=7.522838e+08       pscbe2=1e-10              pvag=0.003
+ delta=0.01                alpha0=0                  alpha1=0.013325
+ beta0=6.2486              kt1=-7.9193170e-02        lkt1=-7.0452670e-10
+ wkt1=1.2720376e-09        pkt1=1.5859915e-16        kt2=0.02
+ at=3.8537330e+03          lat=-3.0116356e-04        wat=1.7358338e-04
+ pat=5.6652450e-11         ute=-0.9972               ua1=1.3437949e-09
+ lua1=-1.1953976e-16       wua1=-1.0422419e-16       pua1=3.4127520e-23
+ ub1=1e-19                 uc1=4.73e-11              kt1l=0
+ prt=0                     cj=cjn_lvt                mj=0.3473
+ pb=0.6209                 cjsw=cjswn_lvt            mjsw=0.1679
+ pbsw=0.6209               cjswg=cjswgn_lvt          mjswg=0.5055
+ pbswg=0.6209              tcj=0.000976              tcjsw=0.000255
+ tcjswg=0.000255           tpb=0.001367              tpbsw=0.001367
+ tpbswg=0.001367           js=6e-07                  jsw=1e-11
+ n=1                       xti=3                     cgdo=cgon_lvt
+ cgso=cgon_lvt             capmod=3                  nqsmod=0
+ xpart=1                   cf=0                      tlev=1
+ tlevc=1                   dlc=1.80e-8               cgdl=cgln_lvt
+ cgsl=cgln_lvt             wwc=-0.041                dwc=0
+ noia=8.0e+18              noib=1.0e+4               noic=1.0e-13
+ em=4.1e+7                 ef=0.948                  noimod=2
+ sa0=0.35e-6               sb0=0.35e-6               kvsat=0.4
+ wlod=0.5e-6               tku0=0.03                 ku0=-0.62e-7
+ llodku0=1                 wlodku0=1                 lku0=1.8e-7
+ wku0=0.7e-6               pku0=-0.5e-13             kvth0=5.2e-9
+ stk2=2.5e-9               steta0=-1.1e-10           lkvth0=-1.0e-8
+ wkvth0=2.2e-6             pkvth0=-5e-14             llodvth=1.0
+ wlodvth=1                 lodk2=1                   lodeta0=2
+ minr=1e-3                 imax=0.01                 imelt=0.01

     11: type=n
+ lmin=1.6e-07-dxl_lvt      lmax=4.7e-07-dxl_lvt      wmin=1.5e-07
+ wmax=6.1e-07-dxw_lvt      tnom=25                   version=3.24
+ tox=toxn_lvt              toxm=toxn_lvt             xj=1.9e-07
+ nch=1.58e+18              lln=1                     lwn=1
+ wln=1                     wwn=-1                    lint=1.2e-09
+ ll=0                      lw=0                      lwl=0
+ wint=2.5e-09              wl=0                      ww=0
+ wwl=0                     mobmod=1                  binunit=2
+ xl=-2e-08+dxl_lvt         xw=1.5e-08+dxw_lvt        dwg=0
+ dwb=0                     ldif=8e-08                hdif=hdifn_lvt
+ rsh=rshn_lvt              rd=0                      rs=0
+ vth0=0.2452306+dvthn_lvt  lvth0=1.3275075e-08+dlvthn_lvt
+ wvth0=-1.6449924e-08+dwvthn_lvt                     pvth0=-6.2630110e-16+dpvthn_lvt
+ k1=0.2641908              lk1=2.50938e-08           wk1=2.103722e-08
+ pk1=-3.288062e-16         k2=0.04118695+dk2n_lvt    lk2=-1.373351e-08+dlk2n_lvt
+ wk2=-1.774681e-08         pk2=1.059953e-15          k3=0
+ dvt0=0                    dvt1=0                    dvt2=0
+ dvt0w=0                   dvt1w=0                   dvt2w=0
+ nlx=0                     w0=0                      k3b=0
+ vfb=-1.120943             vsat=1.1559233e+05        lvsat=1.9003839e-05+dlvsatn_lvt
+ wvsat=-5.0281750e-05      pvsat=1.2853517e-11+dpvsatn_lvt
+ ua=-6.840878e-12          lua=3.474227e-18          wua=-7.677812e-19
+ pua=3.438493e-25          ub=2.003739e-18           lub=-1.257228e-25
+ wub=6.891213e-26          pub=-1.776237e-32         uc=1.800759e-10
+ luc=-2.47986e-17          wuc=-1.136816e-17         puc=1.755911e-24
+ rdsw=155+drdswn_lvt       prwb=0                    prwg=0
+ wr=1                      u0=4.3250440e-02          lu0=4.5417160e-10
+ wu0=-1.3071784e-10        pu0=1.4969228e-17         a0=0.4067271
+ la0=3.64012e-07           wa0=-1.316907e-07         pa0=2.963412e-14
+ keta=-0.05099944          lketa=2.707954e-08        wketa=3.783025e-09
+ pketa=-1.693282e-15       a1=0                      a2=1
+ ags=1.001784              lags=-1.240855e-07        wags=3.959419e-09
+ pags=-5.448161e-16        b0=0                      b1=0
+ voff=-0.1266073           lvoff=-8.534068e-09       wvoff=3.565888e-09
+ pvoff=1.060704e-15        nfactor=0.2233466         lnfactor=5.823453e-08
+ wnfactor=-5.676487e-08    pnfactor=6.689618e-15     cit=9.95561e-05
+ lcit=1.986897e-13         cdsc=0                    cdscb=0
+ cdscd=0                   eta0=0.0007084507         leta0=1.297427e-10
+ weta0=5.210459e-11        peta0=-2.285406e-17       etab=-0.004770291
+ letab=4.701102e-10        wetab=1.876807e-10        petab=-8.40059e-17
+ dsub=0                    pclm=-0.2070665           lpclm=1.523709e-07+dlpclmn_lvt
+ wpclm=2.157971e-08        ppclm=1.139636e-14        pdiblc1=0
+ pdiblc2=0.01456377        lpdiblc2=2.756896e-09     wpdiblc2=9.831806e-10
+ ppdiblc2=-2.161058e-16    pdiblcb=1.188831          lpdiblcb=-1.740408e-07
+ drout=0                   pscbe1=7.522838e+08       pscbe2=1e-10
+ pvag=0.003                delta=0.01                alpha0=0
+ alpha1=0.013325           beta0=6.2486              kt1=-0.08066885
+ lkt1=-4.400691e-11        wkt1=1.56541e-09          pkt1=2.728432e-17
+ kt2=0.02                  at=3199.024               lat=-8.121723e-06
+ wat=0.000288905           pat=5.035469e-12          ute=-0.9972
+ ua1=1.075036e-09          lua1=7.570623e-19         wua1=-2.693009e-17
+ pua1=-4.693779e-25        ub1=1e-19                 uc1=4.73e-11
+ kt1l=0                    prt=0                     cj=cjn_lvt
+ mj=0.3473                 pb=0.6209                 cjsw=cjswn_lvt
+ mjsw=0.1679               pbsw=0.6209               cjswg=cjswgn_lvt
+ mjswg=0.5055              pbswg=0.6209              tcj=0.000976
+ tcjsw=0.000255            tcjswg=0.000255           tpb=0.001367
+ tpbsw=0.001367            tpbswg=0.001367           js=6e-07
+ jsw=1e-11                 n=1                       xti=3
+ cgdo=cgon_lvt             cgso=cgon_lvt             capmod=3
+ nqsmod=0                  xpart=1                   cf=0
+ tlev=1                    tlevc=1                   dlc=1.80e-8
+ cgdl=cgln_lvt             cgsl=cgln_lvt             wwc=-0.041
+ dwc=0                     noia=8.0e+18              noib=1.0e+4
+ noic=1.0e-13              em=4.1e+7                 ef=0.948
+ noimod=2                  sa0=0.35e-6               sb0=0.35e-6
+ kvsat=0.4                 wlod=0.5e-6               tku0=0.03
+ ku0=-0.62e-7              llodku0=1                 wlodku0=1
+ lku0=1.8e-7               wku0=0.7e-6               pku0=-0.5e-13
+ kvth0=5.2e-9              stk2=2.5e-9               steta0=-1.1e-10
+ lkvth0=-1.0e-8            wkvth0=2.2e-6             pkvth0=-5e-14
+ llodvth=1.0               wlodvth=1                 lodk2=1
+ lodeta0=2                 minr=1e-3                 imax=0.01
+ imelt=0.01

     12: type=n
+ lmin=1.3e-07              lmax=1.6e-07-dxl_lvt      wmin=1.5e-07
+ wmax=6.1e-07-dxw_lvt      tnom=25                   version=3.24
+ tox=toxn_lvt              toxm=toxn_lvt             xj=1.9e-07
+ nch=1.58e+18              lln=1                     lwn=1
+ wln=1                     wwn=-1                    lint=1.2e-09
+ ll=0                      lw=0                      lwl=0
+ wint=2.5e-09              wl=0                      ww=0
+ wwl=0                     mobmod=1                  binunit=2
+ xl=-2e-08+dxl_lvt         xw=1.5e-08+dxw_lvt        dwg=0
+ dwb=0                     ldif=8e-08                hdif=hdifn_lvt
+ rsh=rshn_lvt              rd=0                      rs=0
+ vth0=0.2105056+dvthn_lvt  lvth0=1.8053244e-08+dlvthn_lvt
+ wvth0=-8.0745660e-09+dwvthn_lvt                     pvth0=-1.7787501e-15+dpvthn_lvt
+ k1=-0.5694889             lk1=1.398081e-07          wk1=9.163066e-08
+ pk1=-1.004246e-14         k2=0.3709159+dk2n_lvt     lk2=-5.910421e-08+dlk2n_lvt
+ wk2=-4.090737e-08         pk2=4.246846e-15          k3=0
+ dvt0=0                    dvt1=0                    dvt2=0
+ dvt0w=0                   dvt1w=0                   dvt2w=0
+ nlx=0                     w0=0                      k3b=0
+ vfb=-1.429629             vsat=1.1644777e+05        pvsat=0+dpvsatn_lvt
+ lvsat=-9.8705080e-05+dlvsatn_lvt                    wvsat=4.3130440e-05
+ ua=7.655275e-11           lua=-8.000737e-18         wua=-3.128236e-18
+ pua=6.68648e-25           ub=7.241772e-19           lub=5.034496e-26
+ wub=-1.993844e-25         pub=1.915524e-32          uc=-7.358405e-11
+ luc=1.010501e-17          wuc=1.852037e-17          puc=-2.356751e-24
+ rdsw=155+drdswn_lvt       prwb=0                    prwg=0
+ wr=1                      u0=6.7066080e-03          lu0=5.4826020e-09
+ wu0=2.9156051e-09         pu0=-4.0420480e-16        a0=5.128563
+ la0=-2.857127e-07         wa0=-4.231202e-07         pa0=6.973481e-14
+ keta=0.1239012            lketa=3.013216e-09        wketa=-2.925354e-08
+ pketa=2.852549e-15        a1=0                      a2=1
+ ags=0.1                   b0=0                      b1=0
+ voff=-0.0955862           lvoff=-1.280258e-08       wvoff=-9.608766e-09
+ pvoff=2.873537e-15        nfactor=0.08907563        lnfactor=7.671022e-08
+ wnfactor=4.930306e-08     pnfactor=-7.90533e-15     cit=0.0001059979
+ lcit=-6.877085e-13        wcit=-8.746291e-13        pcit=1.20349e-19
+ cdsc=0                    cdscb=0                   cdscd=0
+ eta0=-0.001915893         leta0=4.908525e-10        weta0=-1.058885e-09
+ peta0=1.300181e-16        etab=0.001196805          letab=-3.509621e-10
+ wetab=1.990499e-09        petab=-3.320737e-16       dsub=0
+ pclm=-0.3782649           lpclm=1.759278e-07+dlpclmn_lvt
+ wpclm=2.057197e-07        ppclm=-1.394131e-14       pdiblc1=0
+ pdiblc2=-0.07836966       lpdiblc2=1.554454e-08     wpdiblc2=1.086252e-08
+ ppdiblc2=-1.575503e-15    pdiblcb=-0.9106975        lpdiblcb=1.148544e-07
+ wpdiblcb=-8.057834e-08    ppdiblcb=1.108758e-14     drout=0
+ pscbe1=7.522838e+08       pscbe2=1e-10              pvag=0.003
+ delta=0.01                alpha0=0                  alpha1=0.013325
+ beta0=6.2486              kt1=0.038413              lkt1=-1.642967e-08
+ wkt1=-1.127722e-08        pkt1=1.794431e-15         kt2=0.02
+ at=-3531.199              lat=0.000917957           wat=0.00149296
+ pat=-1.606425e-10         ute=-0.9972               ua1=-7.291373e-10
+ lua1=2.490112e-16         wua1=1.065434e-16         pua1=-1.883533e-23
+ ub1=1e-19                 uc1=4.73e-11              kt1l=0
+ prt=0                     cj=cjn_lvt                mj=0.3473
+ pb=0.6209                 cjsw=cjswn_lvt            mjsw=0.1679
+ pbsw=0.6209               cjswg=cjswgn_lvt          mjswg=0.5055
+ pbswg=0.6209              tcj=0.000976              tcjsw=0.000255
+ tcjswg=0.000255           tpb=0.001367              tpbsw=0.001367
+ tpbswg=0.001367           js=6e-07                  jsw=1e-11
+ n=1                       xti=3                     cgdo=cgon_lvt
+ cgso=cgon_lvt             capmod=3                  nqsmod=0
+ xpart=1                   cf=0                      tlev=1
+ tlevc=1                   cgdl=cgln_lvt             cgsl=cgln_lvt
+ wwc=-0.041                dlc=1.80e-8               dwc=0
+ noia=8.0e+18              noib=1.0e+4               noic=1.0e-13
+ em=4.1e+7                 ef=0.948                  noimod=2
+ sa0=0.35e-6               sb0=0.35e-6               kvsat=0.4
+ wlod=0.5e-6               tku0=0.03                 ku0=-0.62e-7
+ llodku0=1                 wlodku0=1                 lku0=1.8e-7
+ wku0=0.7e-6               pku0=-0.5e-13             kvth0=5.2e-9
+ stk2=2.5e-9               steta0=-1.1e-10           lkvth0=-1.0e-8
+ wkvth0=2.2e-6             pkvth0=-5e-14             llodvth=1.0
+ wlodvth=1                 lodk2=1                   lodeta0=2
+ minr=1e-3                 imax=0.01                 imelt=0.01
//
// **************************************************************
//                                                              *
//               1.2V LOW Vt PMOS DEVICES MODEL                 *
//                                                              *
// **************************************************************
//
     }
model pch_lvt bsim3v3  {
     1: type=p
+ lmin=0.77e-6-dxl_lvt      lmax=0.000021             wmin=1.0005e-05-dxw_lvt
+ wmax=0.0009001            tnom=25.0                 version=3.24
+ tox=toxp_lvt              toxm=toxp_lvt             xj=2.1000000e-07
+ nch=5.6487000e+17         lln=1.0000000             lwn=1.0000000
+ wln=1.0000000             wwn=-1                    lint=6.5000000e-09
+ ll=0.00                   lw=0.00                   lwl=0.00
+ wint=1.5000000e-09        wl=0.00                   ww=0.00
+ wwl=0.00                  mobmod=1                  binunit=2
+ xl=-2e-8+dxl_lvt          xw=1.5e-8+dxw_lvt         dwg=0.00
+ dwb=0.00                  ldif=8.00e-08             hdif=hdifp_lvt
+ rsh=rshp_lvt              rd=0                      rs=0
+ vth0=-7.7532660e-02+dvthp_lvt                       lvth0=-5.4602370e-08+dlvthp_lvt
+ pvth0=0+dpvthp_lvt        wvth0=0+dwvthp_lvt        k1=0.4000000
+ k2=-5.3239030e-02+dk2p_lvt                          lk2=2.3871616e-09+dlk2p_lvt
+ k3=0.00                   dvt0=0.00                 dvt1=0.00
+ dvt2=0.00                 dvt0w=0.00                dvt1w=0.00
+ dvt2w=0.00                nlx=0.00                  w0=0.00
+ k3b=0.00                  vsat=8.2000000e+04        ua=2.0795985e-11
+ pvsat=0+dpvsatp_lvt       lvsat=0+dlvsatp_lvt       lua=1.8016722e-17
+ ub=2.0619514e-18          lub=-1.1935822e-25        uc=1.0000000e-10
+ rdsw=4.9180000e+02+drdswp_lvt                       prwb=0.00
+ prwg=0.00                 wr=1.0000000              u0=1.0888455e-02
+ lu0=1.1140093e-09         a0=1.8478054              la0=-4.7743250e-07
+ keta=-1.0100800e-02       a1=0.00                   a2=0.9900000
+ ags=0.6760973             lags=2.3871630e-07        b0=0.00
+ b1=0.00                   voff=-9.6867940e-02       lvoff=-1.0344577e-08
+ nfactor=0.9521946         lnfactor=4.7743260e-07    lcit=1.6710139e-09
+ cit=2.3268120e-04         cdsc=0.00                 cdscb=0.00
+ cdscd=0.00                eta0=1.7681296e-03        leta0=3.1828840e-10
+ etab=-1.1362595e-03       letab=-6.3657680e-10      dsub=0.00
+ pclm=1.6849999            lpclm=0+dlpclmp_lvt       wpclm=0+dwpclmp_lvt
+ pdiblc1=0.00              pdiblc2=5.3426380e-02     lpdiblc2=-3.3420280e-08
+ pdiblcb=0.00              drout=0.00                pscbe1=8.4920770e+08
+ pscbe2=1.0000000e-07      pvag=0.00                 delta=8.0000000e-03
+ alpha0=0.00               alpha1=0.019              beta0=12.638
+ kt1=-0.2825935            lkt1=1.5914402e-08        pkt1=0+dpkt1p_lvt
+ kt2=-3.3268120e-03        lkt2=-1.6710139e-08       at=1.0000000e+04
+ ute=-1.7159352            lute=1.5914422e-07        ua1=5.9900000e-10
+ ub1=-2.9836595e-18        lub1=8.3550700e-25        uc1=-1.4600000e-10
+ kt1l=0.00                 prt=0.00                  cj=cjp_lvt
+ pb=0.826557               mj=0.385643               cjsw=cjswp_lvt
+ pbsw=0.826557             mjsw=0.158                cjswg=cjswgp_lvt
+ pbswg=0.826557            mjswg=0.7162              js=2e-7
+ jsw=7.6e-12               n=1.0                     xti=3.0
+ cgdo=cgop_lvt             cgso=cgop_lvt             tcj=0.00090284
+ tcjsw=0.00029887          tpb=0.00165968            tpbsw=0.00165968
+ tcjswg=0.00029887         tpbswg=0.00165968         capmod=3
+ nqsmod=0                  xpart=1                   cf=0
+ tlev=1                    tlevc=1                   dlc=1.50e-8
+ cgdl=cglp_lvt             cgsl=cglp_lvt             wwc=-0.038
+ dwc=0                     noia=9.0e+18              noib=1.0e+3
+ noic=6.0e-12              em=4.1e+7                 ef=1.128
+ noimod=2                  sa0=0.35e-6               sb0=0.35e-6
+ kvsat=-0.6                wlod=0.3e-6               tku0=0.03
+ ku0=1.14e-7               llodku0=1                 wlodku0=1
+ lku0=3e-8                 wku0=3.0e-7               pku0=0e-14
+ kvth0=-2.3e-9             stk2=0e-9                 steta0=0
+ lkvth0=1.0e-8             wkvth0=2.5e-7             pkvth0=4e-14
+ llodvth=1                 wlodvth=1                 lodk2=1
+ lodeta0=1                 minr=1e-3                 imax=0.01
+ imelt=0.01

     2: type=p
+ lmin=2.2e-07-dxl_lvt      lmax=0.77e-6-dxl_lvt      wmin=1.0005e-05-dxw_lvt
+ wmax=0.0009001            tnom=25.0                 version=3.24
+ tox=toxp_lvt              toxm=toxp_lvt             xj=2.1000000e-07
+ nch=5.6487000e+17         lln=1.0000000             lwn=1.0000000
+ wln=1.0000000             wwn=-1                    lint=6.5000000e-09
+ ll=0.00                   lw=0.00                   lwl=0.00
+ wint=1.5000000e-09        wl=0.00                   ww=0.00
+ wwl=0.00                  mobmod=1                  binunit=2
+ xl=-2e-8+dxl_lvt          xw=1.5e-8+dxw_lvt         dwg=0.00
+ dwb=0.00                  ldif=8.00e-08             hdif=hdifp_lvt
+ rsh=rshp_lvt              rd=0                      rs=0
+ vth0=-0.1251476+dvthp_lvt lvth0=-1.9510159e-08+dlvthp_lvt
+ pvth0=0+dpvthp_lvt        wvth0=0+dwvthp_lvt        k1=0.4000000
+ k2=-5.4080000e-02+dk2p_lvt                          lk2=3.0069607e-09+dlk2p_lvt
+ k3=0.00                   dvt0=0.00                 dvt1=0.00
+ dvt2=0.00                 dvt0w=0.00                dvt1w=0.00
+ dvt2w=0.00                nlx=0.00                  w0=0.00
+ k3b=0.00                  vsat=8.2000000e+04        ua=4.3624300e-11
+ pvsat=0+dpvsatp_lvt       lvsat=0+dlvsatp_lvt       lua=1.1922570e-18
+ ub=2.1366332e-18          lub=-1.7439866e-25        uc=1.4110600e-10
+ luc=-3.0295123e-17        rdsw=4.9180000e+02+drdswp_lvt
+ prwb=0.00                 prwg=0.00                 wr=1.0000000
+ u0=1.2298000e-02          lu0=7.5174010e-11         a0=1.2272000
+ la0=-2.0046413e-08        keta=-1.0100800e-02       a1=0.00
+ a2=0.9900000              ags=1.0000000             b0=0.00
+ b1=0.00                   voff=-0.1050914           lvoff=-4.2839180e-09
+ nfactor=1.8040001         lnfactor=-1.5034803e-07   cit=3.1800000e-03
+ lcit=-5.0116000e-10       cdsc=0.00                 cdscb=0.00
+ cdscd=0.00                eta0=8.7906560e-04        leta0=9.7352850e-10
+ etab=-2.0000001e-03       dsub=0.00                 pclm=1.9998400
+ lpclm=-2.3203708e-07+dlpclmp_lvt                    wpclm=0+dwpclmp_lvt
+ pdiblc1=0.00              pdiblc2=1.0420458e-02     lpdiblc2=-1.7249177e-09
+ pdiblcb=0.00              drout=0.00                pscbe1=8.4920770e+08
+ pscbe2=1.0000000e-07      pvag=0.00                 delta=3.9200000e-03
+ ldelta=3.0069600e-09      alpha0=0.00               alpha1=0.019
+ beta0=12.638              kt1=-0.2644000            pkt1=0+dpkt1p_lvt
+ lkt1=2.5058053e-09        kt2=-2.3280000e-02        lkt2=-2.0046405e-09
+ at=1.0000000e+04          ute=-1.5272000            lute=2.0046413e-08
+ ua1=5.9900000e-10         ub1=-1.8500000e-18        uc1=-1.4600000e-10
+ kt1l=0.00                 prt=0.00                  cj=cjp_lvt
+ pb=0.826557               mj=0.385643               cjsw=cjswp_lvt
+ pbsw=0.826557             mjsw=0.158                cjswg=cjswgp_lvt
+ pbswg=0.826557            mjswg=0.7162              js=2e-7
+ jsw=7.6e-12               n=1.0                     xti=3.0
+ cgdo=cgop_lvt             cgso=cgop_lvt             tcj=0.00090284
+ tcjsw=0.00029887          tpb=0.00165968            tpbsw=0.00165968
+ tcjswg=0.00029887         tpbswg=0.00165968         capmod=3
+ nqsmod=0                  xpart=1                   cf=0
+ tlev=1                    tlevc=1                   dlc=1.50e-8
+ cgdl=cglp_lvt             cgsl=cglp_lvt             wwc=-0.038
+ dwc=0                     noia=9.0e+18              noib=1.0e+3
+ noic=6.0e-12              em=4.1e+7                 ef=1.128
+ noimod=2                  sa0=0.35e-6               sb0=0.35e-6
+ kvsat=-0.6                wlod=0.3e-6               tku0=0.03
+ ku0=1.14e-7               llodku0=1                 wlodku0=1
+ lku0=3e-8                 wku0=3.0e-7               pku0=0e-14
+ kvth0=-2.3e-9             stk2=0e-9                 steta0=0
+ lkvth0=1.0e-8             wkvth0=2.5e-7             pkvth0=4e-14
+ llodvth=1                 wlodvth=1                 lodk2=1
+ lodeta0=1                 minr=1e-3                 imax=0.01
+ imelt=0.01

     3: type=p
+ lmin=1.3e-07              lmax=2.2e-07-dxl_lvt      wmin=1.0005e-05-dxw_lvt
+ wmax=0.0009001            tnom=25.0                 version=3.24
+ tox=toxp_lvt              toxm=toxp_lvt             xj=2.1000000e-07
+ nch=5.6487000e+17         lln=1.0000000             lwn=1.0000000
+ wln=1.0000000             wwn=-1                    lint=6.5000000e-09
+ ll=0.00                   lw=0.00                   lwl=0.00
+ wint=1.5000000e-09        wl=0.00                   ww=0.00
+ wwl=0.00                  mobmod=1                  binunit=2
+ xl=-2e-8+dxl_lvt          xw=1.5e-8+dxw_lvt         dwg=0.00
+ dwb=0.00                  ldif=8.00e-08             hdif=hdifp_lvt
+ rsh=rshp_lvt              rd=0                      rs=0
+ vth0=-0.1383345+dvthp_lvt lvth0=-1.7044210e-08+dlvthp_lvt
+ pvth0=0+dpvthp_lvt        wvth0=0+dwvthp_lvt        k1=0.3806000
+ lk1=3.6278010e-09         k2=-4.4486060e-02+dk2p_lvt
+ lk2=1.2128940e-09+dlk2p_lvt                         k3=0.00
+ dvt0=0.00                 dvt1=0.00                 dvt2=0.00
+ dvt0w=0.00                dvt1w=0.00                dvt2w=0.00
+ nlx=0.00                  w0=0.00                   k3b=0.00
+ vsat=8.2000000e+04        pvsat=0+dpvsatp_lvt       lvsat=0+dlvsatp_lvt
+ ua=5.0000000e-11          ub=1.6351310e-18          lub=-8.0617770e-26
+ uc=-2.0900000e-11         rdsw=4.9180000e+02+drdswp_lvt
+ prwb=0.00                 prwg=0.00                 wr=1.0000000
+ u0=1.2700000e-02          a0=0.8721111              la0=4.6355230e-08
+ keta=-1.0100800e-02       a1=0.00                   a2=0.9900000
+ ags=1.0000000             b0=0.00                   b1=0.00
+ voff=-0.1257367           lvoff=-4.2324150e-10      nfactor=1.0000000
+ cit=-1.1729695e-03        lcit=3.1284533e-10        cdsc=0.00
+ cdscb=0.00                cdscd=0.00                eta0=6.9626600e-04
+ leta0=1.0077121e-09       etab=-9.2222240e-04       letab=-2.0154443e-10
+ dsub=0.00                 pclm=0.7590000            lpclm=0+dlpclmp_lvt
+ wpclm=0+dwpclmp_lvt       pdiblc1=0.00              pdiblc2=1.1963000e-03
+ pdiblcb=0.00              drout=0.00                pscbe1=8.4920770e+08
+ pscbe2=1.0000000e-07      pvag=0.00                 delta=2.0000000e-02
+ alpha0=0.00               alpha1=0.019              beta0=12.638
+ kt1=-0.2510000            kt2=-3.4000000e-02        at=1.0000000e+04
+ pkt1=0+dpkt1p_lvt         ute=-1.3876666            lute=-6.0463510e-09
+ ua1=5.9900000e-10         ub1=-1.8500000e-18        uc1=-1.4600000e-10
+ kt1l=0.00                 prt=0.00                  cj=cjp_lvt
+ pb=0.826557               mj=0.385643               cjsw=cjswp_lvt
+ pbsw=0.826557             mjsw=0.158                cjswg=cjswgp_lvt
+ pbswg=0.826557            mjswg=0.7162              js=2e-7
+ jsw=7.6e-12               n=1.0                     xti=3.0
+ cgdo=cgop_lvt             cgso=cgop_lvt             tcj=0.00090284
+ tcjsw=0.00029887          tpb=0.00165968            tpbsw=0.00165968
+ tcjswg=0.00029887         tpbswg=0.00165968         capmod=3
+ nqsmod=0                  xpart=1                   cf=0
+ tlev=1                    tlevc=1                   dlc=1.50e-8
+ cgdl=cglp_lvt             cgsl=cglp_lvt             wwc=-0.038
+ dwc=0                     noia=9.0e+18              noib=1.0e+3
+ noic=6.0e-12              em=4.1e+7                 ef=1.128
+ noimod=2                  sa0=0.35e-6               sb0=0.35e-6
+ kvsat=-0.6                wlod=0.3e-6               tku0=0.03
+ ku0=1.14e-7               llodku0=1                 wlodku0=1
+ lku0=3e-8                 wku0=3.0e-7               pku0=0e-14
+ kvth0=-2.3e-9             stk2=0e-9                 steta0=0
+ lkvth0=1.0e-8             wkvth0=2.5e-7             pkvth0=4e-14
+ llodvth=1                 wlodvth=1                 lodk2=1
+ lodeta0=1                 minr=1e-3                 imax=0.01
+ imelt=0.01

     4: type=p
+ lmin=0.77e-6-dxl_lvt      lmax=0.000021             wmin=1.225e-06-dxw_lvt
+ wmax=1.0005e-05-dxw_lvt   tnom=25.0                 version=3.24
+ tox=toxp_lvt              toxm=toxp_lvt             xj=2.1000000e-07
+ nch=5.6487000e+17         lln=1.0000000             lwn=1.0000000
+ wln=1.0000000             wwn=-1                    lint=6.5000000e-09
+ ll=0.00                   lw=0.00                   lwl=0.00
+ wint=1.5000000e-09        wl=0.00                   ww=0.00
+ wwl=0.00                  mobmod=1                  binunit=2
+ xl=-2e-8+dxl_lvt          xw=1.5e-8+dxw_lvt         dwg=0.00
+ dwb=0.00                  ldif=8.00e-08             hdif=hdifp_lvt
+ rsh=rshp_lvt              rd=0                      rs=0
+ vth0=-7.8944260e-02+dvthp_lvt                       lvth0=-5.4575240e-08+dlvthp_lvt
+ wvth0=1.4140014e-08+dwvthp_lvt                      pvth0=-2.7177312e-16+dpvthp_lvt
+ k1=0.4000000              k2=-5.2709150e-02+dk2p_lvt
+ lk2=2.7234852e-09+dlk2p_lvt                         wk2=-5.3077840e-09
+ pk2=-3.3689510e-15        k3=0.00                   dvt0=0.00
+ dvt1=0.00                 dvt2=0.00                 dvt0w=0.00
+ dvt1w=0.00                dvt2w=0.00                nlx=0.00
+ w0=0.00                   k3b=0.00                  vsat=8.2000000e+04
+ pvsat=0+dpvsatp_lvt       lvsat=0+dlvsatp_lvt       ua=1.9529187e-11
+ lua=1.6597665e-17         wua=1.2689468e-17         pua=1.4214717e-23
+ ub=2.0904659e-18          lub=-1.2272148e-25        wub=-2.8562923e-25
+ pub=3.3689620e-32         uc=9.9663240e-11          luc=3.3632340e-18
+ wuc=3.3733360e-18         puc=-3.3689530e-23        rdsw=4.9180000e+02+drdswp_lvt
+ prwb=0.00                 prwg=0.00                 wr=1.0000000
+ u0=1.0995552e-02          lu0=1.1700633e-09         wu0=-1.0728010e-09
+ pu0=-5.6149210e-16        a0=1.8173827              la0=-4.5501100e-07
+ wa0=3.0474476e-07         pa0=-2.2459688e-13        keta=-1.0100800e-02
+ a1=0.00                   a2=0.9900000              ags=0.6744134
+ lags=2.5553248e-07        wags=1.6866698e-08        pags=-1.6844760e-13
+ b0=0.00                   b1=0.00                   voff=-9.6821760e-02
+ lvoff=-1.0805789e-08      wvoff=-4.6259680e-10      pvoff=4.6199590e-15
+ nfactor=0.9521946         lnfactor=4.7743260e-07    cit=2.1584287e-04
+ lcit=1.8391757e-09        wcit=1.6866702e-10        pcit=-1.6844761e-15
+ cdsc=0.00                 cdscb=0.00                cdscd=0.00
+ eta0=1.8323428e-03        leta0=2.3981295e-10       weta0=-6.4322280e-10
+ peta0=7.8608890e-16       etab=-1.1362595e-03       letab=-6.3657680e-10
+ dsub=0.00                 pclm=1.6944573            lpclm=-9.4450830e-08+dlpclmp_lvt
+ wpclm=-9.4734520e-08+dwpclmp_lvt                    ppclm=9.4611420e-13
+ pdiblc1=0.00              pdiblc2=5.3471510e-02     lpdiblc2=-3.3870960e-08
+ wpdiblc2=-4.5202280e-10   ppdiblc2=4.5143960e-15    pdiblcb=0.00
+ drout=0.00                pscbe1=8.4920770e+08      pscbe2=1.0000000e-07
+ pvag=0.00                 delta=8.0000000e-03       alpha0=0.00
+ alpha1=0.019              beta0=12.638              kt1=-0.2795911
+ lkt1=1.2663274e-08        wkt1=-3.0075231e-08       pkt1=3.2566590e-14+dpkt1p_lvt
+ kt2=-1.0226484e-03        lkt2=-1.8615976e-08       wkt2=-2.3080746e-08
+ pkt2=1.9090732e-14        at=1.0000000e+04          ute=-1.7104738
+ lute=1.4681238e-07        wute=-5.4707240e-08       pute=1.2352828e-13
+ ua1=5.9900000e-10         ub1=-2.9836595e-18        lub1=8.3550710e-25
+ uc1=-1.4600000e-10        kt1l=0.00                 prt=0.00
+ cj=cjp_lvt                pb=0.826557               mj=0.385643
+ cjsw=cjswp_lvt            pbsw=0.826557             mjsw=0.158
+ cjswg=cjswgp_lvt          pbswg=0.826557            mjswg=0.7162
+ js=2e-7                   jsw=7.6e-12               n=1.0
+ xti=3.0                   cgdo=cgop_lvt             cgso=cgop_lvt
+ tcj=0.00090284            tcjsw=0.00029887          tpb=0.00165968
+ tpbsw=0.00165968          tcjswg=0.00029887         tpbswg=0.00165968
+ capmod=3                  nqsmod=0                  xpart=1
+ cf=0                      tlev=1                    tlevc=1
+ dlc=1.50e-8               cgdl=cglp_lvt             cgsl=cglp_lvt
+ wwc=-0.038                dwc=0                     noia=9.0e+18
+ noib=1.0e+3               noic=6.0e-12              em=4.1e+7
+ ef=1.128                  noimod=2                  sa0=0.35e-6
+ sb0=0.35e-6               kvsat=-0.6                wlod=0.3e-6
+ tku0=0.03                 ku0=1.14e-7               llodku0=1
+ wlodku0=1                 lku0=3e-8                 wku0=3.0e-7
+ pku0=0e-14                kvth0=-2.3e-9             stk2=0e-9
+ steta0=0                  lkvth0=1.0e-8             wkvth0=2.5e-7
+ pkvth0=4e-14              llodvth=1                 wlodvth=1
+ lodk2=1                   lodeta0=1                 minr=1e-3
+ imax=0.01                 imelt=0.01

     5: type=p
+ lmin=2.2e-07-dxl_lvt      lmax=0.77e-6-dxl_lvt      wmin=1.225e-06-dxw_lvt
+ wmax=1.0005e-05-dxw_lvt   tnom=25.0                 version=3.24
+ tox=toxp_lvt              toxm=toxp_lvt             xj=2.1000000e-07
+ nch=5.6487000e+17         lln=1.0000000             lwn=1.0000000
+ wln=1.0000000             wwn=-1                    lint=6.5000000e-09
+ ll=0.00                   lw=0.00                   lwl=0.00
+ wint=1.5000000e-09        wl=0.00                   ww=0.00
+ wwl=0.00                  mobmod=1                  binunit=2
+ xl=-2e-8+dxl_lvt          xw=1.5e-8+dxw_lvt         dwg=0.00
+ dwb=0.00                  ldif=8.00e-08             hdif=hdifp_lvt
+ rsh=rshp_lvt              rd=0                      rs=0
+ vth0=-0.1272772+dvthp_lvt lvth0=-1.8953843e-08+dlvthp_lvt
+ wvth0=2.1332486e-08+dwvthp_lvt                      pvth0=-5.5726290e-15+dpvthp_lvt
+ k1=0.4008622              lk1=-6.3546860e-10        wk1=-8.6370280e-09
+ pk1=6.3654910e-15         k2=-5.3812310e-02+dk2p_lvt
+ lk2=3.5365180e-09+dlk2p_lvt                         wk2=-2.6814306e-09
+ pk2=-5.3045740e-15        k3=0.00                   dvt0=0.00
+ dvt1=0.00                 dvt2=0.00                 dvt0w=0.00
+ dvt1w=0.00                dvt2w=0.00                nlx=0.00
+ w0=0.00                   k3b=0.00                  vsat=8.2000000e+04
+ pvsat=0+dpvsatp_lvt       lvsat=0+dlvsatp_lvt       ua=4.4136880e-11
+ lua=-1.5382091e-18        wua=-5.1346390e-18        pua=2.7351095e-23
+ ub=2.1876956e-18          lub=-1.9437991e-25        wub=-5.1149420e-25
+ pub=2.0015215e-31         uc=1.4698527e-10          luc=-3.1513103e-17
+ wuc=-5.8892660e-17        puc=1.2200521e-23         rdsw=4.9180000e+02+drdswp_lvt
+ prwb=0.00                 prwg=0.00                 wr=1.0000000
+ u0=1.2509896e-02          lu0=5.3991730e-11         wu0=-2.1225632e-09
+ pu0=2.1218294e-16         a0=1.2070812              la0=-5.2188100e-09
+ wa0=2.0153060e-07         pa0=-1.4852808e-13        keta=-1.0100800e-02
+ a1=0.00                   a2=0.9900000              ags=1.0283185
+ lags=-5.2955690e-09       wags=-2.8366699e-07       pags=5.3045730e-14
+ b0=0.00                   b1=0.00                   voff=-0.1054896
+ lvoff=-4.4175780e-09      wvoff=3.9893480e-09       pvoff=1.3388763e-15
+ nfactor=1.8040001         lnfactor=-1.5034803e-07   cit=3.4583960e-03
+ lcit=-5.5058540e-10       wcit=-2.7886871e-09       pcit=4.9509350e-16
+ cdsc=0.00                 cdscb=0.00                cdscd=0.00
+ eta0=7.2254820e-04        leta0=1.0577316e-09       weta0=1.5678373e-09
+ peta0=-8.4346260e-16      etab=-1.9520981e-03       letab=-3.5303810e-11
+ wetab=-4.7983470e-10      petab=3.5363830e-16       dsub=0.00
+ pclm=1.8452566            lpclm=-2.0558987e-07+dlpclmp_lvt
+ wpclm=1.5484620e-06+dwpclmp_lvt                     ppclm=-2.6492168e-13
+ pdiblc1=0.00              pdiblc2=9.8820470e-03     lpdiblc2=-1.7455245e-09
+ wpdiblc2=5.3932620e-09    ppdiblc2=2.0641862e-16    pdiblcb=0.00
+ drout=0.00                pscbe1=8.4920770e+08      pscbe2=1.0000000e-07
+ pvag=0.00                 delta=3.9200000e-03       ldelta=3.0069600e-09
+ alpha0=0.00               alpha1=0.019              beta0=12.638
+ kt1=-0.2662879            lkt1=2.8588438e-09        wkt1=1.8911173e-08
+ pkt1=-3.5363900e-15+dpkt1p_lvt                      kt2=-2.3657581e-02
+ lkt2=-1.9340329e-09       wkt2=3.7822270e-09        pkt2=-7.0727660e-16
+ at=1.0000000e+04          ute=-1.5399082            lute=2.1105530e-08
+ wute=1.2729745e-07        pute=-1.0609180e-14       ua1=5.9900000e-10
+ ub1=-1.8500000e-18        uc1=-1.4600000e-10        kt1l=0.00
+ prt=0.00                  cj=cjp_lvt                pb=0.826557
+ mj=0.385643               cjsw=cjswp_lvt            pbsw=0.826557
+ mjsw=0.158                cjswg=cjswgp_lvt          pbswg=0.826557
+ mjswg=0.7162              js=2e-7                   jsw=7.6e-12
+ n=1.0                     xti=3.0                   cgdo=cgop_lvt
+ cgso=cgop_lvt             tcj=0.00090284            tcjsw=0.00029887
+ tpb=0.00165968            tpbsw=0.00165968          tcjswg=0.00029887
+ tpbswg=0.00165968         capmod=3                  nqsmod=0
+ xpart=1                   cf=0                      tlev=1
+ tlevc=1                   dlc=1.50e-8               cgdl=cglp_lvt
+ cgsl=cglp_lvt             wwc=-0.038                dwc=0
+ noia=9.0e+18              noib=1.0e+3               noic=6.0e-12
+ em=4.1e+7                 ef=1.128                  noimod=2
+ sa0=0.35e-6               sb0=0.35e-6               kvsat=-0.6
+ wlod=0.3e-6               tku0=0.03                 ku0=1.14e-7
+ llodku0=1                 wlodku0=1                 lku0=3e-8
+ wku0=3.0e-7               pku0=0e-14                kvth0=-2.3e-9
+ stk2=0e-9                 steta0=0                  lkvth0=1.0e-8
+ wkvth0=2.5e-7             pkvth0=4e-14              llodvth=1
+ wlodvth=1                 lodk2=1                   lodeta0=1
+ minr=1e-3                 imax=0.01                 imelt=0.01

     6: type=p
+ lmin=1.3e-07              lmax=2.2e-07-dxl_lvt      wmin=1.225e-06-dxw_lvt
+ wmax=1.0005e-05-dxw_lvt   tnom=25.0                 version=3.24
+ tox=toxp_lvt              toxm=toxp_lvt             xj=2.1000000e-07
+ nch=5.6487000e+17         lln=1.0000000             lwn=1.0000000
+ wln=1.0000000             wwn=-1                    lint=6.5000000e-09
+ ll=0.00                   lw=0.00                   lwl=0.00
+ wint=1.5000000e-09        wl=0.00                   ww=0.00
+ wwl=0.00                  mobmod=1                  binunit=2
+ xl=-2e-8+dxl_lvt          xw=1.5e-8+dxw_lvt         dwg=0.00
+ dwb=0.00                  ldif=8.00e-08             hdif=hdifp_lvt
+ rsh=rshp_lvt              rd=0                      rs=0
+ vth0=-0.1386663+dvthp_lvt lvth0=-1.6824089e-08+dlvthp_lvt
+ wvth0=3.3234910e-09+dwvthp_lvt                      pvth0=-2.2049483e-15+dpvthp_lvt
+ k1=0.3753308              lk1=4.1389170e-09         wk1=5.2781860e-08
+ pk1=-5.1198400e-15        k2=-3.9236070e-02+dk2p_lvt
+ lk2=8.1076010e-10+dlk2p_lvt                         wk2=-5.2589180e-08
+ pk2=4.0281750e-15         k3=0.00                   dvt0=0.00
+ dvt1=0.00                 dvt2=0.00                 dvt0w=0.00
+ dvt1w=0.00                dvt2w=0.00                nlx=0.00
+ w0=0.00                   k3b=0.00                  vsat=8.2000000e+04
+ pvsat=0+dpvsatp_lvt       lvsat=0+dlvsatp_lvt       ua=1.9208057e-11
+ lua=3.1234811e-18         wua=3.0844287e-16         pua=-3.1287899e-23
+ ub=1.5869344e-18          lub=-8.2037550e-26        wub=4.8278590e-25
+ pub=1.4221777e-32         uc=-2.0705798e-11         luc=-1.5487336e-19
+ wuc=-1.9453185e-18        puc=1.5513661e-24         rdsw=4.9180000e+02+drdswp_lvt
+ prwb=0.00                 prwg=0.00                 wr=1.0000000
+ u0=1.2828992e-02          lu0=-5.6790550e-12        wu0=-1.2921042e-09
+ pu0=5.6887090e-17         a0=0.8113256              la0=6.8787490e-08
+ wa0=6.0888860e-07         pa0=-2.2470402e-13        keta=-1.0100800e-02
+ a1=0.00                   a2=0.9900000              ags=1.0000000
+ b0=0.00                   b1=0.00                   voff=-0.1265308
+ lvoff=-4.8287130e-10      wvoff=7.9549330e-09       pvoff=5.9731180e-16
+ nfactor=1.0000000         cit=-1.2123674e-03        lcit=3.2284730e-10
+ wcit=3.9464540e-10        pcit=-1.0018959e-16       cdsc=0.00
+ cdscb=0.00                cdscd=0.00                eta0=1.3066463e-03
+ leta0=9.4850520e-10       weta0=-6.1141890e-09      peta0=5.9307630e-16
+ etab=-1.2149572e-03       letab=-1.7314916e-10      wetab=2.9323242e-09
+ petab=-2.8443544e-16      dsub=0.00                 pclm=0.7316679
+ lpclm=2.6512150e-09+dlpclmp_lvt                     wpclm=2.7378573e-07+dwpclmp_lvt
+ ppclm=-2.6557219e-14      pdiblc1=0.00              pdiblc2=5.4769220e-04
+ wpdiblc2=6.4971050e-09    pdiblcb=0.00              drout=0.00
+ pscbe1=8.4920770e+08      pscbe2=1.0000000e-07      pvag=0.00
+ delta=2.0000000e-02       alpha0=0.00               alpha1=0.019
+ beta0=12.638              kt1=-0.2510000            kt2=-3.4000000e-02
+ pkt1=0+dpkt1p_lvt         at=1.0000000e+04          ute=-1.3901556
+ lute=-6.8982130e-09       wute=2.4932387e-08        pute=8.5330900e-15
+ ua1=5.9900000e-10         ub1=-1.8500000e-18        uc1=-1.4600000e-10
+ kt1l=0.00                 prt=0.00                  cj=cjp_lvt
+ pb=0.826557               mj=0.385643               cjsw=cjswp_lvt
+ pbsw=0.826557             mjsw=0.158                cjswg=cjswgp_lvt
+ pbswg=0.826557            mjswg=0.7162              js=2e-7
+ jsw=7.6e-12               n=1.0                     xti=3.0
+ cgdo=cgop_lvt             cgso=cgop_lvt             tcj=0.00090284
+ tcjsw=0.00029887          tpb=0.00165968            tpbsw=0.00165968
+ tcjswg=0.00029887         tpbswg=0.00165968         capmod=3
+ nqsmod=0                  xpart=1                   cf=0
+ tlev=1                    tlevc=1                   dlc=1.50e-8
+ cgdl=cglp_lvt             cgsl=cglp_lvt             wwc=-0.038
+ dwc=0                     noia=9.0e+18              noib=1.0e+3
+ noic=6.0e-12              em=4.1e+7                 ef=1.128
+ noimod=2                  sa0=0.35e-6               sb0=0.35e-6
+ kvsat=-0.6                wlod=0.3e-6               tku0=0.03
+ ku0=1.14e-7               llodku0=1                 wlodku0=1
+ lku0=3e-8                 wku0=3.0e-7               pku0=0e-14
+ kvth0=-2.3e-9             stk2=0e-9                 steta0=0
+ lkvth0=1.0e-8             wkvth0=2.5e-7             pkvth0=4e-14
+ llodvth=1                 wlodvth=1                 lodk2=1
+ lodeta0=1                 minr=1e-3                 imax=0.01
+ imelt=0.01

     7: type=p
+ lmin=0.77e-6-dxl_lvt      lmax=0.000021             wmin=6.05e-07-dxw_lvt
+ wmax=1.225e-06-dxw_lvt    tnom=25.0                 version=3.24
+ tox=toxp_lvt              toxm=toxp_lvt             xj=2.1000000e-07
+ nch=5.6487000e+17         lln=1.0000000             lwn=1.0000000
+ wln=1.0000000             wwn=-1                    lint=6.5000000e-09
+ ll=0.00                   lw=0.00                   lwl=0.00
+ wint=1.5000000e-09        wl=0.00                   ww=0.00
+ wwl=0.00                  mobmod=1                  binunit=2
+ xl=-2e-8+dxl_lvt          xw=1.5e-8+dxw_lvt         dwg=0.00
+ dwb=0.00                  ldif=8.00e-08             hdif=hdifp_lvt
+ rsh=rshp_lvt              rd=0                      rs=0
+ vth0=-6.8158640e-02+dvthp_lvt                       lvth0=-4.8350690e-08+dlvthp_lvt
+ wvth0=7.9819180e-10+dwvthp_lvt                      pvth0=-7.9715300e-15+dpvthp_lvt
+ k1=0.3892555              lk1=7.9186990e-09         wk1=1.3290951e-08
+ pk1=-9.7954310e-15        k2=-5.7000000e-02+dk2p_lvt
+ lk2=0+dlk2p_lvt           k3=0.00                   dvt0=0.00
+ dvt1=0.00                 dvt2=0.00                 dvt0w=0.00
+ dvt1w=0.00                dvt2w=0.00                nlx=0.00
+ w0=0.00                   k3b=0.00                  vsat=8.2000000e+04
+ pvsat=0+dpvsatp_lvt       lvsat=0+dlvsatp_lvt       ua=2.1280398e-11
+ lua=-1.3807166e-16        wua=1.0523253e-17         pua=2.0554064e-22
+ ub=1.6777778e-18          lub=2.2918049e-25         wub=2.2486591e-25
+ pub=-4.0161310e-31        uc=5.3920240e-11          luc=2.4685879e-17
+ wuc=5.9957430e-17         puc=-6.0065630e-23        rdsw=4.9180000e+02+drdswp_lvt
+ prwb=0.00                 prwg=0.00                 wr=1.0000000
+ u0=1.0799274e-02          lu0=8.2305080e-10         wu0=-8.3000470e-10
+ pu0=-1.3223761e-16        a0=2.3622890              la0=-6.3657650e-07
+ wa0=-3.6930440e-07        keta=-1.0100800e-02       a1=0.00
+ a2=0.9900000              ags=0.6999422             lags=5.7756780e-10
+ wags=-1.4712293e-08       pags=1.4693159e-13        b0=0.00
+ b1=0.00                   voff=-0.1011522           lvoff=-6.3553280e-09
+ wvoff=4.8942100e-09       pvoff=-8.8526080e-16      nfactor=0.9521946
+ lnfactor=4.7743260e-07    cit=3.5219460e-04         lcit=4.7743250e-10
+ cdsc=0.00                 cdscb=0.00                cdscd=0.00
+ eta0=7.7513080e-04        leta0=1.2712286e-09       weta0=6.6454840e-10
+ peta0=-4.8977210e-16      etab=-1.1362596e-03       letab=-6.3657670e-10
+ dsub=0.00                 pclm=1.6711960            lpclm=1.3786158e-07+dlpclmp_lvt
+ wpclm=-6.5960130e-08+dwpclmp_lvt                    ppclm=6.5874360e-13
+ pdiblc1=0.00              pdiblc2=5.4691890e-02     lpdiblc2=-4.6058900e-08
+ wpdiblc2=-1.9616404e-09   ppdiblc2=1.9590881e-14    pdiblcb=0.00
+ drout=0.00                pscbe1=8.4920770e+08      pscbe2=1.0000000e-07
+ pvag=0.00                 delta=8.3171610e-03       ldelta=-3.1674830e-09
+ wdelta=-3.9232770e-10     pdelta=3.9181760e-15      alpha0=0.00
+ alpha1=0.019              beta0=12.638              kt1=-0.3054106
+ lkt1=5.4035910e-08        wkt1=1.8635573e-09        pkt1=-1.8611360e-14+dpkt1p_lvt
+ kt2=-3.1229066e-02        lkt2=6.7946870e-09        wkt2=1.4284588e-08
+ pkt2=-1.2342255e-14       at=1.0000000e+04          ute=-1.8243608
+ lute=2.4667364e-07        wute=8.6171080e-08        ua1=5.9900000e-10
+ ub1=-2.9836595e-18        lub1=8.3550700e-25        uc1=-1.4600000e-10
+ kt1l=0.00                 prt=0.00                  cj=cjp_lvt
+ pb=0.826557               mj=0.385643               cjsw=cjswp_lvt
+ pbsw=0.826557             mjsw=0.158                cjswg=cjswgp_lvt
+ pbswg=0.826557            mjswg=0.7162              js=2e-7
+ jsw=7.6e-12               n=1.0                     xti=3.0
+ cgdo=cgop_lvt             cgso=cgop_lvt             tcj=0.00090284
+ tcjsw=0.00029887          tpb=0.00165968            tpbsw=0.00165968
+ tcjswg=0.00029887         tpbswg=0.00165968         capmod=3
+ nqsmod=0                  xpart=1                   cf=0
+ tlev=1                    tlevc=1                   dlc=1.50e-8
+ cgdl=cglp_lvt             cgsl=cglp_lvt             wwc=-0.038
+ dwc=0                     noia=9.0e+18              noib=1.0e+3
+ noic=6.0e-12              em=4.1e+7                 ef=1.128
+ noimod=2                  sa0=0.35e-6               sb0=0.35e-6
+ kvsat=-0.6                wlod=0.3e-6               tku0=0.03
+ ku0=1.14e-7               llodku0=1                 wlodku0=1
+ lku0=3e-8                 wku0=3.0e-7               pku0=0e-14
+ kvth0=-2.3e-9             stk2=0e-9                 steta0=0
+ lkvth0=1.0e-8             wkvth0=2.5e-7             pkvth0=4e-14
+ llodvth=1                 wlodvth=1                 lodk2=1
+ lodeta0=1                 minr=1e-3                 imax=0.01
+ imelt=0.01

     8: type=p
+ lmin=2.2e-07-dxl_lvt      lmax=0.77e-6-dxl_lvt      wmin=6.05e-07-dxw_lvt
+ wmax=1.225e-06-dxw_lvt    tnom=25.0                 version=3.24
+ tox=toxp_lvt              toxm=toxp_lvt             xj=2.1000000e-07
+ nch=5.6487000e+17         lln=1.0000000             lwn=1.0000000
+ wln=1.0000000             wwn=-1                    lint=6.5000000e-09
+ ll=0.00                   lw=0.00                   lwl=0.00
+ wint=1.5000000e-09        wl=0.00                   ww=0.00
+ wwl=0.00                  mobmod=1                  binunit=2
+ xl=-2e-8+dxl_lvt          xw=1.5e-8+dxw_lvt         dwg=0.00
+ dwb=0.00                  ldif=8.00e-08             hdif=hdifp_lvt
+ rsh=rshp_lvt              rd=0                      rs=0
+ vth0=-0.0981809+dvthp_lvt lvth0=-2.6224281e-08+dlvthp_lvt
+ wvth0=-1.4659657e-08+dwvthp_lvt                     pvth0=3.4209050e-15+dpvthp_lvt
+ k1=0.4113195              lk1=-8.3424570e-09        wk1=-2.1572642e-08
+ pk1=1.5899034e-14         k2=-6.2747100e-02+dk2p_lvt
+ lk2=4.2356110e-09+dlk2p_lvt                         wk2=8.3708980e-09
+ pk2=-6.1693520e-15        k3=0.00                   dvt0=0.00
+ dvt1=0.00                 dvt2=0.00                 dvt0w=0.00
+ dvt1w=0.00                dvt2w=0.00                nlx=0.00
+ w0=0.00                   k3b=0.00                  vsat=8.1323290e+04
+ lvsat=4.9873500e-04+dlvsatp_lvt                     wvsat=8.3709000e-04
+ pvsat=-6.1693520e-10+dpvsatp_lvt                    ua=-2.9010300e-10
+ lua=9.1417920e-17         wua=4.0832010e-16         pua=-8.7635650e-23
+ ub=2.0950704e-18          lub=-7.8364250e-26        wub=-3.9691690e-25
+ pub=5.6640810e-32         uc=1.2149447e-10          luc=-2.5116322e-17
+ wuc=-2.7360534e-17        puc=4.2877000e-24         rdsw=4.9180000e+02+drdswp_lvt
+ prwb=0.00                 prwg=0.00                 wr=1.0000000
+ u0=1.1312280e-02          lu0=4.4496550e-10         wu0=-6.4111180e-10
+ pu0=-2.7145159e-16        a0=1.6685487              la0=-1.2529006e-07
+ wa0=-3.6930460e-07        keta=-1.0100800e-02       a1=0.00
+ a2=0.9900000              ags=0.5989726             lags=7.4992120e-08
+ wags=2.4743389e-07        pags=-4.6270140e-14       b0=0.00
+ b1=0.00                   voff=-0.1079569           lvoff=-1.3402794e-09
+ wvoff=7.0414030e-09       pvoff=-2.4677416e-15      nfactor=1.8040000
+ lnfactor=-1.5034800e-07   cit=1.2040001e-03         lcit=-1.5034801e-10
+ cdsc=0.00                 cdscb=0.00                cdscd=0.00
+ eta0=1.9900000e-03        leta0=3.7587010e-10       etab=-2.6783552e-03
+ letab=4.9994750e-10       wetab=4.1854530e-10       petab=-3.0846764e-16
+ dsub=0.00                 pclm=2.2568552            lpclm=-2.9376929e-07+dlpclmp_lvt
+ wpclm=1.0393143e-06+dwpclmp_lvt                     ppclm=-1.5584372e-13
+ pdiblc1=0.00              pdiblc2=-1.2428327e-02    lpdiblc2=3.4086960e-09
+ wpdiblc2=3.2991190e-08    ppdiblc2=-6.1693530e-15   pdiblcb=0.00
+ drout=0.00                pscbe1=8.4920770e+08      pscbe2=1.0000000e-07
+ pvag=0.00                 delta=-1.4140644e-03      ldelta=4.0044300e-09
+ wdelta=6.5982380e-09      pdelta=-1.2338704e-15     alpha0=0.00
+ alpha1=0.019              beta0=12.638              kt1=-0.2253248
+ lkt1=-4.9873530e-09       wkt1=-3.1760210e-08       pkt1=6.1693560e-15+dpkt1p_lvt
+ kt2=-1.8271321e-02        lkt2=-2.7551683e-09       wkt2=-2.8805751e-09
+ pkt2=3.0846825e-16        at=1.0000000e+04          ute=-1.4897434
+ lute=6.0595560e-11        wute=6.5243650e-08        pute=1.5423403e-14
+ ua1=5.9900000e-10         ub1=-1.8500000e-18        uc1=-1.4600000e-10
+ kt1l=0.00                 prt=0.00                  cj=cjp_lvt
+ pb=0.826557               mj=0.385643               cjsw=cjswp_lvt
+ pbsw=0.826557             mjsw=0.158                cjswg=cjswgp_lvt
+ pbswg=0.826557            mjswg=0.7162              js=2e-7
+ jsw=7.6e-12               n=1.0                     xti=3.0
+ cgdo=cgop_lvt             cgso=cgop_lvt             tcj=0.00090284
+ tcjsw=0.00029887          tpb=0.00165968            tpbsw=0.00165968
+ tcjswg=0.00029887         tpbswg=0.00165968         capmod=3
+ nqsmod=0                  xpart=1                   cf=0
+ tlev=1                    tlevc=1                   dlc=1.50e-8
+ cgdl=cglp_lvt             cgsl=cglp_lvt             wwc=-0.038
+ dwc=0                     noia=9.0e+18              noib=1.0e+3
+ noic=6.0e-12              em=4.1e+7                 ef=1.128
+ noimod=2                  sa0=0.35e-6               sb0=0.35e-6
+ kvsat=-0.6                wlod=0.3e-6               tku0=0.03
+ ku0=1.14e-7               llodku0=1                 wlodku0=1
+ lku0=3e-8                 wku0=3.0e-7               pku0=0e-14
+ kvth0=-2.3e-9             stk2=0e-9                 steta0=0
+ lkvth0=1.0e-8             wkvth0=2.5e-7             pkvth0=4e-14
+ llodvth=1                 wlodvth=1                 lodk2=1
+ lodeta0=1                 minr=1e-3                 imax=0.01
+ imelt=0.01

     9: type=p
+ lmin=1.3e-07              lmax=2.2e-07-dxl_lvt      wmin=6.05e-07-dxw_lvt
+ wmax=1.225e-06-dxw_lvt    tnom=25.0                 version=3.24
+ tox=toxp_lvt              toxm=toxp_lvt             xj=2.1000000e-07
+ nch=5.6487000e+17         lln=1.0000000             lwn=1.0000000
+ wln=1.0000000             wwn=-1                    lint=6.5000000e-09
+ ll=0.00                   lw=0.00                   lwl=0.00
+ wint=1.5000000e-09        wl=0.00                   ww=0.00
+ wwl=0.00                  mobmod=1                  binunit=2
+ xl=-2e-8+dxl_lvt          xw=1.5e-8+dxw_lvt         dwg=0.00
+ dwb=0.00                  ldif=8.00e-08             hdif=hdifp_lvt
+ rsh=rshp_lvt              rd=0                      rs=0
+ vth0=-0.1267759+dvthp_lvt lvth0=-2.0877030e-08+dlvthp_lvt
+ wvth0=-1.1384977e-08+dwvthp_lvt                     pvth0=2.8085406e-15+dpvthp_lvt
+ k1=0.3667074              wk1=6.3448920e-08         k2=-8.3110210e-02+dk2p_lvt
+ lk2=8.0435130e-09+dlk2p_lvt                         wk2=1.6831395e-09
+ pk2=-4.9187420e-15        k3=0.00                   dvt0=0.00
+ dvt1=0.00                 dvt2=0.00                 dvt0w=0.00
+ dvt1w=0.00                dvt2w=0.00                nlx=0.00
+ w0=0.00                   k3b=0.00                  vsat=8.5062880e+04
+ lvsat=-2.0056911e-04+dlvsatp_lvt                    wvsat=-3.7887880e-03
+ pvsat=2.4810404e-10+dpvsatp_lvt                     ua=3.8596240e-10
+ lua=-3.5006310e-17        wua=-1.4523230e-16        pua=1.5878659e-23
+ ub=2.1957547e-18          lub=-9.7192180e-26        wub=-2.7032473e-25
+ pub=3.2968080e-32         uc=-5.8224240e-11         luc=8.4910780e-18
+ wuc=4.4465000e-17         puc=-9.1436760e-24        rdsw=4.9180000e+02+drdswp_lvt
+ prwb=0.00                 prwg=0.00                 wr=1.0000000
+ u0=1.3905243e-02          lu0=-3.9918730e-11        wu0=-2.6234281e-09
+ pu0=9.9241610e-17         a0=2.0096772              la0=-1.8908115e-07
+ wa0=-8.7347290e-07        pa0=9.4279540e-14         keta=-1.0100800e-02
+ a1=0.00                   a2=0.9900000              ags=1.0000000
+ b0=0.00                   b1=0.00                   voff=-0.1151242
+ wvoff=-6.1550750e-09      nfactor=1.0000000         cit=-4.0827760e-04
+ lcit=1.5114789e-10        wcit=-6.0001390e-10       pcit=1.1220262e-16
+ cdsc=0.00                 cdscb=0.00                cdscd=0.00
+ eta0=-4.7998920e-03       leta0=1.6455801e-09       weta0=1.4396002e-09
+ peta0=-2.6920541e-16      etab=3.2232780e-03        letab=-6.0365800e-10
+ wetab=-2.5577738e-09      petab=2.4810405e-16       dsub=0.00
+ pclm=0.7143636            lpclm=-5.3233330e-09+dlpclmp_lvt
+ wpclm=2.9519123e-07+dwpclmp_lvt                     ppclm=-1.6692705e-14
+ pdiblc1=0.00              pdiblc2=5.8000000e-03     pdiblcb=0.00
+ drout=0.00                pscbe1=8.4920770e+08      pscbe2=1.0000000e-07
+ pvag=0.00                 delta=2.0000000e-02       alpha0=0.00
+ alpha1=0.019              beta0=12.638              kt1=-0.2090927
+ lkt1=-8.0227670e-09       wkt1=-5.1839390e-08       pkt1=9.9241650e-15+dpkt1p_lvt
+ kt2=-5.8746330e-02        lkt2=4.8136590e-09        wkt2=3.0611215e-08
+ pkt2=-5.9544980e-15       at=1.0000000e+04          ute=-1.2212789
+ lute=-5.0142300e-08       wute=-1.8396814e-07       pute=6.2026030e-14
+ ua1=5.9900000e-10         ub1=-1.8500000e-18        uc1=-1.4600000e-10
+ kt1l=0.00                 prt=0.00                  cj=cjp_lvt
+ pb=0.826557               mj=0.385643               cjsw=cjswp_lvt
+ pbsw=0.826557             mjsw=0.158                cjswg=cjswgp_lvt
+ pbswg=0.826557            mjswg=0.7162              js=2e-7
+ jsw=7.6e-12               n=1.0                     xti=3.0
+ cgdo=cgop_lvt             cgso=cgop_lvt             tcj=0.00090284
+ tcjsw=0.00029887          tpb=0.00165968            tpbsw=0.00165968
+ tcjswg=0.00029887         tpbswg=0.00165968         capmod=3
+ nqsmod=0                  xpart=1                   cf=0
+ tlev=1                    tlevc=1                   dlc=1.50e-8
+ cgdl=cglp_lvt             cgsl=cglp_lvt             wwc=-0.038
+ dwc=0                     noia=9.0e+18              noib=1.0e+3
+ noic=6.0e-12              em=4.1e+7                 ef=1.128
+ noimod=2                  sa0=0.35e-6               sb0=0.35e-6
+ kvsat=-0.6                wlod=0.3e-6               tku0=0.03
+ ku0=1.14e-7               llodku0=1                 wlodku0=1
+ lku0=3e-8                 wku0=3.0e-7               pku0=0e-14
+ kvth0=-2.3e-9             stk2=0e-9                 steta0=0
+ lkvth0=1.0e-8             wkvth0=2.5e-7             pkvth0=4e-14
+ llodvth=1                 wlodvth=1                 lodk2=1
+ lodeta0=1                 minr=1e-3                 imax=0.01
+ imelt=0.01

     10: type=p
+ lmin=0.77e-6-dxl_lvt      lmax=0.000021             wmin=1.5e-07
+ wmax=6.05e-07-dxw_lvt     tnom=25.0                 version=3.24
+ tox=toxp_lvt              toxm=toxp_lvt             xj=2.1000000e-07
+ nch=5.6487000e+17         lln=1.0000000             lwn=1.0000000
+ wln=1.0000000             wwn=-1                    lint=6.5000000e-09
+ ll=0.00                   lw=0.00                   lwl=0.00
+ wint=1.5000000e-09        wl=0.00                   ww=0.00
+ wwl=0.00                  mobmod=1                  binunit=2
+ xl=-2e-8+dxl_lvt          xw=1.5e-8+dxw_lvt         dwg=0.00
+ dwb=0.00                  ldif=8.00e-08             hdif=hdifp_lvt
+ rsh=rshp_lvt              rd=0                      rs=0
+ vth0=-7.9411450e-02+dvthp_lvt                       lvth0=-5.6866440e-08+dlvthp_lvt
+ wvth0=7.7411750e-09+dwvthp_lvt                      pvth0=-2.7173177e-15+dpvthp_lvt
+ k1=0.4449006              lk1=-8.7153630e-09        wk1=-2.1042098e-08
+ pk1=4.6778610e-16         k2=-5.9705750e-02+dk2p_lvt
+ lk2=-1.4242210e-09+dlk2p_lvt                        wk2=1.6694445e-09
+ pk2=8.7874410e-16         k3=0.00                   dvt0=0.00
+ dvt1=0.00                 dvt2=0.00                 dvt0w=0.00
+ dvt1w=0.00                dvt2w=0.00                nlx=0.00
+ w0=0.00                   k3b=0.00                  vsat=8.2000000e+04
+ pvsat=0+dpvsatp_lvt       lvsat=0+dlvsatp_lvt       ua=2.1886071e-11
+ lua=2.5646225e-16         wua=1.0149576e-17         pua=-3.7886790e-23
+ ub=2.4859689e-18          lub=-5.8639720e-25        wub=-2.7378806e-25
+ pub=1.0159834e-31         uc=2.0107518e-10          luc=-9.5968920e-17
+ wuc=-3.0837171e-17        puc=1.4378374e-23         rdsw=4.9180000e+02+drdswp_lvt
+ prwb=0.00                 prwg=0.00                 wr=1.0000000
+ u0=9.1844170e-03          lu0=8.3023390e-10         wu0=1.6636185e-10
+ pu0=-1.3666956e-16        a0=1.3470465              la0=-3.8644590e-07
+ wa0=2.5710020e-07         pa0=-1.5433074e-13        keta=-1.0100800e-02
+ a1=0.00                   a2=0.9900000              ags=0.6845393
+ lags=3.3219650e-07        wags=-5.2087190e-09       pags=-5.7677330e-14
+ b0=0.00                   b1=0.00                   voff=-9.6655350e-02
+ lvoff=-5.4832790e-09      wvoff=2.1196280e-09       pvoff=-1.4233151e-15
+ nfactor=0.9521946         lnfactor=4.7743260e-07    cit=4.6751830e-04
+ lcit=3.9243910e-10        wcit=-7.1154670e-11       pcit=5.2440990e-17
+ cdsc=0.00                 cdscb=0.00                cdscd=0.00
+ eta0=2.1581308e-03        leta0=6.2227940e-10       weta0=-1.8876251e-10
+ peta0=-8.9370550e-17      etab=-1.1823460e-03       letab=-8.8747400e-10
+ wetab=2.8435313e-11       petab=1.5480360e-16       dsub=0.00
+ pclm=1.5176355            lpclm=1.6714699e-06+dlpclmp_lvt
+ wpclm=2.8786721e-08+dwpclmp_lvt                     ppclm=-2.8749285e-13
+ pdiblc1=0.00              pdiblc2=5.2066280e-02     lpdiblc2=-1.9836985e-08
+ wpdiblc2=-3.4164060e-10   ppdiblc2=3.4119620e-15    pdiblcb=0.00
+ drout=0.00                pscbe1=8.4920770e+08      pscbe2=1.0000000e-07
+ pvag=0.00                 delta=7.5581140e-03       ldelta=4.4131220e-09
+ wdelta=7.6004440e-11      pdelta=-7.5905690e-16     alpha0=0.00
+ alpha1=0.019              beta0=12.638              kt1=-0.3026983
+ lkt1=2.6947223e-08        wkt1=1.9001126e-10        pkt1=-1.8976407e-15+dpkt1p_lvt
+ kt2=-7.5661730e-03        lkt2=-1.8314459e-08       wkt2=-3.1541847e-10
+ pkt2=3.1500869e-15        at=1.0000000e+04          ute=-1.6395046
+ lute=2.9312648e-07        wute=-2.7885187e-08       pute=-2.8661525e-14
+ ua1=5.9900000e-10         ub1=-3.0159952e-18        lub1=1.1584446e-24
+ wub1=1.9951186e-26        pub1=-1.9925248e-31       uc1=-1.4600000e-10
+ kt1l=0.00                 prt=0.00                  cj=cjp_lvt
+ pb=0.826557               mj=0.385643               cjsw=cjswp_lvt
+ pbsw=0.826557             mjsw=0.158                cjswg=cjswgp_lvt
+ pbswg=0.826557            mjswg=0.7162              js=2e-7
+ jsw=7.6e-12               n=1.0                     xti=3.0
+ cgdo=cgop_lvt             cgso=cgop_lvt             tcj=0.00090284
+ tcjsw=0.00029887          tpb=0.00165968            tpbsw=0.00165968
+ tcjswg=0.00029887         tpbswg=0.00165968         capmod=3
+ nqsmod=0                  xpart=1                   cf=0
+ tlev=1                    tlevc=1                   dlc=1.50e-8
+ cgdl=cglp_lvt             cgsl=cglp_lvt             wwc=-0.038
+ dwc=0                     noia=9.0e+18              noib=1.0e+3
+ noic=6.0e-12              em=4.1e+7                 ef=1.128
+ noimod=2                  sa0=0.35e-6               sb0=0.35e-6
+ kvsat=-0.6                wlod=0.3e-6               tku0=0.03
+ ku0=1.14e-7               llodku0=1                 wlodku0=1
+ lku0=3e-8                 wku0=3.0e-7               pku0=0e-14
+ kvth0=-2.3e-9             stk2=0e-9                 steta0=0
+ lkvth0=1.0e-8             wkvth0=2.5e-7             pkvth0=4e-14
+ llodvth=1                 wlodvth=1                 lodk2=1
+ lodeta0=1                 minr=1e-3                 imax=0.01
+ imelt=0.01

     11: type=p
+ lmin=2.2e-07-dxl_lvt      lmax=0.77e-6-dxl_lvt      wmin=1.5e-07
+ wmax=6.05e-07-dxw_lvt     tnom=25.0                 version=3.24
+ tox=toxp_lvt              toxm=toxp_lvt             xj=2.1000000e-07
+ nch=5.6487000e+17         lln=1.0000000             lwn=1.0000000
+ wln=1.0000000             wwn=-1                    lint=6.5000000e-09
+ ll=0.00                   lw=0.00                   lwl=0.00
+ wint=1.5000000e-09        wl=0.00                   ww=0.00
+ wwl=0.00                  mobmod=1                  binunit=2
+ xl=-2e-8+dxl_lvt          xw=1.5e-8+dxw_lvt         dwg=0.00
+ dwb=0.00                  ldif=8.00e-08             hdif=hdifp_lvt
+ rsh=rshp_lvt              rd=0                      rs=0
+ vth0=-0.1239738+dvthp_lvt lvth0=-2.4024020e-08+dlvthp_lvt
+ wvth0=1.2545246e-09+dwvthp_lvt                      pvth0=2.0633430e-15+dpvthp_lvt
+ k1=0.4002920              lk1=2.4161210e-08         wk1=-1.4768675e-08
+ pk1=-4.1557270e-15        k2=-5.0795640e-02+dk2p_lvt
+ lk2=-7.9909680e-09+dlk2p_lvt                        wk2=9.9685030e-10
+ pk2=1.3744462e-15         k3=0.00                   dvt0=0.00
+ dvt1=0.00                 dvt2=0.00                 dvt0w=0.00
+ dvt1w=0.00                dvt2w=0.00                nlx=0.00
+ w0=0.00                   k3b=0.00                  vsat=8.2680000e+04
+ pvsat=0+dpvsatp_lvt       lvsat=-5.0116000e-04+dlvsatp_lvt
+ ua=4.8388580e-10          lua=-8.4031580e-17        wua=-6.9230990e-17
+ pua=2.0616695e-23         ub=1.5762176e-18          lub=8.4089640e-26
+ wub=-7.6784530e-26        pub=-4.3593250e-32        uc=9.2224160e-11
+ luc=-1.5745715e-17        wuc=-9.3007550e-18        puc=-1.4939636e-24
+ rdsw=4.9180000e+02+drdswp_lvt                       prwb=0.00
+ prwg=0.00                 wr=1.0000000              u0=1.0104370e-02
+ lu0=1.5222865e-10         wu0=1.0416835e-10         pu0=-9.0832970e-17
+ a0=0.9795550              la0=-1.1560466e-07        wa0=5.5804530e-08
+ pa0=-5.9758570e-15        keta=-1.0100800e-02       a1=0.00
+ a2=0.9900000              ags=1.1352810             wags=-8.3468310e-08
+ b0=0.00                   b1=0.00                   voff=-9.3129580e-02
+ lvoff=-8.0817790e-09      wvoff=-2.1070736e-09      pvoff=1.6917642e-15
+ nfactor=1.8040001         cit=1.1645755e-03         lcit=-1.2129202e-10
+ wcit=2.4325035e-11        pcit=-1.7927560e-17       cdsc=0.00
+ lnfactor=-1.5034803e-07   cdscb=0.00                cdscd=0.00
+ eta0=2.4661885e-03        leta0=3.9524080e-10       weta0=-2.9380839e-10
+ peta0=-1.1951729e-17      etab=-2.3076676e-03       letab=-5.8112020e-11
+ wetab=1.8983082e-10       petab=3.5855120e-17       dsub=0.00
+ pclm=4.7234050            lpclm=-6.9118220e-07+dlpclmp_lvt
+ wpclm=-4.8254690e-07+dwpclmp_lvt                    ppclm=8.9359980e-14
+ pdiblc1=0.00              pdiblc2=3.4252760e-02     lpdiblc2=-6.7084160e-09
+ wpdiblc2=4.1889650e-09    ppdiblc2=7.2905360e-17    pdiblcb=0.00
+ drout=0.00                pscbe1=8.4920770e+08      pscbe2=1.0000000e-07
+ pvag=0.00                 delta=9.7747420e-03       ldelta=2.7794669e-09
+ wdelta=-3.0525565e-10     pdelta=-4.7806830e-16     alpha0=0.00
+ alpha1=0.019              beta0=12.638              kt1=-0.2703065
+ lkt1=3.0745364e-09        wkt1=-4.0064760e-09       pkt1=1.1951705e-15+dpkt1p_lvt
+ kt2=-2.8173441e-02        lkt2=-3.1269001e-09       wkt2=3.2290320e-09
+ pkt2=5.3782680e-16        at=1.0000000e+04          ute=-1.2494922
+ lute=5.6873370e-09        wute=-8.2991330e-08       pute=1.1951703e-14
+ ua1=5.9900000e-10         ub1=-1.4441572e-18        wub1=-2.5040496e-25
+ uc1=-1.4600000e-10        kt1l=0.00                 prt=0.00
+ cj=cjp_lvt                pb=0.826557               mj=0.385643
+ cjsw=cjswp_lvt            pbsw=0.826557             mjsw=0.158
+ cjswg=cjswgp_lvt          pbswg=0.826557            mjswg=0.7162
+ js=2e-7                   jsw=7.6e-12               n=1.0
+ xti=3.0                   cgdo=cgop_lvt             cgso=cgop_lvt
+ tcj=0.00090284            tcjsw=0.00029887          tpb=0.00165968
+ tpbsw=0.00165968          tcjswg=0.00029887         tpbswg=0.00165968
+ capmod=3                  nqsmod=0                  xpart=1
+ cf=0                      tlev=1                    tlevc=1
+ dlc=1.50e-8               cgdl=cglp_lvt             cgsl=cglp_lvt
+ wwc=-0.038                dwc=0                     noia=9.0e+18
+ noib=1.0e+3               noic=6.0e-12              em=4.1e+7
+ ef=1.128                  noimod=2                  sa0=0.35e-6
+ sb0=0.35e-6               kvsat=-0.6                wlod=0.3e-6
+ tku0=0.03                 ku0=1.14e-7               llodku0=1
+ wlodku0=1                 lku0=3e-8                 wku0=3.0e-7
+ pku0=0e-14                kvth0=-2.3e-9             stk2=0e-9
+ steta0=0                  lkvth0=1.0e-8             wkvth0=2.5e-7
+ pkvth0=4e-14              llodvth=1                 wlodvth=1
+ lodk2=1                   lodeta0=1                 minr=1e-3
+ imax=0.01                 imelt=0.01

     12: type=p
+ lmin=1.3e-07              lmax=2.2e-07-dxl_lvt      wmin=1.5e-07
+ wmax=6.05e-07-dxw_lvt     tnom=25.0                 version=3.24
+ tox=toxp_lvt              toxm=toxp_lvt             xj=2.1000000e-07
+ nch=5.6487000e+17         lln=1.0000000             lwn=1.0000000
+ wln=1.0000000             wwn=-1                    lint=6.5000000e-09
+ ll=0.00                   lw=0.00                   lwl=0.00
+ wint=1.5000000e-09        wl=0.00                   ww=0.00
+ wwl=0.00                  mobmod=1                  binunit=2
+ xl=-2e-8+dxl_lvt          xw=1.5e-8+dxw_lvt         dwg=0.00
+ dwb=0.00                  ldif=8.00e-08             hdif=hdifp_lvt
+ rsh=rshp_lvt              rd=0                      rs=0
+ vth0=-0.1712064+dvthp_lvt lvth0=-1.5191514e-08+dlvthp_lvt
+ wvth0=1.6028670e-08+dwvthp_lvt                      pvth0=-6.9942230e-16+dpvthp_lvt
+ k1=0.5268623              lk1=4.9256800e-10         wk1=-3.5366610e-08
+ pk1=-3.0391452e-16        k2=-8.9134190e-02+dk2p_lvt
+ lk2=-8.2165990e-10+dlk2p_lvt                        wk2=5.3999290e-09
+ pk2=5.5107050e-16         k3=0.00                   dvt0=0.00
+ dvt1=0.00                 dvt2=0.00                 dvt0w=0.00
+ dvt1w=0.00                dvt2w=0.00                nlx=0.00
+ w0=0.00                   k3b=0.00                  vsat=7.8922220e+04
+ pvsat=0+dpvsatp_lvt       lvsat=2.0154443e-04+dlvsatp_lvt
+ ua=8.1096620e-12          lua=4.9385660e-18         wua=8.7902840e-17
+ pua=-8.7673310e-24        ub=2.2785850e-18          lub=-4.7253070e-26
+ wub=-3.2143110e-25        pub=2.1556502e-33         uc=2.7583371e-11
+ luc=-3.6578880e-18        wuc=-8.4782890e-18        puc=-1.6477646e-24
+ rdsw=4.9180000e+02+drdswp_lvt                       prwb=0.00
+ prwg=0.00                 wr=1.0000000              u0=1.0052684e-02
+ lu0=1.6189390e-10         wu0=-2.4639940e-10        pu0=-2.5276788e-17
+ a0=0.4616632              la0=-1.8758881e-08        wa0=8.1651860e-08
+ pa0=-1.0809303e-14        keta=-1.0100800e-02       a1=0.00
+ a2=0.9900000              ags=1.2160496             lags=-1.5103737e-08
+ wags=-1.3330258e-07       pags=9.3190070e-15        b0=0.00
+ b1=0.00                   voff=-0.1397555           lvoff=6.3727450e-10
+ wvoff=9.0424600e-09       pvoff=-3.9319850e-16      nfactor=1.0000000
+ cit=-1.3792482e-03        lcit=3.5440300e-10        wcit=-9.2503000e-13
+ pcit=-1.3205793e-17       cdsc=0.00                 cdscb=0.00
+ cdscd=0.00                eta0=-1.4571233e-03       leta0=1.1289002e-09
+ weta0=-6.2288740e-10      peta0=4.9586040e-17       etab=-1.0799189e-03
+ letab=-2.8770106e-10      wetab=9.7298590e-11       petab=5.3158650e-17
+ dsub=0.00                 pclm=1.1222085            lpclm=-1.7758342e-08+dlpclmp_lvt
+ wpclm=4.3550970e-08+dwpclmp_lvt                     ppclm=-9.0203080e-15
+ pdiblc1=0.00              pdiblc2=-6.7145890e-03    lpdiblc2=9.5247780e-10
+ wpdiblc2=7.7215020e-09    ppdiblc2=-5.8767890e-16   pdiblcb=0.00
+ drout=0.00                pscbe1=8.4920770e+08      pscbe2=1.0000000e-07
+ pvag=0.00                 delta=2.4434425e-02       ldelta=3.8106170e-11
+ wdelta=-2.7360403e-09     pdelta=-2.3511514e-17     alpha0=0.00
+ alpha1=0.019              beta0=12.638              kt1=-0.3106804
+ lkt1=1.0624451e-08        wkt1=1.0840258e-08        pkt1=-1.5811686e-15+dpkt1p_lvt
+ kt2=-8.1879950e-03        lkt2=-6.8641790e-09       wkt2=-5.8327800e-10
+ pkt2=1.2507287e-15        at=1.0000000e+04          ute=-1.6242852
+ lute=7.5773640e-08        wute=6.4686840e-08        pute=-1.5664114e-14
+ ua1=5.9900000e-10         ub1=-1.4619876e-18        lub1=3.3342900e-27
+ wub1=-2.3940361e-25       pub1=-2.0572578e-33       uc1=-1.4600000e-10
+ kt1l=0.00                 prt=0.00                  cj=cjp_lvt
+ pb=0.826557               mj=0.385643               cjsw=cjswp_lvt
+ pbsw=0.826557             mjsw=0.158                cjswg=cjswgp_lvt
+ pbswg=0.826557            mjswg=0.7162              js=2e-7
+ jsw=7.6e-12               n=1.0                     xti=3.0
+ cgdo=cgop_lvt             cgso=cgop_lvt             tcj=0.00090284
+ tcjsw=0.00029887          tpb=0.00165968            tpbsw=0.00165968
+ tcjswg=0.00029887         tpbswg=0.00165968         capmod=3
+ nqsmod=0                  xpart=1                   cf=0
+ tlev=1                    tlevc=1                   dlc=1.50e-8
+ cgdl=cglp_lvt             cgsl=cglp_lvt             wwc=-0.038
+ dwc=0                     noia=9.0e+18              noib=1.0e+3
+ noic=6.0e-12              em=4.1e+7                 ef=1.128
+ noimod=2                  sa0=0.35e-6               sb0=0.35e-6
+ kvsat=-0.6                wlod=0.3e-6               tku0=0.03
+ ku0=1.14e-7               llodku0=1                 wlodku0=1
+ lku0=3e-8                 wku0=3.0e-7               pku0=0e-14
+ kvth0=-2.3e-9             stk2=0e-9                 steta0=0
+ lkvth0=1.0e-8             wkvth0=2.5e-7             pkvth0=4e-14
+ llodvth=1                 wlodvth=1                 lodk2=1
+ lodeta0=1                 minr=1e-3                 imax=0.01
+ imelt=0.01
//

     }

//   // *********************************
//        Mismatch   model         *
// *********************************

inline subckt nch_lvt_mis ( d g s b )
parameters l=1u w=1u multi=1 factor=1 sa=0.35e-6 sb=0.35e-6 ad=2 * hdifn_lvt
+ / factor * w as=2 * hdifn_lvt / factor * w pd=2 * (2 * hdifn_lvt / factor + w)
+ ps=2 * (2 * hdifn_lvt / factor + w) nrd=hdifn_lvt / factor / w nrs=hdifn_lvt /
+ factor / w temp1=parn1_lvt temp2=parn2_lvt fac1=0.591 * temp1 + 0.806 * temp2
+ fac2=0.591 * temp1 - 0.806 * temp2 lef=l - 2.0e-8 wef=w + 1.5e-8 geo_fac=1 / sqrt(multi
+ * lef * wef * 1e12) vthmisn_lvt=0.002344 * geo_fac * fac1 dlmisn_lvt=0.002069
+ * geo_fac * lef * fac2 dwmisn_lvt= - 0.002069 * geo_fac * wef * fac2 toxmisn_lvt=0.002069
+ * geo_fac * toxn_lvt * fac2
nch_lvt_mis ( d g s b ) nch_lvt w=w l=l ad=ad as=as pd=pd ps=ps nrd=nrd nrs=nrs m=multi sa=sa
+ sb=sb
model nch_lvt bsim3v3  {
     1: type=n
+ lmin=4.7e-07-(dxl_lvt+dlmisn_lvt)                   lmax=2.1e-05
+ wmin=1.0005e-05-(dxw_lvt+dwmisn_lvt)                wmax=0.0009001
+ tnom=25                   version=3.24              tox=(toxn_lvt+toxmisn_lvt)
+ toxm=(toxn_lvt+toxmisn_lvt)                         xj=1.9e-07
+ nch=1.58e+18              lln=1                     lwn=1
+ wln=1                     wwn=-1                    lint=1.2e-09
+ ll=0                      lw=0                      lwl=0
+ wint=2.5e-09              wl=0                      ww=0
+ wwl=0                     mobmod=1                  binunit=2
+ xl=-2e-08+(dxl_lvt+dlmisn_lvt)                      xw=1.5e-08+(dxw_lvt+dwmisn_lvt)
+ dwg=0                     dwb=0                     ldif=8e-08
+ hdif=hdifn_lvt            rsh=rshn_lvt              rd=0
+ rs=0                      vth0=0.2186999+(dvthn_lvt+vthmisn_lvt)
+ pvth0=0+dpvthn_lvt        lvth0=2.831266e-08+dlvthn_lvt
+ wvth0=-6.677064e-09+dwvthn_lvt                      k1=0.3651984
+ lk1=5.989299e-08          k2=-0.007536892+dk2n_lvt  lk2=-2.467438e-08+dlk2n_lvt
+ k3=0                      dvt0=0                    dvt1=0
+ dvt2=0                    dvt0w=0                   dvt1w=0
+ dvt2w=0                   nlx=0                     w0=0
+ k3b=0                     vfb=-1.166902             vsat=117000
+ pvsat=0+dpvsatn_lvt       lvsat=0+dlvsatn_lvt       ua=6.983373e-12
+ lua=4.671626e-20          ub=2.666506e-18           lub=-5.214804e-26
+ uc=2.221286e-10           luc=-2.28941e-17          rdsw=155+drdswn_lvt
+ prwb=0                    prwg=0                    wr=1
+ u0=0.05187641             lu0=1.712371e-09          a0=2.066128
+ la0=-5.464872e-07         keta=0.0009319599         lketa=3.045488e-11
+ a1=0                      a2=1                      ags=0.8441848
+ lags=-1.48742e-08         b0=0                      b1=0
+ voff=-0.09914832          lvoff=-7.915079e-09       nfactor=0.07584696
+ lnfactor=3.72017e-09      cit=0.001715902           lcit=-1.593018e-10
+ cdsc=0                    cdscb=0                   cdscd=0
+ eta0=0.0003645229         leta0=2.844395e-10        etab=-0.0009029813
+ letab=3.404115e-10        dsub=0                    pclm=0.08541831
+ lpclm=4.198514e-08+dlpclmn_lvt                      pdiblc1=0
+ pdiblc2=0.00424947        lpdiblc2=4.296839e-09     pdiblcb=0.8747813
+ lpdiblcb=-4.788341e-07    drout=0                   pscbe1=7.522838e+08
+ pscbe2=1e-10              pvag=1e-20                delta=0.01
+ alpha0=0                  alpha1=0.013325           beta0=6.2486
+ kt1=-0.0910067            lkt1=-8.546768e-10        kt2=0.02
+ at=12065.23               lat=-2.342674e-06         ute=-1.522339
+ lute=7.601984e-08         ua1=1.116939e-10          lua1=1.423642e-17
+ ub1=1e-19                 uc1=4.73e-11              kt1l=0
+ prt=0                     cj=cjn_lvt                mj=0.3473
+ pb=0.6209                 cjsw=cjswn_lvt            mjsw=0.1679
+ pbsw=0.6209               cjswg=cjswgn_lvt          mjswg=0.5055
+ pbswg=0.6209              tcj=0.000976              tcjsw=0.000255
+ tcjswg=0.000255           tpb=0.001367              tpbsw=0.001367
+ tpbswg=0.001367           js=6e-07                  jsw=1e-11
+ n=1                       xti=3                     cgdo=cgon_lvt
+ cgso=cgon_lvt             capmod=3                  nqsmod=0
+ xpart=1                   cf=0                      tlev=1
+ tlevc=1                   dlc=1.80e-8               cgdl=cgln_lvt
+ cgsl=cgln_lvt             wwc=-0.041                dwc=0
+ noia=8.0e+18              noib=1.0e+4               noic=1.0e-13
+ em=4.1e+7                 ef=0.948                  noimod=2
+ sa0=0.35e-6               sb0=0.35e-6               kvsat=0.4
+ wlod=0.5e-6               tku0=0.03                 ku0=-0.62e-7
+ llodku0=1                 wlodku0=1                 lku0=1.8e-7
+ wku0=0.7e-6               pku0=-0.5e-13             kvth0=5.2e-9
+ stk2=2.5e-9               steta0=-1.1e-10           lkvth0=-1.0e-8
+ wkvth0=2.2e-6             pkvth0=-5e-14             llodvth=1.0
+ wlodvth=1                 lodk2=1                   lodeta0=2
+ minr=1e-3                 imax=0.01                 imelt=0.01

     2: type=n
+ lmin=1.6e-07-(dxl_lvt+dlmisn_lvt)                   lmax=4.7e-07-(dxl_lvt+dlmisn_lvt)
+ wmin=1.0005e-05-(dxw_lvt+dwmisn_lvt)                wmax=0.0009001
+ tnom=25                   version=3.24              tox=(toxn_lvt+toxmisn_lvt)
+ toxm=(toxn_lvt+toxmisn_lvt)                         xj=1.9e-07
+ nch=1.58e+18              lln=1                     lwn=1
+ wln=1                     wwn=-1                    lint=1.2e-09
+ ll=0                      lw=0                      lwl=0
+ wint=2.5e-09              wl=0                      ww=0
+ wwl=0                     mobmod=1                  binunit=2
+ xl=-2e-08+(dxl_lvt+dlmisn_lvt)                      xw=1.5e-08+(dxw_lvt+dwmisn_lvt)
+ dwg=0                     dwb=0                     ldif=8e-08
+ hdif=hdifn_lvt            rsh=rshn_lvt              rd=0
+ rs=0                      vth0=0.264771+(dvthn_lvt+vthmisn_lvt)
+ pvth0=0+dpvthn_lvt        lvth0=7.691254e-09+dlvthn_lvt
+ wvth0=-6.676732e-09+dwvthn_lvt                      k1=0.3585702
+ lk1=6.285978e-08          k2=-0.01235577+dk2n_lvt   lk2=-2.251745e-08+dlk2n_lvt
+ k3=0                      dvt0=0                    dvt1=0
+ dvt2=0                    dvt0w=0                   dvt1w=0
+ dvt2w=0                   nlx=0                     w0=0
+ k3b=0                     vfb=-1.438095             vsat=122541.3
+ pvsat=0+dpvsatn_lvt       lvsat=-0.00248028+dlvsatn_lvt
+ ua=7.150491e-12           lua=-2.80858e-20          ub=2.749742e-18
+ lub=-8.940448e-26         uc=1.733938e-10           luc=-1.080403e-18
+ rdsw=155+drdswn_lvt       prwb=0                    prwg=0
+ wr=1                      u0=0.05155703             lu0=1.855326e-09
+ a0=0.5631431              la0=1.262487e-07          keta=-0.01742242
+ lketa=8.245876e-09        a1=0                      a2=1
+ ags=1.126526              lags=-1.412499e-07        b0=0
+ b1=0                      voff=-0.1252335           lvoff=3.760631e-09
+ nfactor=0.01660566        lnfactor=3.023657e-08     cit=0.0002159791
+ lcit=5.120637e-10         cdsc=0                    cdscb=0
+ cdscd=0                   eta0=0.0009729683         leta0=1.209941e-11
+ etab=0.0008206542         letab=-4.310877e-10       dsub=0
+ pclm=-0.1423521           lpclm=1.439351e-07+dlpclmn_lvt
+ pdiblc1=0                 pdiblc2=0.006676776       lpdiblc2=3.210376e-09
+ pdiblcb=-0.1174393        lpdiblcb=-3.471618e-08    drout=0
+ pscbe1=7.522838e+08       pscbe2=1e-10              pvag=1.443871e-20
+ lpvag=-1.986766e-27       delta=0.01                alpha0=0
+ alpha1=0.013325           beta0=6.2486              kt1=-0.0851112
+ lkt1=-3.493499e-09        kt2=0.02                  at=16094.97
+ lat=-0.00180605           ute=-1.293248             lute=-2.652137e-08
+ ua1=1.36677e-11           lua1=5.811293e-17         ub1=1e-19
+ uc1=4.73e-11              kt1l=0                    prt=0
+ cj=cjn_lvt                mj=0.3473                 pb=0.6209
+ cjsw=cjswn_lvt            mjsw=0.1679               pbsw=0.6209
+ cjswg=cjswgn_lvt          mjswg=0.5055              pbswg=0.6209
+ tcj=0.000976              tcjsw=0.000255            tcjswg=0.000255
+ tpb=0.001367              tpbsw=0.001367            tpbswg=0.001367
+ js=6e-07                  jsw=1e-11                 n=1
+ xti=3                     cgdo=cgon_lvt             cgso=cgon_lvt
+ capmod=3                  nqsmod=0                  xpart=1
+ cf=0                      tlev=1                    tlevc=1
+ dlc=1.80e-8               cgdl=cgln_lvt             cgsl=cgln_lvt
+ wwc=-0.041                dwc=0                     noia=8.0e+18
+ noib=1.0e+4               noic=1.0e-13              em=4.1e+7
+ ef=0.948                  noimod=2                  sa0=0.35e-6
+ sb0=0.35e-6               kvsat=0.4                 wlod=0.5e-6
+ tku0=0.03                 ku0=-0.62e-7              llodku0=1
+ wlodku0=1                 lku0=1.8e-7               wku0=0.7e-6
+ pku0=-0.5e-13             kvth0=5.2e-9              stk2=2.5e-9
+ steta0=-1.1e-10           lkvth0=-1.0e-8            wkvth0=2.2e-6
+ pkvth0=-5e-14             llodvth=1.0               wlodvth=1
+ lodk2=1                   lodeta0=2                 minr=1e-3
+ imax=0.01                 imelt=0.01

     3: type=n
+ lmin=1.3e-07              lmax=1.6e-07-(dxl_lvt+dlmisn_lvt)
+ wmin=1.0005e-05-(dxw_lvt+dwmisn_lvt)                wmax=0.0009001
+ tnom=25                   version=3.24              tox=(toxn_lvt+toxmisn_lvt)
+ toxm=(toxn_lvt+toxmisn_lvt)                         xj=1.9e-07
+ nch=1.58e+18              lln=1                     lwn=1
+ wln=1                     wwn=-1                    lint=1.2e-09
+ ll=0                      lw=0                      lwl=0
+ wint=2.5e-09              wl=0                      ww=0
+ wwl=0                     mobmod=1                  binunit=2
+ xl=-2e-08+(dxl_lvt+dlmisn_lvt)                      xw=1.5e-08+(dxw_lvt+dwmisn_lvt)
+ dwg=0                     dwb=0                     ldif=8e-08
+ hdif=hdifn_lvt            rsh=rshn_lvt              rd=0
+ rs=0                      vth0=0.2632801+(dvthn_lvt+vthmisn_lvt)
+ pvth0=0+dpvthn_lvt        lvth0=7.896404e-09+dlvthn_lvt
+ wvth0=-6.677188e-09+dwvthn_lvt                      k1=0.8154
+ k2=-0.176+dk2n_lvt        lk2=0+dlk2n_lvt           k3=0
+ dvt0=0                    dvt1=0                    dvt2=0
+ dvt0w=0                   dvt1w=0                   dvt2w=0
+ nlx=0                     w0=0                      k3b=0
+ vfb=-1.422095             vsat=104516               ua=7.561451e-12
+ lua=-8.463399e-20         pvsat=0+dpvsatn_lvt       lvsat=0+dlvsatn_lvt
+ ub=2.817333e-18           lub=-9.870508e-26         uc=1.417923e-10
+ luc=3.267964e-18          rdsw=155+drdswn_lvt       prwb=0
+ prwg=0                    wr=1                      u0=0.06011489
+ lu0=6.777658e-10          a0=-0.3932121             la0=2.578432e-07
+ keta=-0.003230288         lketa=6.293039e-09        a1=0
+ a2=1                      ags=0.1                   b0=0
+ b1=0                      voff=-0.1154606           lvoff=2.415891e-09
+ nfactor=0.2363482         cit=0.003937372           cdsc=0
+ cdscb=0                   cdscd=0                   eta0=-0.01241958
+ leta0=1.854914e-09        etab=0.01235386           letab=-2.018057e-09
+ dsub=0                    pclm=-0.05429043          lpclm=1.318179e-07+dlpclmn_lvt
+ pdiblc1=0                 pdiblc2=0.01691817        lpdiblc2=1.80116e-09
+ pdiblcb=-2.004314         lpdiblcb=2.249177e-07     drout=0
+ pscbe1=7.522838e+08       pscbe2=1e-10              pvag=0
+ delta=0.01                alpha0=0                  alpha1=0.013325
+ beta0=6.2486              kt1=0.1029066             lkt1=-2.936475e-08
+ kt2=0.02                  at=-58485.4               lat=0.008456209
+ ute=-2.140521             lute=9.006341e-08         ua1=-1.586879e-09
+ lua1=2.783482e-16         ub1=1e-19                 uc1=4.73e-11
+ kt1l=0                    prt=0                     cj=cjn_lvt
+ mj=0.3473                 pb=0.6209                 cjsw=cjswn_lvt
+ mjsw=0.1679               pbsw=0.6209               cjswg=cjswgn_lvt
+ mjswg=0.5055              pbswg=0.6209              tcj=0.000976
+ tcjsw=0.000255            tcjswg=0.000255           tpb=0.001367
+ tpbsw=0.001367            tpbswg=0.001367           js=6e-07
+ jsw=1e-11                 n=1                       xti=3
+ cgdo=cgon_lvt             cgso=cgon_lvt             capmod=3
+ nqsmod=0                  xpart=1                   cf=0
+ tlev=1                    tlevc=1                   dlc=1.80e-8
+ cgdl=cgln_lvt             cgsl=cgln_lvt             wwc=-0.041
+ dwc=0                     noia=8.0e+18              noib=1.0e+4
+ noic=1.0e-13              em=4.1e+7                 ef=0.948
+ noimod=2                  sa0=0.35e-6               sb0=0.35e-6
+ kvsat=0.4                 wlod=0.5e-6               tku0=0.03
+ ku0=-0.62e-7              llodku0=1                 wlodku0=1
+ lku0=1.8e-7               wku0=0.7e-6               pku0=-0.5e-13
+ kvth0=5.2e-9              stk2=2.5e-9               steta0=-1.1e-10
+ lkvth0=-1.0e-8            wkvth0=2.2e-6             pkvth0=-5e-14
+ llodvth=1.0               wlodvth=1                 lodk2=1
+ lodeta0=2                 minr=1e-3                 imax=0.01
+ imelt=0.01

     4: type=n
+ lmin=4.7e-07-(dxl_lvt+dlmisn_lvt)                   lmax=2.1e-05
+ wmin=1.205e-06-(dxw_lvt+dwmisn_lvt)                 wmax=1.0005e-05-(dxw_lvt+dwmisn_lvt)
+ tnom=25                   version=3.24              tox=(toxn_lvt+toxmisn_lvt)
+ toxm=(toxn_lvt+toxmisn_lvt)                         xj=1.9e-07
+ nch=1.58e+18              lln=1                     lwn=1
+ wln=1                     wwn=-1                    lint=1.2e-09
+ ll=0                      lw=0                      lwl=0
+ wint=2.5e-09              wl=0                      ww=0
+ wwl=0                     mobmod=1                  binunit=2
+ xl=-2e-08+(dxl_lvt+dlmisn_lvt)                      xw=1.5e-08+(dxw_lvt+dwmisn_lvt)
+ dwg=0                     dwb=0                     ldif=8e-08
+ hdif=hdifn_lvt            rsh=rshn_lvt              rd=0
+ rs=0                      vth0=0.2185341+(dvthn_lvt+vthmisn_lvt)
+ lvth0=2.835675e-08+dlvthn_lvt                       wvth0=-5.016240e-9+dwvthn_lvt
+ pvth0=-4.4138970e-16+dpvthn_lvt                     k1=0.3642492
+ lk1=6.554062e-08          wk1=9.50652e-09           pk1=-5.6561e-14
+ k2=-0.00646911+dk2n_lvt   lk2=-2.704726e-08+dlk2n_lvt
+ wk2=-1.069385e-08         pk2=2.376442e-14          k3=0
+ dvt0=0                    dvt1=0                    dvt2=0
+ dvt0w=0                   dvt1w=0                   dvt2w=0
+ nlx=0                     w0=0                      k3b=0
+ vfb=-1.088464             vsat=116963.9             lvsat=1.617243e-05+dlvsatn_lvt
+ wvsat=0.0003618565        pvsat=-1.619669e-10+dpvsatn_lvt
+ ua=6.97719e-12            lua=6.657756e-20          wua=6.191665e-20
+ pua=-1.989109e-25         ub=2.730763e-18           lub=-4.399068e-26
+ wub=-6.435365e-25         pub=-8.169596e-32         uc=2.327686e-10
+ luc=-2.361347e-17         wuc=-1.065595e-16         puc=7.204488e-24
+ rdsw=155+drdswn_lvt       prwb=0                    prwg=0
+ wr=1                      u0=0.05288545             lu0=1.84059e-09
+ wu0=-1.010546e-08         pu0=-1.284116e-15         a0=2.071429
+ la0=-5.37297e-07          wa0=-5.308889e-08         pa0=-9.204114e-14
+ keta=0.0009948396         lketa=-6.89348e-10        wketa=-6.297373e-10
+ pketa=7.208826e-15        a1=0                      a2=1
+ ags=0.8444371             lags=-9.922409e-09        wags=-2.526e-09
+ pags=-4.959223e-14        b0=0                      b1=0
+ voff=-0.09402448          lvoff=-8.121651e-09       wvoff=-5.131522e-08
+ pvoff=2.068805e-15        nfactor=0.07296902        lnfactor=6.369044e-09
+ wnfactor=2.882255e-08     pnfactor=-2.652847e-14    cit=0.001519322
+ lcit=-1.12563e-10         wcit=1.968752e-09         pcit=-4.680885e-16
+ cdsc=0                    cdscb=0                   cdscd=0
+ eta0=0.0003575815         leta0=2.875465e-10        weta0=6.951847e-11
+ peta0=-3.111644e-17       etab=-0.0006329031        letab=3.360514e-10
+ wetab=-2.704833e-09       petab=4.366639e-17        dsub=0
+ pclm=0.09043974           lpclm=5.019517e-08+dlpclmn_lvt
+ wpclm=-5.028955e-08       ppclm=-8.222338e-14       pdiblc1=0
+ pdiblc2=0.004287268       lpdiblc2=3.763847e-09     wpdiblc2=-3.785372e-10
+ ppdiblc2=5.337912e-15     pdiblcb=0.8519068         lpdiblcb=-4.696254e-07
+ wpdiblcb=2.290889e-07     ppdiblcb=-9.222537e-14    drout=0
+ pscbe1=7.522838e+08       pscbe2=1e-10              pvag=-0.0004142047
+ wpvag=4.148259e-09        delta=0.01                alpha0=0
+ alpha1=0.013325           beta0=6.2486              kt1=-0.09552659
+ lkt1=-9.726804e-10        wkt1=4.526676e-08         pkt1=1.181807e-15
+ kt2=0.02                  at=11942.14               lat=-2.666123e-06
+ wat=0.001232814           pat=3.239339e-12          ute=-1.594844
+ lute=8.651576e-08         wute=7.261371e-07         pute=-1.051166e-13
+ ua1=1.227562e-11          lua1=1.620201e-17         wua1=9.956736e-16
+ pua1=-1.968544e-23        ub1=1e-19                 uc1=4.73e-11
+ kt1l=0                    prt=0                     cj=cjn_lvt
+ mj=0.3473                 pb=0.6209                 cjsw=cjswn_lvt
+ mjsw=0.1679               pbsw=0.6209               cjswg=cjswgn_lvt
+ mjswg=0.5055              pbswg=0.6209              tcj=0.000976
+ tcjsw=0.000255            tcjswg=0.000255           tpb=0.001367
+ tpbsw=0.001367            tpbswg=0.001367           js=6e-07
+ jsw=1e-11                 n=1                       xti=3
+ cgdo=cgon_lvt             cgso=cgon_lvt             capmod=3
+ nqsmod=0                  xpart=1                   cf=0
+ tlev=1                    tlevc=1                   dlc=1.80e-8
+ cgdl=cgln_lvt             cgsl=cgln_lvt             wwc=-0.041
+ dwc=0                     noia=8.0e+18              noib=1.0e+4
+ noic=1.0e-13              em=4.1e+7                 ef=0.948
+ noimod=2                  sa0=0.35e-6               sb0=0.35e-6
+ kvsat=0.4                 wlod=0.5e-6               tku0=0.03
+ ku0=-0.62e-7              llodku0=1                 wlodku0=1
+ lku0=1.8e-7               wku0=0.7e-6               pku0=-0.5e-13
+ kvth0=5.2e-9              stk2=2.5e-9               steta0=-1.1e-10
+ lkvth0=-1.0e-8            wkvth0=2.2e-6             pkvth0=-5e-14
+ llodvth=1.0               wlodvth=1                 lodk2=1
+ lodeta0=2                 minr=1e-3                 imax=0.01
+ imelt=0.01

     5: type=n
+ lmin=1.6e-07-(dxl_lvt+dlmisn_lvt)                   lmax=4.7e-07-(dxl_lvt+dlmisn_lvt)
+ wmin=1.205e-06-(dxw_lvt+dwmisn_lvt)                 wmax=1.0005e-05-(dxw_lvt+dwmisn_lvt)
+ tnom=25                   version=3.24              tox=(toxn_lvt+toxmisn_lvt)
+ toxm=(toxn_lvt+toxmisn_lvt)                         xj=1.9e-07
+ nch=1.58e+18              lln=1                     lwn=1
+ wln=1                     wwn=-1                    lint=1.2e-09
+ ll=0                      lw=0                      lwl=0
+ wint=2.5e-09              wl=0                      ww=0
+ wwl=0                     mobmod=1                  binunit=2
+ xl=-2e-08+(dxl_lvt+dlmisn_lvt)                      xw=1.5e-08+(dxw_lvt+dwmisn_lvt)
+ dwg=0                     dwb=0                     ldif=8e-08
+ hdif=hdifn_lvt            rsh=rshn_lvt              rd=0
+ rs=0                      vth0=0.2649697+(dvthn_lvt+vthmisn_lvt)
+ lvth0=7.572175e-09+dlvthn_lvt                       wvth0=-8.666475e-09+dwvthn_lvt
+ pvth0=1.192507e-15+dpvthn_lvt                       k1=0.3687194
+ lk1=6.353976e-08          wk1=-1.016443e-07         pk1=-6.809914e-15
+ k2=-0.01681033+dk2n_lvt   lk2=-2.241853e-08+dlk2n_lvt
+ wk2=4.461251e-08          pk2=-9.907082e-16         k3=0
+ dvt0=0                    dvt1=0                    dvt2=0
+ dvt0w=0                   dvt1w=0                   dvt2w=0
+ nlx=0                     w0=0                      k3b=0
+ vfb=-1.32663              vsat=122570.9             lvsat=-0.002493556+dlvsatn_lvt
+ wvsat=-0.000297061        pvsat=1.329648e-10+dpvsatn_lvt
+ ua=7.205343e-12           lua=-3.554361e-20         wua=-5.493456e-19
+ pua=7.469005e-26          ub=2.836354e-18           lub=-9.125332e-26
+ wub=-8.674242e-25         pub=1.851615e-32          uc=1.802748e-10
+ luc=-1.172736e-19         wuc=-6.891378e-17         puc=-9.645743e-24
+ rdsw=155+drdswn_lvt       prwb=0                    prwg=0
+ wr=1                      u0=0.05259407             lu0=1.971013e-09
+ wu0=-1.038588e-08         pu0=-1.1586e-15           a0=0.5902705
+ la0=1.256694e-07          wa0=-2.716822e-07         pa0=5.801237e-15
+ keta=-0.01737404          lketa=7.532563e-09        wketa=-4.845435e-10
+ pketa=7.143837e-15        a1=0                      a2=1
+ ags=1.142863              lags=-1.43498e-07         wags=-1.636221e-07
+ pags=2.251441e-14         b0=0                      b1=0
+ voff=-0.1213025           lvoff=4.087997e-09        wvoff=-3.936844e-08
+ pvoff=-3.278571e-15       nfactor=0.01263903        lnfactor=3.337275e-08
+ wnfactor=3.972592e-08     pnfactor=-3.140882e-14    cit=3.506316e-05
+ lcit=5.517911e-10         wcit=1.811874e-09         pcit=-3.978703e-16
+ cdsc=0                    cdscb=0                   cdscd=0
+ eta0=0.0009716384         leta0=1.269465e-11        weta0=1.331856e-11
+ peta0=-5.961389e-18       etab=0.001213966          letab=-4.906071e-10
+ wetab=-3.939018e-09       petab=5.960877e-16        dsub=0
+ pclm=-0.1018935           lpclm=1.362835e-07+dlpclmn_lvt
+ wpclm=-4.05192e-07        ppclm=7.663094e-14        pdiblc1=0
+ pdiblc2=0.004702318       lpdiblc2=3.578069e-09     wpdiblc2=1.977417e-08
+ ppdiblc2=-3.682438e-15    pdiblcb=-0.1090316        lpdiblcb=-3.950938e-08
+ wpdiblcb=-8.420253e-08    ppdiblcb=4.80039e-14      drout=0
+ pscbe1=7.522838e+08       pscbe2=1e-10              pvag=-0.0004142047
+ wpvag=4.148259e-09        delta=0.01                alpha0=0
+ alpha1=0.013325           beta0=6.2486              kt1=-0.08971371
+ lkt1=-3.574525e-09        wkt1=4.609412e-08         pkt1=8.114817e-16
+ kt2=0.02                  at=16528.25               lat=-0.002055408
+ wat=-0.004339308          pat=2.497321e-09          ute=-1.334122
+ lute=-3.018312e-08        wute=4.093606e-07         pute=3.667249e-14
+ ua1=-9.097832e-11         lua1=6.241849e-17         wua1=1.04803e-15
+ pua1=-4.312016e-23        ub1=1e-19                 uc1=4.73e-11
+ kt1l=0                    prt=0                     cj=cjn_lvt
+ mj=0.3473                 pb=0.6209                 cjsw=cjswn_lvt
+ mjsw=0.1679               pbsw=0.6209               cjswg=cjswgn_lvt
+ mjswg=0.5055              pbswg=0.6209              tcj=0.000976
+ tcjsw=0.000255            tcjswg=0.000255           tpb=0.001367
+ tpbsw=0.001367            tpbswg=0.001367           js=6e-07
+ jsw=1e-11                 n=1                       xti=3
+ cgdo=cgon_lvt             cgso=cgon_lvt             capmod=3
+ nqsmod=0                  xpart=1                   cf=0
+ tlev=1                    tlevc=1                   dlc=1.80e-8
+ cgdl=cgln_lvt             cgsl=cgln_lvt             wwc=-0.041
+ dwc=0                     noia=8.0e+18              noib=1.0e+4
+ noic=1.0e-13              em=4.1e+7                 ef=0.948
+ noimod=2                  sa0=0.35e-6               sb0=0.35e-6
+ kvsat=0.4                 wlod=0.5e-6               tku0=0.03
+ ku0=-0.62e-7              llodku0=1                 wlodku0=1
+ lku0=1.8e-7               wku0=0.7e-6               pku0=-0.5e-13
+ kvth0=5.2e-9              stk2=2.5e-9               steta0=-1.1e-10
+ lkvth0=-1.0e-8            wkvth0=2.2e-6             pkvth0=-5e-14
+ llodvth=1.0               wlodvth=1                 lodk2=1
+ lodeta0=2                 minr=1e-3                 imax=0.01
+ imelt=0.01

     6: type=n
+ lmin=1.3e-07              lmax=1.6e-07-(dxl_lvt+dlmisn_lvt)
+ wmin=1.205e-06-(dxw_lvt+dwmisn_lvt)                 wmax=1.0005e-05-(dxw_lvt+dwmisn_lvt)
+ tnom=25                   version=3.24              tox=(toxn_lvt+toxmisn_lvt)
+ toxm=(toxn_lvt+toxmisn_lvt)                         xj=1.9e-07
+ nch=1.58e+18              lln=1                     lwn=1
+ wln=1                     wwn=-1                    lint=1.2e-09
+ ll=0                      lw=0                      lwl=0
+ wint=2.5e-09              wl=0                      ww=0
+ wwl=0                     mobmod=1                  binunit=2
+ xl=-2e-08+(dxl_lvt+dlmisn_lvt)                      xw=1.5e-08+(dxw_lvt+dwmisn_lvt)
+ dwg=0                     dwb=0                     ldif=8e-08
+ hdif=hdifn_lvt            rsh=rshn_lvt              rd=0
+ rs=0                      vth0=0.2626133+(dvthn_lvt+vthmisn_lvt)
+ pvth0=0+dpvthn_lvt        lvth0=7.896404e-09+dlvthn_lvt
+ wvth0=0+dwvthn_lvt        k1=0.7739359              lk1=7.781956e-09
+ wk1=4.152633e-07          pk1=-7.79364e-14          k2=-0.1606747+dk2n_lvt
+ lk2=-2.622784e-09+dlk2n_lvt                         wk2=-1.534829e-07
+ pk2=2.626722e-14          k3=0                      dvt0=0
+ dvt1=0                    dvt2=0                    dvt0w=0
+ dvt1w=0                   dvt2w=0                   nlx=0
+ w0=0                      k3b=0                     vfb=-1.18882
+ vsat=104209.5             lvsat=3.297975e-05+dlvsatn_lvt
+ wvsat=0.003069636         pvsat=-3.302928e-10+dpvsatn_lvt
+ ua=9.026951e-12           lua=-2.861971e-19         wua=-1.467702e-17
+ pua=2.018658e-24          ub=2.820647e-18           lub=-8.909198e-26
+ wub=-3.318362e-26         pub=-9.627535e-32         uc=1.251536e-10
+ luc=7.46741e-18           wuc=1.66637e-16           puc=-4.205753e-23
+ rdsw=155+drdswn_lvt       prwb=0                    prwg=0
+ wr=1                      u0=0.06570523             lu0=1.669163e-10
+ wu0=-5.598737e-08         pu0=5.116167e-15          a0=-0.03525737
+ la0=2.117421e-07          wa0=-3.584923e-06         pa0=4.617032e-13
+ keta=-0.000864153         lketa=5.260801e-09        wketa=-2.369715e-08
+ pketa=1.033789e-14        a1=0                      a2=1
+ ags=0.1                   b0=0                      b1=0
+ voff=-0.1088687           lvoff=2.377104e-09        wvoff=-6.601836e-08
+ pvoff=3.88457e-16         nfactor=0.2516509         lnfactor=4.847223e-10
+ wnfactor=-1.532561e-07    pnfactor=-4.8545e-15      cit=0.004012196
+ lcit=4.537603e-12         wcit=-7.493621e-10        pcit=-4.544417e-17
+ cdsc=0                    cdscb=0                   cdscd=0
+ eta0=-0.01282964          leta0=1.91175e-09         weta0=4.106691e-09
+ peta0=-5.692095e-16       etab=0.01268106           letab=-2.06848e-09
+ wetab=-3.276918e-09       petab=5.049828e-16        dsub=0
+ pclm=-0.1311391           lpclm=1.403077e-07+dlpclmn_lvt
+ wpclm=7.696391e-07        ppclm=-8.502582e-14       pdiblc1=0
+ pdiblc2=0.02998604        lpdiblc2=9.902933e-11     wpdiblc2=-1.308749e-07
+ ppdiblc2=1.704688e-14     pdiblcb=-2.125524         lpdiblcb=2.379599e-07
+ wpdiblcb=1.21392e-06      ppdiblcb=-1.306178e-13    drout=0
+ pscbe1=7.522838e+08       pscbe2=1e-10              pvag=-0.001899815
+ lpvag=2.044201e-10        wpvag=1.902667e-08        ppvag=-2.04727e-15
+ delta=0.01                alpha0=0                  alpha1=0.013325
+ beta0=6.2486              kt1=0.1110016             lkt1=-3.119295e-08
+ wkt1=-8.107108e-08        pkt1=1.830941e-14         kt2=0.02
+ at=-61115.25              lat=0.008628338           wat=0.02633794
+ pat=-1.723869e-09         ute=-2.298377             lute=1.024983e-07
+ wute=1.58093e-06          pute=-1.245354e-13        ua1=-1.918385e-09
+ lua1=3.138696e-16         wua1=3.320029e-15         pua1=-3.557472e-22
+ ub1=1e-19                 uc1=4.73e-11              kt1l=0
+ prt=0                     cj=cjn_lvt                mj=0.3473
+ pb=0.6209                 cjsw=cjswn_lvt            mjsw=0.1679
+ pbsw=0.6209               cjswg=cjswgn_lvt          mjswg=0.5055
+ pbswg=0.6209              tcj=0.000976              tcjsw=0.000255
+ tcjswg=0.000255           tpb=0.001367              tpbsw=0.001367
+ tpbswg=0.001367           js=6e-07                  jsw=1e-11
+ n=1                       xti=3                     cgdo=cgon_lvt
+ cgso=cgon_lvt             capmod=3                  nqsmod=0
+ xpart=1                   cf=0                      tlev=1
+ tlevc=1                   dlc=1.80e-8               cgdl=cgln_lvt
+ cgsl=cgln_lvt             wwc=-0.041                dwc=0
+ noia=8.0e+18              noib=1.0e+4               noic=1.0e-13
+ em=4.1e+7                 ef=0.948                  noimod=2
+ sa0=0.35e-6               sb0=0.35e-6               kvsat=0.4
+ wlod=0.5e-6               tku0=0.03                 ku0=-0.62e-7
+ llodku0=1                 wlodku0=1                 lku0=1.8e-7
+ wku0=0.7e-6               pku0=-0.5e-13             kvth0=5.2e-9
+ stk2=2.5e-9               steta0=-1.1e-10           lkvth0=-1.0e-8
+ wkvth0=2.2e-6             pkvth0=-5e-14             llodvth=1.0
+ wlodvth=1                 lodk2=1                   lodeta0=2
+ minr=1e-3                 imax=0.01                 imelt=0.01

     7: type=n
+ lmin=4.7e-07-(dxl_lvt+dlmisn_lvt)                   lmax=2.1e-05
+ wmin=6.1e-07-(dxw_lvt+dwmisn_lvt)                   wmax=1.205e-06-(dxw_lvt+dwmisn_lvt)
+ tnom=25                   version=3.24              tox=(toxn_lvt+toxmisn_lvt)
+ toxm=(toxn_lvt+toxmisn_lvt)                         xj=1.9e-07
+ nch=1.58e+18              lln=1                     lwn=1
+ wln=1                     wwn=-1                    lint=1.2e-09
+ ll=0                      lw=0                      lwl=0
+ wint=2.5e-09              wl=0                      ww=0
+ wwl=0                     mobmod=1                  binunit=2
+ xl=-2e-08+(dxl_lvt+dlmisn_lvt)                      xw=1.5e-08+(dxw_lvt+dwmisn_lvt)
+ dwg=0                     dwb=0                     ldif=8e-08
+ hdif=hdifn_lvt            rsh=rshn_lvt              rd=0
+ rs=0                      vth0=0.2309822+(dvthn_lvt+vthmisn_lvt)
+ lvth0=3.4960950e-08+dlvthn_lvt                      wvth0=-2.0140657e-08+dwvthn_lvt
+ pvth0=-8.4654520e-15+dpvthn_lvt                     k1=0.4092222
+ lk1=3.104279e-08          wk1=-4.513567e-08         pk1=-1.464614e-14
+ k2=-0.03038621+dk2n_lvt   lk2=-8.977733e-09+dlk2n_lvt
+ wk2=1.836542e-08          pk2=1.809949e-15          k3=0
+ dvt0=0                    dvt1=0                    dvt2=0
+ dvt0w=0                   dvt1w=0                   dvt2w=0
+ nlx=0                     w0=0                      k3b=0
+ vfb=-1.088464             vsat=1.2446090e+05        lvsat=-2.6865730e-03+dlvsatn_lvt
+ wvsat=-8.7469970e-03      pvsat=3.1218248e-09+dpvsatn_lvt
+ ua=1.038705e-11           lua=1.146289e-18          wua=-4.081064e-18
+ pua=-1.51076e-24          ub=2.337551e-18           lub=-8.71382e-26
+ wub=-1.657836e-25         pub=-2.927173e-32         uc=1.527568e-10
+ luc=-2.44413e-17          wuc=-9.345229e-18         puc=8.210295e-24
+ rdsw=155+drdswn_lvt       prwb=0                    prwg=0
+ wr=1                      u0=4.8247020e-02          lu0=1.6823193e-10
+ wu0=-4.4697750e-09        pu0=7.4780120e-16         a0=1.815234
+ la0=-7.307417e-07         wa0=2.581879e-07          pa0=1.429943e-13
+ keta=0.0003453363         lketa=6.558135e-09        wketa=1.59407e-10
+ pketa=-1.596866e-15       a1=0                      a2=1
+ ags=0.9397634             lags=-9.432971e-08        wags=-1.183476e-07
+ pags=5.296263e-14         b0=0                      b1=0
+ voff=-0.1476755           lvoff=-8.071907e-09       wvoff=1.387077e-08
+ pvoff=2.008365e-15        nfactor=-0.416532         lnfactor=1.098439e-07
+ wnfactor=6.235663e-07     pnfactor=-1.522504e-13    cit=0.006195111
+ lcit=-9.664304e-10        wcit=-3.712332e-09        pcit=5.693605e-16
+ cdsc=0                    cdscb=0                   cdscd=0
+ eta0=0.0002921318         leta0=3.168418e-10        weta0=1.490398e-10
+ peta0=-6.671022e-17       etab=-0.004936935         letab=2.091177e-09
+ wetab=2.524566e-09        petab=-2.088811e-15       dsub=0
+ pclm=0.004050262          lpclm=-9.025595e-08+dlpclmn_lvt
+ wpclm=5.467367e-08        ppclm=8.842474e-14        pdiblc1=0
+ pdiblc2=3.9430640e-03     lpdiblc2=8.4842490e-09    wpdiblc2=3.9669120e-11
+ ppdiblc2=-3.9737670e-16   pdiblcb=2.208723          lpdiblcb=-1.524748e-06
+ wpdiblcb=-1.419443e-06    ppdiblcb=1.189749e-12     drout=0
+ pscbe1=7.522838e+08       pscbe2=1e-10              pvag=0.003
+ delta=0.01                alpha0=0                  alpha1=0.013325
+ beta0=6.2486              kt1=-0.03860558           lkt1=4.675711e-10
+ wkt1=-2.389227e-08        pkt1=-5.680988e-16        kt2=0.02
+ at=22150.61               lat=0.000218606           wat=-0.01117048
+ pat=-2.656063e-10         ute=-0.9972               ua1=4.733778e-10
+ lua1=6.720521e-17         wua1=4.354344e-16         pua1=-8.165433e-23
+ ub1=1e-19                 uc1=4.73e-11              kt1l=0
+ prt=0                     cj=cjn_lvt                mj=0.3473
+ pb=0.6209                 cjsw=cjswn_lvt            mjsw=0.1679
+ pbsw=0.6209               cjswg=cjswgn_lvt          mjswg=0.5055
+ pbswg=0.6209              tcj=0.000976              tcjsw=0.000255
+ tcjswg=0.000255           tpb=0.001367              tpbsw=0.001367
+ tpbswg=0.001367           js=6e-07                  jsw=1e-11
+ n=1                       xti=3                     cgdo=cgon_lvt
+ cgso=cgon_lvt             capmod=3                  nqsmod=0
+ xpart=1                   cf=0                      tlev=1
+ tlevc=1                   dlc=1.80e-8               cgdl=cgln_lvt
+ cgsl=cgln_lvt             wwc=-0.041                dwc=0
+ noia=8.0e+18              noib=1.0e+4               noic=1.0e-13
+ em=4.1e+7                 ef=0.948                  noimod=2
+ sa0=0.35e-6               sb0=0.35e-6               kvsat=0.4
+ wlod=0.5e-6               tku0=0.03                 ku0=-0.62e-7
+ llodku0=1                 wlodku0=1                 lku0=1.8e-7
+ wku0=0.7e-6               pku0=-0.5e-13             kvth0=5.2e-9
+ stk2=2.5e-9               steta0=-1.1e-10           lkvth0=-1.0e-8
+ wkvth0=2.2e-6             pkvth0=-5e-14             llodvth=1.0
+ wlodvth=1                 lodk2=1                   lodeta0=2
+ minr=1e-3                 imax=0.01                 imelt=0.01

     8: type=n
+ lmin=1.6e-07-(dxl_lvt+dlmisn_lvt)                   lmax=4.7e-07-(dxl_lvt+dlmisn_lvt)
+ wmin=6.1e-07-(dxw_lvt+dwmisn_lvt)                   wmax=1.205e-06-(dxw_lvt+dwmisn_lvt)
+ tnom=25                   version=3.24              tox=(toxn_lvt+toxmisn_lvt)
+ toxm=(toxn_lvt+toxmisn_lvt)                         xj=1.9e-07
+ nch=1.58e+18              lln=1                     lwn=1
+ wln=1                     wwn=-1                    lint=1.2e-09
+ ll=0                      lw=0                      lwl=0
+ wint=2.5e-09              wl=0                      ww=0
+ wwl=0                     mobmod=1                  binunit=2
+ xl=-2e-08+(dxl_lvt+dlmisn_lvt)                      xw=1.5e-08+(dxw_lvt+dwmisn_lvt)
+ dwg=0                     dwb=0                     ldif=8e-08
+ hdif=hdifn_lvt            rsh=rshn_lvt              rd=0
+ rs=0                      vth0=0.2986195+(dvthn_lvt+vthmisn_lvt)
+ lvth0=4.6864860e-09+dlvthn_lvt                      wvth0=-4.9551010e-08+dwvthn_lvt
+ pvth0=4.6986230e-15+dpvthn_lvt                      k1=0.2714527
+ lk1=9.270845e-08          wk1=1.653488e-08          pk1=-4.224989e-14
+ k2=0.02756109+dk2n_lvt    lk2=-3.491494e-08+dlk2n_lvt
+ wk2=-9.29877e-09          pk2=1.419244e-14          k3=0
+ dvt0=0                    dvt1=0                    dvt2=0
+ dvt0w=0                   dvt1w=0                   dvt2w=0
+ nlx=0                     w0=0                      k3b=0
+ vfb=-1.120943             vsat=1.2942793e+05        lvsat=-4.9098170e-03+dlvsatn_lvt
+ wvsat=-8.6283580e-03      pvsat=3.0687224e-09+dpvsatn_lvt
+ ua=2.220885e-11           lua=-4.145151e-18         wua=-1.877861e-17
+ pua=5.067864e-24          ub=2.130279e-18           lub=5.636728e-27
+ wub=-9.542479e-27         pub=-9.920527e-32         uc=8.376679e-11
+ luc=6.438639e-18          wuc=4.834349e-17          puc=-1.761118e-23
+ rdsw=155+drdswn_lvt       prwb=0                    prwg=0
+ wr=1                      u0=4.5094720e-02          lu0=1.5792028e-09
+ wu0=-1.2741737e-09        pu0=-6.8255020e-16        a0=0.5462454
+ la0=-1.627426e-07         wa0=-2.181918e-07         pa0=3.562219e-13
+ keta=0.01049178           lketa=2.016584e-09        wketa=-3.434153e-08
+ pketa=1.384575e-14        a1=0                      a2=1
+ ags=1.008221              lags=-1.249712e-07        wags=-3.139239e-11
+ pags=4.317878e-18         b0=0                      b1=0
+ voff=-0.1879333           lvoff=9.947499e-09        wvoff=4.1588e-08
+ pvoff=-1.039787e-14       nfactor=-0.04475243       lnfactor=-5.656461e-08
+ wnfactor=1.094565e-07     pnfactor=7.78651e-14      cit=0.003013027
+ lcit=4.5787e-10           wcit=-1.806352e-09        pcit=-2.837562e-16
+ cdsc=0                    cdscb=0                   cdscd=0
+ eta0=0.001180698          leta0=-8.088033e-11       weta0=-2.406886e-10
+ peta0=1.077322e-16        etab=0.000514033          letab=-3.486762e-10
+ wetab=-3.0886e-09         petab=4.236417e-16        dsub=0
+ pclm=-0.709565            lpclm=2.291582e-07+dlpclmn_lvt
+ wpclm=3.331288e-07        ppclm=-3.621177e-14       pdiblc1=0
+ pdiblc2=0.02600801        lpdiblc2=-1.392024e-09    wpdiblc2=-6.112255e-09
+ ppdiblc2=2.356225e-15     pdiblcb=-1.602943         lpdiblcb=1.813533e-07
+ wpdiblcb=1.7309e-06       ppdiblcb=-2.203444e-13    drout=0
+ pscbe1=7.522838e+08       pscbe2=1e-10              pvag=0.003
+ delta=0.01                alpha0=0                  alpha1=0.013325
+ beta0=6.2486              kt1=-0.02430046           lkt1=-5.935405e-09
+ wkt1=-3.3383e-08          pkt1=3.679951e-15         kt2=0.02
+ at=22639.01               wat=-0.01176388           ute=-0.9972
+ ua1=5.006711e-10          lua1=5.498873e-17         wua1=3.291758e-16
+ pua1=-3.409301e-23        ub1=1e-19                 uc1=4.73e-11
+ kt1l=0                    prt=0                     cj=cjn_lvt
+ mj=0.3473                 pb=0.6209                 cjsw=cjswn_lvt
+ mjsw=0.1679               pbsw=0.6209               cjswg=cjswgn_lvt
+ mjswg=0.5055              pbswg=0.6209              tcj=0.000976
+ tcjsw=0.000255            tcjswg=0.000255           tpb=0.001367
+ tpbsw=0.001367            tpbswg=0.001367           js=6e-07
+ jsw=1e-11                 n=1                       xti=3
+ cgdo=cgon_lvt             cgso=cgon_lvt             capmod=3
+ nqsmod=0                  xpart=1                   cf=0
+ tlev=1                    tlevc=1                   dlc=1.80e-8
+ cgdl=cgln_lvt             cgsl=cgln_lvt             wwc=-0.041
+ dwc=0                     noia=8.0e+18              noib=1.0e+4
+ noic=1.0e-13              em=4.1e+7                 ef=0.948
+ noimod=2                  sa0=0.35e-6               sb0=0.35e-6
+ kvsat=0.4                 wlod=0.5e-6               tku0=0.03
+ ku0=-0.62e-7              llodku0=1                 wlodku0=1
+ lku0=1.8e-7               wku0=0.7e-6               pku0=-0.5e-13
+ kvth0=5.2e-9              stk2=2.5e-9               steta0=-1.1e-10
+ lkvth0=-1.0e-8            wkvth0=2.2e-6             pkvth0=-5e-14
+ llodvth=1.0               wlodvth=1                 lodk2=1
+ lodeta0=2                 minr=1e-3                 imax=0.01
+ imelt=0.01

     9: type=n
+ lmin=1.3e-07              lmax=1.6e-07-(dxl_lvt+dlmisn_lvt)
+ wmin=6.1e-07-(dxw_lvt+dwmisn_lvt)                   wmax=1.205e-06-(dxw_lvt+dwmisn_lvt)
+ tnom=25                   version=3.24              tox=(toxn_lvt+toxmisn_lvt)
+ toxm=(toxn_lvt+toxmisn_lvt)                         xj=1.9e-07
+ nch=1.58e+18              lln=1                     lwn=1
+ wln=1                     wwn=-1                    lint=1.2e-09
+ ll=0                      lw=0                      lwl=0
+ wint=2.5e-09              wl=0                      ww=0
+ wwl=0                     mobmod=1                  binunit=2
+ xl=-2e-08+(dxl_lvt+dlmisn_lvt)                      xw=1.5e-08+(dxw_lvt+dwmisn_lvt)
+ dwg=0                     dwb=0                     ldif=8e-08
+ hdif=hdifn_lvt            rsh=rshn_lvt              rd=0
+ rs=0                      vth0=0.3304819+(dvthn_lvt+vthmisn_lvt)
+ lvth0=3.0222150e-10+dlvthn_lvt                      wvth0=-8.2459890e-08+dwvthn_lvt
+ pvth0=9.2268840e-15+dpvthn_lvt                      k1=2.717728
+ lk1=-2.43899e-07          wk1=-1.946443e-06         pk1=2.278559e-13
+ k2=-0.9038036+dk2n_lvt    lk2=9.324084e-08+dlk2n_lvt
+ wk2=7.494186e-07          pk2=-9.020708e-14         k3=0
+ dvt0=0                    dvt1=0                    dvt2=0
+ dvt0w=0                   dvt1w=0                   dvt2w=0
+ nlx=0                     w0=0                      k3b=0
+ vfb=-1.333006             vsat=9.6543140e+04        lvsat=-3.8486930e-04+dlvsatn_lvt
+ wvsat=1.2384001e-02       pvsat=1.7742183e-10+dpvsatn_lvt
+ ua=-8.074579e-11          lua=1.002141e-17          wua=9.439685e-17
+ pua=-1.050508e-23         ub=5.284533e-18           lub=-4.283886e-25
+ wub=-3.026805e-24         pub=3.1597e-31            uc=5.81177e-10
+ luc=-6.200502e-17         wuc=-3.874315e-16         puc=4.235146e-23
+ rdsw=155+drdswn_lvt       prwb=0                    prwg=0
+ wr=1                      u0=2.8186157e-02          lu0=3.9058210e-09
+ wu0=-1.0401711e-08        pu0=5.7339900e-16         a0=-10.73
+ la0=1.388869e-06          wa0=9.409187e-06          pa0=-9.685055e-13
+ keta=-0.1215333           lketa=2.018323e-08        wketa=1.229158e-07
+ pketa=-7.792859e-15       a1=0                      a2=1
+ ags=0.1                   b0=0                      b1=0
+ voff=-0.2175153           lvoff=1.401798e-08        wvoff=6.598727e-08
+ pvoff=-1.37552e-14        nfactor=0.08062168        lnfactor=-7.38161e-08
+ wnfactor=5.454456e-08     pnfactor=8.542098e-14     cit=0.006824558
+ lcit=-6.659656e-11        wcit=-4.166382e-09        pcit=4.098383e-17
+ cdsc=0                    cdscb=0                   cdscd=0
+ eta0=-0.0155203           leta0=2.217177e-09        weta0=7.375848e-09
+ peta0=-9.403032e-16       etab=0.01579505           letab=-2.451344e-09
+ wetab=-7.060414e-09       petab=9.701632e-16        dsub=0
+ pclm=1.074134             lpclm=-1.627879e-08+dlpclmn_lvt
+ wpclm=-6.947675e-07       ppclm=1.052268e-13        pdiblc1=0
+ pdiblc2=-0.09531967       lpdiblc2=1.530267e-08     wpdiblc2=2.137152e-08
+ ppdiblc2=-1.425543e-15    pdiblcb=-1.215765         lpdiblcb=1.280777e-07
+ wpdiblcb=1.085635e-07     ppdiblcb=2.88913e-15      drout=0
+ pscbe1=7.522838e+08       pscbe2=1e-10              pvag=0.0249721
+ lpvag=-3.023361e-09       wpvag=-1.36227e-08        ppvag=1.874483e-15
+ delta=0.01                alpha0=0                  alpha1=0.013325
+ beta0=6.2486              kt1=0.06933948            lkt1=-1.882026e-08
+ wkt1=-3.045165e-08        pkt1=3.276598e-15         kt2=0.02
+ at=-79362.54              lat=0.01403541            wat=0.04850839
+ pat=-8.293465e-09         ute=-0.9972               ua1=2.243216e-09
+ lua1=-1.847854e-16        wua1=-1.736315e-15        pua1=2.501186e-22
+ ub1=1e-19                 uc1=4.73e-11              kt1l=0
+ prt=0                     cj=cjn_lvt                mj=0.3473
+ pb=0.6209                 cjsw=cjswn_lvt            mjsw=0.1679
+ pbsw=0.6209               cjswg=cjswgn_lvt          mjswg=0.5055
+ pbswg=0.6209              tcj=0.000976              tcjsw=0.000255
+ tcjswg=0.000255           tpb=0.001367              tpbsw=0.001367
+ tpbswg=0.001367           js=6e-07                  jsw=1e-11
+ n=1                       xti=3                     cgdo=cgon_lvt
+ cgso=cgon_lvt             capmod=3                  nqsmod=0
+ xpart=1                   cf=0                      tlev=1
+ tlevc=1                   dlc=1.80e-8               cgdl=cgln_lvt
+ cgsl=cgln_lvt             wwc=-0.041                dwc=0
+ noia=8.0e+18              noib=1.0e+4               noic=1.0e-13
+ em=4.1e+7                 ef=0.948                  noimod=2
+ sa0=0.35e-6               sb0=0.35e-6               kvsat=0.4
+ wlod=0.5e-6               tku0=0.03                 ku0=-0.62e-7
+ llodku0=1                 wlodku0=1                 lku0=1.8e-7
+ wku0=0.7e-6               pku0=-0.5e-13             kvth0=5.2e-9
+ stk2=2.5e-9               steta0=-1.1e-10           lkvth0=-1.0e-8
+ wkvth0=2.2e-6             pkvth0=-5e-14             llodvth=1.0
+ wlodvth=1                 lodk2=1                   lodeta0=2
+ minr=1e-3                 imax=0.01                 imelt=0.01

     10: type=n
+ lmin=4.7e-07-(dxl_lvt+dlmisn_lvt)                   lmax=2.1e-05
+ wmin=1.5e-07              wmax=6.1e-07-(dxw_lvt+dwmisn_lvt)
+ tnom=25                   version=3.24              tox=(toxn_lvt+toxmisn_lvt)
+ toxm=(toxn_lvt+toxmisn_lvt)                         xj=1.9e-07
+ nch=1.58e+18              lln=1                     lwn=1
+ wln=1                     wwn=-1                    lint=1.2e-09
+ ll=0                      lw=0                      lwl=0
+ wint=2.5e-09              wl=0                      ww=0
+ wwl=0                     mobmod=1                  binunit=2
+ xl=-2e-08+(dxl_lvt+dlmisn_lvt)                      xw=1.5e-08+(dxw_lvt+dwmisn_lvt)
+ dwg=0                     dwb=0                     ldif=8e-08
+ hdif=hdifn_lvt            rsh=rshn_lvt              rd=0
+ rs=0                      vth0=0.2351561+(dvthn_lvt+vthmisn_lvt)
+ lvth0=1.7784442e-08+dlvthn_lvt                      wvth0=-2.2728472e-08+dwvthn_lvt
+ pvth0=2.1839764e-15+dpvthn_lvt                      k1=0.4207048
+ lk1=-4.4961830e-08        wk1=-5.2254860e-08        pk1=3.2476730e-14
+ k2=-2.0899918e-02+dk2n_lvt                          lk2=1.4056583e-08+dlk2n_lvt
+ wk2=1.2483916e-08         pk2=-1.2471323e-14        k3=0
+ dvt0=0                    dvt1=0                    dvt2=0
+ dvt0w=0                   dvt1w=0                   dvt2w=0
+ nlx=0                     w0=0                      k3b=0
+ vfb=-0.9656632            vsat=1.0801257e+05        lvsat=3.4117030e-03+dlvsatn_lvt
+ wvsat=1.4509674e-03       pvsat=-6.5910570e-10+dpvsatn_lvt
+ ua=4.7431240e-12          lua=-1.7107693e-18        wua=-5.8183020e-19
+ pua=2.6061711e-25         ub=2.1620185e-18          lub=-1.9656855e-25
+ wub=-5.6953480e-26        pub=3.8575060e-32         uc=1.5563596e-10
+ luc=-1.3859294e-17        wuc=-1.1130317e-17        puc=1.6494537e-24
+ rdsw=155+drdswn_lvt       prwb=0                    prwg=0
+ wr=1                      u0=4.3399560e-02          lu0=3.8742300e-10
+ wu0=-1.4643523e-09        pu0=6.1190400e-16         a0=1.7841951
+ la0=-2.5254255e-07        wa0=2.7743206e-07         pa0=-1.5348924e-13
+ keta=1.1451785e-02        lketa=-8.7363010e-10      wketa=-6.7265910e-09
+ pketa=3.0108227e-15       a1=0                      a2=1
+ ags=0.7623376             lags=-1.6909201e-08       wags=-8.3436330e-09
+ pags=4.9620110e-15        b0=0                      b1=0
+ voff=-0.1422990           lvoff=-1.5104732e-09      wvoff=1.0537338e-08
+ pvoff=-2.0597152e-15      nfactor=0.7132385         lnfactor=-1.6104107e-07
+ wnfactor=-7.6891430e-08   pnfactor=1.5698260e-14    cit=2.4552821e-04
+ lcit=-6.5138460e-11       wcit=-2.3590645e-11       pcit=1.0559176e-17
+ cdsc=0                    cdscb=0                   cdscd=0
+ eta0=6.0638770e-04        leta0=1.7542617e-10       weta0=-4.5798910e-11
+ peta0=2.0967528e-17       etab=-1.0165505e-03       letab=-1.2100637e-09
+ wetab=9.3927660e-11       petab=-4.2042110e-17      dsub=0
+ pclm=-7.1235970e-02       lpclm=9.1573170e-08+dlpclmn_lvt
+ wpclm=1.0135114e-07       ppclm=-2.4309334e-14      pdiblc1=0
+ pdiblc2=4.0447940e-03     lpdiblc2=7.4651840e-09    wpdiblc2=-2.3403286e-11
+ ppdiblc2=2.3444202e-16    pdiblcb=-0.3733662        lpdiblcb=5.2519860e-07
+ wpdiblcb=1.8145231e-07    ppdiblcb=-8.1218050e-14   drout=0
+ pscbe1=7.522838e+08       pscbe2=1e-10              pvag=0.003
+ delta=0.01                alpha0=0                  alpha1=0.013325
+ beta0=6.2486              kt1=-7.9193170e-02        lkt1=-7.0452670e-10
+ wkt1=1.2720376e-09        pkt1=1.5859915e-16        kt2=0.02
+ at=3.8537330e+03          lat=-3.0116356e-04        wat=1.7358338e-04
+ pat=5.6652450e-11         ute=-0.9972               ua1=1.3437949e-09
+ lua1=-1.1953976e-16       wua1=-1.0422419e-16       pua1=3.4127520e-23
+ ub1=1e-19                 uc1=4.73e-11              kt1l=0
+ prt=0                     cj=cjn_lvt                mj=0.3473
+ pb=0.6209                 cjsw=cjswn_lvt            mjsw=0.1679
+ pbsw=0.6209               cjswg=cjswgn_lvt          mjswg=0.5055
+ pbswg=0.6209              tcj=0.000976              tcjsw=0.000255
+ tcjswg=0.000255           tpb=0.001367              tpbsw=0.001367
+ tpbswg=0.001367           js=6e-07                  jsw=1e-11
+ n=1                       xti=3                     cgdo=cgon_lvt
+ cgso=cgon_lvt             capmod=3                  nqsmod=0
+ xpart=1                   cf=0                      tlev=1
+ tlevc=1                   dlc=1.80e-8               cgdl=cgln_lvt
+ cgsl=cgln_lvt             wwc=-0.041                dwc=0
+ noia=8.0e+18              noib=1.0e+4               noic=1.0e-13
+ em=4.1e+7                 ef=0.948                  noimod=2
+ sa0=0.35e-6               sb0=0.35e-6               kvsat=0.4
+ wlod=0.5e-6               tku0=0.03                 ku0=-0.62e-7
+ llodku0=1                 wlodku0=1                 lku0=1.8e-7
+ wku0=0.7e-6               pku0=-0.5e-13             kvth0=5.2e-9
+ stk2=2.5e-9               steta0=-1.1e-10           lkvth0=-1.0e-8
+ wkvth0=2.2e-6             pkvth0=-5e-14             llodvth=1.0
+ wlodvth=1                 lodk2=1                   lodeta0=2
+ minr=1e-3                 imax=0.01                 imelt=0.01

     11: type=n
+ lmin=1.6e-07-(dxl_lvt+dlmisn_lvt)                   lmax=4.7e-07-(dxl_lvt+dlmisn_lvt)
+ wmin=1.5e-07              wmax=6.1e-07-(dxw_lvt+dwmisn_lvt)
+ tnom=25                   version=3.24              tox=(toxn_lvt+toxmisn_lvt)
+ toxm=(toxn_lvt+toxmisn_lvt)                         xj=1.9e-07
+ nch=1.58e+18              lln=1                     lwn=1
+ wln=1                     wwn=-1                    lint=1.2e-09
+ ll=0                      lw=0                      lwl=0
+ wint=2.5e-09              wl=0                      ww=0
+ wwl=0                     mobmod=1                  binunit=2
+ xl=-2e-08+(dxl_lvt+dlmisn_lvt)                      xw=1.5e-08+(dxw_lvt+dwmisn_lvt)
+ dwg=0                     dwb=0                     ldif=8e-08
+ hdif=hdifn_lvt            rsh=rshn_lvt              rd=0
+ rs=0                      vth0=0.2452306+(dvthn_lvt+vthmisn_lvt)
+ lvth0=1.3275075e-08+dlvthn_lvt                      wvth0=-1.6449924e-08+dwvthn_lvt
+ pvth0=-6.2630110e-16+dpvthn_lvt                     k1=0.2641908
+ lk1=2.50938e-08           wk1=2.103722e-08          pk1=-3.288062e-16
+ k2=0.04118695+dk2n_lvt    lk2=-1.373351e-08+dlk2n_lvt
+ wk2=-1.774681e-08         pk2=1.059953e-15          k3=0
+ dvt0=0                    dvt1=0                    dvt2=0
+ dvt0w=0                   dvt1w=0                   dvt2w=0
+ nlx=0                     w0=0                      k3b=0
+ vfb=-1.120943             vsat=1.1559233e+05        lvsat=1.9003839e-05+dlvsatn_lvt
+ wvsat=-5.0281750e-05      pvsat=1.2853517e-11+dpvsatn_lvt
+ ua=-6.840878e-12          lua=3.474227e-18          wua=-7.677812e-19
+ pua=3.438493e-25          ub=2.003739e-18           lub=-1.257228e-25
+ wub=6.891213e-26          pub=-1.776237e-32         uc=1.800759e-10
+ luc=-2.47986e-17          wuc=-1.136816e-17         puc=1.755911e-24
+ rdsw=155+drdswn_lvt       prwb=0                    prwg=0
+ wr=1                      u0=4.3250440e-02          lu0=4.5417160e-10
+ wu0=-1.3071784e-10        pu0=1.4969228e-17         a0=0.4067271
+ la0=3.64012e-07           wa0=-1.316907e-07         pa0=2.963412e-14
+ keta=-0.05099944          lketa=2.707954e-08        wketa=3.783025e-09
+ pketa=-1.693282e-15       a1=0                      a2=1
+ ags=1.001784              lags=-1.240855e-07        wags=3.959419e-09
+ pags=-5.448161e-16        b0=0                      b1=0
+ voff=-0.1266073           lvoff=-8.534068e-09       wvoff=3.565888e-09
+ pvoff=1.060704e-15        nfactor=0.2233466         lnfactor=5.823453e-08
+ wnfactor=-5.676487e-08    pnfactor=6.689618e-15     cit=9.95561e-05
+ lcit=1.986897e-13         cdsc=0                    cdscb=0
+ cdscd=0                   eta0=0.0007084507         leta0=1.297427e-10
+ weta0=5.210459e-11        peta0=-2.285406e-17       etab=-0.004770291
+ letab=4.701102e-10        wetab=1.876807e-10        petab=-8.40059e-17
+ dsub=0                    pclm=-0.2070665           lpclm=1.523709e-07+dlpclmn_lvt
+ wpclm=2.157971e-08        ppclm=1.139636e-14        pdiblc1=0
+ pdiblc2=0.01456377        lpdiblc2=2.756896e-09     wpdiblc2=9.831806e-10
+ ppdiblc2=-2.161058e-16    pdiblcb=1.188831          lpdiblcb=-1.740408e-07
+ drout=0                   pscbe1=7.522838e+08       pscbe2=1e-10
+ pvag=0.003                delta=0.01                alpha0=0
+ alpha1=0.013325           beta0=6.2486              kt1=-0.08066885
+ lkt1=-4.400691e-11        wkt1=1.56541e-09          pkt1=2.728432e-17
+ kt2=0.02                  at=3199.024               lat=-8.121723e-06
+ wat=0.000288905           pat=5.035469e-12          ute=-0.9972
+ ua1=1.075036e-09          lua1=7.570623e-19         wua1=-2.693009e-17
+ pua1=-4.693779e-25        ub1=1e-19                 uc1=4.73e-11
+ kt1l=0                    prt=0                     cj=cjn_lvt
+ mj=0.3473                 pb=0.6209                 cjsw=cjswn_lvt
+ mjsw=0.1679               pbsw=0.6209               cjswg=cjswgn_lvt
+ mjswg=0.5055              pbswg=0.6209              tcj=0.000976
+ tcjsw=0.000255            tcjswg=0.000255           tpb=0.001367
+ tpbsw=0.001367            tpbswg=0.001367           js=6e-07
+ jsw=1e-11                 n=1                       xti=3
+ cgdo=cgon_lvt             cgso=cgon_lvt             capmod=3
+ nqsmod=0                  xpart=1                   cf=0
+ tlev=1                    tlevc=1                   dlc=1.80e-8
+ cgdl=cgln_lvt             cgsl=cgln_lvt             wwc=-0.041
+ dwc=0                     noia=8.0e+18              noib=1.0e+4
+ noic=1.0e-13              em=4.1e+7                 ef=0.948
+ noimod=2                  sa0=0.35e-6               sb0=0.35e-6
+ kvsat=0.4                 wlod=0.5e-6               tku0=0.03
+ ku0=-0.62e-7              llodku0=1                 wlodku0=1
+ lku0=1.8e-7               wku0=0.7e-6               pku0=-0.5e-13
+ kvth0=5.2e-9              stk2=2.5e-9               steta0=-1.1e-10
+ lkvth0=-1.0e-8            wkvth0=2.2e-6             pkvth0=-5e-14
+ llodvth=1.0               wlodvth=1                 lodk2=1
+ lodeta0=2                 minr=1e-3                 imax=0.01
+ imelt=0.01

     12: type=n
+ lmin=1.3e-07              lmax=1.6e-07-(dxl_lvt+dlmisn_lvt)
+ wmin=1.5e-07              wmax=6.1e-07-(dxw_lvt+dwmisn_lvt)
+ tnom=25                   version=3.24              tox=(toxn_lvt+toxmisn_lvt)
+ toxm=(toxn_lvt+toxmisn_lvt)                         xj=1.9e-07
+ nch=1.58e+18              lln=1                     lwn=1
+ wln=1                     wwn=-1                    lint=1.2e-09
+ ll=0                      lw=0                      lwl=0
+ wint=2.5e-09              wl=0                      ww=0
+ wwl=0                     mobmod=1                  binunit=2
+ xl=-2e-08+(dxl_lvt+dlmisn_lvt)                      xw=1.5e-08+(dxw_lvt+dwmisn_lvt)
+ dwg=0                     dwb=0                     ldif=8e-08
+ hdif=hdifn_lvt            rsh=rshn_lvt              rd=0
+ rs=0                      vth0=0.2105056+(dvthn_lvt+vthmisn_lvt)
+ lvth0=1.8053244e-08+dlvthn_lvt                      wvth0=-8.0745660e-09+dwvthn_lvt
+ pvth0=-1.7787501e-15+dpvthn_lvt                     k1=-0.5694889
+ lk1=1.398081e-07          wk1=9.163066e-08          pk1=-1.004246e-14
+ k2=0.3709159+dk2n_lvt     lk2=-5.910421e-08+dlk2n_lvt
+ wk2=-4.090737e-08         pk2=4.246846e-15          k3=0
+ dvt0=0                    dvt1=0                    dvt2=0
+ dvt0w=0                   dvt1w=0                   dvt2w=0
+ nlx=0                     w0=0                      k3b=0
+ vfb=-1.429629             vsat=1.1644777e+05        pvsat=0+dpvsatn_lvt
+ lvsat=-9.8705080e-05+dlvsatn_lvt                    wvsat=4.3130440e-05
+ ua=7.655275e-11           lua=-8.000737e-18         wua=-3.128236e-18
+ pua=6.68648e-25           ub=7.241772e-19           lub=5.034496e-26
+ wub=-1.993844e-25         pub=1.915524e-32          uc=-7.358405e-11
+ luc=1.010501e-17          wuc=1.852037e-17          puc=-2.356751e-24
+ rdsw=155+drdswn_lvt       prwb=0                    prwg=0
+ wr=1                      u0=6.7066080e-03          lu0=5.4826020e-09
+ wu0=2.9156051e-09         pu0=-4.0420480e-16        a0=5.128563
+ la0=-2.857127e-07         wa0=-4.231202e-07         pa0=6.973481e-14
+ keta=0.1239012            lketa=3.013216e-09        wketa=-2.925354e-08
+ pketa=2.852549e-15        a1=0                      a2=1
+ ags=0.1                   b0=0                      b1=0
+ voff=-0.0955862           lvoff=-1.280258e-08       wvoff=-9.608766e-09
+ pvoff=2.873537e-15        nfactor=0.08907563        lnfactor=7.671022e-08
+ wnfactor=4.930306e-08     pnfactor=-7.90533e-15     cit=0.0001059979
+ lcit=-6.877085e-13        wcit=-8.746291e-13        pcit=1.20349e-19
+ cdsc=0                    cdscb=0                   cdscd=0
+ eta0=-0.001915893         leta0=4.908525e-10        weta0=-1.058885e-09
+ peta0=1.300181e-16        etab=0.001196805          letab=-3.509621e-10
+ wetab=1.990499e-09        petab=-3.320737e-16       dsub=0
+ pclm=-0.3782649           lpclm=1.759278e-07+dlpclmn_lvt
+ wpclm=2.057197e-07        ppclm=-1.394131e-14       pdiblc1=0
+ pdiblc2=-0.07836966       lpdiblc2=1.554454e-08     wpdiblc2=1.086252e-08
+ ppdiblc2=-1.575503e-15    pdiblcb=-0.9106975        lpdiblcb=1.148544e-07
+ wpdiblcb=-8.057834e-08    ppdiblcb=1.108758e-14     drout=0
+ pscbe1=7.522838e+08       pscbe2=1e-10              pvag=0.003
+ delta=0.01                alpha0=0                  alpha1=0.013325
+ beta0=6.2486              kt1=0.038413              lkt1=-1.642967e-08
+ wkt1=-1.127722e-08        pkt1=1.794431e-15         kt2=0.02
+ at=-3531.199              lat=0.000917957           wat=0.00149296
+ pat=-1.606425e-10         ute=-0.9972               ua1=-7.291373e-10
+ lua1=2.490112e-16         wua1=1.065434e-16         pua1=-1.883533e-23
+ ub1=1e-19                 uc1=4.73e-11              kt1l=0
+ prt=0                     cj=cjn_lvt                mj=0.3473
+ pb=0.6209                 cjsw=cjswn_lvt            mjsw=0.1679
+ pbsw=0.6209               cjswg=cjswgn_lvt          mjswg=0.5055
+ pbswg=0.6209              tcj=0.000976              tcjsw=0.000255
+ tcjswg=0.000255           tpb=0.001367              tpbsw=0.001367
+ tpbswg=0.001367           js=6e-07                  jsw=1e-11
+ n=1                       xti=3                     cgdo=cgon_lvt
+ cgso=cgon_lvt             capmod=3                  nqsmod=0
+ xpart=1                   cf=0                      tlev=1
+ tlevc=1                   cgdl=cgln_lvt             cgsl=cgln_lvt
+ wwc=-0.041                dlc=1.80e-8               dwc=0
+ noia=8.0e+18              noib=1.0e+4               noic=1.0e-13
+ em=4.1e+7                 ef=0.948                  noimod=2
+ sa0=0.35e-6               sb0=0.35e-6               kvsat=0.4
+ wlod=0.5e-6               tku0=0.03                 ku0=-0.62e-7
+ llodku0=1                 wlodku0=1                 lku0=1.8e-7
+ wku0=0.7e-6               pku0=-0.5e-13             kvth0=5.2e-9
+ stk2=2.5e-9               steta0=-1.1e-10           lkvth0=-1.0e-8
+ wkvth0=2.2e-6             pkvth0=-5e-14             llodvth=1.0
+ wlodvth=1                 lodk2=1                   lodeta0=2
+ minr=1e-3                 imax=0.01                 imelt=0.01
//
// **************************************************************
//                                                              *
//               1.2V LOW Vt PMOS DEVICES MODEL                 *
//                                                              *
// **************************************************************
//
     }
ends nch_lvt_mis

inline subckt pch_lvt_mis ( d g s b )
parameters l=1u w=1u multi=1 factor=1 sa=0.35e-6 sb=0.35e-6 ad=2 * hdifp_lvt
+ / factor * w as=2 * hdifp_lvt / factor * w pd=2 * (2 * hdifp_lvt / factor + w)
+ ps=2 * (2 * hdifp_lvt / factor + w) nrd=hdifp_lvt / factor / w nrs=hdifp_lvt /
+ factor / w temp1=parp1_lvt temp2=parp2_lvt fac1=0.798 * temp1 + 0.602 * temp2
+ fac2=0.798 * temp1 - 0.602 * temp2 lef=l - 2.0e-8 wef=w + 1.5e-8 geo_fac=1 / sqrt(multi
+ * lef * wef * 1e12) vthmisp_lvt=0.002917 * geo_fac * fac1 dlmisp_lvt=0.001870
+ * geo_fac * lef * fac2 dwmisp_lvt= - 0.001870 * geo_fac * wef * fac2 toxmisp_lvt=0.001870
+ * geo_fac * toxp_lvt * fac2
pch_lvt_mis ( d g s b ) pch_lvt w=w l=l ad=ad as=as pd=pd ps=ps nrd=nrd nrs=nrs m=multi sa=sa
+ sb=sb
model pch_lvt bsim3v3  {
     1: type=p
+ lmin=0.77e-6-(dxl_lvt+dlmisp_lvt)                   lmax=0.000021
+ wmin=1.0005e-05-(dxw_lvt+dwmisp_lvt)                wmax=0.0009001
+ tnom=25.0                 version=3.24              tox=(toxp_lvt+toxmisp_lvt)
+ toxm=(toxp_lvt+toxmisp_lvt)                         xj=2.1000000e-07
+ nch=5.6487000e+17         lln=1.0000000             lwn=1.0000000
+ wln=1.0000000             wwn=-1                    lint=6.5000000e-09
+ ll=0.00                   lw=0.00                   lwl=0.00
+ wint=1.5000000e-09        wl=0.00                   ww=0.00
+ wwl=0.00                  mobmod=1                  binunit=2
+ xl=-2e-8+(dxl_lvt+dlmisp_lvt)                       xw=1.5e-8+(dxw_lvt+dwmisp_lvt)
+ dwg=0.00                  dwb=0.00                  ldif=8.00e-08
+ hdif=hdifp_lvt            rsh=rshp_lvt              rd=0
+ rs=0                      vth0=-7.7532660e-02+(dvthp_lvt+vthmisp_lvt)
+ lvth0=-5.4602370e-08+dlvthp_lvt                     pvth0=0+dpvthp_lvt
+ wvth0=0+dwvthp_lvt        k1=0.4000000              k2=-5.3239030e-02+dk2p_lvt
+ lk2=2.3871616e-09+dlk2p_lvt                         k3=0.00
+ dvt0=0.00                 dvt1=0.00                 dvt2=0.00
+ dvt0w=0.00                dvt1w=0.00                dvt2w=0.00
+ nlx=0.00                  w0=0.00                   k3b=0.00
+ vsat=8.2000000e+04        ua=2.0795985e-11          pvsat=0+dpvsatp_lvt
+ lvsat=0+dlvsatp_lvt       lua=1.8016722e-17         ub=2.0619514e-18
+ lub=-1.1935822e-25        uc=1.0000000e-10          rdsw=4.9180000e+02+drdswp_lvt
+ prwb=0.00                 prwg=0.00                 wr=1.0000000
+ u0=1.0888455e-02          lu0=1.1140093e-09         a0=1.8478054
+ la0=-4.7743250e-07        keta=-1.0100800e-02       a1=0.00
+ a2=0.9900000              ags=0.6760973             lags=2.3871630e-07
+ b0=0.00                   b1=0.00                   voff=-9.6867940e-02
+ lvoff=-1.0344577e-08      nfactor=0.9521946         lnfactor=4.7743260e-07
+ lcit=1.6710139e-09        cit=2.3268120e-04         cdsc=0.00
+ cdscb=0.00                cdscd=0.00                eta0=1.7681296e-03
+ leta0=3.1828840e-10       etab=-1.1362595e-03       letab=-6.3657680e-10
+ dsub=0.00                 pclm=1.6849999            lpclm=0+dlpclmp_lvt
+ wpclm=0+dwpclmp_lvt       pdiblc1=0.00              pdiblc2=5.3426380e-02
+ lpdiblc2=-3.3420280e-08   pdiblcb=0.00              drout=0.00
+ pscbe1=8.4920770e+08      pscbe2=1.0000000e-07      pvag=0.00
+ delta=8.0000000e-03       alpha0=0.00               alpha1=0.019
+ beta0=12.638              kt1=-0.2825935            lkt1=1.5914402e-08
+ pkt1=0+dpkt1p_lvt         kt2=-3.3268120e-03        lkt2=-1.6710139e-08
+ at=1.0000000e+04          ute=-1.7159352            lute=1.5914422e-07
+ ua1=5.9900000e-10         ub1=-2.9836595e-18        lub1=8.3550700e-25
+ uc1=-1.4600000e-10        kt1l=0.00                 prt=0.00
+ cj=cjp_lvt                pb=0.826557               mj=0.385643
+ cjsw=cjswp_lvt            pbsw=0.826557             mjsw=0.158
+ cjswg=cjswgp_lvt          pbswg=0.826557            mjswg=0.7162
+ js=2e-7                   jsw=7.6e-12               n=1.0
+ xti=3.0                   cgdo=cgop_lvt             cgso=cgop_lvt
+ tcj=0.00090284            tcjsw=0.00029887          tpb=0.00165968
+ tpbsw=0.00165968          tcjswg=0.00029887         tpbswg=0.00165968
+ capmod=3                  nqsmod=0                  xpart=1
+ cf=0                      tlev=1                    tlevc=1
+ dlc=1.50e-8               cgdl=cglp_lvt             cgsl=cglp_lvt
+ wwc=-0.038                dwc=0                     noia=9.0e+18
+ noib=1.0e+3               noic=6.0e-12              em=4.1e+7
+ ef=1.128                  noimod=2                  sa0=0.35e-6
+ sb0=0.35e-6               kvsat=-0.6                wlod=0.3e-6
+ tku0=0.03                 ku0=1.14e-7               llodku0=1
+ wlodku0=1                 lku0=3e-8                 wku0=3.0e-7
+ pku0=0e-14                kvth0=-2.3e-9             stk2=0e-9
+ steta0=0                  lkvth0=1.0e-8             wkvth0=2.5e-7
+ pkvth0=4e-14              llodvth=1                 wlodvth=1
+ lodk2=1                   lodeta0=1                 minr=1e-3
+ imax=0.01                 imelt=0.01

     2: type=p
+ lmin=2.2e-07-(dxl_lvt+dlmisp_lvt)                   lmax=0.77e-6-(dxl_lvt+dlmisp_lvt)
+ wmin=1.0005e-05-(dxw_lvt+dwmisp_lvt)                wmax=0.0009001
+ tnom=25.0                 version=3.24              tox=(toxp_lvt+toxmisp_lvt)
+ toxm=(toxp_lvt+toxmisp_lvt)                         xj=2.1000000e-07
+ nch=5.6487000e+17         lln=1.0000000             lwn=1.0000000
+ wln=1.0000000             wwn=-1                    lint=6.5000000e-09
+ ll=0.00                   lw=0.00                   lwl=0.00
+ wint=1.5000000e-09        wl=0.00                   ww=0.00
+ wwl=0.00                  mobmod=1                  binunit=2
+ xl=-2e-8+(dxl_lvt+dlmisp_lvt)                       xw=1.5e-8+(dxw_lvt+dwmisp_lvt)
+ dwg=0.00                  dwb=0.00                  ldif=8.00e-08
+ hdif=hdifp_lvt            rsh=rshp_lvt              rd=0
+ rs=0                      vth0=-0.1251476+(dvthp_lvt+vthmisp_lvt)
+ lvth0=-1.9510159e-08+dlvthp_lvt                     pvth0=0+dpvthp_lvt
+ wvth0=0+dwvthp_lvt        k1=0.4000000              k2=-5.4080000e-02+dk2p_lvt
+ lk2=3.0069607e-09+dlk2p_lvt                         k3=0.00
+ dvt0=0.00                 dvt1=0.00                 dvt2=0.00
+ dvt0w=0.00                dvt1w=0.00                dvt2w=0.00
+ nlx=0.00                  w0=0.00                   k3b=0.00
+ vsat=8.2000000e+04        ua=4.3624300e-11          pvsat=0+dpvsatp_lvt
+ lvsat=0+dlvsatp_lvt       lua=1.1922570e-18         ub=2.1366332e-18
+ lub=-1.7439866e-25        uc=1.4110600e-10          luc=-3.0295123e-17
+ rdsw=4.9180000e+02+drdswp_lvt                       prwb=0.00
+ prwg=0.00                 wr=1.0000000              u0=1.2298000e-02
+ lu0=7.5174010e-11         a0=1.2272000              la0=-2.0046413e-08
+ keta=-1.0100800e-02       a1=0.00                   a2=0.9900000
+ ags=1.0000000             b0=0.00                   b1=0.00
+ voff=-0.1050914           lvoff=-4.2839180e-09      nfactor=1.8040001
+ lnfactor=-1.5034803e-07   cit=3.1800000e-03         lcit=-5.0116000e-10
+ cdsc=0.00                 cdscb=0.00                cdscd=0.00
+ eta0=8.7906560e-04        leta0=9.7352850e-10       etab=-2.0000001e-03
+ dsub=0.00                 pclm=1.9998400            lpclm=-2.3203708e-07+dlpclmp_lvt
+ wpclm=0+dwpclmp_lvt       pdiblc1=0.00              pdiblc2=1.0420458e-02
+ lpdiblc2=-1.7249177e-09   pdiblcb=0.00              drout=0.00
+ pscbe1=8.4920770e+08      pscbe2=1.0000000e-07      pvag=0.00
+ delta=3.9200000e-03       ldelta=3.0069600e-09      alpha0=0.00
+ alpha1=0.019              beta0=12.638              kt1=-0.2644000
+ pkt1=0+dpkt1p_lvt         lkt1=2.5058053e-09        kt2=-2.3280000e-02
+ lkt2=-2.0046405e-09       at=1.0000000e+04          ute=-1.5272000
+ lute=2.0046413e-08        ua1=5.9900000e-10         ub1=-1.8500000e-18
+ uc1=-1.4600000e-10        kt1l=0.00                 prt=0.00
+ cj=cjp_lvt                pb=0.826557               mj=0.385643
+ cjsw=cjswp_lvt            pbsw=0.826557             mjsw=0.158
+ cjswg=cjswgp_lvt          pbswg=0.826557            mjswg=0.7162
+ js=2e-7                   jsw=7.6e-12               n=1.0
+ xti=3.0                   cgdo=cgop_lvt             cgso=cgop_lvt
+ tcj=0.00090284            tcjsw=0.00029887          tpb=0.00165968
+ tpbsw=0.00165968          tcjswg=0.00029887         tpbswg=0.00165968
+ capmod=3                  nqsmod=0                  xpart=1
+ cf=0                      tlev=1                    tlevc=1
+ dlc=1.50e-8               cgdl=cglp_lvt             cgsl=cglp_lvt
+ wwc=-0.038                dwc=0                     noia=9.0e+18
+ noib=1.0e+3               noic=6.0e-12              em=4.1e+7
+ ef=1.128                  noimod=2                  sa0=0.35e-6
+ sb0=0.35e-6               kvsat=-0.6                wlod=0.3e-6
+ tku0=0.03                 ku0=1.14e-7               llodku0=1
+ wlodku0=1                 lku0=3e-8                 wku0=3.0e-7
+ pku0=0e-14                kvth0=-2.3e-9             stk2=0e-9
+ steta0=0                  lkvth0=1.0e-8             wkvth0=2.5e-7
+ pkvth0=4e-14              llodvth=1                 wlodvth=1
+ lodk2=1                   lodeta0=1                 minr=1e-3
+ imax=0.01                 imelt=0.01

     3: type=p
+ lmin=1.3e-07              lmax=2.2e-07-(dxl_lvt+dlmisp_lvt)
+ wmin=1.0005e-05-(dxw_lvt+dwmisp_lvt)                wmax=0.0009001
+ tnom=25.0                 version=3.24              tox=(toxp_lvt+toxmisp_lvt)
+ toxm=(toxp_lvt+toxmisp_lvt)                         xj=2.1000000e-07
+ nch=5.6487000e+17         lln=1.0000000             lwn=1.0000000
+ wln=1.0000000             wwn=-1                    lint=6.5000000e-09
+ ll=0.00                   lw=0.00                   lwl=0.00
+ wint=1.5000000e-09        wl=0.00                   ww=0.00
+ wwl=0.00                  mobmod=1                  binunit=2
+ xl=-2e-8+(dxl_lvt+dlmisp_lvt)                       xw=1.5e-8+(dxw_lvt+dwmisp_lvt)
+ dwg=0.00                  dwb=0.00                  ldif=8.00e-08
+ hdif=hdifp_lvt            rsh=rshp_lvt              rd=0
+ rs=0                      vth0=-0.1383345+(dvthp_lvt+vthmisp_lvt)
+ lvth0=-1.7044210e-08+dlvthp_lvt                     pvth0=0+dpvthp_lvt
+ wvth0=0+dwvthp_lvt        k1=0.3806000              lk1=3.6278010e-09
+ k2=-4.4486060e-02+dk2p_lvt                          lk2=1.2128940e-09+dlk2p_lvt
+ k3=0.00                   dvt0=0.00                 dvt1=0.00
+ dvt2=0.00                 dvt0w=0.00                dvt1w=0.00
+ dvt2w=0.00                nlx=0.00                  w0=0.00
+ k3b=0.00                  vsat=8.2000000e+04        pvsat=0+dpvsatp_lvt
+ lvsat=0+dlvsatp_lvt       ua=5.0000000e-11          ub=1.6351310e-18
+ lub=-8.0617770e-26        uc=-2.0900000e-11         rdsw=4.9180000e+02+drdswp_lvt
+ prwb=0.00                 prwg=0.00                 wr=1.0000000
+ u0=1.2700000e-02          a0=0.8721111              la0=4.6355230e-08
+ keta=-1.0100800e-02       a1=0.00                   a2=0.9900000
+ ags=1.0000000             b0=0.00                   b1=0.00
+ voff=-0.1257367           lvoff=-4.2324150e-10      nfactor=1.0000000
+ cit=-1.1729695e-03        lcit=3.1284533e-10        cdsc=0.00
+ cdscb=0.00                cdscd=0.00                eta0=6.9626600e-04
+ leta0=1.0077121e-09       etab=-9.2222240e-04       letab=-2.0154443e-10
+ dsub=0.00                 pclm=0.7590000            lpclm=0+dlpclmp_lvt
+ wpclm=0+dwpclmp_lvt       pdiblc1=0.00              pdiblc2=1.1963000e-03
+ pdiblcb=0.00              drout=0.00                pscbe1=8.4920770e+08
+ pscbe2=1.0000000e-07      pvag=0.00                 delta=2.0000000e-02
+ alpha0=0.00               alpha1=0.019              beta0=12.638
+ kt1=-0.2510000            kt2=-3.4000000e-02        at=1.0000000e+04
+ pkt1=0+dpkt1p_lvt         ute=-1.3876666            lute=-6.0463510e-09
+ ua1=5.9900000e-10         ub1=-1.8500000e-18        uc1=-1.4600000e-10
+ kt1l=0.00                 prt=0.00                  cj=cjp_lvt
+ pb=0.826557               mj=0.385643               cjsw=cjswp_lvt
+ pbsw=0.826557             mjsw=0.158                cjswg=cjswgp_lvt
+ pbswg=0.826557            mjswg=0.7162              js=2e-7
+ jsw=7.6e-12               n=1.0                     xti=3.0
+ cgdo=cgop_lvt             cgso=cgop_lvt             tcj=0.00090284
+ tcjsw=0.00029887          tpb=0.00165968            tpbsw=0.00165968
+ tcjswg=0.00029887         tpbswg=0.00165968         capmod=3
+ nqsmod=0                  xpart=1                   cf=0
+ tlev=1                    tlevc=1                   dlc=1.50e-8
+ cgdl=cglp_lvt             cgsl=cglp_lvt             wwc=-0.038
+ dwc=0                     noia=9.0e+18              noib=1.0e+3
+ noic=6.0e-12              em=4.1e+7                 ef=1.128
+ noimod=2                  sa0=0.35e-6               sb0=0.35e-6
+ kvsat=-0.6                wlod=0.3e-6               tku0=0.03
+ ku0=1.14e-7               llodku0=1                 wlodku0=1
+ lku0=3e-8                 wku0=3.0e-7               pku0=0e-14
+ kvth0=-2.3e-9             stk2=0e-9                 steta0=0
+ lkvth0=1.0e-8             wkvth0=2.5e-7             pkvth0=4e-14
+ llodvth=1                 wlodvth=1                 lodk2=1
+ lodeta0=1                 minr=1e-3                 imax=0.01
+ imelt=0.01

     4: type=p
+ lmin=0.77e-6-(dxl_lvt+dlmisp_lvt)                   lmax=0.000021
+ wmin=1.225e-06-(dxw_lvt+dwmisp_lvt)                 wmax=1.0005e-05-(dxw_lvt+dwmisp_lvt)
+ tnom=25.0                 version=3.24              tox=(toxp_lvt+toxmisp_lvt)
+ toxm=(toxp_lvt+toxmisp_lvt)                         xj=2.1000000e-07
+ nch=5.6487000e+17         lln=1.0000000             lwn=1.0000000
+ wln=1.0000000             wwn=-1                    lint=6.5000000e-09
+ ll=0.00                   lw=0.00                   lwl=0.00
+ wint=1.5000000e-09        wl=0.00                   ww=0.00
+ wwl=0.00                  mobmod=1                  binunit=2
+ xl=-2e-8+(dxl_lvt+dlmisp_lvt)                       xw=1.5e-8+(dxw_lvt+dwmisp_lvt)
+ dwg=0.00                  dwb=0.00                  ldif=8.00e-08
+ hdif=hdifp_lvt            rsh=rshp_lvt              rd=0
+ rs=0                      vth0=-7.8944260e-02+(dvthp_lvt+vthmisp_lvt)
+ lvth0=-5.4575240e-08+dlvthp_lvt                     wvth0=1.4140014e-08+dwvthp_lvt
+ pvth0=-2.7177312e-16+dpvthp_lvt                     k1=0.4000000
+ k2=-5.2709150e-02+dk2p_lvt                          lk2=2.7234852e-09+dlk2p_lvt
+ wk2=-5.3077840e-09        pk2=-3.3689510e-15        k3=0.00
+ dvt0=0.00                 dvt1=0.00                 dvt2=0.00
+ dvt0w=0.00                dvt1w=0.00                dvt2w=0.00
+ nlx=0.00                  w0=0.00                   k3b=0.00
+ vsat=8.2000000e+04        pvsat=0+dpvsatp_lvt       lvsat=0+dlvsatp_lvt
+ ua=1.9529187e-11          lua=1.6597665e-17         wua=1.2689468e-17
+ pua=1.4214717e-23         ub=2.0904659e-18          lub=-1.2272148e-25
+ wub=-2.8562923e-25        pub=3.3689620e-32         uc=9.9663240e-11
+ luc=3.3632340e-18         wuc=3.3733360e-18         puc=-3.3689530e-23
+ rdsw=4.9180000e+02+drdswp_lvt                       prwb=0.00
+ prwg=0.00                 wr=1.0000000              u0=1.0995552e-02
+ lu0=1.1700633e-09         wu0=-1.0728010e-09        pu0=-5.6149210e-16
+ a0=1.8173827              la0=-4.5501100e-07        wa0=3.0474476e-07
+ pa0=-2.2459688e-13        keta=-1.0100800e-02       a1=0.00
+ a2=0.9900000              ags=0.6744134             lags=2.5553248e-07
+ wags=1.6866698e-08        pags=-1.6844760e-13       b0=0.00
+ b1=0.00                   voff=-9.6821760e-02       lvoff=-1.0805789e-08
+ wvoff=-4.6259680e-10      pvoff=4.6199590e-15       nfactor=0.9521946
+ lnfactor=4.7743260e-07    cit=2.1584287e-04         lcit=1.8391757e-09
+ wcit=1.6866702e-10        pcit=-1.6844761e-15       cdsc=0.00
+ cdscb=0.00                cdscd=0.00                eta0=1.8323428e-03
+ leta0=2.3981295e-10       weta0=-6.4322280e-10      peta0=7.8608890e-16
+ etab=-1.1362595e-03       letab=-6.3657680e-10      dsub=0.00
+ pclm=1.6944573            lpclm=-9.4450830e-08+dlpclmp_lvt
+ wpclm=-9.4734520e-08+dwpclmp_lvt                    ppclm=9.4611420e-13
+ pdiblc1=0.00              pdiblc2=5.3471510e-02     lpdiblc2=-3.3870960e-08
+ wpdiblc2=-4.5202280e-10   ppdiblc2=4.5143960e-15    pdiblcb=0.00
+ drout=0.00                pscbe1=8.4920770e+08      pscbe2=1.0000000e-07
+ pvag=0.00                 delta=8.0000000e-03       alpha0=0.00
+ alpha1=0.019              beta0=12.638              kt1=-0.2795911
+ lkt1=1.2663274e-08        wkt1=-3.0075231e-08       pkt1=3.2566590e-14+dpkt1p_lvt
+ kt2=-1.0226484e-03        lkt2=-1.8615976e-08       wkt2=-2.3080746e-08
+ pkt2=1.9090732e-14        at=1.0000000e+04          ute=-1.7104738
+ lute=1.4681238e-07        wute=-5.4707240e-08       pute=1.2352828e-13
+ ua1=5.9900000e-10         ub1=-2.9836595e-18        lub1=8.3550710e-25
+ uc1=-1.4600000e-10        kt1l=0.00                 prt=0.00
+ cj=cjp_lvt                pb=0.826557               mj=0.385643
+ cjsw=cjswp_lvt            pbsw=0.826557             mjsw=0.158
+ cjswg=cjswgp_lvt          pbswg=0.826557            mjswg=0.7162
+ js=2e-7                   jsw=7.6e-12               n=1.0
+ xti=3.0                   cgdo=cgop_lvt             cgso=cgop_lvt
+ tcj=0.00090284            tcjsw=0.00029887          tpb=0.00165968
+ tpbsw=0.00165968          tcjswg=0.00029887         tpbswg=0.00165968
+ capmod=3                  nqsmod=0                  xpart=1
+ cf=0                      tlev=1                    tlevc=1
+ dlc=1.50e-8               cgdl=cglp_lvt             cgsl=cglp_lvt
+ wwc=-0.038                dwc=0                     noia=9.0e+18
+ noib=1.0e+3               noic=6.0e-12              em=4.1e+7
+ ef=1.128                  noimod=2                  sa0=0.35e-6
+ sb0=0.35e-6               kvsat=-0.6                wlod=0.3e-6
+ tku0=0.03                 ku0=1.14e-7               llodku0=1
+ wlodku0=1                 lku0=3e-8                 wku0=3.0e-7
+ pku0=0e-14                kvth0=-2.3e-9             stk2=0e-9
+ steta0=0                  lkvth0=1.0e-8             wkvth0=2.5e-7
+ pkvth0=4e-14              llodvth=1                 wlodvth=1
+ lodk2=1                   lodeta0=1                 minr=1e-3
+ imax=0.01                 imelt=0.01

     5: type=p
+ lmin=2.2e-07-(dxl_lvt+dlmisp_lvt)                   lmax=0.77e-6-(dxl_lvt+dlmisp_lvt)
+ wmin=1.225e-06-(dxw_lvt+dwmisp_lvt)                 wmax=1.0005e-05-(dxw_lvt+dwmisp_lvt)
+ tnom=25.0                 version=3.24              tox=(toxp_lvt+toxmisp_lvt)
+ toxm=(toxp_lvt+toxmisp_lvt)                         xj=2.1000000e-07
+ nch=5.6487000e+17         lln=1.0000000             lwn=1.0000000
+ wln=1.0000000             wwn=-1                    lint=6.5000000e-09
+ ll=0.00                   lw=0.00                   lwl=0.00
+ wint=1.5000000e-09        wl=0.00                   ww=0.00
+ wwl=0.00                  mobmod=1                  binunit=2
+ xl=-2e-8+(dxl_lvt+dlmisp_lvt)                       xw=1.5e-8+(dxw_lvt+dwmisp_lvt)
+ dwg=0.00                  dwb=0.00                  ldif=8.00e-08
+ hdif=hdifp_lvt            rsh=rshp_lvt              rd=0
+ rs=0                      vth0=-0.1272772+(dvthp_lvt+vthmisp_lvt)
+ lvth0=-1.8953843e-08+dlvthp_lvt                     wvth0=2.1332486e-08+dwvthp_lvt
+ pvth0=-5.5726290e-15+dpvthp_lvt                     k1=0.4008622
+ lk1=-6.3546860e-10        wk1=-8.6370280e-09        pk1=6.3654910e-15
+ k2=-5.3812310e-02+dk2p_lvt                          lk2=3.5365180e-09+dlk2p_lvt
+ wk2=-2.6814306e-09        pk2=-5.3045740e-15        k3=0.00
+ dvt0=0.00                 dvt1=0.00                 dvt2=0.00
+ dvt0w=0.00                dvt1w=0.00                dvt2w=0.00
+ nlx=0.00                  w0=0.00                   k3b=0.00
+ vsat=8.2000000e+04        pvsat=0+dpvsatp_lvt       lvsat=0+dlvsatp_lvt
+ ua=4.4136880e-11          lua=-1.5382091e-18        wua=-5.1346390e-18
+ pua=2.7351095e-23         ub=2.1876956e-18          lub=-1.9437991e-25
+ wub=-5.1149420e-25        pub=2.0015215e-31         uc=1.4698527e-10
+ luc=-3.1513103e-17        wuc=-5.8892660e-17        puc=1.2200521e-23
+ rdsw=4.9180000e+02+drdswp_lvt                       prwb=0.00
+ prwg=0.00                 wr=1.0000000              u0=1.2509896e-02
+ lu0=5.3991730e-11         wu0=-2.1225632e-09        pu0=2.1218294e-16
+ a0=1.2070812              la0=-5.2188100e-09        wa0=2.0153060e-07
+ pa0=-1.4852808e-13        keta=-1.0100800e-02       a1=0.00
+ a2=0.9900000              ags=1.0283185             lags=-5.2955690e-09
+ wags=-2.8366699e-07       pags=5.3045730e-14        b0=0.00
+ b1=0.00                   voff=-0.1054896           lvoff=-4.4175780e-09
+ wvoff=3.9893480e-09       pvoff=1.3388763e-15       nfactor=1.8040001
+ lnfactor=-1.5034803e-07   cit=3.4583960e-03         lcit=-5.5058540e-10
+ wcit=-2.7886871e-09       pcit=4.9509350e-16        cdsc=0.00
+ cdscb=0.00                cdscd=0.00                eta0=7.2254820e-04
+ leta0=1.0577316e-09       weta0=1.5678373e-09       peta0=-8.4346260e-16
+ etab=-1.9520981e-03       letab=-3.5303810e-11      wetab=-4.7983470e-10
+ petab=3.5363830e-16       dsub=0.00                 pclm=1.8452566
+ lpclm=-2.0558987e-07+dlpclmp_lvt                    wpclm=1.5484620e-06+dwpclmp_lvt
+ ppclm=-2.6492168e-13      pdiblc1=0.00              pdiblc2=9.8820470e-03
+ lpdiblc2=-1.7455245e-09   wpdiblc2=5.3932620e-09    ppdiblc2=2.0641862e-16
+ pdiblcb=0.00              drout=0.00                pscbe1=8.4920770e+08
+ pscbe2=1.0000000e-07      pvag=0.00                 delta=3.9200000e-03
+ ldelta=3.0069600e-09      alpha0=0.00               alpha1=0.019
+ beta0=12.638              kt1=-0.2662879            lkt1=2.8588438e-09
+ wkt1=1.8911173e-08        pkt1=-3.5363900e-15+dpkt1p_lvt
+ kt2=-2.3657581e-02        lkt2=-1.9340329e-09       wkt2=3.7822270e-09
+ pkt2=-7.0727660e-16       at=1.0000000e+04          ute=-1.5399082
+ lute=2.1105530e-08        wute=1.2729745e-07        pute=-1.0609180e-14
+ ua1=5.9900000e-10         ub1=-1.8500000e-18        uc1=-1.4600000e-10
+ kt1l=0.00                 prt=0.00                  cj=cjp_lvt
+ pb=0.826557               mj=0.385643               cjsw=cjswp_lvt
+ pbsw=0.826557             mjsw=0.158                cjswg=cjswgp_lvt
+ pbswg=0.826557            mjswg=0.7162              js=2e-7
+ jsw=7.6e-12               n=1.0                     xti=3.0
+ cgdo=cgop_lvt             cgso=cgop_lvt             tcj=0.00090284
+ tcjsw=0.00029887          tpb=0.00165968            tpbsw=0.00165968
+ tcjswg=0.00029887         tpbswg=0.00165968         capmod=3
+ nqsmod=0                  xpart=1                   cf=0
+ tlev=1                    tlevc=1                   dlc=1.50e-8
+ cgdl=cglp_lvt             cgsl=cglp_lvt             wwc=-0.038
+ dwc=0                     noia=9.0e+18              noib=1.0e+3
+ noic=6.0e-12              em=4.1e+7                 ef=1.128
+ noimod=2                  sa0=0.35e-6               sb0=0.35e-6
+ kvsat=-0.6                wlod=0.3e-6               tku0=0.03
+ ku0=1.14e-7               llodku0=1                 wlodku0=1
+ lku0=3e-8                 wku0=3.0e-7               pku0=0e-14
+ kvth0=-2.3e-9             stk2=0e-9                 steta0=0
+ lkvth0=1.0e-8             wkvth0=2.5e-7             pkvth0=4e-14
+ llodvth=1                 wlodvth=1                 lodk2=1
+ lodeta0=1                 minr=1e-3                 imax=0.01
+ imelt=0.01

     6: type=p
+ lmin=1.3e-07              lmax=2.2e-07-(dxl_lvt+dlmisp_lvt)
+ wmin=1.225e-06-(dxw_lvt+dwmisp_lvt)                 wmax=1.0005e-05-(dxw_lvt+dwmisp_lvt)
+ tnom=25.0                 version=3.24              tox=(toxp_lvt+toxmisp_lvt)
+ toxm=(toxp_lvt+toxmisp_lvt)                         xj=2.1000000e-07
+ nch=5.6487000e+17         lln=1.0000000             lwn=1.0000000
+ wln=1.0000000             wwn=-1                    lint=6.5000000e-09
+ ll=0.00                   lw=0.00                   lwl=0.00
+ wint=1.5000000e-09        wl=0.00                   ww=0.00
+ wwl=0.00                  mobmod=1                  binunit=2
+ xl=-2e-8+(dxl_lvt+dlmisp_lvt)                       xw=1.5e-8+(dxw_lvt+dwmisp_lvt)
+ dwg=0.00                  dwb=0.00                  ldif=8.00e-08
+ hdif=hdifp_lvt            rsh=rshp_lvt              rd=0
+ rs=0                      vth0=-0.1386663+(dvthp_lvt+vthmisp_lvt)
+ lvth0=-1.6824089e-08+dlvthp_lvt                     wvth0=3.3234910e-09+dwvthp_lvt
+ pvth0=-2.2049483e-15+dpvthp_lvt                     k1=0.3753308
+ lk1=4.1389170e-09         wk1=5.2781860e-08         pk1=-5.1198400e-15
+ k2=-3.9236070e-02+dk2p_lvt                          lk2=8.1076010e-10+dlk2p_lvt
+ wk2=-5.2589180e-08        pk2=4.0281750e-15         k3=0.00
+ dvt0=0.00                 dvt1=0.00                 dvt2=0.00
+ dvt0w=0.00                dvt1w=0.00                dvt2w=0.00
+ nlx=0.00                  w0=0.00                   k3b=0.00
+ vsat=8.2000000e+04        pvsat=0+dpvsatp_lvt       lvsat=0+dlvsatp_lvt
+ ua=1.9208057e-11          lua=3.1234811e-18         wua=3.0844287e-16
+ pua=-3.1287899e-23        ub=1.5869344e-18          lub=-8.2037550e-26
+ wub=4.8278590e-25         pub=1.4221777e-32         uc=-2.0705798e-11
+ luc=-1.5487336e-19        wuc=-1.9453185e-18        puc=1.5513661e-24
+ rdsw=4.9180000e+02+drdswp_lvt                       prwb=0.00
+ prwg=0.00                 wr=1.0000000              u0=1.2828992e-02
+ lu0=-5.6790550e-12        wu0=-1.2921042e-09        pu0=5.6887090e-17
+ a0=0.8113256              la0=6.8787490e-08         wa0=6.0888860e-07
+ pa0=-2.2470402e-13        keta=-1.0100800e-02       a1=0.00
+ a2=0.9900000              ags=1.0000000             b0=0.00
+ b1=0.00                   voff=-0.1265308           lvoff=-4.8287130e-10
+ wvoff=7.9549330e-09       pvoff=5.9731180e-16       nfactor=1.0000000
+ cit=-1.2123674e-03        lcit=3.2284730e-10        wcit=3.9464540e-10
+ pcit=-1.0018959e-16       cdsc=0.00                 cdscb=0.00
+ cdscd=0.00                eta0=1.3066463e-03        leta0=9.4850520e-10
+ weta0=-6.1141890e-09      peta0=5.9307630e-16       etab=-1.2149572e-03
+ letab=-1.7314916e-10      wetab=2.9323242e-09       petab=-2.8443544e-16
+ dsub=0.00                 pclm=0.7316679            lpclm=2.6512150e-09+dlpclmp_lvt
+ wpclm=2.7378573e-07+dwpclmp_lvt                     ppclm=-2.6557219e-14
+ pdiblc1=0.00              pdiblc2=5.4769220e-04     wpdiblc2=6.4971050e-09
+ pdiblcb=0.00              drout=0.00                pscbe1=8.4920770e+08
+ pscbe2=1.0000000e-07      pvag=0.00                 delta=2.0000000e-02
+ alpha0=0.00               alpha1=0.019              beta0=12.638
+ kt1=-0.2510000            kt2=-3.4000000e-02        pkt1=0+dpkt1p_lvt
+ at=1.0000000e+04          ute=-1.3901556            lute=-6.8982130e-09
+ wute=2.4932387e-08        pute=8.5330900e-15        ua1=5.9900000e-10
+ ub1=-1.8500000e-18        uc1=-1.4600000e-10        kt1l=0.00
+ prt=0.00                  cj=cjp_lvt                pb=0.826557
+ mj=0.385643               cjsw=cjswp_lvt            pbsw=0.826557
+ mjsw=0.158                cjswg=cjswgp_lvt          pbswg=0.826557
+ mjswg=0.7162              js=2e-7                   jsw=7.6e-12
+ n=1.0                     xti=3.0                   cgdo=cgop_lvt
+ cgso=cgop_lvt             tcj=0.00090284            tcjsw=0.00029887
+ tpb=0.00165968            tpbsw=0.00165968          tcjswg=0.00029887
+ tpbswg=0.00165968         capmod=3                  nqsmod=0
+ xpart=1                   cf=0                      tlev=1
+ tlevc=1                   dlc=1.50e-8               cgdl=cglp_lvt
+ cgsl=cglp_lvt             wwc=-0.038                dwc=0
+ noia=9.0e+18              noib=1.0e+3               noic=6.0e-12
+ em=4.1e+7                 ef=1.128                  noimod=2
+ sa0=0.35e-6               sb0=0.35e-6               kvsat=-0.6
+ wlod=0.3e-6               tku0=0.03                 ku0=1.14e-7
+ llodku0=1                 wlodku0=1                 lku0=3e-8
+ wku0=3.0e-7               pku0=0e-14                kvth0=-2.3e-9
+ stk2=0e-9                 steta0=0                  lkvth0=1.0e-8
+ wkvth0=2.5e-7             pkvth0=4e-14              llodvth=1
+ wlodvth=1                 lodk2=1                   lodeta0=1
+ minr=1e-3                 imax=0.01                 imelt=0.01

     7: type=p
+ lmin=0.77e-6-(dxl_lvt+dlmisp_lvt)                   lmax=0.000021
+ wmin=6.05e-07-(dxw_lvt+dwmisp_lvt)                  wmax=1.225e-06-(dxw_lvt+dwmisp_lvt)
+ tnom=25.0                 version=3.24              tox=(toxp_lvt+toxmisp_lvt)
+ toxm=(toxp_lvt+toxmisp_lvt)                         xj=2.1000000e-07
+ nch=5.6487000e+17         lln=1.0000000             lwn=1.0000000
+ wln=1.0000000             wwn=-1                    lint=6.5000000e-09
+ ll=0.00                   lw=0.00                   lwl=0.00
+ wint=1.5000000e-09        wl=0.00                   ww=0.00
+ wwl=0.00                  mobmod=1                  binunit=2
+ xl=-2e-8+(dxl_lvt+dlmisp_lvt)                       xw=1.5e-8+(dxw_lvt+dwmisp_lvt)
+ dwg=0.00                  dwb=0.00                  ldif=8.00e-08
+ hdif=hdifp_lvt            rsh=rshp_lvt              rd=0
+ rs=0                      vth0=-6.8158640e-02+(dvthp_lvt+vthmisp_lvt)
+ lvth0=-4.8350690e-08+dlvthp_lvt                     wvth0=7.9819180e-10+dwvthp_lvt
+ pvth0=-7.9715300e-15+dpvthp_lvt                     k1=0.3892555
+ lk1=7.9186990e-09         wk1=1.3290951e-08         pk1=-9.7954310e-15
+ k2=-5.7000000e-02+dk2p_lvt                          lk2=0+dlk2p_lvt
+ k3=0.00                   dvt0=0.00                 dvt1=0.00
+ dvt2=0.00                 dvt0w=0.00                dvt1w=0.00
+ dvt2w=0.00                nlx=0.00                  w0=0.00
+ k3b=0.00                  vsat=8.2000000e+04        pvsat=0+dpvsatp_lvt
+ lvsat=0+dlvsatp_lvt       ua=2.1280398e-11          lua=-1.3807166e-16
+ wua=1.0523253e-17         pua=2.0554064e-22         ub=1.6777778e-18
+ lub=2.2918049e-25         wub=2.2486591e-25         pub=-4.0161310e-31
+ uc=5.3920240e-11          luc=2.4685879e-17         wuc=5.9957430e-17
+ puc=-6.0065630e-23        rdsw=4.9180000e+02+drdswp_lvt
+ prwb=0.00                 prwg=0.00                 wr=1.0000000
+ u0=1.0799274e-02          lu0=8.2305080e-10         wu0=-8.3000470e-10
+ pu0=-1.3223761e-16        a0=2.3622890              la0=-6.3657650e-07
+ wa0=-3.6930440e-07        keta=-1.0100800e-02       a1=0.00
+ a2=0.9900000              ags=0.6999422             lags=5.7756780e-10
+ wags=-1.4712293e-08       pags=1.4693159e-13        b0=0.00
+ b1=0.00                   voff=-0.1011522           lvoff=-6.3553280e-09
+ wvoff=4.8942100e-09       pvoff=-8.8526080e-16      nfactor=0.9521946
+ lnfactor=4.7743260e-07    cit=3.5219460e-04         lcit=4.7743250e-10
+ cdsc=0.00                 cdscb=0.00                cdscd=0.00
+ eta0=7.7513080e-04        leta0=1.2712286e-09       weta0=6.6454840e-10
+ peta0=-4.8977210e-16      etab=-1.1362596e-03       letab=-6.3657670e-10
+ dsub=0.00                 pclm=1.6711960            lpclm=1.3786158e-07+dlpclmp_lvt
+ wpclm=-6.5960130e-08+dwpclmp_lvt                    ppclm=6.5874360e-13
+ pdiblc1=0.00              pdiblc2=5.4691890e-02     lpdiblc2=-4.6058900e-08
+ wpdiblc2=-1.9616404e-09   ppdiblc2=1.9590881e-14    pdiblcb=0.00
+ drout=0.00                pscbe1=8.4920770e+08      pscbe2=1.0000000e-07
+ pvag=0.00                 delta=8.3171610e-03       ldelta=-3.1674830e-09
+ wdelta=-3.9232770e-10     pdelta=3.9181760e-15      alpha0=0.00
+ alpha1=0.019              beta0=12.638              kt1=-0.3054106
+ lkt1=5.4035910e-08        wkt1=1.8635573e-09        pkt1=-1.8611360e-14+dpkt1p_lvt
+ kt2=-3.1229066e-02        lkt2=6.7946870e-09        wkt2=1.4284588e-08
+ pkt2=-1.2342255e-14       at=1.0000000e+04          ute=-1.8243608
+ lute=2.4667364e-07        wute=8.6171080e-08        ua1=5.9900000e-10
+ ub1=-2.9836595e-18        lub1=8.3550700e-25        uc1=-1.4600000e-10
+ kt1l=0.00                 prt=0.00                  cj=cjp_lvt
+ pb=0.826557               mj=0.385643               cjsw=cjswp_lvt
+ pbsw=0.826557             mjsw=0.158                cjswg=cjswgp_lvt
+ pbswg=0.826557            mjswg=0.7162              js=2e-7
+ jsw=7.6e-12               n=1.0                     xti=3.0
+ cgdo=cgop_lvt             cgso=cgop_lvt             tcj=0.00090284
+ tcjsw=0.00029887          tpb=0.00165968            tpbsw=0.00165968
+ tcjswg=0.00029887         tpbswg=0.00165968         capmod=3
+ nqsmod=0                  xpart=1                   cf=0
+ tlev=1                    tlevc=1                   dlc=1.50e-8
+ cgdl=cglp_lvt             cgsl=cglp_lvt             wwc=-0.038
+ dwc=0                     noia=9.0e+18              noib=1.0e+3
+ noic=6.0e-12              em=4.1e+7                 ef=1.128
+ noimod=2                  sa0=0.35e-6               sb0=0.35e-6
+ kvsat=-0.6                wlod=0.3e-6               tku0=0.03
+ ku0=1.14e-7               llodku0=1                 wlodku0=1
+ lku0=3e-8                 wku0=3.0e-7               pku0=0e-14
+ kvth0=-2.3e-9             stk2=0e-9                 steta0=0
+ lkvth0=1.0e-8             wkvth0=2.5e-7             pkvth0=4e-14
+ llodvth=1                 wlodvth=1                 lodk2=1
+ lodeta0=1                 minr=1e-3                 imax=0.01
+ imelt=0.01

     8: type=p
+ lmin=2.2e-07-(dxl_lvt+dlmisp_lvt)                   lmax=0.77e-6-(dxl_lvt+dlmisp_lvt)
+ wmin=6.05e-07-(dxw_lvt+dwmisp_lvt)                  wmax=1.225e-06-(dxw_lvt+dwmisp_lvt)
+ tnom=25.0                 version=3.24              tox=(toxp_lvt+toxmisp_lvt)
+ toxm=(toxp_lvt+toxmisp_lvt)                         xj=2.1000000e-07
+ nch=5.6487000e+17         lln=1.0000000             lwn=1.0000000
+ wln=1.0000000             wwn=-1                    lint=6.5000000e-09
+ ll=0.00                   lw=0.00                   lwl=0.00
+ wint=1.5000000e-09        wl=0.00                   ww=0.00
+ wwl=0.00                  mobmod=1                  binunit=2
+ xl=-2e-8+(dxl_lvt+dlmisp_lvt)                       xw=1.5e-8+(dxw_lvt+dwmisp_lvt)
+ dwg=0.00                  dwb=0.00                  ldif=8.00e-08
+ hdif=hdifp_lvt            rsh=rshp_lvt              rd=0
+ rs=0                      vth0=-0.0981809+(dvthp_lvt+vthmisp_lvt)
+ lvth0=-2.6224281e-08+dlvthp_lvt                     wvth0=-1.4659657e-08+dwvthp_lvt
+ pvth0=3.4209050e-15+dpvthp_lvt                      k1=0.4113195
+ lk1=-8.3424570e-09        wk1=-2.1572642e-08        pk1=1.5899034e-14
+ k2=-6.2747100e-02+dk2p_lvt                          lk2=4.2356110e-09+dlk2p_lvt
+ wk2=8.3708980e-09         pk2=-6.1693520e-15        k3=0.00
+ dvt0=0.00                 dvt1=0.00                 dvt2=0.00
+ dvt0w=0.00                dvt1w=0.00                dvt2w=0.00
+ nlx=0.00                  w0=0.00                   k3b=0.00
+ vsat=8.1323290e+04        lvsat=4.9873500e-04+dlvsatp_lvt
+ wvsat=8.3709000e-04       pvsat=-6.1693520e-10+dpvsatp_lvt
+ ua=-2.9010300e-10         lua=9.1417920e-17         wua=4.0832010e-16
+ pua=-8.7635650e-23        ub=2.0950704e-18          lub=-7.8364250e-26
+ wub=-3.9691690e-25        pub=5.6640810e-32         uc=1.2149447e-10
+ luc=-2.5116322e-17        wuc=-2.7360534e-17        puc=4.2877000e-24
+ rdsw=4.9180000e+02+drdswp_lvt                       prwb=0.00
+ prwg=0.00                 wr=1.0000000              u0=1.1312280e-02
+ lu0=4.4496550e-10         wu0=-6.4111180e-10        pu0=-2.7145159e-16
+ a0=1.6685487              la0=-1.2529006e-07        wa0=-3.6930460e-07
+ keta=-1.0100800e-02       a1=0.00                   a2=0.9900000
+ ags=0.5989726             lags=7.4992120e-08        wags=2.4743389e-07
+ pags=-4.6270140e-14       b0=0.00                   b1=0.00
+ voff=-0.1079569           lvoff=-1.3402794e-09      wvoff=7.0414030e-09
+ pvoff=-2.4677416e-15      nfactor=1.8040000         lnfactor=-1.5034800e-07
+ cit=1.2040001e-03         lcit=-1.5034801e-10       cdsc=0.00
+ cdscb=0.00                cdscd=0.00                eta0=1.9900000e-03
+ leta0=3.7587010e-10       etab=-2.6783552e-03       letab=4.9994750e-10
+ wetab=4.1854530e-10       petab=-3.0846764e-16      dsub=0.00
+ pclm=2.2568552            lpclm=-2.9376929e-07+dlpclmp_lvt
+ wpclm=1.0393143e-06+dwpclmp_lvt                     ppclm=-1.5584372e-13
+ pdiblc1=0.00              pdiblc2=-1.2428327e-02    lpdiblc2=3.4086960e-09
+ wpdiblc2=3.2991190e-08    ppdiblc2=-6.1693530e-15   pdiblcb=0.00
+ drout=0.00                pscbe1=8.4920770e+08      pscbe2=1.0000000e-07
+ pvag=0.00                 delta=-1.4140644e-03      ldelta=4.0044300e-09
+ wdelta=6.5982380e-09      pdelta=-1.2338704e-15     alpha0=0.00
+ alpha1=0.019              beta0=12.638              kt1=-0.2253248
+ lkt1=-4.9873530e-09       wkt1=-3.1760210e-08       pkt1=6.1693560e-15+dpkt1p_lvt
+ kt2=-1.8271321e-02        lkt2=-2.7551683e-09       wkt2=-2.8805751e-09
+ pkt2=3.0846825e-16        at=1.0000000e+04          ute=-1.4897434
+ lute=6.0595560e-11        wute=6.5243650e-08        pute=1.5423403e-14
+ ua1=5.9900000e-10         ub1=-1.8500000e-18        uc1=-1.4600000e-10
+ kt1l=0.00                 prt=0.00                  cj=cjp_lvt
+ pb=0.826557               mj=0.385643               cjsw=cjswp_lvt
+ pbsw=0.826557             mjsw=0.158                cjswg=cjswgp_lvt
+ pbswg=0.826557            mjswg=0.7162              js=2e-7
+ jsw=7.6e-12               n=1.0                     xti=3.0
+ cgdo=cgop_lvt             cgso=cgop_lvt             tcj=0.00090284
+ tcjsw=0.00029887          tpb=0.00165968            tpbsw=0.00165968
+ tcjswg=0.00029887         tpbswg=0.00165968         capmod=3
+ nqsmod=0                  xpart=1                   cf=0
+ tlev=1                    tlevc=1                   dlc=1.50e-8
+ cgdl=cglp_lvt             cgsl=cglp_lvt             wwc=-0.038
+ dwc=0                     noia=9.0e+18              noib=1.0e+3
+ noic=6.0e-12              em=4.1e+7                 ef=1.128
+ noimod=2                  sa0=0.35e-6               sb0=0.35e-6
+ kvsat=-0.6                wlod=0.3e-6               tku0=0.03
+ ku0=1.14e-7               llodku0=1                 wlodku0=1
+ lku0=3e-8                 wku0=3.0e-7               pku0=0e-14
+ kvth0=-2.3e-9             stk2=0e-9                 steta0=0
+ lkvth0=1.0e-8             wkvth0=2.5e-7             pkvth0=4e-14
+ llodvth=1                 wlodvth=1                 lodk2=1
+ lodeta0=1                 minr=1e-3                 imax=0.01
+ imelt=0.01

     9: type=p
+ lmin=1.3e-07              lmax=2.2e-07-(dxl_lvt+dlmisp_lvt)
+ wmin=6.05e-07-(dxw_lvt+dwmisp_lvt)                  wmax=1.225e-06-(dxw_lvt+dwmisp_lvt)
+ tnom=25.0                 version=3.24              tox=(toxp_lvt+toxmisp_lvt)
+ toxm=(toxp_lvt+toxmisp_lvt)                         xj=2.1000000e-07
+ nch=5.6487000e+17         lln=1.0000000             lwn=1.0000000
+ wln=1.0000000             wwn=-1                    lint=6.5000000e-09
+ ll=0.00                   lw=0.00                   lwl=0.00
+ wint=1.5000000e-09        wl=0.00                   ww=0.00
+ wwl=0.00                  mobmod=1                  binunit=2
+ xl=-2e-8+(dxl_lvt+dlmisp_lvt)                       xw=1.5e-8+(dxw_lvt+dwmisp_lvt)
+ dwg=0.00                  dwb=0.00                  ldif=8.00e-08
+ hdif=hdifp_lvt            rsh=rshp_lvt              rd=0
+ rs=0                      vth0=-0.1267759+(dvthp_lvt+vthmisp_lvt)
+ lvth0=-2.0877030e-08+dlvthp_lvt                     wvth0=-1.1384977e-08+dwvthp_lvt
+ pvth0=2.8085406e-15+dpvthp_lvt                      k1=0.3667074
+ wk1=6.3448920e-08         k2=-8.3110210e-02+dk2p_lvt
+ lk2=8.0435130e-09+dlk2p_lvt                         wk2=1.6831395e-09
+ pk2=-4.9187420e-15        k3=0.00                   dvt0=0.00
+ dvt1=0.00                 dvt2=0.00                 dvt0w=0.00
+ dvt1w=0.00                dvt2w=0.00                nlx=0.00
+ w0=0.00                   k3b=0.00                  vsat=8.5062880e+04
+ lvsat=-2.0056911e-04+dlvsatp_lvt                    wvsat=-3.7887880e-03
+ pvsat=2.4810404e-10+dpvsatp_lvt                     ua=3.8596240e-10
+ lua=-3.5006310e-17        wua=-1.4523230e-16        pua=1.5878659e-23
+ ub=2.1957547e-18          lub=-9.7192180e-26        wub=-2.7032473e-25
+ pub=3.2968080e-32         uc=-5.8224240e-11         luc=8.4910780e-18
+ wuc=4.4465000e-17         puc=-9.1436760e-24        rdsw=4.9180000e+02+drdswp_lvt
+ prwb=0.00                 prwg=0.00                 wr=1.0000000
+ u0=1.3905243e-02          lu0=-3.9918730e-11        wu0=-2.6234281e-09
+ pu0=9.9241610e-17         a0=2.0096772              la0=-1.8908115e-07
+ wa0=-8.7347290e-07        pa0=9.4279540e-14         keta=-1.0100800e-02
+ a1=0.00                   a2=0.9900000              ags=1.0000000
+ b0=0.00                   b1=0.00                   voff=-0.1151242
+ wvoff=-6.1550750e-09      nfactor=1.0000000         cit=-4.0827760e-04
+ lcit=1.5114789e-10        wcit=-6.0001390e-10       pcit=1.1220262e-16
+ cdsc=0.00                 cdscb=0.00                cdscd=0.00
+ eta0=-4.7998920e-03       leta0=1.6455801e-09       weta0=1.4396002e-09
+ peta0=-2.6920541e-16      etab=3.2232780e-03        letab=-6.0365800e-10
+ wetab=-2.5577738e-09      petab=2.4810405e-16       dsub=0.00
+ pclm=0.7143636            lpclm=-5.3233330e-09+dlpclmp_lvt
+ wpclm=2.9519123e-07+dwpclmp_lvt                     ppclm=-1.6692705e-14
+ pdiblc1=0.00              pdiblc2=5.8000000e-03     pdiblcb=0.00
+ drout=0.00                pscbe1=8.4920770e+08      pscbe2=1.0000000e-07
+ pvag=0.00                 delta=2.0000000e-02       alpha0=0.00
+ alpha1=0.019              beta0=12.638              kt1=-0.2090927
+ lkt1=-8.0227670e-09       wkt1=-5.1839390e-08       pkt1=9.9241650e-15+dpkt1p_lvt
+ kt2=-5.8746330e-02        lkt2=4.8136590e-09        wkt2=3.0611215e-08
+ pkt2=-5.9544980e-15       at=1.0000000e+04          ute=-1.2212789
+ lute=-5.0142300e-08       wute=-1.8396814e-07       pute=6.2026030e-14
+ ua1=5.9900000e-10         ub1=-1.8500000e-18        uc1=-1.4600000e-10
+ kt1l=0.00                 prt=0.00                  cj=cjp_lvt
+ pb=0.826557               mj=0.385643               cjsw=cjswp_lvt
+ pbsw=0.826557             mjsw=0.158                cjswg=cjswgp_lvt
+ pbswg=0.826557            mjswg=0.7162              js=2e-7
+ jsw=7.6e-12               n=1.0                     xti=3.0
+ cgdo=cgop_lvt             cgso=cgop_lvt             tcj=0.00090284
+ tcjsw=0.00029887          tpb=0.00165968            tpbsw=0.00165968
+ tcjswg=0.00029887         tpbswg=0.00165968         capmod=3
+ nqsmod=0                  xpart=1                   cf=0
+ tlev=1                    tlevc=1                   dlc=1.50e-8
+ cgdl=cglp_lvt             cgsl=cglp_lvt             wwc=-0.038
+ dwc=0                     noia=9.0e+18              noib=1.0e+3
+ noic=6.0e-12              em=4.1e+7                 ef=1.128
+ noimod=2                  sa0=0.35e-6               sb0=0.35e-6
+ kvsat=-0.6                wlod=0.3e-6               tku0=0.03
+ ku0=1.14e-7               llodku0=1                 wlodku0=1
+ lku0=3e-8                 wku0=3.0e-7               pku0=0e-14
+ kvth0=-2.3e-9             stk2=0e-9                 steta0=0
+ lkvth0=1.0e-8             wkvth0=2.5e-7             pkvth0=4e-14
+ llodvth=1                 wlodvth=1                 lodk2=1
+ lodeta0=1                 minr=1e-3                 imax=0.01
+ imelt=0.01

     10: type=p
+ lmin=0.77e-6-(dxl_lvt+dlmisp_lvt)                   lmax=0.000021
+ wmin=1.5e-07              wmax=6.05e-07-(dxw_lvt+dwmisp_lvt)
+ tnom=25.0                 version=3.24              tox=(toxp_lvt+toxmisp_lvt)
+ toxm=(toxp_lvt+toxmisp_lvt)                         xj=2.1000000e-07
+ nch=5.6487000e+17         lln=1.0000000             lwn=1.0000000
+ wln=1.0000000             wwn=-1                    lint=6.5000000e-09
+ ll=0.00                   lw=0.00                   lwl=0.00
+ wint=1.5000000e-09        wl=0.00                   ww=0.00
+ wwl=0.00                  mobmod=1                  binunit=2
+ xl=-2e-8+(dxl_lvt+dlmisp_lvt)                       xw=1.5e-8+(dxw_lvt+dwmisp_lvt)
+ dwg=0.00                  dwb=0.00                  ldif=8.00e-08
+ hdif=hdifp_lvt            rsh=rshp_lvt              rd=0
+ rs=0                      vth0=-7.9411450e-02+(dvthp_lvt+vthmisp_lvt)
+ lvth0=-5.6866440e-08+dlvthp_lvt                     wvth0=7.7411750e-09+dwvthp_lvt
+ pvth0=-2.7173177e-15+dpvthp_lvt                     k1=0.4449006
+ lk1=-8.7153630e-09        wk1=-2.1042098e-08        pk1=4.6778610e-16
+ k2=-5.9705750e-02+dk2p_lvt                          lk2=-1.4242210e-09+dlk2p_lvt
+ wk2=1.6694445e-09         pk2=8.7874410e-16         k3=0.00
+ dvt0=0.00                 dvt1=0.00                 dvt2=0.00
+ dvt0w=0.00                dvt1w=0.00                dvt2w=0.00
+ nlx=0.00                  w0=0.00                   k3b=0.00
+ vsat=8.2000000e+04        pvsat=0+dpvsatp_lvt       lvsat=0+dlvsatp_lvt
+ ua=2.1886071e-11          lua=2.5646225e-16         wua=1.0149576e-17
+ pua=-3.7886790e-23        ub=2.4859689e-18          lub=-5.8639720e-25
+ wub=-2.7378806e-25        pub=1.0159834e-31         uc=2.0107518e-10
+ luc=-9.5968920e-17        wuc=-3.0837171e-17        puc=1.4378374e-23
+ rdsw=4.9180000e+02+drdswp_lvt                       prwb=0.00
+ prwg=0.00                 wr=1.0000000              u0=9.1844170e-03
+ lu0=8.3023390e-10         wu0=1.6636185e-10         pu0=-1.3666956e-16
+ a0=1.3470465              la0=-3.8644590e-07        wa0=2.5710020e-07
+ pa0=-1.5433074e-13        keta=-1.0100800e-02       a1=0.00
+ a2=0.9900000              ags=0.6845393             lags=3.3219650e-07
+ wags=-5.2087190e-09       pags=-5.7677330e-14       b0=0.00
+ b1=0.00                   voff=-9.6655350e-02       lvoff=-5.4832790e-09
+ wvoff=2.1196280e-09       pvoff=-1.4233151e-15      nfactor=0.9521946
+ lnfactor=4.7743260e-07    cit=4.6751830e-04         lcit=3.9243910e-10
+ wcit=-7.1154670e-11       pcit=5.2440990e-17        cdsc=0.00
+ cdscb=0.00                cdscd=0.00                eta0=2.1581308e-03
+ leta0=6.2227940e-10       weta0=-1.8876251e-10      peta0=-8.9370550e-17
+ etab=-1.1823460e-03       letab=-8.8747400e-10      wetab=2.8435313e-11
+ petab=1.5480360e-16       dsub=0.00                 pclm=1.5176355
+ lpclm=1.6714699e-06+dlpclmp_lvt                     wpclm=2.8786721e-08+dwpclmp_lvt
+ ppclm=-2.8749285e-13      pdiblc1=0.00              pdiblc2=5.2066280e-02
+ lpdiblc2=-1.9836985e-08   wpdiblc2=-3.4164060e-10   ppdiblc2=3.4119620e-15
+ pdiblcb=0.00              drout=0.00                pscbe1=8.4920770e+08
+ pscbe2=1.0000000e-07      pvag=0.00                 delta=7.5581140e-03
+ ldelta=4.4131220e-09      wdelta=7.6004440e-11      pdelta=-7.5905690e-16
+ alpha0=0.00               alpha1=0.019              beta0=12.638
+ kt1=-0.3026983            lkt1=2.6947223e-08        wkt1=1.9001126e-10
+ pkt1=-1.8976407e-15+dpkt1p_lvt                      kt2=-7.5661730e-03
+ lkt2=-1.8314459e-08       wkt2=-3.1541847e-10       pkt2=3.1500869e-15
+ at=1.0000000e+04          ute=-1.6395046            lute=2.9312648e-07
+ wute=-2.7885187e-08       pute=-2.8661525e-14       ua1=5.9900000e-10
+ ub1=-3.0159952e-18        lub1=1.1584446e-24        wub1=1.9951186e-26
+ pub1=-1.9925248e-31       uc1=-1.4600000e-10        kt1l=0.00
+ prt=0.00                  cj=cjp_lvt                pb=0.826557
+ mj=0.385643               cjsw=cjswp_lvt            pbsw=0.826557
+ mjsw=0.158                cjswg=cjswgp_lvt          pbswg=0.826557
+ mjswg=0.7162              js=2e-7                   jsw=7.6e-12
+ n=1.0                     xti=3.0                   cgdo=cgop_lvt
+ cgso=cgop_lvt             tcj=0.00090284            tcjsw=0.00029887
+ tpb=0.00165968            tpbsw=0.00165968          tcjswg=0.00029887
+ tpbswg=0.00165968         capmod=3                  nqsmod=0
+ xpart=1                   cf=0                      tlev=1
+ tlevc=1                   dlc=1.50e-8               cgdl=cglp_lvt
+ cgsl=cglp_lvt             wwc=-0.038                dwc=0
+ noia=9.0e+18              noib=1.0e+3               noic=6.0e-12
+ em=4.1e+7                 ef=1.128                  noimod=2
+ sa0=0.35e-6               sb0=0.35e-6               kvsat=-0.6
+ wlod=0.3e-6               tku0=0.03                 ku0=1.14e-7
+ llodku0=1                 wlodku0=1                 lku0=3e-8
+ wku0=3.0e-7               pku0=0e-14                kvth0=-2.3e-9
+ stk2=0e-9                 steta0=0                  lkvth0=1.0e-8
+ wkvth0=2.5e-7             pkvth0=4e-14              llodvth=1
+ wlodvth=1                 lodk2=1                   lodeta0=1
+ minr=1e-3                 imax=0.01                 imelt=0.01

     11: type=p
+ lmin=2.2e-07-(dxl_lvt+dlmisp_lvt)                   lmax=0.77e-6-(dxl_lvt+dlmisp_lvt)
+ wmin=1.5e-07              wmax=6.05e-07-(dxw_lvt+dwmisp_lvt)
+ tnom=25.0                 version=3.24              tox=(toxp_lvt+toxmisp_lvt)
+ toxm=(toxp_lvt+toxmisp_lvt)                         xj=2.1000000e-07
+ nch=5.6487000e+17         lln=1.0000000             lwn=1.0000000
+ wln=1.0000000             wwn=-1                    lint=6.5000000e-09
+ ll=0.00                   lw=0.00                   lwl=0.00
+ wint=1.5000000e-09        wl=0.00                   ww=0.00
+ wwl=0.00                  mobmod=1                  binunit=2
+ xl=-2e-8+(dxl_lvt+dlmisp_lvt)                       xw=1.5e-8+(dxw_lvt+dwmisp_lvt)
+ dwg=0.00                  dwb=0.00                  ldif=8.00e-08
+ hdif=hdifp_lvt            rsh=rshp_lvt              rd=0
+ rs=0                      vth0=-0.1239738+(dvthp_lvt+vthmisp_lvt)
+ lvth0=-2.4024020e-08+dlvthp_lvt                     wvth0=1.2545246e-09+dwvthp_lvt
+ pvth0=2.0633430e-15+dpvthp_lvt                      k1=0.4002920
+ lk1=2.4161210e-08         wk1=-1.4768675e-08        pk1=-4.1557270e-15
+ k2=-5.0795640e-02+dk2p_lvt                          lk2=-7.9909680e-09+dlk2p_lvt
+ wk2=9.9685030e-10         pk2=1.3744462e-15         k3=0.00
+ dvt0=0.00                 dvt1=0.00                 dvt2=0.00
+ dvt0w=0.00                dvt1w=0.00                dvt2w=0.00
+ nlx=0.00                  w0=0.00                   k3b=0.00
+ vsat=8.2680000e+04        pvsat=0+dpvsatp_lvt       lvsat=-5.0116000e-04+dlvsatp_lvt
+ ua=4.8388580e-10          lua=-8.4031580e-17        wua=-6.9230990e-17
+ pua=2.0616695e-23         ub=1.5762176e-18          lub=8.4089640e-26
+ wub=-7.6784530e-26        pub=-4.3593250e-32        uc=9.2224160e-11
+ luc=-1.5745715e-17        wuc=-9.3007550e-18        puc=-1.4939636e-24
+ rdsw=4.9180000e+02+drdswp_lvt                       prwb=0.00
+ prwg=0.00                 wr=1.0000000              u0=1.0104370e-02
+ lu0=1.5222865e-10         wu0=1.0416835e-10         pu0=-9.0832970e-17
+ a0=0.9795550              la0=-1.1560466e-07        wa0=5.5804530e-08
+ pa0=-5.9758570e-15        keta=-1.0100800e-02       a1=0.00
+ a2=0.9900000              ags=1.1352810             wags=-8.3468310e-08
+ b0=0.00                   b1=0.00                   voff=-9.3129580e-02
+ lvoff=-8.0817790e-09      wvoff=-2.1070736e-09      pvoff=1.6917642e-15
+ nfactor=1.8040001         cit=1.1645755e-03         lcit=-1.2129202e-10
+ wcit=2.4325035e-11        pcit=-1.7927560e-17       cdsc=0.00
+ lnfactor=-1.5034803e-07   cdscb=0.00                cdscd=0.00
+ eta0=2.4661885e-03        leta0=3.9524080e-10       weta0=-2.9380839e-10
+ peta0=-1.1951729e-17      etab=-2.3076676e-03       letab=-5.8112020e-11
+ wetab=1.8983082e-10       petab=3.5855120e-17       dsub=0.00
+ pclm=4.7234050            lpclm=-6.9118220e-07+dlpclmp_lvt
+ wpclm=-4.8254690e-07+dwpclmp_lvt                    ppclm=8.9359980e-14
+ pdiblc1=0.00              pdiblc2=3.4252760e-02     lpdiblc2=-6.7084160e-09
+ wpdiblc2=4.1889650e-09    ppdiblc2=7.2905360e-17    pdiblcb=0.00
+ drout=0.00                pscbe1=8.4920770e+08      pscbe2=1.0000000e-07
+ pvag=0.00                 delta=9.7747420e-03       ldelta=2.7794669e-09
+ wdelta=-3.0525565e-10     pdelta=-4.7806830e-16     alpha0=0.00
+ alpha1=0.019              beta0=12.638              kt1=-0.2703065
+ lkt1=3.0745364e-09        wkt1=-4.0064760e-09       pkt1=1.1951705e-15+dpkt1p_lvt
+ kt2=-2.8173441e-02        lkt2=-3.1269001e-09       wkt2=3.2290320e-09
+ pkt2=5.3782680e-16        at=1.0000000e+04          ute=-1.2494922
+ lute=5.6873370e-09        wute=-8.2991330e-08       pute=1.1951703e-14
+ ua1=5.9900000e-10         ub1=-1.4441572e-18        wub1=-2.5040496e-25
+ uc1=-1.4600000e-10        kt1l=0.00                 prt=0.00
+ cj=cjp_lvt                pb=0.826557               mj=0.385643
+ cjsw=cjswp_lvt            pbsw=0.826557             mjsw=0.158
+ cjswg=cjswgp_lvt          pbswg=0.826557            mjswg=0.7162
+ js=2e-7                   jsw=7.6e-12               n=1.0
+ xti=3.0                   cgdo=cgop_lvt             cgso=cgop_lvt
+ tcj=0.00090284            tcjsw=0.00029887          tpb=0.00165968
+ tpbsw=0.00165968          tcjswg=0.00029887         tpbswg=0.00165968
+ capmod=3                  nqsmod=0                  xpart=1
+ cf=0                      tlev=1                    tlevc=1
+ dlc=1.50e-8               cgdl=cglp_lvt             cgsl=cglp_lvt
+ wwc=-0.038                dwc=0                     noia=9.0e+18
+ noib=1.0e+3               noic=6.0e-12              em=4.1e+7
+ ef=1.128                  noimod=2                  sa0=0.35e-6
+ sb0=0.35e-6               kvsat=-0.6                wlod=0.3e-6
+ tku0=0.03                 ku0=1.14e-7               llodku0=1
+ wlodku0=1                 lku0=3e-8                 wku0=3.0e-7
+ pku0=0e-14                kvth0=-2.3e-9             stk2=0e-9
+ steta0=0                  lkvth0=1.0e-8             wkvth0=2.5e-7
+ pkvth0=4e-14              llodvth=1                 wlodvth=1
+ lodk2=1                   lodeta0=1                 minr=1e-3
+ imax=0.01                 imelt=0.01

     12: type=p
+ lmin=1.3e-07              lmax=2.2e-07-(dxl_lvt+dlmisp_lvt)
+ wmin=1.5e-07              wmax=6.05e-07-(dxw_lvt+dwmisp_lvt)
+ tnom=25.0                 version=3.24              tox=(toxp_lvt+toxmisp_lvt)
+ toxm=(toxp_lvt+toxmisp_lvt)                         xj=2.1000000e-07
+ nch=5.6487000e+17         lln=1.0000000             lwn=1.0000000
+ wln=1.0000000             wwn=-1                    lint=6.5000000e-09
+ ll=0.00                   lw=0.00                   lwl=0.00
+ wint=1.5000000e-09        wl=0.00                   ww=0.00
+ wwl=0.00                  mobmod=1                  binunit=2
+ xl=-2e-8+(dxl_lvt+dlmisp_lvt)                       xw=1.5e-8+(dxw_lvt+dwmisp_lvt)
+ dwg=0.00                  dwb=0.00                  ldif=8.00e-08
+ hdif=hdifp_lvt            rsh=rshp_lvt              rd=0
+ rs=0                      vth0=-0.1712064+(dvthp_lvt+vthmisp_lvt)
+ lvth0=-1.5191514e-08+dlvthp_lvt                     wvth0=1.6028670e-08+dwvthp_lvt
+ pvth0=-6.9942230e-16+dpvthp_lvt                     k1=0.5268623
+ lk1=4.9256800e-10         wk1=-3.5366610e-08        pk1=-3.0391452e-16
+ k2=-8.9134190e-02+dk2p_lvt                          lk2=-8.2165990e-10+dlk2p_lvt
+ wk2=5.3999290e-09         pk2=5.5107050e-16         k3=0.00
+ dvt0=0.00                 dvt1=0.00                 dvt2=0.00
+ dvt0w=0.00                dvt1w=0.00                dvt2w=0.00
+ nlx=0.00                  w0=0.00                   k3b=0.00
+ vsat=7.8922220e+04        pvsat=0+dpvsatp_lvt       lvsat=2.0154443e-04+dlvsatp_lvt
+ ua=8.1096620e-12          lua=4.9385660e-18         wua=8.7902840e-17
+ pua=-8.7673310e-24        ub=2.2785850e-18          lub=-4.7253070e-26
+ wub=-3.2143110e-25        pub=2.1556502e-33         uc=2.7583371e-11
+ luc=-3.6578880e-18        wuc=-8.4782890e-18        puc=-1.6477646e-24
+ rdsw=4.9180000e+02+drdswp_lvt                       prwb=0.00
+ prwg=0.00                 wr=1.0000000              u0=1.0052684e-02
+ lu0=1.6189390e-10         wu0=-2.4639940e-10        pu0=-2.5276788e-17
+ a0=0.4616632              la0=-1.8758881e-08        wa0=8.1651860e-08
+ pa0=-1.0809303e-14        keta=-1.0100800e-02       a1=0.00
+ a2=0.9900000              ags=1.2160496             lags=-1.5103737e-08
+ wags=-1.3330258e-07       pags=9.3190070e-15        b0=0.00
+ b1=0.00                   voff=-0.1397555           lvoff=6.3727450e-10
+ wvoff=9.0424600e-09       pvoff=-3.9319850e-16      nfactor=1.0000000
+ cit=-1.3792482e-03        lcit=3.5440300e-10        wcit=-9.2503000e-13
+ pcit=-1.3205793e-17       cdsc=0.00                 cdscb=0.00
+ cdscd=0.00                eta0=-1.4571233e-03       leta0=1.1289002e-09
+ weta0=-6.2288740e-10      peta0=4.9586040e-17       etab=-1.0799189e-03
+ letab=-2.8770106e-10      wetab=9.7298590e-11       petab=5.3158650e-17
+ dsub=0.00                 pclm=1.1222085            lpclm=-1.7758342e-08+dlpclmp_lvt
+ wpclm=4.3550970e-08+dwpclmp_lvt                     ppclm=-9.0203080e-15
+ pdiblc1=0.00              pdiblc2=-6.7145890e-03    lpdiblc2=9.5247780e-10
+ wpdiblc2=7.7215020e-09    ppdiblc2=-5.8767890e-16   pdiblcb=0.00
+ drout=0.00                pscbe1=8.4920770e+08      pscbe2=1.0000000e-07
+ pvag=0.00                 delta=2.4434425e-02       ldelta=3.8106170e-11
+ wdelta=-2.7360403e-09     pdelta=-2.3511514e-17     alpha0=0.00
+ alpha1=0.019              beta0=12.638              kt1=-0.3106804
+ lkt1=1.0624451e-08        wkt1=1.0840258e-08        pkt1=-1.5811686e-15+dpkt1p_lvt
+ kt2=-8.1879950e-03        lkt2=-6.8641790e-09       wkt2=-5.8327800e-10
+ pkt2=1.2507287e-15        at=1.0000000e+04          ute=-1.6242852
+ lute=7.5773640e-08        wute=6.4686840e-08        pute=-1.5664114e-14
+ ua1=5.9900000e-10         ub1=-1.4619876e-18        lub1=3.3342900e-27
+ wub1=-2.3940361e-25       pub1=-2.0572578e-33       uc1=-1.4600000e-10
+ kt1l=0.00                 prt=0.00                  cj=cjp_lvt
+ pb=0.826557               mj=0.385643               cjsw=cjswp_lvt
+ pbsw=0.826557             mjsw=0.158                cjswg=cjswgp_lvt
+ pbswg=0.826557            mjswg=0.7162              js=2e-7
+ jsw=7.6e-12               n=1.0                     xti=3.0
+ cgdo=cgop_lvt             cgso=cgop_lvt             tcj=0.00090284
+ tcjsw=0.00029887          tpb=0.00165968            tpbsw=0.00165968
+ tcjswg=0.00029887         tpbswg=0.00165968         capmod=3
+ nqsmod=0                  xpart=1                   cf=0
+ tlev=1                    tlevc=1                   dlc=1.50e-8
+ cgdl=cglp_lvt             cgsl=cglp_lvt             wwc=-0.038
+ dwc=0                     noia=9.0e+18              noib=1.0e+3
+ noic=6.0e-12              em=4.1e+7                 ef=1.128
+ noimod=2                  sa0=0.35e-6               sb0=0.35e-6
+ kvsat=-0.6                wlod=0.3e-6               tku0=0.03
+ ku0=1.14e-7               llodku0=1                 wlodku0=1
+ lku0=3e-8                 wku0=3.0e-7               pku0=0e-14
+ kvth0=-2.3e-9             stk2=0e-9                 steta0=0
+ lkvth0=1.0e-8             wkvth0=2.5e-7             pkvth0=4e-14
+ llodvth=1                 wlodvth=1                 lodk2=1
+ lodeta0=1                 minr=1e-3                 imax=0.01
+ imelt=0.01
//
     }
ends pch_lvt_mis

endsection mos_lvt
//
//
//  *************************************************************
//                                                              *
//                    2.5V LOW Vt DEVICE MODEL                  *
//                                                              *
//  *************************************************************
//
section mos_lvt25
//
//  ********************************
//        Mismatch   model         *
//  ********************************
inline subckt nch_lvt25_mis ( d g s b )
parameters l=1u w=1u factor=1 multi=1 sa=0.35u sb=0.35u ad=2 * hdifn_lvt25 / factor
+ * w as=2 * hdifn_lvt25 / factor * w pd=2 * (2 * hdifn_lvt25 / factor + w) ps=2 *
+ (2 * hdifn_lvt25 / factor + w) nrd=hdifn_lvt25 / factor / w nrs=hdifn_lvt25 / factor
+ / w temp1=parn1_lvt25 temp2=parn2_lvt25 fac1=0.484 * temp1 + 0.875 * temp2 fac2=0.484
+ * temp1 - 0.875 * temp2 lef=l - 4.0e-8 wef=w + 1.0e-8 geo_fac=1 / sqrt(multi *
+ lef * wef * 1e12) vthmis=0.005731 * geo_fac * fac1 dlmis=0.001943 * geo_fac *
+ lef * fac2 dwmis= - 0.001943 * geo_fac * wef * fac2 toxmis=0.001943 * geo_fac
+ * toxn_lvt25 * fac2
nch_lvt25_mis ( d g s b ) nch_lvt25 w=w l=l ad=ad as=as pd=pd ps=ps nrd=nrd nrs=nrs m=multi
+ sa=sa sb=sb
model nch_lvt25 bsim3v3  {
     1: type=n
+ lmin=1.205e-06-(dxl_lvt25+dlmis)                    lmax=21e-06
+ wmin=10e-06-(dxw_lvt25+dwmis)                       wmax=0.0009001
+ tnom=25                   version=3.24              tox=(toxn_lvt25+toxmis)
+ toxm=(toxn_lvt25+toxmis)  xj=1.9e-07                nch=3.28e+17
+ lln=1                     lwn=1                     wln=1
+ wwn=-1                    lint=3.5e-08              wint=1.5e-08
+ mobmod=1                  binunit=2                 xl=-4e-08+(dxl_lvt25+dlmis)
+ xw=1e-8+(dxw_lvt25+dwmis) dwg=0                     dwb=0
+ ldif=8e-08                hdif=hdifn_lvt25          rsh=6.6
+ rd=0                      rs=0                      vth0=(dvthn_lvt25+vthmis)+0.3427561
+ lvth0=1.391781e-08        k1=0.4536357              lk1=4.307491e-08
+ k2=-0.005712273           lk2=-2.659506e-08         k3=0
+ dvt0=0                    dvt1=0                    dvt2=0
+ dvt0w=0                   dvt1w=0                   dvt2w=0
+ nlx=0                     w0=0                      k3b=0
+ vfb=-0.9637643            vsat=100008.2             lvsat=-8.965059e-06
+ ua=-1.49896e-09           lua=6.823603e-16          ub=2.447586e-18
+ lub=-4.206343e-25         uc=5.75241e-11            luc=-1.129423e-17
+ rdsw=367                  prwb=0                    prwg=0
+ wr=1                      u0=0.02688027             lu0=6.13222e-09
+ a0=1.281963               la0=-9.705163e-07         keta=-0.02013726
+ lketa=-1.73535e-08        a1=0                      a2=0.99
+ ags=0.3414737             lags=-2.85903e-07         b0=0
+ b1=0                      voff=-0.09921951          lvoff=1.735437e-08
+ nfactor=0.3624902         lnfactor=2.437751e-07     cit=1.647012e-05
+ lcit=6.119943e-11         cdsc=0                    cdscb=0
+ cdscd=0                   eta0=3.854855e-05         leta0=3.170184e-11
+ etab=-4.095684e-05        letab=1.473524e-11        dsub=0
+ pclm=0.7335739            lpclm=-3.816884e-07       pdiblc1=1e-06
+ pdiblc2=2.565179e-06      lpdiblc2=7.388441e-09     pdiblcb=0.1159362
+ lpdiblcb=-1.105321e-07    drout=0                   pscbe1=1.812124e+08
+ lpscbe1=184.8224          pscbe2=1e-06              pvag=0
+ delta=0.01                alpha0=0                  alpha1=3.8824
+ beta0=18.9788             kt1=-0.2922067            lkt1=7.766363e-09
+ kt2=-0.02949182           lkt2=1.700352e-09         at=11984.76
+ lat=-0.002173308          ute=-1.622338             lute=2.287255e-07
+ ua1=1.055804e-09          lua1=7.5248e-16           ub1=-1.37869e-18
+ lub1=-7.649806e-25        uc1=-3.5125e-11           luc1=-1.825632e-17
+ kt1l=0                    prt=0                     cj=cjn_lvt25
+ mj=0.2904575              pb=0.6842167              cjsw=cjswn_lvt25
+ mjsw=0.2                  pbsw=0.6842167            cjswg=cjswgn_lvt25
+ mjswg=0.2                 pbswg=0.6842167           tpb=1.89277e-3
+ tpbsw=1.89277e-3          tpbswg=1.89277e-3         tcj=1.042239e-3
+ tcjsw=7.570649e-4         tcjswg=7.570649e-4        js=3.03e-7
+ jsw=5.31e-12              n=1                       xti=3
+ cgdo=cgon_lvt25           cgso=cgon_lvt25           capmod=3
+ nqsmod=0                  xpart=1                   cf=0
+ tlev=1                    tlevc=1                   dlc=3.0e-08
+ cgdl=cgln_lvt25           cgsl=cgln_lvt25           wwc=-0.018
+ dwc=0                     noia=2.5e+19              noib=3.0e+4
+ noic=1.0e-13              em=4.1e+7                 ef=0.888
+ noimod=2                  sa0=0.35e-6               sb0=0.35e-6
+ kvsat=0.35                wlod=0.3e-6               tku0=0.03
+ ku0=-5.95e-8              llodku0=1                 wlodku0=1
+ lku0=1.0e-7               wku0=2.5e-7               pku0=0
+ kvth0=7.2e-9              stk2=0                    steta0=-1.1e-10
+ lkvth0=-5.5e-08           wkvth0=3.5e-06            pkvth0=0
+ llodvth=1.0               wlodvth=1                 lodk2=1
+ lodeta0=2                 minr=1e-3                 imax=0.01
+ imelt=0.01

     2: type=n
+ lmin=5.05e-07-(dxl_lvt25+dlmis)                     lmax=1.205e-06-(dxl_lvt25+dlmis)
+ wmin=10e-06-(dxw_lvt25+dwmis)                       wmax=0.0009001
+ tnom=25                   version=3.24              tox=(toxn_lvt25+toxmis)
+ toxm=(toxn_lvt25+toxmis)  xj=1.9e-07                nch=3.28e+17
+ lln=1                     lwn=1                     wln=1
+ wwn=-1                    lint=3.5e-08              wint=1.5e-08
+ mobmod=1                  binunit=2                 xl=-4e-08+(dxl_lvt25+dlmis)
+ xw=1e-8+(dxw_lvt25+dwmis) dwg=0                     dwb=0
+ ldif=8e-08                hdif=hdifn_lvt25          rsh=6.6
+ rd=0                      rs=0                      vth0=(dvthn_lvt25+vthmis)+0.3467384
+ lvth0=9.557144e-09        k1=0.4801617              lk1=1.402894e-08
+ k2=-0.006043235           lk2=-2.623265e-08         k3=0
+ dvt0=0                    dvt1=0                    dvt2=0
+ dvt0w=0                   dvt1w=0                   dvt2w=0
+ nlx=0                     w0=0                      k3b=0
+ vfb=-0.9852535            vsat=111844.1             lvsat=-0.01296932
+ ua=-8.081139e-10          lua=-7.411622e-17         ub=2.068229e-18
+ lub=-5.237973e-27         uc=4.482829e-11           luc=2.607675e-18
+ rdsw=367                  prwb=0                    prwg=0
+ wr=1                      u0=0.03212956             lu0=3.842484e-10
+ a0=0.5237088              la0=-1.402283e-07         keta=-0.04800742
+ lketa=1.316433e-08        a1=0                      a2=0.99
+ ags=0.1404009             lags=-6.572836e-08        b0=0
+ b1=0                      voff=-0.09034456          lvoff=7.636308e-09
+ nfactor=0.5751529         lnfactor=1.090946e-08     cit=3.249885e-05
+ lcit=4.364795e-11         cdsc=0                    cdscb=0
+ cdscd=0                   eta0=-0.0007126252        leta0=8.54237e-10
+ etab=0.000521268          letab=-6.009009e-10       dsub=0
+ pclm=-0.01054389          lpclm=4.331205e-07        pdiblc1=1e-06
+ pdiblc2=0.007032143       lpdiblc2=-3.089465e-10    pdiblcb=0.0200686
+ lpdiblcb=-5.557099e-09    drout=0                   pscbe1=3.6975e+08
+ lpscbe1=-21.62625         pscbe2=1e-06              pvag=0
+ delta=0.01                alpha0=0                  alpha1=3.8824
+ beta0=18.9788             kt1=-0.2923966            lkt1=7.974351e-09
+ kt2=-0.02880714           lkt2=9.506238e-10         at=6219.285
+ lat=0.004139883           ute=-1.443621             lute=3.303035e-08
+ ua1=1.695346e-09          lua1=5.218113e-17         ub1=-2.120923e-18
+ lub1=4.776467e-26         uc1=-6.30817e-11          luc1=1.235627e-17
+ kt1l=0                    prt=0                     cj=cjn_lvt25
+ mj=0.2904575              pb=0.6842167              cjsw=cjswn_lvt25
+ mjsw=0.2                  pbsw=0.6842167            cjswg=cjswgn_lvt25
+ mjswg=0.2                 pbswg=0.6842167           tpb=1.89277e-3
+ tpbsw=1.89277e-3          tpbswg=1.89277e-3         tcj=1.042239e-3
+ tcjsw=7.570649e-4         tcjswg=7.570649e-4        js=3.03e-7
+ jsw=5.31e-12              n=1                       xti=3
+ cgdo=cgon_lvt25           cgso=cgon_lvt25           capmod=3
+ nqsmod=0                  xpart=1                   cf=0
+ tlev=1                    tlevc=1                   dlc=3.0e-08
+ cgdl=cgln_lvt25           cgsl=cgln_lvt25           wwc=-0.018
+ dwc=0                     noia=2.5e+19              noib=3.0e+4
+ noic=1.0e-13              em=4.1e+7                 ef=0.888
+ noimod=2                  sa0=0.35e-6               sb0=0.35e-6
+ kvsat=0.35                wlod=0.3e-6               tku0=0.03
+ ku0=-5.95e-8              llodku0=1                 wlodku0=1
+ lku0=1.0e-7               wku0=2.5e-7               pku0=0
+ kvth0=7.2e-9              stk2=0                    steta0=-1.1e-10
+ lkvth0=-5.5e-08           wkvth0=3.5e-06            pkvth0=0
+ llodvth=1.0               wlodvth=1                 lodk2=1
+ lodeta0=2                 minr=1e-3                 imax=0.01
+ imelt=0.01

     3: type=n
+ lmin=3.7e-07              lmax=5.05e-07-(dxl_lvt25+dlmis)
+ wmin=10e-06-(dxw_lvt25+dwmis)                       wmax=0.0009001
+ tnom=25                   version=3.24              tox=(toxn_lvt25+toxmis)
+ toxm=(toxn_lvt25+toxmis)  xj=1.9e-07                nch=3.28e+17
+ lln=1                     lwn=1                     wln=1
+ wwn=-1                    lint=3.5e-08              wint=1.5e-08
+ mobmod=1                  binunit=2                 xl=-4e-08+(dxl_lvt25+dlmis)
+ xw=1e-8+(dxw_lvt25+dwmis) dwg=0                     dwb=0
+ ldif=8e-08                hdif=hdifn_lvt25          rsh=6.6
+ rd=0                      rs=0                      vth0=(dvthn_lvt25+vthmis)+0.4024139
+ lvth0=-1.243468e-08       k1=0.8097053              lk1=-1.161408e-07
+ k2=-0.0931579             lk2=8.177641e-09          k3=0
+ dvt0=0                    dvt1=0                    dvt2=0
+ dvt0w=0                   dvt1w=0                   dvt2w=0
+ nlx=0                     w0=0                      k3b=0
+ vfb=-0.8713078            vsat=66800.85             lvsat=0.004822775
+ ua=-6.405478e-10          lua=-1.403048e-16         ub=2.207788e-18
+ lub=-6.036383e-26         uc=1.358835e-10           luc=-3.335912e-17
+ rdsw=367                  prwb=0                    prwg=0
+ wr=1                      u0=0.03640268             lu0=-1.303636e-09
+ a0=-1.128372              la0=5.123436e-07          keta=-0.09195808
+ lketa=3.052484e-08        a1=0                      a2=0.99
+ ags=0.3286924             lags=-1.401035e-07        b0=0
+ b1=0                      voff=-0.02853175          lvoff=-1.677976e-08
+ nfactor=0.7205374         lnfactor=-4.651742e-08    cit=-0.0001044482
+ lcit=9.774204e-11         cdsc=0                    cdscb=0
+ cdscd=0                   eta0=-0.006725388         leta0=3.229278e-09
+ etab=0.0007048237         letab=-6.734054e-10       dsub=0
+ pclm=1.221312             lpclm=-5.346241e-08       pdiblc1=1e-06
+ pdiblc2=-0.005471155      lpdiblc2=4.629856e-09     pdiblcb=-0.002153846
+ lpdiblcb=3.220769e-09     drout=0                   pscbe1=2.774374e+08
+ lpscbe1=14.83721          pscbe2=1e-06              pvag=0
+ delta=-0.0001923079       ldelta=4.025962e-09       alpha0=0
+ alpha1=3.8824             beta0=18.9788             kt1=-0.3146241
+ lkt1=1.675419e-08         kt2=-0.04856995           lkt2=8.756932e-09
+ at=11196.15               lat=0.00217402            ute=-1.987623
+ lute=2.479112e-07         ua1=7.598061e-10          lua1=4.217194e-16
+ ub1=-2.1325e-18           lub1=5.233755e-26         uc1=-6.860239e-11
+ luc1=1.453694e-17         kt1l=0                    prt=0
+ cj=cjn_lvt25              mj=0.2904575              pb=0.6842167
+ cjsw=cjswn_lvt25          mjsw=0.2                  pbsw=0.6842167
+ cjswg=cjswgn_lvt25        mjswg=0.2                 pbswg=0.6842167
+ tpb=1.89277e-3            tpbsw=1.89277e-3          tpbswg=1.89277e-3
+ tcj=1.042239e-3           tcjsw=7.570649e-4         tcjswg=7.570649e-4
+ js=3.03e-7                jsw=5.31e-12              n=1
+ xti=3                     cgdo=cgon_lvt25           cgso=cgon_lvt25
+ capmod=3                  nqsmod=0                  xpart=1
+ cf=0                      tlev=1                    tlevc=1
+ dlc=3.0e-08               cgdl=cgln_lvt25           cgsl=cgln_lvt25
+ wwc=-0.018                dwc=0                     noia=2.5e+19
+ noib=3.0e+4               noic=1.0e-13              em=4.1e+7
+ ef=0.888                  noimod=2                  sa0=0.35e-6
+ sb0=0.35e-6               kvsat=0.35                wlod=0.3e-6
+ tku0=0.03                 ku0=-5.95e-8              llodku0=1
+ wlodku0=1                 lku0=1.0e-7               wku0=2.5e-7
+ pku0=0                    kvth0=7.2e-9              stk2=0
+ steta0=-1.1e-10           lkvth0=-5.5e-08           wkvth0=3.5e-06
+ pkvth0=0                  llodvth=1.0               wlodvth=1
+ lodk2=1                   lodeta0=2                 minr=1e-3
+ imax=0.01                 imelt=0.01

     4: type=n
+ lmin=1.205e-06-(dxl_lvt25+dlmis)                    lmax=21e-06
+ wmin=1.2e-06-(dxw_lvt25+dwmis)                      wmax=10e-06-(dxw_lvt25+dwmis)
+ tnom=25                   version=3.24              tox=(toxn_lvt25+toxmis)
+ toxm=(toxn_lvt25+toxmis)  xj=1.9e-07                nch=3.28e+17
+ lln=1                     lwn=1                     wln=1
+ wwn=-1                    lint=3.5e-08              wint=1.5e-08
+ mobmod=1                  binunit=2                 xl=-4e-08+(dxl_lvt25+dlmis)
+ xw=1e-8+(dxw_lvt25+dwmis) dwg=0                     dwb=0
+ ldif=8e-08                hdif=hdifn_lvt25          rsh=6.6
+ rd=0                      rs=0                      vth0=(dvthn_lvt25+vthmis)+0.3447919
+ lvth0=1.351315e-08        wvth0=-2.031806e-08       pvth0=4.038557e-15
+ k1=0.435513               lk1=7.130307e-08          wk1=1.808644e-07
+ pk1=-2.817171e-13         k2=0.001408136            lk2=-3.690907e-08
+ wk2=-7.106168e-08         pk2=1.029339e-13          k3=0
+ dvt0=0                    dvt1=0                    dvt2=0
+ dvt0w=0                   dvt1w=0                   dvt2w=0
+ nlx=0                     w0=0                      k3b=0
+ vfb=-0.9637643            vsat=99842.43             lvsat=0.00164083
+ wvsat=0.001654223         pvsat=-1.646495e-08       ua=-1.601741e-09
+ lua=7.932024e-16          wua=1.025756e-15          pua=-1.106204e-21
+ ub=2.577797e-18           lub=-4.728713e-25         wub=-1.299504e-24
+ pub=5.213256e-31          uc=6.234915e-11           luc=-1.282767e-17
+ wuc=-4.815398e-17         puc=1.530373e-23          rdsw=367.1502
+ lrdsw=-1.485898e-06       wrdsw=-1.498663e-06       prdsw=1.482927e-11
+ prwb=0                    prwg=0                    wr=1
+ u0=0.02661457             lu0=7.399187e-09          wu0=2.651666e-09
+ pu0=-1.264434e-14         a0=1.311309               la0=-9.871217e-07
+ wa0=-2.92879e-07          pa0=1.657208e-13          keta=-0.02122476
+ lketa=-1.73513e-08        wketa=1.085326e-08        pketa=-2.187482e-17
+ a1=0                      a2=0.99                   ags=0.3497159
+ lags=-2.78722e-07         wags=-8.225793e-08        pags=-7.166661e-14
+ b0=0                      b1=0                      voff=-0.1008665
+ lvoff=1.833545e-08        wvoff=1.643687e-08        pvoff=-9.791215e-15
+ nfactor=0.3401159         lnfactor=2.750204e-07     wnfactor=2.232953e-07
+ pnfactor=-3.118281e-13    cit=2.061145e-05          lcit=3.740944e-11
+ wcit=-4.133048e-11        pcit=2.37424e-16          cdsc=0
+ cdscb=0                   cdscd=0                   eta0=3.889923e-05
+ leta0=3.719101e-11        weta0=-3.499874e-12       peta0=-5.478199e-17
+ etab=-4.102617e-05        letab=1.481116e-11        wetab=6.919539e-13
+ petab=-7.576895e-19       dsub=0                    pclm=0.6996098
+ lpclm=-4.033375e-07       wpclm=3.389618e-07        ppclm=2.160581e-13
+ pdiblc1=1e-06             pdiblc2=-1.171311e-05     lpdiblc2=7.202185e-09
+ wpdiblc2=1.424971e-10     ppdiblc2=1.858833e-15     pdiblcb=0.1301412
+ lpdiblcb=-1.253533e-07    wpdiblcb=-1.417661e-07    ppdiblcb=1.479154e-13
+ drout=0                   pscbe1=1.80342e+08        lpscbe1=193.4841
+ wpscbe1=8.686943          ppscbe1=-8.644354e-05     pscbe2=1e-06
+ pvag=0                    delta=0.01                alpha0=0
+ alpha1=3.8824             beta0=18.9788             kt1=-0.292361
+ lkt1=9.899401e-09         wkt1=1.540206e-09         pkt1=-2.128773e-14
+ kt2=-0.02970118           lkt2=2.049148e-09         wkt2=2.089362e-09
+ pkt2=-3.480992e-15        at=12250.89               lat=-0.002464728
+ wat=-0.002656055          pat=2.90838e-09           ute=-1.65986
+ lute=2.373246e-07         wute=3.744681e-07         pute=-8.581954e-14
+ ua1=9.636568e-10          lua1=8.533808e-16         wua1=9.19625e-16
+ pua1=-1.006989e-21        ub1=-1.287903e-18         lub1=-8.952327e-25
+ wub1=-9.060547e-25        pub1=1.299916e-30         uc1=-2.993473e-11
+ luc1=-2.353558e-17        wuc1=-5.179889e-17        puc1=5.26871e-23
+ kt1l=0                    prt=0                     cj=cjn_lvt25
+ mj=0.2904575              pb=0.6842167              cjsw=cjswn_lvt25
+ mjsw=0.2                  pbsw=0.6842167            cjswg=cjswgn_lvt25
+ mjswg=0.2                 pbswg=0.6842167           tpb=1.89277e-3
+ tpbsw=1.89277e-3          tpbswg=1.89277e-3         tcj=1.042239e-3
+ tcjsw=7.570649e-4         tcjswg=7.570649e-4        js=3.03e-7
+ jsw=5.31e-12              n=1                       xti=3
+ cgdo=cgon_lvt25           cgso=cgon_lvt25           capmod=3
+ nqsmod=0                  xpart=1                   cf=0
+ tlev=1                    tlevc=1                   dlc=3.0e-08
+ cgdl=cgln_lvt25           cgsl=cgln_lvt25           wwc=-0.018
+ dwc=0                     noia=2.5e+19              noib=3.0e+4
+ noic=1.0e-13              em=4.1e+7                 ef=0.888
+ noimod=2                  sa0=0.35e-6               sb0=0.35e-6
+ kvsat=0.35                wlod=0.3e-6               tku0=0.03
+ ku0=-5.95e-8              llodku0=1                 wlodku0=1
+ lku0=1.0e-7               wku0=2.5e-7               pku0=0
+ kvth0=7.2e-9              stk2=0                    steta0=-1.1e-10
+ lkvth0=-5.5e-08           wkvth0=3.5e-06            pkvth0=0
+ llodvth=1.0               wlodvth=1                 lodk2=1
+ lodeta0=2                 minr=1e-3                 imax=0.01
+ imelt=0.01

     5: type=n
+ lmin=5.05e-07-(dxl_lvt25+dlmis)                     lmax=1.205e-06-(dxl_lvt25+dlmis)
+ wmin=1.2e-06-(dxw_lvt25+dwmis)                      wmax=10e-06-(dxw_lvt25+dwmis)
+ tnom=25                   version=3.24              tox=(toxn_lvt25+toxmis)
+ toxm=(toxn_lvt25+toxmis)  xj=1.9e-07                nch=3.28e+17
+ lln=1                     lwn=1                     wln=1
+ wwn=-1                    lint=3.5e-08              wint=1.5e-08
+ mobmod=1                  binunit=2                 xl=-4e-08+(dxl_lvt25+dlmis)
+ xw=1e-8+(dxw_lvt25+dwmis) dwg=0                     dwb=0
+ ldif=8e-08                hdif=hdifn_lvt25          rsh=6.6
+ rd=0                      rs=0                      vth0=(dvthn_lvt25+vthmis)+0.3497133
+ lvth0=8.124239e-09        wvth0=-2.96896e-08        pvth0=1.43004e-14
+ k1=0.4898478              lk1=1.180643e-08          wk1=-9.666772e-08
+ pk1=2.218061e-14          k2=-0.008815954           lk2=-2.57137e-08
+ wk2=2.767172e-08          pk2=-5.179158e-15         k3=0
+ dvt0=0                    dvt1=0                    dvt2=0
+ dvt0w=0                   dvt1w=0                   dvt2w=0
+ nlx=0                     w0=0                      k3b=0
+ vfb=-0.9852535            vsat=114394.9             lvsat=-0.01429412
+ wvsat=-0.02545668         pvsat=1.322149e-08        ua=-8.0491e-10
+ lua=-7.932772e-17         wua=-3.197497e-17         pua=5.201075e-23
+ ub=2.160035e-18           lub=-1.542211e-26         wub=-9.162274e-25
+ pub=1.016377e-31          uc=4.81886e-11            luc=2.678123e-18
+ wuc=-3.353589e-17         puc=-7.030719e-25         rdsw=365.1122
+ lrdsw=7.456844e-07        wrdsw=1.884033e-05        prdsw=-7.441932e-12
+ prwb=0                    prwg=0                    wr=1
+ u0=0.03311752             lu0=2.784588e-10          wu0=-9.859858e-09
+ pu0=1.05578e-15           a0=0.5641858              la0=-1.690214e-07
+ wa0=-4.039602e-07         pa0=2.873548e-13          keta=-0.0498446
+ lketa=1.398742e-08        wketa=1.833501e-08        pketa=-8.214382e-15
+ a1=0                      a2=0.99                   ags=0.1657014
+ lags=-7.722613e-08        wags=-2.524993e-07        pags=1.147477e-13
+ b0=0                      b1=0                      voff=-0.09200203
+ lvoff=8.628878e-09        wvoff=1.654155e-08        pvoff=-9.905838e-15
+ nfactor=0.5845796         lnfactor=7.332743e-09     wnfactor=-9.407803e-08
+ pnfactor=3.569565e-14     cit=2.323058e-05          lcit=3.454148e-11
+ wcit=9.249738e-11         pcit=9.088253e-17         cdsc=0
+ cdscb=0                   cdscd=0                   eta0=-0.0007685506
+ leta0=9.213485e-10        weta0=5.581365e-10        peta0=-6.697737e-16
+ etab=0.0005515342         letab=-6.340424e-10       wetab=-3.020571e-10
+ petab=3.307525e-16        dsub=0                    pclm=-0.09661797
+ lpclm=4.685318e-07        wpclm=8.590192e-07        ppclm=-3.534047e-13
+ pdiblc1=1e-06             pdiblc2=0.007312951       lpdiblc2=-8.183217e-10
+ wpdiblc2=-2.802463e-09    ppdiblc2=5.083565e-15     pdiblcb=0.02141892
+ lpdiblcb=-6.302381e-09    wpdiblcb=-1.347618e-08    ppdiblcb=7.437923e-15
+ drout=0                   pscbe1=3.820864e+08       lpscbe1=-27.42602
+ wpscbe1=-123.1169         ppscbe1=5.788169e-05      pscbe2=1e-06
+ pvag=0                    delta=0.01                alpha0=0
+ alpha1=3.8824             beta0=18.9788             kt1=-0.2905486
+ lkt1=7.914847e-09         wkt1=-1.844297e-08        pkt1=5.938465e-16
+ kt2=-0.02876413           lkt2=1.023077e-09         wkt2=-4.292746e-10
+ pkt2=-7.230851e-16        at=5712.326               lat=0.004695003
+ wat=0.005059456           pat=-5.540104e-09         ute=-1.473385
+ lute=3.31346e-08          wute=2.970443e-07         pute=-1.040525e-15
+ ua1=1.695346e-09          lua1=5.218113e-17         ub1=-2.144551e-18
+ lub1=4.279688e-26         wub1=2.358062e-25         pub1=4.957855e-32
+ uc1=-6.188398e-11         luc1=1.144885e-17         wuc1=-1.195315e-17
+ puc1=9.056012e-24         kt1l=0                    prt=0
+ cj=cjn_lvt25              mj=0.2904575              pb=0.6842167
+ cjsw=cjswn_lvt25          mjsw=0.2                  pbsw=0.6842167
+ cjswg=cjswgn_lvt25        mjswg=0.2                 pbswg=0.6842167
+ tpb=1.89277e-3            tpbsw=1.89277e-3          tpbswg=1.89277e-3
+ tcj=1.042239e-3           tcjsw=7.570649e-4         tcjswg=7.570649e-4
+ js=3.03e-7                jsw=5.31e-12              n=1
+ xti=3                     cgdo=cgon_lvt25           cgso=cgon_lvt25
+ capmod=3                  nqsmod=0                  xpart=1
+ cf=0                      tlev=1                    tlevc=1
+ dlc=3.0e-08               cgdl=cgln_lvt25           cgsl=cgln_lvt25
+ wwc=-0.018                dwc=0                     noia=2.5e+19
+ noib=3.0e+4               noic=1.0e-13              em=4.1e+7
+ ef=0.888                  noimod=2                  sa0=0.35e-6
+ sb0=0.35e-6               kvsat=0.35                wlod=0.3e-6
+ tku0=0.03                 ku0=-5.95e-8              llodku0=1
+ wlodku0=1                 lku0=1.0e-7               wku0=2.5e-7
+ pku0=0                    kvth0=7.2e-9              stk2=0
+ steta0=-1.1e-10           lkvth0=-5.5e-08           wkvth0=3.5e-06
+ pkvth0=0                  llodvth=1.0               wlodvth=1
+ lodk2=1                   lodeta0=2                 minr=1e-3
+ imax=0.01                 imelt=0.01

     6: type=n
+ lmin=3.7e-07              lmax=5.05e-07-(dxl_lvt25+dlmis)
+ wmin=1.2e-06-(dxw_lvt25+dwmis)                      wmax=10e-06-(dxw_lvt25+dwmis)
+ tnom=25                   version=3.24              tox=(toxn_lvt25+toxmis)
+ toxm=(toxn_lvt25+toxmis)  xj=1.9e-07                nch=3.28e+17
+ lln=1                     lwn=1                     wln=1
+ wwn=-1                    lint=3.5e-08              wint=1.5e-08
+ mobmod=1                  binunit=2                 xl=-4e-08+(dxl_lvt25+dlmis)
+ xw=1e-8+(dxw_lvt25+dwmis) dwg=0                     dwb=0
+ ldif=8e-08                hdif=hdifn_lvt25          rsh=6.6
+ rd=0                      rs=0                      vth0=(dvthn_lvt25+vthmis)+0.4071534
+ lvth0=-1.456459e-08       wvth0=-4.729997e-08       pvth0=2.125649e-14
+ k1=0.8107244              lk1=-1.149398e-07         wk1=-1.017102e-08
+ pk1=-1.19856e-14          k2=-0.09221292            lk2=7.228102e-09
+ wk2=-9.430947e-09         pk2=9.476396e-15          k3=0
+ dvt0=0                    dvt1=0                    dvt2=0
+ dvt0w=0                   dvt1w=0                   dvt2w=0
+ nlx=0                     w0=0                      k3b=0
+ vfb=-0.8713078            vsat=64360.51             lvsat=0.005469466
+ wvsat=0.0243546           pvsat=-6.45397e-09        ua=-5.136105e-10
+ lua=-1.94391e-16          wua=-1.266834e-15         pua=5.397802e-22
+ ub=2.241641e-18           lub=-4.765664e-26         wub=-3.378593e-25
+ pub=-1.268177e-31         uc=1.46905e-10            luc=-3.631487e-17
+ wuc=-1.099953e-16         puc=2.949841e-23          rdsw=367
+ prwb=0                    prwg=0                    wr=1
+ u0=0.03901967             lu0=-2.052891e-09         wu0=-2.611754e-08
+ pu0=7.477564e-15          a0=-1.351925              la0=5.878425e-07
+ wa0=2.231061e-06          pa0=-7.534786e-13         keta=-0.09752005
+ lketa=3.281922e-08        wketa=5.550838e-08        pketa=-2.289787e-14
+ a1=0                      a2=0.99                   ags=0.3663425
+ lags=-1.564793e-07        wags=-3.757478e-07        pags=1.634309e-13
+ b0=0                      b1=0                      voff=-0.03142808
+ lvoff=-1.529783e-08       wvoff=2.890546e-08        pvoff=-1.478959e-14
+ nfactor=0.7257496         lnfactor=-4.842943e-08    wnfactor=-5.201786e-08
+ pnfactor=1.908189e-14     cit=-0.0002053442         lcit=1.248285e-10
+ wcit=1.006943e-09         pcit=-2.703233e-16        cdsc=0
+ cdscb=0                   cdscd=0                   eta0=-0.006544308
+ leta0=3.202773e-09        weta0=-1.807172e-09       peta0=2.64523e-16
+ etab=0.0006244213         letab=-6.628328e-10       wetab=8.024165e-10
+ petab=-1.055146e-16       dsub=0                    pclm=1.287195
+ lpclm=-7.807433e-08       wpclm=-6.575164e-07       ppclm=2.456269e-13
+ pdiblc1=1e-06             pdiblc2=-0.005791998      lpdiblc2=4.358133e-09
+ wpdiblc2=3.202022e-09     ppdiblc2=2.711793e-15     pdiblcb=-0.00379662
+ lpdiblcb=3.657758e-09     wpdiblcb=1.639488e-08     ppdiblcb=-4.361144e-15
+ drout=0                   pscbe1=2.70054e+08        lpscbe1=16.82675
+ wpscbe1=73.68623          ppscbe1=-1.985556e-05     pscbe2=1e-06
+ pvag=0                    delta=-0.001559005        ldelta=4.565807e-09
+ wdelta=1.363963e-08       pdelta=-5.387653e-15      alpha0=0
+ alpha1=3.8824             beta0=18.9788             kt1=-0.3092136
+ lkt1=1.528751e-08         wkt1=-5.399652e-08        pkt1=1.46375e-14
+ kt2=-0.04884838           lkt2=8.956357e-09         wkt2=2.778749e-09
+ pkt2=-1.990254e-15        at=13809.52               lat=0.001496613
+ wat=-0.02608136           pat=6.760521e-09          ute=-2.092839
+ lute=2.77819e-07          wute=1.050056e-06         pute=-2.984802e-13
+ ua1=7.118615e-10          lua1=4.406575e-16         wua1=4.784866e-16
+ pua1=-1.890022e-22        ub1=-2.174545e-18         lub1=5.464438e-26
+ wub1=4.196056e-25         pub1=-2.302219e-32        uc1=-7.24267e-11
+ luc1=1.561322e-17         wuc1=3.816657e-17         puc1=-1.074128e-23
+ kt1l=0                    prt=0                     cj=cjn_lvt25
+ mj=0.2904575              pb=0.6842167              cjsw=cjswn_lvt25
+ mjsw=0.2                  pbsw=0.6842167            cjswg=cjswgn_lvt25
+ mjswg=0.2                 pbswg=0.6842167           tpb=1.89277e-3
+ tpbsw=1.89277e-3          tpbswg=1.89277e-3         tcj=1.042239e-3
+ tcjsw=7.570649e-4         tcjswg=7.570649e-4        js=3.03e-7
+ jsw=5.31e-12              n=1                       xti=3
+ cgdo=cgon_lvt25           cgso=cgon_lvt25           capmod=3
+ nqsmod=0                  xpart=1                   cf=0
+ tlev=1                    tlevc=1                   dlc=3.0e-08
+ cgdl=cgln_lvt25           cgsl=cgln_lvt25           wwc=-0.018
+ dwc=0                     noia=2.5e+19              noib=3.0e+4
+ noic=1.0e-13              em=4.1e+7                 ef=0.888
+ noimod=2                  sa0=0.35e-6               sb0=0.35e-6
+ kvsat=0.35                wlod=0.3e-6               tku0=0.03
+ ku0=-5.95e-8              llodku0=1                 wlodku0=1
+ lku0=1.0e-7               wku0=2.5e-7               pku0=0
+ kvth0=7.2e-9              stk2=0                    steta0=-1.1e-10
+ lkvth0=-5.5e-08           wkvth0=3.5e-06            pkvth0=0
+ llodvth=1.0               wlodvth=1                 lodk2=1
+ lodeta0=2                 minr=1e-3                 imax=0.01
+ imelt=0.01

     7: type=n
+ lmin=1.205e-06-(dxl_lvt25+dlmis)                    lmax=21e-06
+ wmin=6e-07-(dxw_lvt25+dwmis)                        wmax=1.2e-06-(dxw_lvt25+dwmis)
+ tnom=25                   version=3.24              tox=(toxn_lvt25+toxmis)
+ toxm=(toxn_lvt25+toxmis)  xj=1.9e-07                nch=3.28e+17
+ lln=1                     lwn=1                     wln=1
+ wwn=-1                    lint=3.5e-08              wint=1.5e-08
+ mobmod=1                  binunit=2                 xl=-4e-08+(dxl_lvt25+dlmis)
+ xw=1e-8+(dxw_lvt25+dwmis) dwg=0                     dwb=0
+ ldif=8e-08                hdif=hdifn_lvt25          rsh=6.6
+ rd=0                      rs=0                      vth0=(dvthn_lvt25+vthmis)+0.320031
+ lvth0=2.626397e-08        wvth0=8.899785e-09        pvth0=-1.100742e-14
+ k1=0.7532799              lk1=-4.380018e-07         wk1=-1.941006e-07
+ pk1=3.192628e-13          k2=-0.1124415             lk2=1.463879e-07
+ wk2=6.32809e-08           pk2=-1.133565e-13         k3=0
+ dvt0=0                    dvt1=0                    dvt2=0
+ dvt0w=0                   dvt1w=0                   dvt2w=0
+ nlx=0                     w0=0                      k3b=0
+ vfb=-1.085385             vsat=1.0174883e+05        lvsat=-1.7310670e-02
+ wvsat=-5.9531890e-04      pvsat=5.8978190e-09       ua=-1.086702e-09
+ lua=3.08261e-16           wua=4.180091e-16          pua=-5.339732e-22
+ ub=1.865544e-18           lub=-6.365103e-25         wub=-4.590451e-25
+ pub=7.144195e-31          uc=3.371462e-11           luc=-1.250083e-17
+ wuc=-1.436523e-17         puc=1.491806e-23          rdsw=364.7975
+ lrdsw=2.179318e-05        wrdsw=1.277417e-06        prdsw=-1.264004e-11
+ prwb=0                    prwg=0                    wr=1
+ u0=2.9180478e-02          lu0=-4.1511200e-09        wu0=-3.7610530e-10
+ pu0=9.8502170e-16         a0=0.8869891              la0=-5.527311e-07
+ wa0=2.07819e-07           pa0=-3.4686e-13           keta=-0.01154415
+ lketa=-1.241816e-08       wketa=-5.6986e-10         pketa=-5.842981e-15
+ a1=0                      a2=0.99                   ags=0.2780897
+ lags=-3.807568e-07        wags=2.261046e-09         pags=4.873443e-14
+ b0=0                      b1=0                      voff=-0.07524026
+ lvoff=1.30766e-08         wvoff=-1.380208e-08       pvoff=-3.585769e-15
+ nfactor=0.5093868         lnfactor=2.116e-08        wnfactor=2.355566e-08
+ pnfactor=-1.22728e-14     cit=-3.810801e-06         lcit=1.128461e-10
+ wcit=-1.251222e-11        pcit=1.484088e-16         cdsc=0
+ cdscb=0                   cdscd=0                   eta0=3.302745e-06
+ leta0=-2.113653e-11       weta0=3.850398e-11        peta0=1.404451e-17
+ etab=-4.518495e-05        letab=6.699752e-11        wetab=5.599311e-12
+ petab=-6.233759e-17       dsub=0                    pclm=1.407262
+ lpclm=-7.992068e-07       wpclm=-4.960675e-07       ppclm=6.83184e-13
+ pdiblc1=1e-06             pdiblc2=-0.0004167299     lpdiblc2=1.107325e-08
+ wpdiblc2=6.204171e-10     ppdiblc2=-2.70903e-15     pdiblcb=0.01163135
+ lpdiblcb=-1.787753e-09    wpdiblcb=-1.924434e-09    ppdiblcb=2.108022e-15
+ drout=0                   pscbe1=1.854402e+08       lpscbe1=141.2293
+ wpscbe1=2.671065          ppscbe1=-2.478284e-05     pscbe2=7.282622e-07
+ lpscbe2=2.975529e-13      wpscbe2=3.206506e-13      ppscbe2=-3.511124e-19
+ pvag=0                    delta=0.01                alpha0=0
+ alpha1=3.8824             beta0=18.9788             kt1=-0.2874168
+ lkt1=-2.893677e-08        wkt1=-4.29395e-09         pkt1=2.453895e-14
+ kt2=-0.02674006           lkt2=-4.592277e-09        wkt2=-1.404761e-09
+ pkt2=4.355891e-15         at=10000                  ute=-1.502766
+ lute=3.549254e-07         wute=1.890976e-07         pute=-2.245884e-13
+ ua1=1.651207e-09          lua1=1.005135e-16         wua1=1.083159e-16
+ pua1=-1.186059e-22        ub1=-2.22855e-18          lub1=4.34759e-25
+ wub1=2.039089e-25         pub1=-2.694741e-31        uc1=-7.901336e-11
+ luc1=3.413929e-17         wuc1=6.113892e-18         puc1=-1.536925e-23
+ kt1l=0                    prt=0                     cj=cjn_lvt25
+ mj=0.2904575              pb=0.6842167              cjsw=cjswn_lvt25
+ mjsw=0.2                  pbsw=0.6842167            cjswg=cjswgn_lvt25
+ mjswg=0.2                 pbswg=0.6842167           tpb=1.89277e-3
+ tpbsw=1.89277e-3          tpbswg=1.89277e-3         tcj=1.042239e-3
+ tcjsw=7.570649e-4         tcjswg=7.570649e-4        js=3.03e-7
+ jsw=5.31e-12              n=1                       xti=3
+ cgdo=cgon_lvt25           cgso=cgon_lvt25           capmod=3
+ nqsmod=0                  xpart=1                   cf=0
+ tlev=1                    tlevc=1                   dlc=3.0e-08
+ cgdl=cgln_lvt25           cgsl=cgln_lvt25           wwc=-0.018
+ dwc=0                     noia=2.5e+19              noib=3.0e+4
+ noic=1.0e-13              em=4.1e+7                 ef=0.888
+ noimod=2                  sa0=0.35e-6               sb0=0.35e-6
+ kvsat=0.35                wlod=0.3e-6               tku0=0.03
+ ku0=-5.95e-8              llodku0=1                 wlodku0=1
+ lku0=1.0e-7               wku0=2.5e-7               pku0=0
+ kvth0=7.2e-9              stk2=0                    steta0=-1.1e-10
+ lkvth0=-5.5e-08           wkvth0=3.5e-06            pkvth0=0
+ llodvth=1.0               wlodvth=1                 lodk2=1
+ lodeta0=2                 minr=1e-3                 imax=0.01
+ imelt=0.01

     8: type=n
+ lmin=5.05e-07-(dxl_lvt25+dlmis)                     lmax=1.205e-06-(dxl_lvt25+dlmis)
+ wmin=6e-07-(dxw_lvt25+dwmis)                        wmax=1.2e-06-(dxw_lvt25+dwmis)
+ tnom=25                   version=3.24              tox=(toxn_lvt25+toxmis)
+ toxm=(toxn_lvt25+toxmis)  xj=1.9e-07                nch=3.28e+17
+ lln=1                     lwn=1                     wln=1
+ wwn=-1                    lint=3.5e-08              wint=1.5e-08
+ mobmod=1                  binunit=2                 xl=-4e-08+(dxl_lvt25+dlmis)
+ xw=1e-8+(dxw_lvt25+dwmis) dwg=0                     dwb=0
+ ldif=8e-08                hdif=hdifn_lvt25          rsh=6.6
+ rd=0                      rs=0                      vth0=(dvthn_lvt25+vthmis)+0.3128033
+ lvth0=3.4178410e-08       wvth0=1.3864215e-08       pvth0=-1.6443508e-14
+ k1=0.2873159              lk1=7.222878e-08          wk1=1.4232e-07
+ pk1=-4.911777e-14         k2=0.06058107             lk2=-4.307184e-08
+ wk2=-5.421678e-08         pk2=1.530346e-14          k3=0
+ dvt0=0                    dvt1=0                    dvt2=0
+ dvt0w=0                   dvt1w=0                   dvt2w=0
+ nlx=0                     w0=0                      k3b=0
+ vfb=-0.9441584            vsat=8.9743280e+04        lvsat=-4.1645970e-03
+ wvsat=3.6322320e-03       pvsat=1.2686521e-09       ua=-6.752431e-10
+ lua=-1.422864e-16         wua=-1.84982e-16          pua=1.26302e-22
+ ub=1.051467e-18           lub=2.549035e-25          wub=3.918828e-25
+ pub=-2.173465e-31         uc=1.254729e-11           luc=1.067739e-17
+ wuc=8.520861e-18          puc=-1.014221e-23         rdsw=394.6879
+ lrdsw=-1.09367e-05        wrdsw=-1.605896e-05       prdsw=6.343288e-12
+ prwb=0                    prwg=0                    wr=1
+ u0=2.5317138e-02          lu0=7.9237190e-11         wu0=-6.5541130e-10
+ pu0=1.2908614e-15         a0=0.4477632              la0=-7.177867e-08
+ wa0=-2.665815e-07         pa0=1.726084e-13          keta=-0.02373895
+ lketa=9.351396e-10        wketa=-1.246967e-08       pketa=7.187307e-15
+ a1=0                      a2=0.99                   ags=-0.1279505
+ lags=6.385729e-08         wags=9.401003e-08         pags=-5.173072e-14
+ b0=0                      b1=0                      voff=-0.05857327
+ lvoff=-5.173757e-09       wvoff=-2.29044e-08        pvoff=6.381273e-15
+ nfactor=0.4612098         lnfactor=7.39138e-08      wnfactor=5.149832e-08
+ pnfactor=-4.287001e-14    cit=-8.857658e-05         lcit=2.056646e-10
+ wcit=2.244299e-10         pcit=-1.110428e-16        cdsc=0
+ cdscb=0                   cdscd=0                   eta0=-0.0003363262
+ leta0=3.507571e-10        weta0=4.811164e-11        peta0=3.524128e-18
+ etab=0.0003636001         letab=-3.806221e-10       wetab=-8.029477e-11
+ petab=3.171642e-17        dsub=0                    pclm=0.5569212
+ lpclm=1.31916e-07         wpclm=8.784298e-08        ppclm=4.380202e-14
+ pdiblc1=1e-06             pdiblc2=0.008337318       lpdiblc2=1.487573e-09
+ wpdiblc2=-4.011217e-09    ppdiblc2=2.362608e-15     pdiblcb=0.009997575
+ lpdiblcb=1.233512e-12     wpdiblcb=1.015252e-12     ppdiblcb=-3.439563e-19
+ drout=0                   pscbe1=2.946294e+08       lpscbe1=21.66709
+ wpscbe1=-19.91765         ppscbe1=-4.819698e-08     pscbe2=1e-06
+ pvag=0                    delta=0.01                alpha0=0
+ alpha1=3.8824             beta0=18.9788             kt1=-0.288242
+ lkt1=-2.803317e-08        wkt1=-2.116478e-08        pkt1=4.301251e-14
+ kt2=-0.03237297           lkt2=1.575763e-09         wkt2=3.829161e-09
+ pkt2=-1.375254e-15        at=10000                  ute=-1.255246
+ lute=8.389021e-08         wute=3.963982e-08         pute=-6.093214e-14
+ ua1=1.738028e-09          lua1=5.443756e-18         wua1=-5.036539e-17
+ pua1=5.51501e-23          ub1=-2.017129e-18         lub1=2.032532e-25
+ wub1=8.54484e-26          pub1=-1.397599e-31        uc1=-5.469754e-11
+ luc1=7.513473e-18         wuc1=-2.043315e-17        puc1=1.369976e-23
+ kt1l=0                    prt=0                     cj=cjn_lvt25
+ mj=0.2904575              pb=0.6842167              cjsw=cjswn_lvt25
+ mjsw=0.2                  pbsw=0.6842167            cjswg=cjswgn_lvt25
+ mjswg=0.2                 pbswg=0.6842167           tpb=1.89277e-3
+ tpbsw=1.89277e-3          tpbswg=1.89277e-3         tcj=1.042239e-3
+ tcjsw=7.570649e-4         tcjswg=7.570649e-4        js=3.03e-7
+ jsw=5.31e-12              n=1                       xti=3
+ cgdo=cgon_lvt25           cgso=cgon_lvt25           capmod=3
+ nqsmod=0                  xpart=1                   cf=0
+ tlev=1                    tlevc=1                   dlc=3.0e-08
+ cgdl=cgln_lvt25           cgsl=cgln_lvt25           wwc=-0.018
+ dwc=0                     noia=2.5e+19              noib=3.0e+4
+ noic=1.0e-13              em=4.1e+7                 ef=0.888
+ noimod=2                  sa0=0.35e-6               sb0=0.35e-6
+ kvsat=0.35                wlod=0.3e-6               tku0=0.03
+ ku0=-5.95e-8              llodku0=1                 wlodku0=1
+ lku0=1.0e-7               wku0=2.5e-7               pku0=0
+ kvth0=7.2e-9              stk2=0                    steta0=-1.1e-10
+ lkvth0=-5.5e-08           wkvth0=3.5e-06            pkvth0=0
+ llodvth=1.0               wlodvth=1                 lodk2=1
+ lodeta0=2                 minr=1e-3                 imax=0.01
+ imelt=0.01

     9: type=n
+ lmin=3.7e-07              lmax=5.05e-07-(dxl_lvt25+dlmis)
+ wmin=6e-07-(dxw_lvt25+dwmis)                        wmax=1.2e-06-(dxw_lvt25+dwmis)
+ tnom=25                   version=3.24              tox=(toxn_lvt25+toxmis)
+ toxm=(toxn_lvt25+toxmis)  xj=1.9e-07                nch=3.28e+17
+ lln=1                     lwn=1                     wln=1
+ wwn=-1                    lint=3.5e-08              wint=1.5e-08
+ mobmod=1                  binunit=2                 xl=-4e-08+(dxl_lvt25+dlmis)
+ xw=1e-8+(dxw_lvt25+dwmis) dwg=0                     dwb=0
+ ldif=8e-08                hdif=hdifn_lvt25          rsh=6.6
+ rd=0                      rs=0                      vth0=(dvthn_lvt25+vthmis)+0.3827403
+ lvth0=6.5532750e-09       wvth0=-1.8492539e-08      pvth0=-3.6625920e-15
+ k1=0.7234104              lk1=-1.000286e-07         wk1=9.285946e-08
+ pk1=-2.958085e-14         k2=-0.0522119             lk2=1.481375e-09
+ wk2=-5.663215e-08         pk2=1.625753e-14          k3=0
+ dvt0=0                    dvt1=0                    dvt2=0
+ dvt0w=0                   dvt1w=0                   dvt2w=0
+ nlx=0                     w0=0                      k3b=0
+ vfb=-0.7707245            vsat=7.9199990e+04        wvsat=6.8440100e-03
+ ua=-3.220981e-09          lua=8.632799e-16          wua=1.927862e-15
+ pua=-7.082716e-22         ub=3.229613e-18           lub=-6.05464e-25
+ wub=-1.503665e-24         pub=5.313949e-31          uc=8.439516e-11
+ luc=-1.770251e-17         wuc=-3.623366e-17         puc=7.535823e-24
+ rdsw=367                  prwb=0                    prwg=0
+ wr=1                      u0=1.4084544e-03          lu0=9.5231640e-09
+ wu0=1.8263687e-08         pu0=-6.1821820e-15        a0=1.426817
+ la0=-4.585051e-07         wa0=-1.047856e-06         pa0=4.812116e-13
+ keta=-0.0529984           lketa=1.249262e-08        wketa=2.972836e-09
+ pketa=1.087519e-15        a1=0                      a2=0.99
+ ags=0.470204              lags=-1.724137e-07        wags=-4.983043e-07
+ pags=1.822334e-13         b0=0                      b1=0
+ voff=-0.03126579          lvoff=-1.596021e-08       wvoff=2.871396e-08
+ pvoff=-1.400798e-14       nfactor=0.5550355         lnfactor=3.685266e-08
+ wnfactor=1.494248e-07     pnfactor=-8.155098e-14    cit=0.0005896387
+ lcit=-6.223042e-11        wcit=6.886244e-11         pcit=-4.959366e-17
+ cdsc=0                    cdscb=0                   cdscd=0
+ eta0=-0.004214944         leta0=1.882811e-09        weta0=-4.555821e-09
+ peta0=1.822078e-15        etab=0.001426944          letab=-8.006428e-10
+ wetab=-1.445601e-10       petab=5.710124e-17        dsub=0
+ pclm=-0.1965591           lpclm=4.295407e-07        wpclm=1.093314e-06
+ ppclm=-3.533589e-13       pdiblc1=1e-06             pdiblc2=-0.00978798
+ lpdiblc2=8.647065e-09     wpdiblc2=7.917278e-09     ppdiblc2=-2.349147e-15
+ pdiblcb=0.002289167       lpdiblcb=3.046054e-09     wpdiblcb=9.213649e-09
+ ppdiblcb=-3.639334e-15    drout=0                   pscbe1=3.772213e+08
+ lpscbe1=-10.95672         wpscbe1=-52.77114         ppscbe1=1.292893e-05
+ pscbe2=1e-06              pvag=0                    delta=0.01
+ alpha0=0                  alpha1=3.8824             beta0=18.9788
+ kt1=-0.539868             lkt1=7.13591e-08          wkt1=2.181757e-07
+ pkt1=-5.152698e-14        kt2=-0.05259364           lkt2=9.562927e-09
+ wkt2=7.198158e-09         pkt2=-2.706008e-15        at=-15398.33
+ lat=0.01003234            wat=0.0083839             pat=-3.311641e-09
+ ute=-0.9922474            lute=-1.999412e-08        wute=-2.486424e-07
+ pute=5.293934e-14         ua1=5.063202e-10          lua1=4.919685e-16
+ wua1=7.210253e-16         pua1=-2.495492e-22        ub1=-1.274437e-18
+ lub1=-9.011022e-26        wub1=-6.425217e-25        pub1=1.477882e-31
+ uc1=-7.139479e-11         luc1=1.410889e-17         wuc1=3.694893e-17
+ puc1=-8.966161e-24        kt1l=0                    prt=0
+ cj=cjn_lvt25              mj=0.2904575              pb=0.6842167
+ cjsw=cjswn_lvt25          mjsw=0.2                  pbsw=0.6842167
+ cjswg=cjswgn_lvt25        mjswg=0.2                 pbswg=0.6842167
+ tpb=1.89277e-3            tpbsw=1.89277e-3          tpbswg=1.89277e-3
+ tcj=1.042239e-3           tcjsw=7.570649e-4         tcjswg=7.570649e-4
+ js=3.03e-7                jsw=5.31e-12              n=1
+ xti=3                     cgdo=cgon_lvt25           cgso=cgon_lvt25
+ capmod=3                  nqsmod=0                  xpart=1
+ cf=0                      tlev=1                    tlevc=1
+ dlc=3.0e-08               cgdl=cgln_lvt25           cgsl=cgln_lvt25
+ wwc=-0.018                dwc=0                     noia=2.5e+19
+ noib=3.0e+4               noic=1.0e-13              em=4.1e+7
+ ef=0.888                  noimod=2                  sa0=0.35e-6
+ sb0=0.35e-6               kvsat=0.35                wlod=0.3e-6
+ tku0=0.03                 ku0=-5.95e-8              llodku0=1
+ wlodku0=1                 lku0=1.0e-7               wku0=2.5e-7
+ pku0=0                    kvth0=7.2e-9              stk2=0
+ steta0=-1.1e-10           lkvth0=-5.5e-08           wkvth0=3.5e-06
+ pkvth0=0                  llodvth=1.0               wlodvth=1
+ lodk2=1                   lodeta0=2                 minr=1e-3
+ imax=0.01                 imelt=0.01

     10: type=n
+ lmin=1.205e-06-(dxl_lvt25+dlmis)                    lmax=21e-06
+ wmin=1.5e-07              wmax=6e-07-(dxw_lvt25+dwmis)
+ tnom=25                   version=3.24              tox=(toxn_lvt25+toxmis)
+ toxm=(toxn_lvt25+toxmis)  xj=1.9e-07                nch=3.28e+17
+ lln=1                     lwn=1                     wln=1
+ wwn=-1                    lint=3.5e-08              wint=1.5e-08
+ mobmod=1                  binunit=2                 xl=-4e-08+(dxl_lvt25+dlmis)
+ xw=1e-8+(dxw_lvt25+dwmis) dwg=0                     dwb=0
+ ldif=8e-08                hdif=hdifn_lvt25          rsh=6.6
+ rd=0                      rs=0                      vth0=(dvthn_lvt25+vthmis)+0.3446315
+ lvth0=2.719209e-08        wvth0=-5.368482e-09       pvth0=-1.154572e-14
+ k1=0.3995275              lk1=1.662187e-07          wk1=1.107583e-08
+ pk1=-3.118515e-14         k2=0.0118681              lk2=-6.760317e-08
+ wk2=-8.818683e-09         pk2=1.075832e-14          k3=0
+ dvt0=0                    dvt1=0                    dvt2=0
+ dvt0w=0                   dvt1w=0                   dvt2w=0
+ nlx=0                     w0=0                      k3b=0
+ vfb=-1.028903             vsat=1.0133802e+05        lvsat=-1.0373162e-02
+ wvsat=-3.5704750e-04      pvsat=1.8740640e-09       ua=-4.429365e-10
+ lua=-7.723305e-16         wua=4.462516e-17          pua=9.276987e-23
+ ub=9.337934e-19           lub=9.770701e-25          wub=8.137011e-26
+ pub=-2.214572e-31         uc=7.304763e-13           luc=2.501126e-17
+ wuc=4.765571e-18          puc=-6.838959e-24         rdsw=367
+ prwb=0                    prwg=0                    wr=1
+ u0=2.6701150e-02          lu0=-2.6497535e-09        wu0=1.0619043e-09
+ pu0=1.1422861e-16         a0=1.404992               la0=-1.303911e-06
+ wa0=-9.262294e-08         pa0=8.882464e-14          keta=-0.007380755
+ lketa=-2.996032e-08       wketa=-2.984629e-09       pketa=4.33147e-15
+ a1=0                      a2=0.99                   ags=0.2612626
+ lags=-2.771732e-07        wags=1.20208e-08          pags=-1.134408e-14
+ b0=0                      b1=0                      voff=-0.09571052
+ lvoff=-4.740103e-09       wvoff=-1.929335e-09       pvoff=6.747921e-15
+ nfactor=0.5294412         lnfactor=8.908767e-08     wnfactor=1.192413e-08
+ pnfactor=-5.167086e-14    cit=-4.163744e-05         lcit=4.907078e-10
+ wcit=9.427229e-12         pcit=-7.075099e-17        cdsc=0
+ cdscb=0                   cdscd=0                   eta0=7.9186540e-05
+ leta0=-8.2885770e-12      weta0=-5.5086210e-12      peta0=6.5927010e-18
+ etab=-3.027922e-05        letab=-6.278118e-11       wetab=-3.046016e-12
+ petab=1.293406e-17        dsub=0                    pclm=0.6262414
+ lpclm=3.662929e-07        wpclm=-4.307577e-08       ppclm=7.194141e-15
+ pdiblc1=1e-06             pdiblc2=0.0008587558      lpdiblc2=4.332522e-09
+ wpdiblc2=-1.193647e-10    ppdiblc2=1.200596e-15     pdiblcb=0.007826125
+ lpdiblcb=2.380168e-09     wpdiblcb=2.825987e-10     ppdiblcb=-3.093717e-16
+ drout=0                   pscbe1=1.863192e+08       lpscbe1=78.20065
+ wpscbe1=2.161242          ppscbe1=1.177375e-05      pscbe2=1.362317e-06
+ lpscbe2=-3.967371e-13     wpscbe2=-4.710121e-14     ppscbe2=5.157583e-20
+ pvag=0                    delta=0.01                alpha0=0
+ alpha1=3.8824             beta0=18.9788             kt1=-0.3065531
+ lkt1=1.879909e-08         wkt1=6.805123e-09         pkt1=-3.147848e-15
+ kt2=-0.03169849           lkt2=5.251259e-09         wkt2=1.471131e-09
+ pkt2=-1.353361e-15        at=10443.43               lat=-0.004387736
+ wat=-0.0002571892         pat=2.544887e-09          ute=-1.198939
+ lute=-4.045242e-08        wute=1.287792e-08         pute=4.730705e-15
+ ua1=1.865391e-09          lua1=-1.340179e-16        wua1=-1.591081e-17
+ pua1=1.742233e-23         ub1=-1.910423e-18         lub1=7.420331e-26
+ wub1=1.939489e-26         pub1=-6.035183e-32        uc1=-7.947958e-11
+ luc1=1.51431e-17          wuc1=6.384305e-18         puc1=-4.351462e-24
+ kt1l=0                    prt=0                     cj=cjn_lvt25
+ mj=0.2904575              pb=0.6842167              cjsw=cjswn_lvt25
+ mjsw=0.2                  pbsw=0.6842167            cjswg=cjswgn_lvt25
+ mjswg=0.2                 pbswg=0.6842167           tpb=1.89277e-3
+ tpbsw=1.89277e-3          tpbswg=1.89277e-3         tcj=1.042239e-3
+ tcjsw=7.570649e-4         tcjswg=7.570649e-4        js=3.03e-7
+ jsw=5.31e-12              n=1                       xti=3
+ cgdo=cgon_lvt25           cgso=cgon_lvt25           capmod=3
+ nqsmod=0                  xpart=1                   cf=0
+ tlev=1                    tlevc=1                   dlc=3.0e-08
+ cgdl=cgln_lvt25           cgsl=cgln_lvt25           wwc=-0.018
+ dwc=0                     noia=2.5e+19              noib=3.0e+4
+ noic=1.0e-13              em=4.1e+7                 ef=0.888
+ noimod=2                  sa0=0.35e-6               sb0=0.35e-6
+ kvsat=0.35                wlod=0.3e-6               tku0=0.03
+ ku0=-5.95e-8              llodku0=1                 wlodku0=1
+ lku0=1.0e-7               wku0=2.5e-7               pku0=0
+ kvth0=7.2e-9              stk2=0                    steta0=-1.1e-10
+ lkvth0=-5.5e-08           wkvth0=3.5e-06            pkvth0=0
+ llodvth=1.0               wlodvth=1                 lodk2=1
+ lodeta0=2                 minr=1e-3                 imax=0.01
+ imelt=0.01

     11: type=n
+ lmin=5.05e-07-(dxl_lvt25+dlmis)                     lmax=1.205e-06-(dxl_lvt25+dlmis)
+ wmin=1.5e-07              wmax=6e-07-(dxw_lvt25+dwmis)
+ tnom=25                   version=3.24              tox=(toxn_lvt25+toxmis)
+ toxm=(toxn_lvt25+toxmis)  xj=1.9e-07                nch=3.28e+17
+ lln=1                     lwn=1                     wln=1
+ wwn=-1                    lint=3.5e-08              wint=1.5e-08
+ mobmod=1                  binunit=2                 xl=-4e-08+(dxl_lvt25+dlmis)
+ xw=1e-8+(dxw_lvt25+dwmis) dwg=0                     dwb=0
+ ldif=8e-08                hdif=hdifn_lvt25          rsh=6.6
+ rd=0                      rs=0                      vth0=(dvthn_lvt25+vthmis)+0.3657833
+ lvth0=4.0308490e-09       wvth0=-1.6864183e-08      pvth0=1.0420777e-15
+ k1=0.5641519              lk1=-1.404498e-08         wk1=-1.824487e-08
+ pk1=9.210139e-16          k2=-0.03294823            lk2=-1.852928e-08
+ wk2=3.0221e-11            pk2=1.068773e-15          k3=0
+ dvt0=0                    dvt1=0                    dvt2=0
+ dvt0w=0                   dvt1w=0                   dvt2w=0
+ nlx=0                     w0=0                      k3b=0
+ vfb=-1.023088             vsat=9.4353570e+04        lvsat=-2.7251947e-03
+ wvsat=9.5826360e-04       pvsat=4.3379810e-10       ua=-1.308827e-09
+ lua=1.758199e-16          wua=1.824969e-16          pua=-5.81997e-23
+ ub=2.005374e-18           lub=-1.96311e-25          wub=-1.613834e-25
+ pub=4.435792e-32          uc=3.456975e-11           luc=-1.204273e-17
+ wuc=-4.252165e-18         puc=3.035461e-24          rdsw=367
+ prwb=0                    prwg=0                    wr=1
+ u0=2.1755682e-02          lu0=2.7655345e-09         wu0=1.4102328e-09
+ pu0=-2.6719112e-16        a0=-0.06180262            la0=3.022288e-07
+ wa0=2.896668e-08          pa0=-4.431601e-14         keta=-0.0460932
+ lketa=1.242981e-08        wketa=4.958032e-10        pketa=5.203971e-16
+ a1=0                      a2=0.99                   ags=0.04219527
+ lags=-3.72945e-08         wags=-4.67454e-09         pags=6.937317e-15
+ b0=0                      b1=0                      voff=-0.1074134
+ lvoff=8.074538e-09        wvoff=5.422867e-09        pvoff=-1.30274e-15
+ nfactor=0.6189232         lnfactor=-8.895124e-09    wnfactor=-3.997545e-08
+ pnfactor=5.159176e-15     cit=0.0003927978          lcit=1.500117e-11
+ wcit=-5.476731e-11        pcit=-4.579779e-19        cdsc=0
+ cdscb=0                   cdscd=0                   eta0=-1.3841083e-04
+ leta0=2.2998052e-10       weta0=-6.6679270e-11      peta0=7.3574570e-17
+ etab=0.0001458578         letab=-2.556512e-10       wetab=4.59957e-11
+ petab=-4.076662e-17       dsub=0                    pclm=0.7696757
+ lpclm=2.092323e-07        wpclm=-3.555468e-08       ppclm=-1.041438e-15
+ pdiblc1=1e-06             pdiblc2=0.0003078757      lpdiblc2=4.935736e-09
+ wpdiblc2=6.458607e-10     ppdiblc2=3.62674e-16      pdiblcb=0.01001411
+ lpdiblcb=-1.567905e-11    wpdiblcb=-8.576764e-12    ppdiblcb=9.465329e-18
+ drout=0                   pscbe1=2.317566e+08       lpscbe1=28.44667
+ wpscbe1=16.54855          ppscbe1=-3.980353e-06     pscbe2=1e-06
+ pvag=0                    delta=0.01                alpha0=0
+ alpha1=3.8824             beta0=18.9788             kt1=-0.3421046
+ lkt1=5.772791e-08         wkt1=1.007551e-08         pkt1=-6.728917e-15
+ kt2=-0.02587449           lkt2=-1.126018e-09        wkt2=6.004372e-11
+ pkt2=1.917789e-16         at=5224.434               lat=0.001327065
+ wat=0.002769829           pat=-7.696979e-10         ute=-1.233199
+ lute=-2.938557e-09        wute=2.68525e-08          pute=-1.057146e-14
+ ua1=1.621441e-09          lua1=1.331068e-16         wua1=1.725521e-17
+ pua1=-1.889446e-23        ub1=-1.794061e-18         lub1=-5.32123e-26
+ wub1=-4.393104e-26        pub1=8.990075e-33         uc1=-1.021541e-10
+ luc1=3.997173e-17         wuc1=7.091672e-18         puc1=-5.126029e-24
+ kt1l=0                    prt=0                     cj=cjn_lvt25
+ mj=0.2904575              pb=0.6842167              cjsw=cjswn_lvt25
+ mjsw=0.2                  pbsw=0.6842167            cjswg=cjswgn_lvt25
+ mjswg=0.2                 pbswg=0.6842167           tpb=1.89277e-3
+ tpbsw=1.89277e-3          tpbswg=1.89277e-3         tcj=1.042239e-3
+ tcjsw=7.570649e-4         tcjswg=7.570649e-4        js=3.03e-7
+ jsw=5.31e-12              n=1                       xti=3
+ cgdo=cgon_lvt25           cgso=cgon_lvt25           capmod=3
+ nqsmod=0                  xpart=1                   cf=0
+ tlev=1                    tlevc=1                   dlc=3.0e-08
+ cgdl=cgln_lvt25           cgsl=cgln_lvt25           wwc=-0.018
+ dwc=0                     noia=2.5e+19              noib=3.0e+4
+ noic=1.0e-13              em=4.1e+7                 ef=0.888
+ noimod=2                  sa0=0.35e-6               sb0=0.35e-6
+ kvsat=0.35                wlod=0.3e-6               tku0=0.03
+ ku0=-5.95e-8              llodku0=1                 wlodku0=1
+ lku0=1.0e-7               wku0=2.5e-7               pku0=0
+ kvth0=7.2e-9              stk2=0                    steta0=-1.1e-10
+ lkvth0=-5.5e-08           wkvth0=3.5e-06            pkvth0=0
+ llodvth=1.0               wlodvth=1                 lodk2=1
+ lodeta0=2                 minr=1e-3                 imax=0.01
+ imelt=0.01

     12: type=n
+ lmin=3.7e-07              lmax=5.05e-07-(dxl_lvt25+dlmis)
+ wmin=1.5e-07              wmax=6e-07-(dxw_lvt25+dwmis)
+ tnom=25                   version=3.24              tox=(toxn_lvt25+toxmis)
+ toxm=(toxn_lvt25+toxmis)  xj=1.9e-07                nch=3.28e+17
+ lln=1                     lwn=1                     wln=1
+ wwn=-1                    lint=3.5e-08              wint=1.5e-08
+ mobmod=1                  binunit=2                 xl=-4e-08+(dxl_lvt25+dlmis)
+ xw=1e-8+(dxw_lvt25+dwmis) dwg=0                     dwb=0
+ ldif=8e-08                hdif=hdifn_lvt25          rsh=6.6
+ rd=0                      rs=0                      vth0=(dvthn_lvt25+vthmis)+0.3681791
+ lvth0=3.0844787e-09       wvth0=-1.0047049e-08      pvth0=-1.6506895e-15
+ k1=0.9416191              lk1=-1.631446e-07         wk1=-3.370159e-08
+ pk1=7.026418e-15          k2=-0.1596789             lk2=3.152933e-08
+ wk2=5.698712e-09          pk2=-1.170281e-15         k3=0
+ dvt0=0                    dvt1=0                    dvt2=0
+ dvt0w=0                   dvt1w=0                   dvt2w=0
+ nlx=0                     w0=0                      k3b=0
+ vfb=-0.8432227            vsat=8.7398700e+04        lvsat=2.1976957e-05
+ wvsat=2.0887565e-03       pvsat=-1.2746634e-11      ua=1.895398e-10
+ lua=-4.160351e-16         wua=-5.023947e-17         pua=3.373117e-23
+ ub=5.09612e-19            lub=3.945152e-25          wub=7.393535e-26
+ pub=-4.8593e-32           uc=6.756374e-12           luc=-1.05645e-18
+ wuc=8.796841e-18          puc=-2.118897e-24         rdsw=367
+ prwb=0                    prwg=0                    wr=1
+ u0=3.3693340e-02          lu0=-1.9498381e-09        wu0=-4.6154210e-10
+ pu0=4.7215990e-16         a0=-0.5191821             la0=4.828937e-07
+ wa0=8.082413e-08          pa0=-6.47997e-14          keta=-0.05865234
+ lketa=1.739067e-08        wketa=6.252121e-09        pketa=-1.753348e-15
+ a1=0                      a2=0.99                   ags=-0.4026658
+ lags=1.384256e-07         wags=7.960238e-09         pags=1.946579e-15
+ b0=0                      b1=0                      voff=0.04786693
+ lvoff=-5.326119e-08       wvoff=-1.718303e-08       pvoff=7.626591e-15
+ nfactor=1.083453          lnfactor=-1.923844e-07    wnfactor=-1.570574e-07
+ pnfactor=5.140653e-14     cit=0.0009324652          lcit=-1.981674e-10
+ wcit=-1.299769e-10        pcit=2.924983e-17         cdsc=0
+ cdscb=0                   cdscd=0                   eta0=-0.01501045
+ leta0=6.104434e-09        weta0=1.705571e-09        peta0=-6.264641e-16
+ etab=0.001659307          letab=-8.534639e-10       wetab=-2.793311e-10
+ petab=8.773748e-17        dsub=0                    pclm=1.921926
+ lpclm=-2.459065e-07       wpclm=-1.354078e-07       ppclm=3.840053e-14
+ pdiblc1=1e-06             pdiblc2=0.008501258       lpdiblc2=1.69935e-09
+ wpdiblc2=-2.690481e-09    ppdiblc2=1.680529e-15     pdiblcb=0.03193061
+ lpdiblcb=-8.672696e-09    wpdiblcb=-7.978395e-09    ppdiblcb=3.157544e-15
+ drout=0                   pscbe1=2.659482e+08       lpscbe1=14.94098
+ wpscbe1=11.76725          ppscbe1=-2.091737e-06     pscbe2=1e-06
+ pvag=0                    delta=0.01                alpha0=0
+ alpha1=3.8824             beta0=18.9788             kt1=-0.1376225
+ lkt1=-2.304251e-08        wkt1=-1.512669e-08        pkt1=3.225951e-15
+ kt2=-0.04506861           lkt2=6.455658e-09         wkt2=2.833641e-09
+ pkt2=-9.037922e-16        at=-2825.409              lat=0.004506753
+ wat=0.001091605           pat=-1.067991e-10         ute=-1.447604
+ lute=8.175148e-08         wute=1.546429e-08         pute=-6.073113e-15
+ ua1=1.732687e-09          lua1=8.916458e-17         wua1=9.732318e-18
+ pua1=-1.592291e-23        ub1=-2.083429e-18         lub1=6.108776e-26
+ wub1=-1.733067e-25        pub1=6.009345e-32         uc1=2.152684e-11
+ luc1=-8.882255e-18        wuc1=-1.694562e-17        puc1=4.368703e-24
+ kt1l=0                    prt=0                     cj=cjn_lvt25
+ mj=0.2904575              pb=0.6842167              cjsw=cjswn_lvt25
+ mjsw=0.2                  pbsw=0.6842167            cjswg=cjswgn_lvt25
+ mjswg=0.2                 pbswg=0.6842167           tpb=1.89277e-3
+ tpbsw=1.89277e-3          tpbswg=1.89277e-3         tcj=1.042239e-3
+ tcjsw=7.570649e-4         tcjswg=7.570649e-4        js=3.03e-7
+ jsw=5.31e-12              n=1                       xti=3
+ cgdo=cgon_lvt25           cgso=cgon_lvt25           capmod=3
+ nqsmod=0                  xpart=1                   cf=0
+ tlev=1                    tlevc=1                   dlc=3.0e-08
+ cgdl=cgln_lvt25           cgsl=cgln_lvt25           wwc=-0.018
+ dwc=0                     noia=2.5e+19              noib=3.0e+4
+ noic=1.0e-13              em=4.1e+7                 ef=0.888
+ noimod=2                  sa0=0.35e-6               sb0=0.35e-6
+ kvsat=0.35                wlod=0.3e-6               tku0=0.03
+ ku0=-5.95e-8              llodku0=1                 wlodku0=1
+ lku0=1.0e-7               wku0=2.5e-7               pku0=0
+ kvth0=7.2e-9              stk2=0                    steta0=-1.1e-10
+ lkvth0=-5.5e-08           wkvth0=3.5e-06            pkvth0=0
+ llodvth=1.0               wlodvth=1                 lodk2=1
+ lodeta0=2                 minr=1e-3                 imax=0.01
+ imelt=0.01
//
//  *************************************************************
//                                                              *
//                 2.5V LOW Vt PMOS DEVICE MODEL                *
//                                                              *
//  *************************************************************
//
     }
ends nch_lvt25_mis

//  ********************************
//        Mismatch   model         *
//  ********************************
inline subckt pch_lvt25_mis ( d g s b )
parameters l=1u w=1u factor=1 multi=1 sa=0.35u sb=0.35u ad=2 * hdifp_lvt25 / factor
+ * w as=2 * hdifp_lvt25 / factor * w pd=2 * (2 * hdifp_lvt25 / factor + w) ps=2 *
+ (2 * hdifp_lvt25 / factor + w) nrd=hdifp_lvt25 / factor / w nrs=hdifp_lvt25 / factor
+ / w temp1=parp1_lvt25 temp2=parp2_lvt25 fac1=0.906 * temp1 + 0.424 * temp2 fac2=0.906
+ * temp1 - 0.424 * temp2 lef=l - 4.0e-8 wef=w + 1.0e-8 geo_fac=1 / sqrt(multi *
+ lef * wef * 1e12) vthmis=0.003800 * geo_fac * fac1 dlmis=0.001992 * geo_fac *
+ lef * fac2 dwmis= - 0.001992 * geo_fac * wef * fac2 toxmis=0.001992 * geo_fac
+ * toxp_lvt25 * fac2
pch_lvt25_mis ( d g s b ) pch_lvt25 w=w l=l ad=ad as=as pd=pd ps=ps nrd=nrd nrs=nrs m=multi
+ sa=sa sb=sb
model pch_lvt25 bsim3v3  {
     1: type=p
+ lmin=1.21e-6-(dxl_lvt25+dlmis)                      lmax=2.1e-05
+ wmin=1.0e-5-(dxw_lvt25+dwmis)                       wmax=0.0009001
+ tnom=25                   version=3.24              tox=(toxp_lvt25+toxmis)
+ toxm=(toxp_lvt25+toxmis)  xj=2.1e-07                nch=5.0106e+17
+ lln=1                     lwn=1                     wln=1
+ wwn=-1                    lint=4.358e-08            ll=0
+ lw=0                      lwl=0                     wint=1.5e-08
+ wl=0                      ww=0                      wwl=0
+ mobmod=1                  binunit=2                 xl=-4e-08+(dxl_lvt25+dlmis)
+ xw=1e-08+(dxw_lvt25+dwmis)                          dwg=0
+ dwb=0                     ldif=8e-08                hdif=hdifp_lvt25
+ rsh=7.2                   rd=0                      rs=0
+ vth0=-0.3835383+(dvthp_lvt25+vthmis)                lvth0=2.245623e-08
+ k1=0.6588699              lk1=2.678793e-08          k2=-0.08428726
+ lk2=-1.744752e-08         k3=0                      dvt0=0
+ dvt1=0                    dvt2=0                    dvt0w=0
+ dvt1w=0                   dvt2w=0                   nlx=0
+ w0=0                      k3b=0                     vfb=-1.186274
+ vsat=151000               ua=2.155462e-09           lua=-2.380102e-16
+ ub=5.06322e-19            lub=-1.269086e-27         uc=-5.080309e-12
+ luc=3.353319e-22          rdsw=674                  prwb=0
+ prwg=0                    wr=1                      u0=0.01594737
+ lu0=6.144635e-11          a0=0.953822               la0=-3.263548e-07
+ keta=-0.02698593          lketa=-2.221346e-08       a1=0
+ a2=0.99                   ags=0.3240156             lags=1.794854e-07
+ b0=0                      b1=0                      voff=-0.09785233
+ lvoff=2.024753e-08        nfactor=1                 cit=-0.001110397
+ lcit=1.043132e-10         cdsc=0                    cdscb=0
+ cdscd=0                   eta0=0.0001               etab=-1e-05
+ dsub=0                    pclm=0.5429353            lpclm=3.069956e-07
+ pdiblc1=0                 pdiblc2=-0.0002694357     lpdiblc2=6.347579e-09
+ pdiblcb=0.01839013        lpdiblcb=-1.845052e-07    drout=0
+ pscbe1=4.908216e+08       pscbe2=1e-20              pvag=0
+ delta=0.01                alpha0=0                  alpha1=0.1476
+ beta0=20.5                kt1=-0.1613               kt2=0.01023361
+ lkt2=7.388069e-09         at=-45103.43              lat=-0.04956928
+ ute=-0.8377483            lute=-9.123107e-08        ua1=1.670882e-09
+ lua1=-5.104973e-16        ub1=-2.059226e-18         uc1=2.50956e-11
+ luc1=-8.781355e-17        kt1l=0                    prt=0
+ cj=cjp_lvt25              mj=0.3576069              pb=0.8564895
+ cjsw=cjswp_lvt25          mjsw=0.2                  pbsw=0.8564895
+ cjswg=cjswgp_lvt25        mjswg=0.2                 pbswg=0.8564895
+ tcj=0.001012982           tcjsw=0.0006497512        tcjswg=0.0006497512
+ tpb=0.00202374            tpbsw=0.00202374          tpbswg=0.00202374
+ js=2.03e-7                jsw=1.3e-12               n=1
+ xti=3                     cgdo=cgop_lvt25           cgso=cgop_lvt25
+ capmod=3                  nqsmod=0                  xpart=1
+ cf=0                      tlev=1                    dlc=3.0e-08
+ tlevc=1                   cgdl=cglp_lvt25           cgsl=cglp_lvt25
+ wwc=-0.018                dwc=0                     noia=2.0e+19
+ noib=6.0e+3               noic=6.0e-12              em=1.0e+8
+ ef=1.262                  noimod=2                  sa0=0.35e-6
+ sb0=0.35e-6               kvsat=-1                  wlod=0.3e-6
+ tku0=0.03                 ku0=8.5e-08               llodku0=1
+ wlodku0=1                 lku0=8.0e-09              wku0=6.0e-07
+ pku0=0                    kvth0=1.1e-09             stk2=0
+ steta0=-3e-10             lkvth0=-1.0e-07           wkvth0=0
+ pkvth0=0                  llodvth=1                 wlodvth=1
+ lodk2=1                   lodeta0=1                 minr=1e-3
+ imax=0.01                 imelt=0.01

     2: type=p
+ lmin=5e-7-(dxl_lvt25+dlmis)                         lmax=1.21e-6-(dxl_lvt25+dlmis)
+ wmin=1.0e-5-(dxw_lvt25+dwmis)                       wmax=0.0009001
+ tnom=25                   version=3.24              tox=(toxp_lvt25+toxmis)
+ toxm=(toxp_lvt25+toxmis)  xj=2.1e-07                nch=5.0106e+17
+ lln=1                     lwn=1                     wln=1
+ wwn=-1                    lint=4.358e-08            ll=0
+ lw=0                      lwl=0                     wint=1.5e-08
+ wl=0                      ww=0                      wwl=0
+ mobmod=1                  binunit=2                 xl=-4e-08+(dxl_lvt25+dlmis)
+ xw=1e-08+(dxw_lvt25+dwmis)                          dwg=0
+ dwb=0                     ldif=8e-08                hdif=hdifp_lvt25
+ rsh=7.2                   rd=0                      rs=0
+ vth0=-0.3782912+(dvthp_lvt25+vthmis)                lvth0=1.677454e-08
+ k1=0.7062972              lk1=-2.456824e-08         k2=-0.08937234
+ lk2=-1.194119e-08         k3=0                      dvt0=0
+ dvt1=0                    dvt2=0                    dvt0w=0
+ dvt1w=0                   dvt2w=0                   nlx=0
+ w0=0                      k3b=0                     vfb=-1.174776
+ vsat=151000               ua=2.059412e-09           lua=-1.340032e-16
+ ub=2.935173e-19           lub=2.291643e-25          uc=-7.222517e-12
+ luc=2.320003e-18          rdsw=674                  prwb=0
+ prwg=0                    wr=1                      u0=0.01600476
+ lu0=-6.923911e-13         a0=0.8025334              la0=-1.625334e-07
+ keta=-0.06486069          lketa=1.879885e-08        a1=0
+ a2=0.99                   ags=0.7417099             lags=-2.728107e-07
+ b0=0                      b1=0                      voff=-0.0859424
+ lvoff=7.350986e-09        nfactor=1                 cit=-0.001092485
+ lcit=8.491668e-11         cdsc=0                    cdscb=0
+ cdscd=0                   eta0=-0.0003726143        leta0=5.117656e-10
+ etab=0.0005916642         letab=-6.515059e-10       dsub=0
+ pclm=0.8230612            lpclm=3.663991e-09        pdiblc1=0
+ pdiblc2=-5.93816e-05      lpdiblc2=6.120124e-09     pdiblcb=-0.2318193
+ lpdiblcb=8.643151e-08     drout=0                   pscbe1=4.908216e+08
+ pscbe2=1e-20              pvag=0                    delta=0.01
+ alpha0=0                  alpha1=0.1476             beta0=20.5
+ kt1=-0.1613               kt2=0.02973644            lkt2=-1.373037e-08
+ at=-48807.64              lat=-0.0455582            ute=-0.8118809
+ lute=-1.192414e-07        ua1=1.474837e-09          lua1=-2.982111e-16
+ ub1=-2.059226e-18         uc1=-5.6e-11              kt1l=0
+ prt=0                     cj=cjp_lvt25              mj=0.3576069
+ pb=0.8564895              cjsw=cjswp_lvt25          mjsw=0.2
+ pbsw=0.8564895            cjswg=cjswgp_lvt25        mjswg=0.2
+ pbswg=0.8564895           tcj=0.001012982           tcjsw=0.0006497512
+ tcjswg=0.0006497512       tpb=0.00202374            tpbsw=0.00202374
+ tpbswg=0.00202374         js=2.03e-7                jsw=1.3e-12
+ n=1                       xti=3                     cgdo=cgop_lvt25
+ cgso=cgop_lvt25           capmod=3                  nqsmod=0
+ xpart=1                   cf=0                      dlc=3.0e-08
+ tlev=1                    tlevc=1                   cgdl=cglp_lvt25
+ cgsl=cglp_lvt25           wwc=-0.018                dwc=0
+ noia=2.0e+19              noib=6.0e+3               noic=6.0e-12
+ em=1.0e+8                 ef=1.262                  noimod=2
+ sa0=0.35e-6               sb0=0.35e-6               kvsat=-1
+ wlod=0.3e-6               tku0=0.03                 ku0=8.5e-08
+ llodku0=1                 wlodku0=1                 lku0=8.0e-09
+ wku0=6.0e-07              pku0=0                    kvth0=1.1e-09
+ stk2=0                    steta0=-3e-10             lkvth0=-1.0e-07
+ wkvth0=0                  pkvth0=0                  llodvth=1
+ wlodvth=1                 lodk2=1                   lodeta0=1
+ minr=1e-3                 imax=0.01                 imelt=0.01

     3: type=p
+ lmin=3.7e-7               lmax=5e-7-(dxl_lvt25+dlmis)
+ wmin=1.0e-5-(dxw_lvt25+dwmis)                       wmax=0.0009001
+ tnom=25                   version=3.24              tox=(toxp_lvt25+toxmis)
+ toxm=(toxp_lvt25+toxmis)  xj=2.1e-07                nch=5.0106e+17
+ lln=1                     lwn=1                     wln=1
+ wwn=-1                    lint=4.358e-08            ll=0
+ lw=0                      lwl=0                     wint=1.5e-08
+ wl=0                      ww=0                      wwl=0
+ mobmod=1                  binunit=2                 xl=-4e-08+(dxl_lvt25+dlmis)
+ xw=1e-08+(dxw_lvt25+dwmis)                          dwg=0
+ dwb=0                     ldif=8e-08                hdif=hdifp_lvt25
+ rsh=7.2                   rd=0                      rs=0
+ vth0=-0.4035368+(dvthp_lvt25+vthmis)                lvth0=2.618708e-08
+ k1=1.10723                lk1=-1.74052e-07          k2=-0.2218984
+ lk2=3.746983e-08          k3=0                      dvt0=0
+ dvt1=0                    dvt2=0                    dvt0w=0
+ dvt1w=0                   dvt2w=0                   nlx=0
+ w0=0                      k3b=0                     vsat=151000
+ ua=5.386926e-10           lua=4.329819e-16          ub=1.910593e-18
+ lub=-3.737464e-25         uc=2.980893e-11           luc=-1.14868e-17
+ rdsw=674                  prwb=0                    prwg=0
+ wr=1                      u0=0.01424166             lu0=6.56661e-10
+ a0=-1.954203              la0=8.652884e-07          keta=-0.07832187
+ lketa=2.381772e-08        a1=0                      a2=0.99
+ ags=0.01                  b0=0                      b1=0
+ voff=-0.07004911          lvoff=1.425334e-09        nfactor=1
+ cit=-0.001259837          lcit=1.473125e-10         cdsc=0
+ cdscb=0                   cdscd=0                   eta0=-0.008637013
+ leta0=3.593064e-09        etab=-0.0004351685        letab=-2.686616e-10
+ dsub=0                    pclm=0.634555             lpclm=7.394667e-08
+ pdiblc1=0                 pdiblc2=0.03569957        lpdiblc2=-7.212244e-09
+ pdiblcb=0                 drout=0                   pscbe1=4.908216e+08
+ pscbe2=1e-20              pvag=0                    delta=0.01
+ alpha0=0                  alpha1=0.1476             beta0=20.5
+ kt1=-0.1613               kt2=0.03226876            lkt2=-1.467452e-08
+ at=-171000                ute=-0.9673162            lute=-6.128889e-08
+ ua1=1.4689e-09            lua1=-2.959977e-16        ub1=-2.059226e-18
+ uc1=-5.6e-11              kt1l=0                    prt=0
+ cj=cjp_lvt25              mj=0.3576069              pb=0.8564895
+ cjsw=cjswp_lvt25          mjsw=0.2                  pbsw=0.8564895
+ cjswg=cjswgp_lvt25        mjswg=0.2                 pbswg=0.8564895
+ tcj=0.001012982           tcjsw=0.0006497512        tcjswg=0.0006497512
+ tpb=0.00202374            tpbsw=0.00202374          tpbswg=0.00202374
+ js=2.03e-7                jsw=1.3e-12               n=1
+ xti=3                     cgdo=cgop_lvt25           cgso=cgop_lvt25
+ capmod=3                  nqsmod=0                  xpart=1
+ cf=0                      tlev=1                    dlc=3.0e-08
+ tlevc=1                   cgdl=cglp_lvt25           cgsl=cglp_lvt25
+ wwc=-0.018                dwc=0                     noia=2.0e+19
+ noib=6.0e+3               noic=6.0e-12              em=1.0e+8
+ ef=1.262                  noimod=2                  sa0=0.35e-6
+ sb0=0.35e-6               kvsat=-1                  wlod=0.3e-6
+ tku0=0.03                 ku0=8.5e-08               llodku0=1
+ wlodku0=1                 lku0=8.0e-09              wku0=6.0e-07
+ pku0=0                    kvth0=1.1e-09             stk2=0
+ steta0=-3e-10             lkvth0=-1.0e-07           wkvth0=0
+ pkvth0=0                  llodvth=1                 wlodvth=1
+ lodk2=1                   lodeta0=1                 minr=1e-3
+ imax=0.01                 imelt=0.01

     4: type=p
+ lmin=1.21e-6-(dxl_lvt25+dlmis)                      lmax=2.1e-05
+ wmin=1.20e-6-(dxw_lvt25+dwmis)                      wmax=1.0e-5-(dxw_lvt25+dwmis)
+ tnom=25                   version=3.24              tox=(toxp_lvt25+toxmis)
+ toxm=(toxp_lvt25+toxmis)  xj=2.1e-07                nch=5.0106e+17
+ lln=1                     lwn=1                     wln=1
+ wwn=-1                    lint=4.358e-08            ll=0
+ lw=0                      lwl=0                     wint=1.5e-08
+ wl=0                      ww=0                      wwl=0
+ mobmod=1                  binunit=2                 xl=-4e-08+(dxl_lvt25+dlmis)
+ xw=1e-08+(dxw_lvt25+dwmis)                          dwg=0
+ dwb=0                     ldif=8e-08                hdif=hdifp_lvt25
+ rsh=7.2                   rd=0                      rs=0
+ vth0=-0.3839642+(dvthp_lvt25+vthmis)                lvth0=2.161761e-08
+ wvth0=4.251067e-09        pvth0=8.369411e-15        k1=0.6627182
+ lk1=2.247444e-08          wk1=-3.840648e-08         pk1=4.304862e-14
+ k2=-0.08468857            lk2=-1.675725e-08         wk2=4.005075e-09
+ pk2=-6.888842e-15         k3=0                      dvt0=0
+ dvt1=0                    dvt2=0                    dvt0w=0
+ dvt1w=0                   dvt2w=0                   nlx=0
+ w0=0                      k3b=0                     vfb=-1.196183
+ vsat=151000               ua=2.183066e-09           lua=-2.61773e-16
+ wua=-2.754853e-16         pua=2.371522e-22          ub=5.403099e-19
+ lub=-1.57627e-26          wub=-3.39199e-25          pub=1.446462e-31
+ uc=-4.734588e-13          luc=-5.026334e-18         wuc=-4.597634e-17
+ puc=5.016613e-23          rdsw=674                  prwb=0
+ prwg=0                    wr=1                      u0=0.0162409
+ lu0=6.516855e-11          wu0=-2.929435e-09         pu0=-3.714752e-17
+ a0=0.953822               la0=-3.263548e-07         keta=-0.02768819
+ lketa=-2.145301e-08       wketa=7.008639e-09        pketa=-7.589233e-15
+ a1=0                      a2=0.99                   ags=0.3263683
+ lags=1.733775e-07         wags=-2.347986e-08        pags=6.095662e-14
+ b0=0                      b1=0                      voff=-0.09799273
+ lvoff=2.039932e-08        wvoff=1.401174e-09        pvoff=-1.514796e-15
+ nfactor=1                 cit=-0.00111081           lcit=1.08451e-10
+ wcit=4.116035e-12         pcit=-4.129544e-17        cdsc=0
+ cdscb=0                   cdscd=0                   eta0=0.0001
+ etab=-1e-05               dsub=0                    pclm=0.5736984
+ lpclm=2.264681e-07        wpclm=-3.070159e-07       ppclm=8.03664e-13
+ pdiblc1=0                 pdiblc2=-0.0002842414     lpdiblc2=6.496124e-09
+ wpdiblc2=1.47762e-10      ppdiblc2=-1.482472e-15    pdiblcb=0.01839013
+ lpdiblcb=-1.845052e-07    drout=0                   pscbe1=4.908216e+08
+ pscbe2=1e-20              pvag=0                    delta=0.01
+ alpha0=0                  alpha1=0.1476             beta0=20.5
+ kt1=-0.1613               kt2=0.01023361            lkt2=7.388069e-09
+ at=-45103.43              lat=-0.04956928           ute=-0.8850012
+ lute=-6.148346e-08        wute=4.715841e-07         pute=-2.968809e-13
+ ua1=1.526418e-09          lua1=-4.06418e-16         wua1=1.441759e-15
+ pua1=-1.038711e-21        ub1=-2.059226e-18         uc1=2.50956e-11
+ luc1=-8.781355e-17        kt1l=0                    prt=0
+ cj=cjp_lvt25              mj=0.3576069              pb=0.8564895
+ cjsw=cjswp_lvt25          mjsw=0.2                  pbsw=0.8564895
+ cjswg=cjswgp_lvt25        mjswg=0.2                 pbswg=0.8564895
+ tcj=0.001012982           tcjsw=0.0006497512        tcjswg=0.0006497512
+ tpb=0.00202374            tpbsw=0.00202374          tpbswg=0.00202374
+ js=2.03e-7                jsw=1.3e-12               n=1
+ xti=3                     cgdo=cgop_lvt25           cgso=cgop_lvt25
+ capmod=3                  nqsmod=0                  xpart=1
+ cf=0                      tlev=1                    dlc=3.0e-08
+ tlevc=1                   cgdl=cglp_lvt25           cgsl=cglp_lvt25
+ wwc=-0.018                dwc=0                     noia=2.0e+19
+ noib=6.0e+3               noic=6.0e-12              em=1.0e+8
+ ef=1.262                  noimod=2                  sa0=0.35e-6
+ sb0=0.35e-6               kvsat=-1                  wlod=0.3e-6
+ tku0=0.03                 ku0=8.5e-08               llodku0=1
+ wlodku0=1                 lku0=8.0e-09              wku0=6.0e-07
+ pku0=0                    kvth0=1.1e-09             stk2=0
+ steta0=-3e-10             lkvth0=-1.0e-07           wkvth0=0
+ pkvth0=0                  llodvth=1                 wlodvth=1
+ lodk2=1                   lodeta0=1                 minr=1e-3
+ imax=0.01                 imelt=0.01

     5: type=p
+ lmin=5e-7-(dxl_lvt25+dlmis)                         lmax=1.21e-6-(dxl_lvt25+dlmis)
+ wmin=1.20e-6-(dxw_lvt25+dwmis)                      wmax=1.0e-5-(dxw_lvt25+dwmis)
+ tnom=25                   version=3.24              tox=(toxp_lvt25+toxmis)
+ toxm=(toxp_lvt25+toxmis)  xj=2.1e-07                nch=5.0106e+17
+ lln=1                     lwn=1                     wln=1
+ wwn=-1                    lint=4.358e-08            ll=0
+ lw=0                      lwl=0                     wint=1.5e-08
+ wl=0                      ww=0                      wwl=0
+ mobmod=1                  binunit=2                 xl=-4e-08+(dxl_lvt25+dlmis)
+ xw=1e-08+(dxw_lvt25+dwmis)                          dwg=0
+ dwb=0                     ldif=8e-08                hdif=hdifp_lvt25
+ rsh=7.2                   rd=0                      rs=0
+ vth0=-0.37977+(dvthp_lvt25+vthmis)                  lvth0=1.707589e-08
+ wvth0=1.475763e-08        pvth0=-3.007514e-15       k1=0.7050192
+ lk1=-2.333079e-08         wk1=1.275381e-08          pk1=-1.234977e-14
+ k2=-0.08865307            lk2=-1.246434e-08         wk2=-7.178314e-09
+ pk2=5.220979e-15          k3=0                      dvt0=0
+ dvt1=0                    dvt2=0                    dvt0w=0
+ dvt1w=0                   dvt2w=0                   nlx=0
+ w0=0                      k3b=0                     vfb=-1.165333
+ vsat=151000               ua=2.07722e-09            lua=-1.471588e-16
+ wua=-1.777241e-16         pua=1.312924e-22          ub=3.072541e-19
+ lub=2.365994e-25          wub=-1.370928e-25         pub=-7.420248e-32
+ uc=-7.276225e-12          luc=2.339973e-18          wuc=5.360018e-19
+ puc=-1.992949e-25         rdsw=674                  prwb=0
+ prwg=0                    wr=1                      u0=0.01631391
+ lu0=-1.388804e-11         wu0=-3.085358e-09         pu0=1.316934e-16
+ a0=0.7881335              la0=-1.469407e-07         wa0=1.437101e-07
+ pa0=-1.556151e-13         keta=-0.06612958          lketa=2.017286e-08
+ wketa=1.26635e-08         pketa=-1.371254e-14       a1=0
+ a2=0.99                   ags=0.7366954             lags=-2.709411e-07
+ wags=5.004464e-08         pags=-1.865864e-14        b0=0
+ b1=0                      voff=-0.0860112           lvoff=7.425243e-09
+ wvoff=6.86652e-10         pvoff=-7.410837e-16       nfactor=1
+ cit=-0.001085083          lcit=8.059294e-11         wcit=-7.386994e-11
+ pcit=4.315089e-17         cdsc=0                    cdscb=0
+ cdscd=0                   eta0=-0.0003726141        leta0=5.117655e-10
+ etab=0.0006120667         letab=-6.735987e-10       wetab=-2.036185e-10
+ petab=2.204863e-16        dsub=0                    pclm=0.7647421
+ lpclm=1.959833e-08        wpclm=5.820248e-07        ppclm=-1.590249e-13
+ pdiblc1=0                 pdiblc2=-1.076163e-05     lpdiblc2=6.199989e-09
+ wpdiblc2=-4.852191e-10    ppdiblc2=-7.970535e-16    pdiblcb=-0.2318193
+ lpdiblcb=8.64315e-08      drout=0                   pscbe1=4.908216e+08
+ pscbe2=1e-20              pvag=0                    delta=0.01
+ alpha0=0                  alpha1=0.1476             beta0=20.5
+ kt1=-0.1613               kt2=0.03032961            lkt2=-1.437268e-08
+ wkt2=-5.919874e-09        pkt2=6.410275e-15         at=-48807.64
+ lat=-0.0455582            ute=-0.8261154            lute=-1.252474e-07
+ wute=1.420606e-07         pute=5.994029e-14         ua1=1.424689e-09
+ lua1=-2.962622e-16        wua1=5.004744e-16         pua1=-1.945043e-23
+ ub1=-2.059226e-18         uc1=-5.6e-11              kt1l=0
+ prt=0                     cj=cjp_lvt25              mj=0.3576069
+ pb=0.8564895              cjsw=cjswp_lvt25          mjsw=0.2
+ pbsw=0.8564895            cjswg=cjswgp_lvt25        mjswg=0.2
+ pbswg=0.8564895           tcj=0.001012982           tcjsw=0.0006497512
+ tcjswg=0.0006497512       tpb=0.00202374            tpbsw=0.00202374
+ tpbswg=0.00202374         js=2.03e-7                jsw=1.3e-12
+ n=1                       xti=3                     cgdo=cgop_lvt25
+ cgso=cgop_lvt25           capmod=3                  nqsmod=0
+ xpart=1                   cf=0                      dlc=3.0e-08
+ tlev=1                    tlevc=1                   cgdl=cglp_lvt25
+ cgsl=cglp_lvt25           wwc=-0.018                dwc=0
+ noia=2.0e+19              noib=6.0e+3               noic=6.0e-12
+ em=1.0e+8                 ef=1.262                  noimod=2
+ sa0=0.35e-6               sb0=0.35e-6               kvsat=-1
+ wlod=0.3e-6               tku0=0.03                 ku0=8.5e-08
+ llodku0=1                 wlodku0=1                 lku0=8.0e-09
+ wku0=6.0e-07              pku0=0                    kvth0=1.1e-09
+ stk2=0                    steta0=-3e-10             lkvth0=-1.0e-07
+ wkvth0=0                  pkvth0=0                  llodvth=1
+ wlodvth=1                 lodk2=1                   lodeta0=1
+ minr=1e-3                 imax=0.01                 imelt=0.01

     6: type=p
+ lmin=3.7e-07              lmax=5e-7-(dxl_lvt25+dlmis)
+ wmin=1.20e-6-(dxw_lvt25+dwmis)                      wmax=1.0e-5-(dxw_lvt25+dwmis)
+ tnom=25                   version=3.24              tox=(toxp_lvt25+toxmis)
+ toxm=(toxp_lvt25+toxmis)  xj=2.1e-07                nch=5.0106e+17
+ lln=1                     lwn=1                     wln=1
+ wwn=-1                    lint=4.358e-08            ll=0
+ lw=0                      lwl=0                     wint=1.5e-08
+ wl=0                      ww=0                      wwl=0
+ mobmod=1                  binunit=2                 xl=-4e-08+(dxl_lvt25+dlmis)
+ xw=1e-08+(dxw_lvt25+dwmis)                          dwg=0
+ dwb=0                     ldif=8e-08                hdif=hdifp_lvt25
+ rsh=7.2                   rd=0                      rs=0
+ vth0=-0.4042627+(dvthp_lvt25+vthmis)                lvth0=2.620776e-08
+ wvth0=7.244592e-09        pvth0=-2.063541e-16       k1=1.106813
+ lk1=-1.731358e-07         wk1=4.155578e-09          pk1=-9.144004e-15
+ k2=-0.2209646             lk2=3.686668e-08          wk2=-9.319749e-09
+ pk2=6.019391e-15          k3=0                      dvt0=0
+ dvt1=0                    dvt2=0                    dvt0w=0
+ dvt1w=0                   dvt2w=0                   nlx=0
+ w0=0                      k3b=0                     vfb=-0.9752401
+ vsat=151000               ua=5.044291e-10           lua=4.392407e-16
+ wua=3.419515e-16          pua=-6.246343e-23         ub=2.007711e-18
+ lub=-3.973991e-25         wub=-9.692364e-25         pub=2.360539e-31
+ uc=3.295369e-11           luc=-1.265935e-17         wuc=-3.138474e-17
+ puc=1.170204e-23          rdsw=674                  prwb=0
+ prwg=0                    wr=1                      u0=0.01436143
+ lu0=7.14076e-10           wu0=-1.195283e-09         pu0=-5.730022e-16
+ a0=-2.135083              la0=9.429513e-07          wa0=1.805176e-06
+ pa0=-7.750763e-13         keta=-0.07674707          lketa=2.413148e-08
+ wketa=-1.571648e-08       pketa=-3.13135e-15        a1=0
+ a2=0.99                   ags=0.01                  b0=0
+ b1=0                      voff=-0.07026593          lvoff=1.554774e-09
+ wvoff=2.163777e-09        pvoff=-1.291815e-15       nfactor=1
+ cit=-0.001250451          lcit=1.422488e-10         wcit=-9.367474e-11
+ pcit=5.05349e-17          cdsc=0                    cdscb=0
+ cdscd=0                   eta0=-0.008507479         leta0=3.544769e-09
+ weta0=-1.292742e-09       peta0=4.819861e-16        etab=-0.0004080755
+ letab=-2.932488e-10       wetab=-2.703877e-10       petab=2.453806e-16
+ dsub=0                    pclm=0.533783             lpclm=1.057091e-07
+ wpclm=1.005704e-06        ppclm=-3.169895e-13       pdiblc1=0
+ pdiblc2=0.03688385        lpdiblc2=-7.555797e-09    wpdiblc2=-1.181906e-08
+ ppdiblc2=3.428655e-15     pdiblcb=0                 drout=0
+ pscbe1=4.908216e+08       pscbe2=1e-20              pvag=0
+ delta=0.01                alpha0=0                  alpha1=0.1476
+ beta0=20.5                kt1=-0.1613               kt2=0.03857622
+ lkt2=-1.744735e-08        wkt2=-6.294842e-08        pkt2=2.76728e-14
+ at=-171000                ute=-0.9851395            lute=-6.595686e-08
+ wute=1.778777e-07         pute=4.658624e-14         ua1=1.468681e-09
+ lua1=-3.12664e-16         wua1=2.18918e-18          pua1=1.663302e-22
+ ub1=-1.997826e-18         lub1=-2.289248e-26        wub1=-6.127751e-25
+ pub1=2.284671e-31         uc1=-5.6e-11              kt1l=0
+ prt=0                     cj=cjp_lvt25              mj=0.3576069
+ pb=0.8564895              cjsw=cjswp_lvt25          mjsw=0.2
+ pbsw=0.8564895            cjswg=cjswgp_lvt25        mjswg=0.2
+ pbswg=0.8564895           tcj=0.001012982           tcjsw=0.0006497512
+ tcjswg=0.0006497512       tpb=0.00202374            tpbsw=0.00202374
+ tpbswg=0.00202374         js=2.03e-7                jsw=1.3e-12
+ n=1                       xti=3                     cgdo=cgop_lvt25
+ cgso=cgop_lvt25           capmod=3                  nqsmod=0
+ xpart=1                   cf=0                      dlc=3.0e-08
+ tlev=1                    tlevc=1                   cgdl=cglp_lvt25
+ cgsl=cglp_lvt25           wwc=-0.018                dwc=0
+ noia=2.0e+19              noib=6.0e+3               noic=6.0e-12
+ em=1.0e+8                 ef=1.262                  noimod=2
+ sa0=0.35e-6               sb0=0.35e-6               kvsat=-1
+ wlod=0.3e-6               tku0=0.03                 ku0=8.5e-08
+ llodku0=1                 wlodku0=1                 lku0=8.0e-09
+ wku0=6.0e-07              pku0=0                    kvth0=1.1e-09
+ stk2=0                    steta0=-3e-10             lkvth0=-1.0e-07
+ wkvth0=0                  pkvth0=0                  llodvth=1
+ wlodvth=1                 lodk2=1                   lodeta0=1
+ minr=1e-3                 imax=0.01                 imelt=0.01

     7: type=p
+ lmin=1.21e-6-(dxl_lvt25+dlmis)                      lmax=2.1e-05
+ wmin=5.8e-7-(dxw_lvt25+dwmis)                       wmax=1.20e-6-(dxw_lvt25+dwmis)
+ tnom=25                   version=3.24              tox=(toxp_lvt25+toxmis)
+ toxm=(toxp_lvt25+toxmis)  xj=2.1e-07                nch=5.0106e+17
+ lln=1                     lwn=1                     wln=1
+ wwn=-1                    lint=4.358e-08            ll=0
+ lw=0                      lwl=0                     wint=1.5e-08
+ wl=0                      ww=0                      wwl=0
+ mobmod=1                  binunit=2                 xl=-4e-08+(dxl_lvt25+dlmis)
+ xw=1e-08+(dxw_lvt25+dwmis)                          dwg=0
+ dwb=0                     ldif=8e-08                hdif=hdifp_lvt25
+ rsh=7.2                   rd=0                      rs=0
+ vth0=-0.3885612+(dvthp_lvt25+vthmis)                lvth0=3.3043390e-08
+ wvth0=9.6755010e-09       pvth0=-5.1130840e-15      k1=0.6819998
+ lk1=4.791411e-08          wk1=-6.11587e-08          pk1=1.302981e-14
+ k2=-0.09420194            lk2=-1.483996e-08         wk2=1.523086e-08
+ pk2=-9.151241e-15         k3=0                      dvt0=0
+ dvt1=0                    dvt2=0                    dvt0w=0
+ dvt1w=0                   dvt2w=0                   nlx=0
+ w0=0                      k3b=0                     vfb=-1.156694
+ vsat=1.4990720e+05        lvsat=1.0963790e-02       wvsat=1.2894926e-03
+ pvsat=-1.2937274e-08      ua=2.152495e-09           lua=-3.424896e-16
+ wua=-2.394117e-16         pua=3.323978e-22          ub=2.544129e-19
+ lub=1.457188e-25          wub=-1.840577e-27         pub=-4.590202e-32
+ uc=-2.662969e-11          luc=3.795023e-17          wuc=-1.511199e-17
+ puc=-5.462098e-25         rdsw=674                  prwb=0
+ prwg=0                    wr=1                      u0=1.4673601e-02
+ lu0=-5.0626200e-12        wu0=-1.0800212e-09        pu0=4.5727460e-17
+ a0=0.9614633              la0=-4.030182e-07         wa0=-9.016706e-09
+ pa0=9.04629e-14           keta=-0.0216913           lketa=-2.846017e-08
+ wketa=-6.769795e-11       pketa=6.79205e-16         a1=0
+ a2=0.99                   ags=0.3128099             lags=1.614294e-07
+ wags=-7.480972e-09        pags=7.505539e-14         b0=0
+ b1=0                      voff=-0.09051284          lvoff=1.773431e-08
+ wvoff=-7.425088e-09       pvoff=1.629912e-15        nfactor=1
+ cit=-0.0006685374         lcit=-3.424923e-10        wcit=-5.177652e-10
+ pcit=4.908177e-16         cdsc=0                    cdscb=0
+ cdscd=0                   eta0=0.0001               etab=-1e-05
+ dsub=0                    pclm=0.1042367            lpclm=8.525682e-07
+ wpclm=2.46949e-07         ppclm=6.486587e-14        pdiblc1=0
+ pdiblc2=-0.000235732      lpdiblc2=6.009437e-09     wpdiblc2=9.052103e-11
+ ppdiblc2=-9.081815e-16    pdiblcb=0.03500053        lpdiblcb=-3.511551e-07
+ wpdiblcb=-1.960031e-08    ppdiblcb=1.966469e-13     drout=0
+ pscbe1=4.908216e+08       pscbe2=1e-20              pvag=0
+ delta=0.01                alpha0=0                  alpha1=0.1476
+ beta0=20.5                kt1=-0.1613               kt2=0.009301652
+ lkt2=1.673827e-08         wkt2=1.099712e-09         pkt2=-1.103323e-14
+ at=-49915.15              lat=-0.001693858          wat=0.005677841
+ pat=-5.6493e-08           ute=-0.3899921            lute=-5.678347e-07
+ wute=-1.125267e-07        pute=3.006135e-13         ua1=3.221025e-09
+ lua1=-2.042745e-15        wua1=-5.578784e-16        pua1=8.921557e-22
+ ub1=-2.059226e-18         uc1=2.509559e-11          luc1=-8.781355e-17
+ kt1l=0                    prt=0                     cj=cjp_lvt25
+ mj=0.3576069              pb=0.8564895              cjsw=cjswp_lvt25
+ mjsw=0.2                  pbsw=0.8564895            cjswg=cjswgp_lvt25
+ mjswg=0.2                 pbswg=0.8564895           tcj=0.001012982
+ tcjsw=0.0006497512        tcjswg=0.0006497512       tpb=0.00202374
+ tpbsw=0.00202374          tpbswg=0.00202374         js=2.03e-7
+ jsw=1.3e-12               n=1                       xti=3
+ cgdo=cgop_lvt25           cgso=cgop_lvt25           capmod=3
+ nqsmod=0                  xpart=1                   cf=0
+ tlev=1                    tlevc=1                   dlc=3.0e-08
+ cgdl=cglp_lvt25           cgsl=cglp_lvt25           wwc=-0.018
+ dwc=0                     noia=2.0e+19              noib=6.0e+3
+ noic=6.0e-12              em=1.0e+8                 ef=1.262
+ noimod=2                  sa0=0.35e-6               sb0=0.35e-6
+ kvsat=-1                  wlod=0.3e-6               tku0=0.03
+ ku0=8.5e-08               llodku0=1                 wlodku0=1
+ lku0=8.0e-09              wku0=6.0e-07              pku0=0
+ kvth0=1.1e-09             stk2=0                    steta0=-3e-10
+ lkvth0=-1.0e-07           wkvth0=0                  pkvth0=0
+ llodvth=1                 wlodvth=1                 lodk2=1
+ lodeta0=1                 minr=1e-3                 imax=0.01
+ imelt=0.01

     8: type=p
+ lmin=5e-7-(dxl_lvt25+dlmis)                         lmax=1.21e-6-(dxl_lvt25+dlmis)
+ wmin=5.8e-7-(dxw_lvt25+dwmis)                       wmax=1.20e-6-(dxw_lvt25+dwmis)
+ tnom=25                   version=3.24              tox=(toxp_lvt25+toxmis)
+ toxm=(toxp_lvt25+toxmis)  xj=2.1e-07                nch=5.0106e+17
+ lln=1                     lwn=1                     wln=1
+ wwn=-1                    lint=4.358e-08            ll=0
+ lw=0                      lwl=0                     wint=1.5e-08
+ wl=0                      ww=0                      wwl=0
+ mobmod=1                  binunit=2                 xl=-4e-08+(dxl_lvt25+dlmis)
+ xw=1e-08+(dxw_lvt25+dwmis)                          dwg=0
+ dwb=0                     ldif=8e-08                hdif=hdifp_lvt25
+ rsh=7.2                   rd=0                      rs=0
+ vth0=-0.3702509+(dvthp_lvt25+vthmis)                lvth0=1.3216305e-08
+ wvth0=3.5251200e-09       pvth0=1.5467975e-15       k1=0.7607205
+ lk1=-3.732786e-08         wk1=-5.297371e-08         pk1=4.166779e-15
+ k2=-0.09738045            lk2=-1.139815e-08         wk2=3.119994e-09
+ pk2=3.962883e-15          k3=0                      dvt0=0
+ dvt1=0                    dvt2=0                    dvt0w=0
+ dvt1w=0                   dvt2w=0                   nlx=0
+ w0=0                      k3b=0                     vfb=-1.13432
+ vsat=1.7151050e+05        lvsat=-1.2429117e-02      wvsat=-2.4202388e-02
+ pvsat=1.4666360e-08       ua=1.965406e-09           lua=-1.399024e-16
+ wua=-4.578384e-17         pua=1.2273e-22            ub=1.647633e-19
+ lub=2.427951e-25          wub=3.104641e-26          pub=-8.151339e-32
+ uc=9.416496e-12           luc=-1.082032e-18         wuc=-1.916141e-17
+ puc=3.838672e-24          rdsw=674                  prwb=0
+ prwg=0                    wr=1                      u0=1.4433551e-02
+ lu0=2.5487235e-10         wu0=-8.6653500e-10        pu0=-1.8544394e-16
+ a0=0.7416299              la0=-1.649738e-07         wa0=1.985845e-07
+ pa0=-1.34336e-13          keta=-0.05842841          lketa=1.132025e-08
+ wketa=3.576124e-09        pketa=-3.266472e-15       a1=0
+ a2=0.99                   ags=0.6991889             lags=-2.569572e-07
+ wags=9.430239e-08         pags=-3.51597e-14         b0=0
+ b1=0                      voff=-0.07758927          lvoff=3.740139e-09
+ wvoff=-9.251236e-09       pvoff=3.60734e-15         nfactor=1
+ cit=-0.001029325          lcit=4.818287e-11         wcit=-1.39664e-10
+ pcit=8.139478e-17         cdsc=0                    cdscb=0
+ cdscd=0                   eta0=-0.000281737         leta0=4.1336e-10
+ weta0=-1.072353e-10       peta0=1.161187e-16        etab=0.0005560081
+ letab=-6.128962e-10       wetab=-1.374695e-10       petab=1.488574e-16
+ dsub=0                    pclm=0.9502288            lpclm=-6.350592e-08
+ wpclm=3.631506e-07        ppclm=-6.096188e-14       pdiblc1=0
+ pdiblc2=0.001635744       lpdiblc2=3.982925e-09     wpdiblc2=-2.428099e-09
+ ppdiblc2=1.819083e-15     pdiblcb=-0.4412043        lpdiblcb=1.644986e-07
+ wpdiblcb=2.470744e-07     ppdiblcb=-9.211922e-14    drout=0
+ pscbe1=4.908216e+08       pscbe2=1e-20              pvag=0
+ delta=0.01                alpha0=0                  alpha1=0.1476
+ beta0=20.5                kt1=-0.1613               kt2=0.03737658
+ lkt2=-1.36624e-08         wkt2=-1.423531e-08        pkt2=5.572145e-15
+ at=11284.01               lat=-0.06796277           wat=-0.07090817
+ pat=2.643741e-08          ute=-0.8404544            lute=-8.005608e-08
+ wute=1.589806e-07         pute=6.614498e-15         ua1=1.499035e-09
+ lua1=-1.781056e-16        wua1=4.127461e-16         pua1=-1.588753e-22
+ ub1=-2.059226e-18         uc1=-5.6e-11              kt1l=0
+ prt=0                     cj=cjp_lvt25              mj=0.3576069
+ pb=0.8564895              cjsw=cjswp_lvt25          mjsw=0.2
+ pbsw=0.8564895            cjswg=cjswgp_lvt25        mjswg=0.2
+ pbswg=0.8564895           tcj=0.001012982           tcjsw=0.0006497512
+ tcjswg=0.0006497512       tpb=0.00202374            tpbsw=0.00202374
+ tpbswg=0.00202374         js=2.03e-7                jsw=1.3e-12
+ n=1                       xti=3                     cgdo=cgop_lvt25
+ cgso=cgop_lvt25           capmod=3                  nqsmod=0
+ xpart=1                   cf=0                      tlev=1
+ tlevc=1                   dlc=3.0e-08               cgdl=cglp_lvt25
+ cgsl=cglp_lvt25           wwc=-0.018                dwc=0
+ noia=2.0e+19              noib=6.0e+3               noic=6.0e-12
+ em=1.0e+8                 ef=1.262                  noimod=2
+ sa0=0.35e-6               sb0=0.35e-6               kvsat=-1
+ wlod=0.3e-6               tku0=0.03                 ku0=8.5e-08
+ llodku0=1                 wlodku0=1                 lku0=8.0e-09
+ wku0=6.0e-07              pku0=0                    kvth0=1.1e-09
+ stk2=0                    steta0=-3e-10             lkvth0=-1.0e-07
+ wkvth0=0                  pkvth0=0                  llodvth=1
+ wlodvth=1                 lodk2=1                   lodeta0=1
+ minr=1e-3                 imax=0.01                 imelt=0.01

     9: type=p
+ lmin=3.7e-07              lmax=5e-7-(dxl_lvt25+dlmis)
+ wmin=5.8e-7-(dxw_lvt25+dwmis)                       wmax=1.20e-6-(dxw_lvt25+dwmis)
+ tnom=25                   version=3.24              tox=(toxp_lvt25+toxmis)
+ toxm=(toxp_lvt25+toxmis)  xj=2.1e-07                nch=5.0106e+17
+ lln=1                     lwn=1                     wln=1
+ wwn=-1                    lint=4.358e-08            ll=0
+ lw=0                      lwl=0                     wint=1.5e-08
+ wl=0                      ww=0                      wwl=0
+ mobmod=1                  binunit=2                 xl=-4e-08+(dxl_lvt25+dlmis)
+ xw=1e-08+(dxw_lvt25+dwmis)                          dwg=0
+ dwb=0                     ldif=8e-08                hdif=hdifp_lvt25
+ rsh=7.2                   rd=0                      rs=0
+ vth0=-0.4067170+(dvthp_lvt25+vthmis)                lvth0=2.6812332e-08
+ wvth0=1.0140631e-08       pvth0=-9.1972940e-16      k1=1.163442
+ lk1=-1.874786e-07         wk1=-6.266622e-08         pk1=7.780545e-15
+ k2=-0.2475377             lk2=4.458649e-08          wk2=2.203658e-08
+ pk2=-3.089982e-15         k3=0                      dvt0=0
+ dvt1=0                    dvt2=0                    dvt0w=0
+ dvt1w=0                   dvt2w=0                   nlx=0
+ w0=0                      k3b=0                     vfb=-0.8817574
+ vsat=1.3648692e+05        lvsat=6.2907490e-04       wvsat=1.7125441e-02
+ pvsat=-7.4230860e-10      ua=1.195577e-10           lua=5.483038e-16
+ wua=7.960996e-16          pua=-1.911579e-22         ub=1.593939e-18
+ lub=-2.900586e-25         wub=-4.809846e-25         pub=1.093922e-31
+ uc=5.870042e-12           luc=2.402266e-19          wuc=5.739569e-19
+ puc=-3.519462e-24         rdsw=674                  prwb=0
+ prwg=0                    wr=1                      u0=1.4126849e-02
+ lu0=3.6922310e-10         wu0=-9.1848920e-10        pu0=-1.6607332e-16
+ a0=-1.041056              la0=4.996827e-07          wa0=5.14225e-07
+ pa0=-2.520194e-13         keta=-0.1106989           lketa=3.080879e-08
+ wketa=2.434669e-08        pketa=-1.101057e-14       a1=0
+ a2=0.99                   ags=0.01                  b0=0
+ b1=0                      voff=-0.06568749          lvoff=-6.973183e-10
+ wvoff=-3.238775e-09       pvoff=1.365654e-15        nfactor=1
+ cit=-0.001575053          lcit=2.516521e-10         wcit=2.893558e-10
+ pcit=-7.856098e-17        cdsc=0                    cdscb=0
+ cdscd=0                   eta0=-0.01063095          leta0=4.27196e-09
+ weta0=1.212951e-09        peta0=-3.760996e-16       etab=-0.0007691921
+ letab=-1.188086e-10       wetab=1.557298e-10        petab=3.954101e-17
+ dsub=0                    pclm=1.408507             lpclm=-2.343704e-07
+ wpclm=-2.647015e-08       ppclm=8.430432e-14        pdiblc1=0
+ pdiblc2=0.02326492        lpdiblc2=-4.081296e-09    wpdiblc2=4.251277e-09
+ ppdiblc2=-6.712558e-16    pdiblcb=0                 drout=0
+ pscbe1=4.908216e+08       pscbe2=1e-20              pvag=0
+ delta=0.01                alpha0=0                  alpha1=0.1476
+ beta0=20.5                kt1=-0.1613               kt2=-0.02442883
+ lkt2=9.381131e-09         wkt2=1.139753e-08         pkt2=-3.984801e-15
+ at=-171000                ute=-0.9508262            lute=-3.890506e-08
+ wute=1.373879e-07         pute=1.466512e-14         ua1=1.470533e-09
+ lua1=-1.674788e-16        pua1=-4.988391e-24        ub1=-2.517127e-18
+ lub1=1.707237e-25         uc1=-5.6e-11              kt1l=0
+ prt=0                     cj=cjp_lvt25              mj=0.3576069
+ pb=0.8564895              cjsw=cjswp_lvt25          mjsw=0.2
+ pbsw=0.8564895            cjswg=cjswgp_lvt25        mjswg=0.2
+ pbswg=0.8564895           tcj=0.001012982           tcjsw=0.0006497512
+ tcjswg=0.0006497512       tpb=0.00202374            tpbsw=0.00202374
+ tpbswg=0.00202374         js=2.03e-7                jsw=1.3e-12
+ n=1                       xti=3                     cgdo=cgop_lvt25
+ cgso=cgop_lvt25           capmod=3                  nqsmod=0
+ xpart=1                   cf=0                      tlev=1
+ tlevc=1                   dlc=3.0e-08               cgdl=cglp_lvt25
+ cgsl=cglp_lvt25           wwc=-0.018                dwc=0
+ noia=2.0e+19              noib=6.0e+3               noic=6.0e-12
+ em=1.0e+8                 ef=1.262                  noimod=2
+ sa0=0.35e-6               sb0=0.35e-6               kvsat=-1
+ wlod=0.3e-6               tku0=0.03                 ku0=8.5e-08
+ llodku0=1                 wlodku0=1                 lku0=8.0e-09
+ wku0=6.0e-07              pku0=0                    kvth0=1.1e-09
+ stk2=0                    steta0=-3e-10             lkvth0=-1.0e-07
+ wkvth0=0                  pkvth0=0                  llodvth=1
+ wlodvth=1                 lodk2=1                   lodeta0=1
+ minr=1e-3                 imax=0.01                 imelt=0.01

     10: type=p
+ lmin=1.21e-6-(dxl_lvt25+dlmis)                      lmax=2.1e-05
+ wmin=1.5e-07              wmax=5.8e-7-(dxw_lvt25+dwmis)
+ tnom=25                   version=3.24              tox=(toxp_lvt25+toxmis)
+ toxm=(toxp_lvt25+toxmis)  xj=2.1e-07                nch=5.0106e+17
+ lln=1                     lwn=1                     wln=1
+ wwn=-1                    lint=4.358e-08            ll=0
+ lw=0                      lwl=0                     wint=1.5e-08
+ wl=0                      ww=0                      wwl=0
+ mobmod=1                  binunit=2                 xl=-4e-08+(dxl_lvt25+dlmis)
+ xw=1e-08+(dxw_lvt25+dwmis)                          dwg=0
+ dwb=0                     ldif=8e-08                hdif=hdifp_lvt25
+ rsh=7.2                   rd=0                      rs=0
+ vth0=-0.3800694+(dvthp_lvt25+vthmis)                lvth0=2.5917720e-08
+ wvth0=4.9200960e-09       pvth0=-1.1227137e-15      k1=0.5984753
+ lk1=8.488056e-08          wk1=-1.4385e-08           pk1=-7.671394e-15
+ k2=-0.07085884            lk2=-3.743363e-08         wk2=2.15872e-09
+ pk2=3.501205e-15          k3=0                      dvt0=0
+ dvt1=0                    dvt2=0                    dvt0w=0
+ dvt1w=0                   dvt2w=0                   nlx=0
+ w0=0                      k3b=0                     vfb=-1.0592
+ vsat=1.5246592e+05        lvsat=-1.4707326e-02      wvsat=-1.4338404e-04
+ pvsat=1.4385508e-09       ua=1.999559e-09           lua=3.07975e-16
+ wua=-1.537674e-16         pua=-3.186235e-23         ub=2.796782e-19
+ lub=5.774054e-26          wub=-1.598912e-26         pub=3.365829e-33
+ uc=-5.844156e-11          luc=4.223287e-17          wuc=2.702658e-18
+ puc=-2.94449e-24          rdsw=674                  prwb=0
+ prwg=0                    wr=1                      u0=1.3006170e-02
+ lu0=2.5365454e-10         wu0=-1.4626059e-10        pu0=-9.9154130e-17
+ a0=0.8976998              la0=-1.982719e-07         wa0=2.669081e-08
+ pa0=-2.419507e-14         keta=-0.02531755          lketa=-2.882861e-08
+ wketa=1.963003e-09        pketa=8.855332e-16        a1=0
+ a2=0.99                   ags=0.3098276             lags=3.255564e-07
+ wags=-5.810876e-09        pags=-1.685574e-14        b0=0
+ b1=0                      voff=-0.1057689           lvoff=2.001167e-08
+ wvoff=1.118317e-09        pvoff=3.545903e-16        nfactor=1
+ cit=-0.0017422            lcit=6.954001e-10         wcit=8.348602e-11
+ pcit=-9.040201e-17        cdsc=0                    cdscb=0
+ cdscd=0                   eta0=0.0001               etab=-1e-05
+ dsub=0                    pclm=0.2353081            lpclm=1.51378e-06
+ wpclm=1.735491e-07        ppclm=-3.054128e-13       pdiblc1=0
+ pdiblc2=-0.0001203587     lpdiblc2=4.43711e-09      wpdiblc2=2.591181e-11
+ ppdiblc2=-2.767843e-17    pdiblcb=0                 drout=0
+ pscbe1=4.908216e+08       pscbe2=1e-20              pvag=0
+ delta=0.01                alpha0=0                  alpha1=0.1476
+ beta0=20.5                kt1=-0.1613               kt2=0.01314171
+ lkt2=-5.147999e-09        wkt2=-1.050721e-09        pkt2=1.223076e-15
+ at=-37330.32              lat=-0.1271248            wat=-0.001369664
+ pat=1.374831e-08          ute=-0.5744605            lute=-3.871443e-08
+ wute=-9.22444e-09         pute=4.306185e-15         ua1=2.247716e-09
+ lua1=-5.277266e-16        wua1=-1.282531e-17        pua1=4.37452e-23
+ ub1=-2.059226e-18         uc1=2.509559e-11          luc1=-8.781355e-17
+ kt1l=0                    prt=0                     cj=cjp_lvt25
+ mj=0.3576069              pb=0.8564895              cjsw=cjswp_lvt25
+ mjsw=0.2                  pbsw=0.8564895            cjswg=cjswgp_lvt25
+ mjswg=0.2                 pbswg=0.8564895           tcj=0.001012982
+ tcjsw=0.0006497512        tcjswg=0.0006497512       tpb=0.00202374
+ tpbsw=0.00202374          tpbswg=0.00202374         js=2.03e-7
+ jsw=1.3e-12               n=1                       xti=3
+ cgdo=cgop_lvt25           cgso=cgop_lvt25           capmod=3
+ nqsmod=0                  xpart=1                   cf=0
+ tlev=1                    tlevc=1                   dlc=3.0e-08
+ cgdl=cglp_lvt25           cgsl=cglp_lvt25           wwc=-0.018
+ dwc=0                     noia=2.0e+19              noib=6.0e+3
+ noic=6.0e-12              em=1.0e+8                 ef=1.262
+ noimod=2                  sa0=0.35e-6               sb0=0.35e-6
+ kvsat=-1                  wlod=0.3e-6               tku0=0.03
+ ku0=8.5e-08               llodku0=1                 wlodku0=1
+ lku0=8.0e-09              wku0=6.0e-07              pku0=0
+ kvth0=1.1e-09             stk2=0                    steta0=-3e-10
+ lkvth0=-1.0e-07           wkvth0=0                  pkvth0=0
+ llodvth=1                 wlodvth=1                 lodk2=1
+ lodeta0=1                 minr=1e-3                 imax=0.01
+ imelt=0.01

     11: type=p
+ lmin=5e-7-(dxl_lvt25+dlmis)                         lmax=1.21e-6-(dxl_lvt25+dlmis)
+ wmin=1.5e-07              wmax=5.8e-7-(dxw_lvt25+dwmis)
+ tnom=25                   version=3.24              tox=(toxp_lvt25+toxmis)
+ toxm=(toxp_lvt25+toxmis)  xj=2.1e-07                nch=5.0106e+17
+ lln=1                     lwn=1                     wln=1
+ wwn=-1                    lint=4.358e-08            ll=0
+ lw=0                      lwl=0                     wint=1.5e-08
+ wl=0                      ww=0                      wwl=0
+ mobmod=1                  binunit=2                 xl=-4e-08+(dxl_lvt25+dlmis)
+ xw=1e-08+(dxw_lvt25+dwmis)                          dwg=0
+ dwb=0                     ldif=8e-08                hdif=hdifp_lvt25
+ rsh=7.2                   rd=0                      rs=0
+ vth0=-0.3710917+(dvthp_lvt25+vthmis)                lvth0=1.6196365e-08
+ wvth0=3.9959720e-09       pvth0=-1.2203598e-16      k1=0.7175485
+ lk1=-4.40566e-08          wk1=-2.879734e-08         pk1=7.934867e-15
+ k2=-0.1048836             lk2=-5.902162e-10         wk2=7.321778e-09
+ pk2=-2.089562e-15         k3=0                      dvt0=0
+ dvt1=0                    dvt2=0                    dvt0w=0
+ dvt1w=0                   dvt2w=0                   nlx=0
+ w0=0                      k3b=0                     vfb=-1.13432
+ vsat=1.2088939e+05        lvsat=1.9485002e-02       wvsat=4.1454300e-03
+ pvsat=-3.2055480e-09      ua=2.229303e-09           lua=5.919905e-17
+ wua=-1.93566e-16          pua=1.123315e-23          ub=2.209751e-19
+ lub=1.213066e-25          wub=-4.321945e-28         pub=-1.347984e-32
+ uc=-2.511994e-11          luc=6.150891e-18          wuc=1.789924e-19
+ puc=-2.117644e-25         rdsw=674                  prwb=0
+ prwg=0                    wr=1                      u0=1.3282422e-02
+ lu0=-4.5480420e-11        wu0=-2.2190215e-10        pu0=-1.7246383e-17
+ a0=1.106872               la0=-4.247714e-07         wa0=-5.950846e-09
+ pa0=1.115061e-14          keta=-0.05765576          lketa=6.188496e-09
+ wketa=3.143439e-09        pketa=-3.926896e-16       a1=0
+ a2=0.99                   ags=0.9258054             lags=-3.414489e-07
+ wags=-3.260281e-08        pags=1.215563e-14         b0=0
+ b1=0                      voff=-0.09755978          lvoff=1.112247e-08
+ wvoff=1.93225e-09         pvoff=-5.267679e-16       nfactor=1
+ cit=-0.001325405          lcit=2.440775e-10         wcit=2.614071e-11
+ pcit=-2.83062e-17         cdsc=0                    cdscb=0
+ cdscd=0                   eta0=-0.0004575361        leta0=6.037223e-10
+ weta0=-8.787798e-12       peta0=9.515791e-18        etab=0.0003229585
+ letab=-3.605407e-10       wetab=-6.96165e-12        petab=7.538345e-18
+ dsub=0                    pclm=1.862239             lpclm=-2.479261e-07
+ wpclm=-1.475751e-07       ppclm=4.231342e-14        pdiblc1=0
+ pdiblc2=-0.003695457      lpdiblc2=8.308368e-09     wpdiblc2=5.573719e-10
+ ppdiblc2=-6.031647e-16    pdiblcb=0                 drout=0
+ pscbe1=4.908216e+08       pscbe2=1e-20              pvag=0
+ delta=0.01                alpha0=0                  alpha1=0.1476
+ beta0=20.5                kt1=-0.1613               kt2=0.01147925
+ lkt2=-3.347825e-09        wkt2=2.67196e-10          pkt2=-2.040165e-16
+ at=-146185.8              lat=-0.009251735          wat=0.0172749
+ pat=-6.440775e-09         ute=-0.5817512            lute=-3.081976e-08
+ wute=1.410683e-08         pute=-2.095785e-14        ua1=2.12101e-09
+ lua1=-3.905236e-16        wua1=6.444033e-17         pua1=-3.992115e-23
+ ub1=-2.059226e-18         uc1=-5.6e-11              kt1l=0
+ prt=0                     cj=cjp_lvt25              mj=0.3576069
+ pb=0.8564895              cjsw=cjswp_lvt25          mjsw=0.2
+ pbsw=0.8564895            cjswg=cjswgp_lvt25        mjswg=0.2
+ pbswg=0.8564895           tcj=0.001012982           tcjsw=0.0006497512
+ tcjswg=0.0006497512       tpb=0.00202374            tpbsw=0.00202374
+ tpbswg=0.00202374         js=2.03e-7                jsw=1.3e-12
+ n=1                       xti=3                     cgdo=cgop_lvt25
+ cgso=cgop_lvt25           capmod=3                  nqsmod=0
+ xpart=1                   cf=0                      tlev=1
+ tlevc=1                   dlc=3.0e-08               cgdl=cglp_lvt25
+ cgsl=cglp_lvt25           wwc=-0.018                dwc=0
+ noia=2.0e+19              noib=6.0e+3               noic=6.0e-12
+ em=1.0e+8                 ef=1.262                  noimod=2
+ sa0=0.35e-6               sb0=0.35e-6               kvsat=-1
+ wlod=0.3e-6               tku0=0.03                 ku0=8.5e-08
+ llodku0=1                 wlodku0=1                 lku0=8.0e-09
+ wku0=6.0e-07              pku0=0                    kvth0=1.1e-09
+ stk2=0                    steta0=-3e-10             lkvth0=-1.0e-07
+ wkvth0=0                  pkvth0=0                  llodvth=1
+ wlodvth=1                 lodk2=1                   lodeta0=1
+ minr=1e-3                 imax=0.01                 imelt=0.01

     12: type=p
+ lmin=3.7e-07              lmax=5e-07-(dxl_lvt25+dlmis)
+ wmin=1.5e-07              wmax=5.8e-07-(dxw_lvt25+dwmis)
+ tnom=25                   version=3.24              tox=(toxp_lvt25+toxmis)
+ toxm=(toxp_lvt25+toxmis)  xj=2.1e-07                nch=5.0106e+17
+ lln=1                     lwn=1                     wln=1
+ wwn=-1                    lint=4.358e-08            ll=0
+ lw=0                      lwl=0                     wint=1.5e-08
+ wl=0                      ww=0                      wwl=0
+ mobmod=1                  binunit=2                 xl=-4e-08+(dxl_lvt25+dlmis)
+ xw=1e-08+(dxw_lvt25+dwmis)                          dwg=0
+ dwb=0                     ldif=8e-08                hdif=hdifp_lvt25
+ rsh=7.2                   rd=0                      rs=0
+ vth0=-0.3901487+(dvthp_lvt25+vthmis)                lvth0=2.3301578e-08
+ wvth0=8.6237430e-10       pvth0=1.0462947e-15       k1=1.116411
+ lk1=-1.927685e-07         wk1=-3.632884e-08         pk1=1.074291e-14
+ k2=-0.2232544             lk2=4.354316e-08          wk2=8.437962e-09
+ pk2=-2.50572e-15          k3=0                      dvt0=0
+ dvt1=0                    dvt2=0                    dvt0w=0
+ dvt1w=0                   dvt2w=0                   nlx=0
+ w0=0                      k3b=0                     vfb=-0.9722669
+ vsat=1.7558323e+05        lvsat=-9.0704510e-04      wvsat=-4.7684950e-03
+ pvsat=1.1791870e-10       ua=1.639426e-09           lua=2.791287e-16
+ wua=-5.502672e-17         pua=-4.041985e-23         ub=8.9743e-19
+ lub=-1.309029e-25         wub=-9.093981e-26         pub=2.026503e-32
+ uc=8.267921e-12           luc=-6.297441e-18         wuc=-7.68858e-19
+ puc=1.416322e-25          rdsw=674                  prwb=0
+ prwg=0                    wr=1                      u0=1.2538307e-02
+ lu0=2.3195521e-10         wu0=-2.8905305e-11        pu0=-8.9203340e-17
+ a0=-0.2291291             la0=7.334314e-08          wa0=5.9546e-08
+ pa0=-1.326923e-14         keta=-0.07105696          lketa=1.1185e-08
+ wketa=2.147188e-09        pketa=-2.124717e-17       a1=0
+ a2=0.99                   ags=0.01                  b0=0
+ b1=0                      voff=-0.06989231          lvoff=8.069355e-10
+ wvoff=-8.840776e-10       pvoff=5.232717e-16        nfactor=1
+ cit=-0.0009029703         lcit=8.657693e-11         wcit=-8.701063e-11
+ pcit=1.388115e-17         cdsc=0                    cdscb=0
+ cdscd=0                   eta0=-0.009688953         leta0=4.045564e-09
+ weta0=6.854338e-10        peta0=-2.493179e-16       etab=-0.0005459113
+ letab=-3.659129e-11       wetab=3.069257e-11        petab=-6.500653e-18
+ dsub=0                    pclm=1.493221             lpclm=-1.103415e-07
+ wpclm=-7.391006e-08       ppclm=1.484814e-14        pdiblc1=0
+ pdiblc2=0.03742132        lpdiblc2=-7.02161e-09     wpdiblc2=-3.676308e-09
+ ppdiblc2=9.753203e-16     pdiblcb=0                 drout=0
+ pscbe1=4.908216e+08       pscbe2=1e-20              pvag=0
+ delta=0.01                alpha0=0                  alpha1=0.1476
+ beta0=20.5                kt1=-0.1613               kt2=-0.003891298
+ lkt2=2.382932e-09         wkt2=-1.03491e-10         pkt2=-6.580961e-17
+ at=-171000                ute=-0.6318787            lute=-1.213023e-08
+ wute=-4.122269e-08        pute=-3.287864e-16        ua1=1.609753e-09
+ lua1=-1.999067e-16        wua1=-7.795958e-17        pua1=1.317123e-23
+ ub1=-2.517127e-18         lub1=1.707237e-25         uc1=-5.6e-11
+ kt1l=0                    prt=0                     cj=cjp_lvt25
+ mj=0.3576069              pb=0.8564895              cjsw=cjswp_lvt25
+ mjsw=0.2                  pbsw=0.8564895            cjswg=cjswgp_lvt25
+ mjswg=0.2                 pbswg=0.8564895           tcj=0.001012982
+ tcjsw=0.0006497512        tcjswg=0.0006497512       tpb=0.00202374
+ tpbsw=0.00202374          tpbswg=0.00202374         js=2.03e-7
+ jsw=1.3e-12               n=1                       xti=3
+ cgdo=cgop_lvt25           cgso=cgop_lvt25           capmod=3
+ nqsmod=0                  xpart=1                   cf=0
+ tlev=1                    tlevc=1                   dlc=3.0e-08
+ cgdl=cglp_lvt25           cgsl=cglp_lvt25           wwc=-0.018
+ dwc=0                     noia=2.0e+19              noib=6.0e+3
+ noic=6.0e-12              em=1.0e+8                 ef=1.262
+ noimod=2                  sa0=0.35e-6               sb0=0.35e-6
+ kvsat=-1                  wlod=0.3e-6               tku0=0.03
+ ku0=8.5e-08               llodku0=1                 wlodku0=1
+ lku0=8.0e-09              wku0=6.0e-07              pku0=0
+ kvth0=1.1e-09             stk2=0                    steta0=-3e-10
+ lkvth0=-1.0e-07           wkvth0=0                  pkvth0=0
+ llodvth=1                 wlodvth=1                 lodk2=1
+ lodeta0=1                 minr=1e-3                 imax=0.01
+ imelt=0.01
//
     }
ends pch_lvt25_mis
//  *************************************************************
//                                                              *
//                 2.5V LOW Vt NMOS DEVICE MODEL                *
//                                                              *
//  *************************************************************
//
model nch_lvt25 bsim3v3  {
     1: type=n
+ lmin=1.205e-06-dxl_lvt25  lmax=21e-06               wmin=10e-06-dxw_lvt25
+ wmax=0.0009001            tnom=25                   version=3.24
+ tox=toxn_lvt25            toxm=toxn_lvt25           xj=1.9e-07
+ nch=3.28e+17              lln=1                     lwn=1
+ wln=1                     wwn=-1                    lint=3.5e-08
+ wint=1.5e-08              mobmod=1                  binunit=2
+ xl=-4e-08+dxl_lvt25       xw=1e-8+dxw_lvt25         dwg=0
+ dwb=0                     ldif=8e-08                hdif=hdifn_lvt25
+ rsh=6.6                   rd=0                      rs=0
+ vth0=dvthn_lvt25+0.3427561                          lvth0=1.391781e-08
+ k1=0.4536357              lk1=4.307491e-08          k2=-0.005712273
+ lk2=-2.659506e-08         k3=0                      dvt0=0
+ dvt1=0                    dvt2=0                    dvt0w=0
+ dvt1w=0                   dvt2w=0                   nlx=0
+ w0=0                      k3b=0                     vfb=-0.9637643
+ vsat=100008.2             lvsat=-8.965059e-06       ua=-1.49896e-09
+ lua=6.823603e-16          ub=2.447586e-18           lub=-4.206343e-25
+ uc=5.75241e-11            luc=-1.129423e-17         rdsw=367
+ prwb=0                    prwg=0                    wr=1
+ u0=0.02688027             lu0=6.13222e-09           a0=1.281963
+ la0=-9.705163e-07         keta=-0.02013726          lketa=-1.73535e-08
+ a1=0                      a2=0.99                   ags=0.3414737
+ lags=-2.85903e-07         b0=0                      b1=0
+ voff=-0.09921951          lvoff=1.735437e-08        nfactor=0.3624902
+ lnfactor=2.437751e-07     cit=1.647012e-05          lcit=6.119943e-11
+ cdsc=0                    cdscb=0                   cdscd=0
+ eta0=3.854855e-05         leta0=3.170184e-11        etab=-4.095684e-05
+ letab=1.473524e-11        dsub=0                    pclm=0.7335739
+ lpclm=-3.816884e-07       pdiblc1=1e-06             pdiblc2=2.565179e-06
+ lpdiblc2=7.388441e-09     pdiblcb=0.1159362         lpdiblcb=-1.105321e-07
+ drout=0                   pscbe1=1.812124e+08       lpscbe1=184.8224
+ pscbe2=1e-06              pvag=0                    delta=0.01
+ alpha0=0                  alpha1=3.8824             beta0=18.9788
+ kt1=-0.2922067            lkt1=7.766363e-09         kt2=-0.02949182
+ lkt2=1.700352e-09         at=11984.76               lat=-0.002173308
+ ute=-1.622338             lute=2.287255e-07         ua1=1.055804e-09
+ lua1=7.5248e-16           ub1=-1.37869e-18          lub1=-7.649806e-25
+ uc1=-3.5125e-11           luc1=-1.825632e-17        kt1l=0
+ prt=0                     cj=cjn_lvt25              mj=0.2904575
+ pb=0.6842167              cjsw=cjswn_lvt25          mjsw=0.2
+ pbsw=0.6842167            cjswg=cjswgn_lvt25        mjswg=0.2
+ pbswg=0.6842167           tpb=1.89277e-3            tpbsw=1.89277e-3
+ tpbswg=1.89277e-3         tcj=1.042239e-3           tcjsw=7.570649e-4
+ tcjswg=7.570649e-4        js=3.03e-7                jsw=5.31e-12
+ n=1                       xti=3                     cgdo=cgon_lvt25
+ cgso=cgon_lvt25           capmod=3                  nqsmod=0
+ xpart=1                   cf=0                      tlev=1
+ tlevc=1                   dlc=3.0e-08               cgdl=cgln_lvt25
+ cgsl=cgln_lvt25           wwc=-0.018                dwc=0
+ noia=2.5e+19              noib=3.0e+4               noic=1.0e-13
+ em=4.1e+7                 ef=0.888                  noimod=2
+ sa0=0.35e-6               sb0=0.35e-6               kvsat=0.35
+ wlod=0.3e-6               tku0=0.03                 ku0=-5.95e-8
+ llodku0=1                 wlodku0=1                 lku0=1.0e-7
+ wku0=2.5e-7               pku0=0                    kvth0=7.2e-9
+ stk2=0                    steta0=-1.1e-10           lkvth0=-5.5e-08
+ wkvth0=3.5e-06            pkvth0=0                  llodvth=1.0
+ wlodvth=1                 lodk2=1                   lodeta0=2
+ minr=1e-60                imax=0.01                 imelt=0.01

     2: type=n
+ lmin=5.05e-07-dxl_lvt25   lmax=1.205e-06-dxl_lvt25  wmin=10e-06-dxw_lvt25
+ wmax=0.0009001            tnom=25                   version=3.24
+ tox=toxn_lvt25            toxm=toxn_lvt25           xj=1.9e-07
+ nch=3.28e+17              lln=1                     lwn=1
+ wln=1                     wwn=-1                    lint=3.5e-08
+ wint=1.5e-08              mobmod=1                  binunit=2
+ xl=-4e-08+dxl_lvt25       xw=1e-8+dxw_lvt25         dwg=0
+ dwb=0                     ldif=8e-08                hdif=hdifn_lvt25
+ rsh=6.6                   rd=0                      rs=0
+ vth0=dvthn_lvt25+0.3467384                          lvth0=9.557144e-09
+ k1=0.4801617              lk1=1.402894e-08          k2=-0.006043235
+ lk2=-2.623265e-08         k3=0                      dvt0=0
+ dvt1=0                    dvt2=0                    dvt0w=0
+ dvt1w=0                   dvt2w=0                   nlx=0
+ w0=0                      k3b=0                     vfb=-0.9852535
+ vsat=111844.1             lvsat=-0.01296932         ua=-8.081139e-10
+ lua=-7.411622e-17         ub=2.068229e-18           lub=-5.237973e-27
+ uc=4.482829e-11           luc=2.607675e-18          rdsw=367
+ prwb=0                    prwg=0                    wr=1
+ u0=0.03212956             lu0=3.842484e-10          a0=0.5237088
+ la0=-1.402283e-07         keta=-0.04800742          lketa=1.316433e-08
+ a1=0                      a2=0.99                   ags=0.1404009
+ lags=-6.572836e-08        b0=0                      b1=0
+ voff=-0.09034456          lvoff=7.636308e-09        nfactor=0.5751529
+ lnfactor=1.090946e-08     cit=3.249885e-05          lcit=4.364795e-11
+ cdsc=0                    cdscb=0                   cdscd=0
+ eta0=-0.0007126252        leta0=8.54237e-10         etab=0.000521268
+ letab=-6.009009e-10       dsub=0                    pclm=-0.01054389
+ lpclm=4.331205e-07        pdiblc1=1e-06             pdiblc2=0.007032143
+ lpdiblc2=-3.089465e-10    pdiblcb=0.0200686         lpdiblcb=-5.557099e-09
+ drout=0                   pscbe1=3.6975e+08         lpscbe1=-21.62625
+ pscbe2=1e-06              pvag=0                    delta=0.01
+ alpha0=0                  alpha1=3.8824             beta0=18.9788
+ kt1=-0.2923966            lkt1=7.974351e-09         kt2=-0.02880714
+ lkt2=9.506238e-10         at=6219.285               lat=0.004139883
+ ute=-1.443621             lute=3.303035e-08         ua1=1.695346e-09
+ lua1=5.218113e-17         ub1=-2.120923e-18         lub1=4.776467e-26
+ uc1=-6.30817e-11          luc1=1.235627e-17         kt1l=0
+ prt=0                     cj=cjn_lvt25              mj=0.2904575
+ pb=0.6842167              cjsw=cjswn_lvt25          mjsw=0.2
+ pbsw=0.6842167            cjswg=cjswgn_lvt25        mjswg=0.2
+ pbswg=0.6842167           tpb=1.89277e-3            tpbsw=1.89277e-3
+ tpbswg=1.89277e-3         tcj=1.042239e-3           tcjsw=7.570649e-4
+ tcjswg=7.570649e-4        js=3.03e-7                jsw=5.31e-12
+ n=1                       xti=3                     cgdo=cgon_lvt25
+ cgso=cgon_lvt25           capmod=3                  nqsmod=0
+ xpart=1                   cf=0                      tlev=1
+ tlevc=1                   dlc=3.0e-08               cgdl=cgln_lvt25
+ cgsl=cgln_lvt25           wwc=-0.018                dwc=0
+ noia=2.5e+19              noib=3.0e+4               noic=1.0e-13
+ em=4.1e+7                 ef=0.888                  noimod=2
+ sa0=0.35e-6               sb0=0.35e-6               kvsat=0.35
+ wlod=0.3e-6               tku0=0.03                 ku0=-5.95e-8
+ llodku0=1                 wlodku0=1                 lku0=1.0e-7
+ wku0=2.5e-7               pku0=0                    kvth0=7.2e-9
+ stk2=0                    steta0=-1.1e-10           lkvth0=-5.5e-08
+ wkvth0=3.5e-06            pkvth0=0                  llodvth=1.0
+ wlodvth=1                 lodk2=1                   lodeta0=2
+ minr=1e-60                imax=0.01                 imelt=0.01

     3: type=n
+ lmin=3.7e-07              lmax=5.05e-07-dxl_lvt25   wmin=10e-06-dxw_lvt25
+ wmax=0.0009001            tnom=25                   version=3.24
+ tox=toxn_lvt25            toxm=toxn_lvt25           xj=1.9e-07
+ nch=3.28e+17              lln=1                     lwn=1
+ wln=1                     wwn=-1                    lint=3.5e-08
+ wint=1.5e-08              mobmod=1                  binunit=2
+ xl=-4e-08+dxl_lvt25       xw=1e-8+dxw_lvt25         dwg=0
+ dwb=0                     ldif=8e-08                hdif=hdifn_lvt25
+ rsh=6.6                   rd=0                      rs=0
+ vth0=dvthn_lvt25+0.4024139                          lvth0=-1.243468e-08
+ k1=0.8097053              lk1=-1.161408e-07         k2=-0.0931579
+ lk2=8.177641e-09          k3=0                      dvt0=0
+ dvt1=0                    dvt2=0                    dvt0w=0
+ dvt1w=0                   dvt2w=0                   nlx=0
+ w0=0                      k3b=0                     vfb=-0.8713078
+ vsat=66800.85             lvsat=0.004822775         ua=-6.405478e-10
+ lua=-1.403048e-16         ub=2.207788e-18           lub=-6.036383e-26
+ uc=1.358835e-10           luc=-3.335912e-17         rdsw=367
+ prwb=0                    prwg=0                    wr=1
+ u0=0.03640268             lu0=-1.303636e-09         a0=-1.128372
+ la0=5.123436e-07          keta=-0.09195808          lketa=3.052484e-08
+ a1=0                      a2=0.99                   ags=0.3286924
+ lags=-1.401035e-07        b0=0                      b1=0
+ voff=-0.02853175          lvoff=-1.677976e-08       nfactor=0.7205374
+ lnfactor=-4.651742e-08    cit=-0.0001044482         lcit=9.774204e-11
+ cdsc=0                    cdscb=0                   cdscd=0
+ eta0=-0.006725388         leta0=3.229278e-09        etab=0.0007048237
+ letab=-6.734054e-10       dsub=0                    pclm=1.221312
+ lpclm=-5.346241e-08       pdiblc1=1e-06             pdiblc2=-0.005471155
+ lpdiblc2=4.629856e-09     pdiblcb=-0.002153846      lpdiblcb=3.220769e-09
+ drout=0                   pscbe1=2.774374e+08       lpscbe1=14.83721
+ pscbe2=1e-06              pvag=0                    delta=-0.0001923079
+ ldelta=4.025962e-09       alpha0=0                  alpha1=3.8824
+ beta0=18.9788             kt1=-0.3146241            lkt1=1.675419e-08
+ kt2=-0.04856995           lkt2=8.756932e-09         at=11196.15
+ lat=0.00217402            ute=-1.987623             lute=2.479112e-07
+ ua1=7.598061e-10          lua1=4.217194e-16         ub1=-2.1325e-18
+ lub1=5.233755e-26         uc1=-6.860239e-11         luc1=1.453694e-17
+ kt1l=0                    prt=0                     cj=cjn_lvt25
+ mj=0.2904575              pb=0.6842167              cjsw=cjswn_lvt25
+ mjsw=0.2                  pbsw=0.6842167            cjswg=cjswgn_lvt25
+ mjswg=0.2                 pbswg=0.6842167           tpb=1.89277e-3
+ tpbsw=1.89277e-3          tpbswg=1.89277e-3         tcj=1.042239e-3
+ tcjsw=7.570649e-4         tcjswg=7.570649e-4        js=3.03e-7
+ jsw=5.31e-12              n=1                       xti=3
+ cgdo=cgon_lvt25           cgso=cgon_lvt25           capmod=3
+ nqsmod=0                  xpart=1                   cf=0
+ tlev=1                    tlevc=1                   dlc=3.0e-08
+ cgdl=cgln_lvt25           cgsl=cgln_lvt25           wwc=-0.018
+ dwc=0                     noia=2.5e+19              noib=3.0e+4
+ noic=1.0e-13              em=4.1e+7                 ef=0.888
+ noimod=2                  sa0=0.35e-6               sb0=0.35e-6
+ kvsat=0.35                wlod=0.3e-6               tku0=0.03
+ ku0=-5.95e-8              llodku0=1                 wlodku0=1
+ lku0=1.0e-7               wku0=2.5e-7               pku0=0
+ kvth0=7.2e-9              stk2=0                    steta0=-1.1e-10
+ lkvth0=-5.5e-08           wkvth0=3.5e-06            pkvth0=0
+ llodvth=1.0               wlodvth=1                 lodk2=1
+ lodeta0=2                 minr=1e-60                imax=0.01
+ imelt=0.01

     4: type=n
+ lmin=1.205e-06-dxl_lvt25  lmax=21e-06               wmin=1.2e-06-dxw_lvt25
+ wmax=10e-06-dxw_lvt25     tnom=25                   version=3.24
+ tox=toxn_lvt25            toxm=toxn_lvt25           xj=1.9e-07
+ nch=3.28e+17              lln=1                     lwn=1
+ wln=1                     wwn=-1                    lint=3.5e-08
+ wint=1.5e-08              mobmod=1                  binunit=2
+ xl=-4e-08+dxl_lvt25       xw=1e-8+dxw_lvt25         dwg=0
+ dwb=0                     ldif=8e-08                hdif=hdifn_lvt25
+ rsh=6.6                   rd=0                      rs=0
+ vth0=dvthn_lvt25+0.3447919                          lvth0=1.351315e-08
+ wvth0=-2.031806e-08       pvth0=4.038557e-15        k1=0.435513
+ lk1=7.130307e-08          wk1=1.808644e-07          pk1=-2.817171e-13
+ k2=0.001408136            lk2=-3.690907e-08         wk2=-7.106168e-08
+ pk2=1.029339e-13          k3=0                      dvt0=0
+ dvt1=0                    dvt2=0                    dvt0w=0
+ dvt1w=0                   dvt2w=0                   nlx=0
+ w0=0                      k3b=0                     vfb=-0.9637643
+ vsat=99842.43             lvsat=0.00164083          wvsat=0.001654223
+ pvsat=-1.646495e-08       ua=-1.601741e-09          lua=7.932024e-16
+ wua=1.025756e-15          pua=-1.106204e-21         ub=2.577797e-18
+ lub=-4.728713e-25         wub=-1.299504e-24         pub=5.213256e-31
+ uc=6.234915e-11           luc=-1.282767e-17         wuc=-4.815398e-17
+ puc=1.530373e-23          rdsw=367.1502             lrdsw=-1.485898e-06
+ wrdsw=-1.498663e-06       prdsw=1.482927e-11        prwb=0
+ prwg=0                    wr=1                      u0=0.02661457
+ lu0=7.399187e-09          wu0=2.651666e-09          pu0=-1.264434e-14
+ a0=1.311309               la0=-9.871217e-07         wa0=-2.92879e-07
+ pa0=1.657208e-13          keta=-0.02122476          lketa=-1.73513e-08
+ wketa=1.085326e-08        pketa=-2.187482e-17       a1=0
+ a2=0.99                   ags=0.3497159             lags=-2.78722e-07
+ wags=-8.225793e-08        pags=-7.166661e-14        b0=0
+ b1=0                      voff=-0.1008665           lvoff=1.833545e-08
+ wvoff=1.643687e-08        pvoff=-9.791215e-15       nfactor=0.3401159
+ lnfactor=2.750204e-07     wnfactor=2.232953e-07     pnfactor=-3.118281e-13
+ cit=2.061145e-05          lcit=3.740944e-11         wcit=-4.133048e-11
+ pcit=2.37424e-16          cdsc=0                    cdscb=0
+ cdscd=0                   eta0=3.889923e-05         leta0=3.719101e-11
+ weta0=-3.499874e-12       peta0=-5.478199e-17       etab=-4.102617e-05
+ letab=1.481116e-11        wetab=6.919539e-13        petab=-7.576895e-19
+ dsub=0                    pclm=0.6996098            lpclm=-4.033375e-07
+ wpclm=3.389618e-07        ppclm=2.160581e-13        pdiblc1=1e-06
+ pdiblc2=-1.171311e-05     lpdiblc2=7.202185e-09     wpdiblc2=1.424971e-10
+ ppdiblc2=1.858833e-15     pdiblcb=0.1301412         lpdiblcb=-1.253533e-07
+ wpdiblcb=-1.417661e-07    ppdiblcb=1.479154e-13     drout=0
+ pscbe1=1.80342e+08        lpscbe1=193.4841          wpscbe1=8.686943
+ ppscbe1=-8.644354e-05     pscbe2=1e-06              pvag=0
+ delta=0.01                alpha0=0                  alpha1=3.8824
+ beta0=18.9788             kt1=-0.292361             lkt1=9.899401e-09
+ wkt1=1.540206e-09         pkt1=-2.128773e-14        kt2=-0.02970118
+ lkt2=2.049148e-09         wkt2=2.089362e-09         pkt2=-3.480992e-15
+ at=12250.89               lat=-0.002464728          wat=-0.002656055
+ pat=2.90838e-09           ute=-1.65986              lute=2.373246e-07
+ wute=3.744681e-07         pute=-8.581954e-14        ua1=9.636568e-10
+ lua1=8.533808e-16         wua1=9.19625e-16          pua1=-1.006989e-21
+ ub1=-1.287903e-18         lub1=-8.952327e-25        wub1=-9.060547e-25
+ pub1=1.299916e-30         uc1=-2.993473e-11         luc1=-2.353558e-17
+ wuc1=-5.179889e-17        puc1=5.26871e-23          kt1l=0
+ prt=0                     cj=cjn_lvt25              mj=0.2904575
+ pb=0.6842167              cjsw=cjswn_lvt25          mjsw=0.2
+ pbsw=0.6842167            cjswg=cjswgn_lvt25        mjswg=0.2
+ pbswg=0.6842167           tpb=1.89277e-3            tpbsw=1.89277e-3
+ tpbswg=1.89277e-3         tcj=1.042239e-3           tcjsw=7.570649e-4
+ tcjswg=7.570649e-4        js=3.03e-7                jsw=5.31e-12
+ n=1                       xti=3                     cgdo=cgon_lvt25
+ cgso=cgon_lvt25           capmod=3                  nqsmod=0
+ xpart=1                   cf=0                      tlev=1
+ tlevc=1                   dlc=3.0e-08               cgdl=cgln_lvt25
+ cgsl=cgln_lvt25           wwc=-0.018                dwc=0
+ noia=2.5e+19              noib=3.0e+4               noic=1.0e-13
+ em=4.1e+7                 ef=0.888                  noimod=2
+ sa0=0.35e-6               sb0=0.35e-6               kvsat=0.35
+ wlod=0.3e-6               tku0=0.03                 ku0=-5.95e-8
+ llodku0=1                 wlodku0=1                 lku0=1.0e-7
+ wku0=2.5e-7               pku0=0                    kvth0=7.2e-9
+ stk2=0                    steta0=-1.1e-10           lkvth0=-5.5e-08
+ wkvth0=3.5e-06            pkvth0=0                  llodvth=1.0
+ wlodvth=1                 lodk2=1                   lodeta0=2
+ minr=1e-60                imax=0.01                 imelt=0.01

     5: type=n
+ lmin=5.05e-07-dxl_lvt25   lmax=1.205e-06-dxl_lvt25  wmin=1.2e-06-dxw_lvt25
+ wmax=10e-06-dxw_lvt25     tnom=25                   version=3.24
+ tox=toxn_lvt25            toxm=toxn_lvt25           xj=1.9e-07
+ nch=3.28e+17              lln=1                     lwn=1
+ wln=1                     wwn=-1                    lint=3.5e-08
+ wint=1.5e-08              mobmod=1                  binunit=2
+ xl=-4e-08+dxl_lvt25       xw=1e-8+dxw_lvt25         dwg=0
+ dwb=0                     ldif=8e-08                hdif=hdifn_lvt25
+ rsh=6.6                   rd=0                      rs=0
+ vth0=dvthn_lvt25+0.3497133                          lvth0=8.124239e-09
+ wvth0=-2.96896e-08        pvth0=1.43004e-14         k1=0.4898478
+ lk1=1.180643e-08          wk1=-9.666772e-08         pk1=2.218061e-14
+ k2=-0.008815954           lk2=-2.57137e-08          wk2=2.767172e-08
+ pk2=-5.179158e-15         k3=0                      dvt0=0
+ dvt1=0                    dvt2=0                    dvt0w=0
+ dvt1w=0                   dvt2w=0                   nlx=0
+ w0=0                      k3b=0                     vfb=-0.9852535
+ vsat=114394.9             lvsat=-0.01429412         wvsat=-0.02545668
+ pvsat=1.322149e-08        ua=-8.0491e-10            lua=-7.932772e-17
+ wua=-3.197497e-17         pua=5.201075e-23          ub=2.160035e-18
+ lub=-1.542211e-26         wub=-9.162274e-25         pub=1.016377e-31
+ uc=4.81886e-11            luc=2.678123e-18          wuc=-3.353589e-17
+ puc=-7.030719e-25         rdsw=365.1122             lrdsw=7.456844e-07
+ wrdsw=1.884033e-05        prdsw=-7.441932e-12       prwb=0
+ prwg=0                    wr=1                      u0=0.03311752
+ lu0=2.784588e-10          wu0=-9.859858e-09         pu0=1.05578e-15
+ a0=0.5641858              la0=-1.690214e-07         wa0=-4.039602e-07
+ pa0=2.873548e-13          keta=-0.0498446           lketa=1.398742e-08
+ wketa=1.833501e-08        pketa=-8.214382e-15       a1=0
+ a2=0.99                   ags=0.1657014             lags=-7.722613e-08
+ wags=-2.524993e-07        pags=1.147477e-13         b0=0
+ b1=0                      voff=-0.09200203          lvoff=8.628878e-09
+ wvoff=1.654155e-08        pvoff=-9.905838e-15       nfactor=0.5845796
+ lnfactor=7.332743e-09     wnfactor=-9.407803e-08    pnfactor=3.569565e-14
+ cit=2.323058e-05          lcit=3.454148e-11         wcit=9.249738e-11
+ pcit=9.088253e-17         cdsc=0                    cdscb=0
+ cdscd=0                   eta0=-0.0007685506        leta0=9.213485e-10
+ weta0=5.581365e-10        peta0=-6.697737e-16       etab=0.0005515342
+ letab=-6.340424e-10       wetab=-3.020571e-10       petab=3.307525e-16
+ dsub=0                    pclm=-0.09661797          lpclm=4.685318e-07
+ wpclm=8.590192e-07        ppclm=-3.534047e-13       pdiblc1=1e-06
+ pdiblc2=0.007312951       lpdiblc2=-8.183217e-10    wpdiblc2=-2.802463e-09
+ ppdiblc2=5.083565e-15     pdiblcb=0.02141892        lpdiblcb=-6.302381e-09
+ wpdiblcb=-1.347618e-08    ppdiblcb=7.437923e-15     drout=0
+ pscbe1=3.820864e+08       lpscbe1=-27.42602         wpscbe1=-123.1169
+ ppscbe1=5.788169e-05      pscbe2=1e-06              pvag=0
+ delta=0.01                alpha0=0                  alpha1=3.8824
+ beta0=18.9788             kt1=-0.2905486            lkt1=7.914847e-09
+ wkt1=-1.844297e-08        pkt1=5.938465e-16         kt2=-0.02876413
+ lkt2=1.023077e-09         wkt2=-4.292746e-10        pkt2=-7.230851e-16
+ at=5712.326               lat=0.004695003           wat=0.005059456
+ pat=-5.540104e-09         ute=-1.473385             lute=3.31346e-08
+ wute=2.970443e-07         pute=-1.040525e-15        ua1=1.695346e-09
+ lua1=5.218113e-17         ub1=-2.144551e-18         lub1=4.279688e-26
+ wub1=2.358062e-25         pub1=4.957855e-32         uc1=-6.188398e-11
+ luc1=1.144885e-17         wuc1=-1.195315e-17        puc1=9.056012e-24
+ kt1l=0                    prt=0                     cj=cjn_lvt25
+ mj=0.2904575              pb=0.6842167              cjsw=cjswn_lvt25
+ mjsw=0.2                  pbsw=0.6842167            cjswg=cjswgn_lvt25
+ mjswg=0.2                 pbswg=0.6842167           tpb=1.89277e-3
+ tpbsw=1.89277e-3          tpbswg=1.89277e-3         tcj=1.042239e-3
+ tcjsw=7.570649e-4         tcjswg=7.570649e-4        js=3.03e-7
+ jsw=5.31e-12              n=1                       xti=3
+ cgdo=cgon_lvt25           cgso=cgon_lvt25           capmod=3
+ nqsmod=0                  xpart=1                   cf=0
+ tlev=1                    tlevc=1                   dlc=3.0e-08
+ cgdl=cgln_lvt25           cgsl=cgln_lvt25           wwc=-0.018
+ dwc=0                     noia=2.5e+19              noib=3.0e+4
+ noic=1.0e-13              em=4.1e+7                 ef=0.888
+ noimod=2                  sa0=0.35e-6               sb0=0.35e-6
+ kvsat=0.35                wlod=0.3e-6               tku0=0.03
+ ku0=-5.95e-8              llodku0=1                 wlodku0=1
+ lku0=1.0e-7               wku0=2.5e-7               pku0=0
+ kvth0=7.2e-9              stk2=0                    steta0=-1.1e-10
+ lkvth0=-5.5e-08           wkvth0=3.5e-06            pkvth0=0
+ llodvth=1.0               wlodvth=1                 lodk2=1
+ lodeta0=2                 minr=1e-60                imax=0.01
+ imelt=0.01

     6: type=n
+ lmin=3.7e-07              lmax=5.05e-07-dxl_lvt25   wmin=1.2e-06-dxw_lvt25
+ wmax=10e-06-dxw_lvt25     tnom=25                   version=3.24
+ tox=toxn_lvt25            toxm=toxn_lvt25           xj=1.9e-07
+ nch=3.28e+17              lln=1                     lwn=1
+ wln=1                     wwn=-1                    lint=3.5e-08
+ wint=1.5e-08              mobmod=1                  binunit=2
+ xl=-4e-08+dxl_lvt25       xw=1e-8+dxw_lvt25         dwg=0
+ dwb=0                     ldif=8e-08                hdif=hdifn_lvt25
+ rsh=6.6                   rd=0                      rs=0
+ vth0=dvthn_lvt25+0.4071534                          lvth0=-1.456459e-08
+ wvth0=-4.729997e-08       pvth0=2.125649e-14        k1=0.8107244
+ lk1=-1.149398e-07         wk1=-1.017102e-08         pk1=-1.19856e-14
+ k2=-0.09221292            lk2=7.228102e-09          wk2=-9.430947e-09
+ pk2=9.476396e-15          k3=0                      dvt0=0
+ dvt1=0                    dvt2=0                    dvt0w=0
+ dvt1w=0                   dvt2w=0                   nlx=0
+ w0=0                      k3b=0                     vfb=-0.8713078
+ vsat=64360.51             lvsat=0.005469466         wvsat=0.0243546
+ pvsat=-6.45397e-09        ua=-5.136105e-10          lua=-1.94391e-16
+ wua=-1.266834e-15         pua=5.397802e-22          ub=2.241641e-18
+ lub=-4.765664e-26         wub=-3.378593e-25         pub=-1.268177e-31
+ uc=1.46905e-10            luc=-3.631487e-17         wuc=-1.099953e-16
+ puc=2.949841e-23          rdsw=367                  prwb=0
+ prwg=0                    wr=1                      u0=0.03901967
+ lu0=-2.052891e-09         wu0=-2.611754e-08         pu0=7.477564e-15
+ a0=-1.351925              la0=5.878425e-07          wa0=2.231061e-06
+ pa0=-7.534786e-13         keta=-0.09752005          lketa=3.281922e-08
+ wketa=5.550838e-08        pketa=-2.289787e-14       a1=0
+ a2=0.99                   ags=0.3663425             lags=-1.564793e-07
+ wags=-3.757478e-07        pags=1.634309e-13         b0=0
+ b1=0                      voff=-0.03142808          lvoff=-1.529783e-08
+ wvoff=2.890546e-08        pvoff=-1.478959e-14       nfactor=0.7257496
+ lnfactor=-4.842943e-08    wnfactor=-5.201786e-08    pnfactor=1.908189e-14
+ cit=-0.0002053442         lcit=1.248285e-10         wcit=1.006943e-09
+ pcit=-2.703233e-16        cdsc=0                    cdscb=0
+ cdscd=0                   eta0=-0.006544308         leta0=3.202773e-09
+ weta0=-1.807172e-09       peta0=2.64523e-16         etab=0.0006244213
+ letab=-6.628328e-10       wetab=8.024165e-10        petab=-1.055146e-16
+ dsub=0                    pclm=1.287195             lpclm=-7.807433e-08
+ wpclm=-6.575164e-07       ppclm=2.456269e-13        pdiblc1=1e-06
+ pdiblc2=-0.005791998      lpdiblc2=4.358133e-09     wpdiblc2=3.202022e-09
+ ppdiblc2=2.711793e-15     pdiblcb=-0.00379662       lpdiblcb=3.657758e-09
+ wpdiblcb=1.639488e-08     ppdiblcb=-4.361144e-15    drout=0
+ pscbe1=2.70054e+08        lpscbe1=16.82675          wpscbe1=73.68623
+ ppscbe1=-1.985556e-05     pscbe2=1e-06              pvag=0
+ delta=-0.001559005        ldelta=4.565807e-09       wdelta=1.363963e-08
+ pdelta=-5.387653e-15      alpha0=0                  alpha1=3.8824
+ beta0=18.9788             kt1=-0.3092136            lkt1=1.528751e-08
+ wkt1=-5.399652e-08        pkt1=1.46375e-14          kt2=-0.04884838
+ lkt2=8.956357e-09         wkt2=2.778749e-09         pkt2=-1.990254e-15
+ at=13809.52               lat=0.001496613           wat=-0.02608136
+ pat=6.760521e-09          ute=-2.092839             lute=2.77819e-07
+ wute=1.050056e-06         pute=-2.984802e-13        ua1=7.118615e-10
+ lua1=4.406575e-16         wua1=4.784866e-16         pua1=-1.890022e-22
+ ub1=-2.174545e-18         lub1=5.464438e-26         wub1=4.196056e-25
+ pub1=-2.302219e-32        uc1=-7.24267e-11          luc1=1.561322e-17
+ wuc1=3.816657e-17         puc1=-1.074128e-23        kt1l=0
+ prt=0                     cj=cjn_lvt25              mj=0.2904575
+ pb=0.6842167              cjsw=cjswn_lvt25          mjsw=0.2
+ pbsw=0.6842167            cjswg=cjswgn_lvt25        mjswg=0.2
+ pbswg=0.6842167           tpb=1.89277e-3            tpbsw=1.89277e-3
+ tpbswg=1.89277e-3         tcj=1.042239e-3           tcjsw=7.570649e-4
+ tcjswg=7.570649e-4        js=3.03e-7                jsw=5.31e-12
+ n=1                       xti=3                     cgdo=cgon_lvt25
+ cgso=cgon_lvt25           capmod=3                  nqsmod=0
+ xpart=1                   cf=0                      tlev=1
+ tlevc=1                   dlc=3.0e-08               cgdl=cgln_lvt25
+ cgsl=cgln_lvt25           wwc=-0.018                dwc=0
+ noia=2.5e+19              noib=3.0e+4               noic=1.0e-13
+ em=4.1e+7                 ef=0.888                  noimod=2
+ sa0=0.35e-6               sb0=0.35e-6               kvsat=0.35
+ wlod=0.3e-6               tku0=0.03                 ku0=-5.95e-8
+ llodku0=1                 wlodku0=1                 lku0=1.0e-7
+ wku0=2.5e-7               pku0=0                    kvth0=7.2e-9
+ stk2=0                    steta0=-1.1e-10           lkvth0=-5.5e-08
+ wkvth0=3.5e-06            pkvth0=0                  llodvth=1.0
+ wlodvth=1                 lodk2=1                   lodeta0=2
+ minr=1e-60                imax=0.01                 imelt=0.01

     7: type=n
+ lmin=1.205e-06-dxl_lvt25  lmax=21e-06               wmin=6e-07-dxw_lvt25
+ wmax=1.2e-06-dxw_lvt25    tnom=25                   version=3.24
+ tox=toxn_lvt25            toxm=toxn_lvt25           xj=1.9e-07
+ nch=3.28e+17              lln=1                     lwn=1
+ wln=1                     wwn=-1                    lint=3.5e-08
+ wint=1.5e-08              mobmod=1                  binunit=2
+ xl=-4e-08+dxl_lvt25       xw=1e-8+dxw_lvt25         dwg=0
+ dwb=0                     ldif=8e-08                hdif=hdifn_lvt25
+ rsh=6.6                   rd=0                      rs=0
+ vth0=dvthn_lvt25+0.320031 lvth0=2.626397e-08        wvth0=8.899785e-09
+ pvth0=-1.100742e-14       k1=0.7532799              lk1=-4.380018e-07
+ wk1=-1.941006e-07         pk1=3.192628e-13          k2=-0.1124415
+ lk2=1.463879e-07          wk2=6.32809e-08           pk2=-1.133565e-13
+ k3=0                      dvt0=0                    dvt1=0
+ dvt2=0                    dvt0w=0                   dvt1w=0
+ dvt2w=0                   nlx=0                     w0=0
+ k3b=0                     vfb=-1.085385             vsat=1.0174883e+05
+ lvsat=-1.7310670e-02      wvsat=-5.9531890e-04      pvsat=5.8978190e-09
+ ua=-1.086702e-09          lua=3.08261e-16           wua=4.180091e-16
+ pua=-5.339732e-22         ub=1.865544e-18           lub=-6.365103e-25
+ wub=-4.590451e-25         pub=7.144195e-31          uc=3.371462e-11
+ luc=-1.250083e-17         wuc=-1.436523e-17         puc=1.491806e-23
+ rdsw=364.7975             lrdsw=2.179318e-05        wrdsw=1.277417e-06
+ prdsw=-1.264004e-11       prwb=0                    prwg=0
+ wr=1                      u0=2.9180478e-02          lu0=-4.1511200e-09
+ wu0=-3.7610530e-10        pu0=9.8502170e-16         a0=0.8869891
+ la0=-5.527311e-07         wa0=2.07819e-07           pa0=-3.4686e-13
+ keta=-0.01154415          lketa=-1.241816e-08       wketa=-5.6986e-10
+ pketa=-5.842981e-15       a1=0                      a2=0.99
+ ags=0.2780897             lags=-3.807568e-07        wags=2.261046e-09
+ pags=4.873443e-14         b0=0                      b1=0
+ voff=-0.07524026          lvoff=1.30766e-08         wvoff=-1.380208e-08
+ pvoff=-3.585769e-15       nfactor=0.5093868         lnfactor=2.116e-08
+ wnfactor=2.355566e-08     pnfactor=-1.22728e-14     cit=-3.810801e-06
+ lcit=1.128461e-10         wcit=-1.251222e-11        pcit=1.484088e-16
+ cdsc=0                    cdscb=0                   cdscd=0
+ eta0=3.302745e-06         leta0=-2.113653e-11       weta0=3.850398e-11
+ peta0=1.404451e-17        etab=-4.518495e-05        letab=6.699752e-11
+ wetab=5.599311e-12        petab=-6.233759e-17       dsub=0
+ pclm=1.407262             lpclm=-7.992068e-07       wpclm=-4.960675e-07
+ ppclm=6.83184e-13         pdiblc1=1e-06             pdiblc2=-0.0004167299
+ lpdiblc2=1.107325e-08     wpdiblc2=6.204171e-10     ppdiblc2=-2.70903e-15
+ pdiblcb=0.01163135        lpdiblcb=-1.787753e-09    wpdiblcb=-1.924434e-09
+ ppdiblcb=2.108022e-15     drout=0                   pscbe1=1.854402e+08
+ lpscbe1=141.2293          wpscbe1=2.671065          ppscbe1=-2.478284e-05
+ pscbe2=7.282622e-07       lpscbe2=2.975529e-13      wpscbe2=3.206506e-13
+ ppscbe2=-3.511124e-19     pvag=0                    delta=0.01
+ alpha0=0                  alpha1=3.8824             beta0=18.9788
+ kt1=-0.2874168            lkt1=-2.893677e-08        wkt1=-4.29395e-09
+ pkt1=2.453895e-14         kt2=-0.02674006           lkt2=-4.592277e-09
+ wkt2=-1.404761e-09        pkt2=4.355891e-15         at=10000
+ ute=-1.502766             lute=3.549254e-07         wute=1.890976e-07
+ pute=-2.245884e-13        ua1=1.651207e-09          lua1=1.005135e-16
+ wua1=1.083159e-16         pua1=-1.186059e-22        ub1=-2.22855e-18
+ lub1=4.34759e-25          wub1=2.039089e-25         pub1=-2.694741e-31
+ uc1=-7.901336e-11         luc1=3.413929e-17         wuc1=6.113892e-18
+ puc1=-1.536925e-23        kt1l=0                    prt=0
+ cj=cjn_lvt25              mj=0.2904575              pb=0.6842167
+ cjsw=cjswn_lvt25          mjsw=0.2                  pbsw=0.6842167
+ cjswg=cjswgn_lvt25        mjswg=0.2                 pbswg=0.6842167
+ tpb=1.89277e-3            tpbsw=1.89277e-3          tpbswg=1.89277e-3
+ tcj=1.042239e-3           tcjsw=7.570649e-4         tcjswg=7.570649e-4
+ js=3.03e-7                jsw=5.31e-12              n=1
+ xti=3                     cgdo=cgon_lvt25           cgso=cgon_lvt25
+ capmod=3                  nqsmod=0                  xpart=1
+ cf=0                      tlev=1                    tlevc=1
+ dlc=3.0e-08               cgdl=cgln_lvt25           cgsl=cgln_lvt25
+ wwc=-0.018                dwc=0                     noia=2.5e+19
+ noib=3.0e+4               noic=1.0e-13              em=4.1e+7
+ ef=0.888                  noimod=2                  sa0=0.35e-6
+ sb0=0.35e-6               kvsat=0.35                wlod=0.3e-6
+ tku0=0.03                 ku0=-5.95e-8              llodku0=1
+ wlodku0=1                 lku0=1.0e-7               wku0=2.5e-7
+ pku0=0                    kvth0=7.2e-9              stk2=0
+ steta0=-1.1e-10           lkvth0=-5.5e-08           wkvth0=3.5e-06
+ pkvth0=0                  llodvth=1.0               wlodvth=1
+ lodk2=1                   lodeta0=2                 minr=1e-60
+ imax=0.01                 imelt=0.01

     8: type=n
+ lmin=5.05e-07-dxl_lvt25   lmax=1.205e-06-dxl_lvt25  wmin=6e-07-dxw_lvt25
+ wmax=1.2e-06-dxw_lvt25    tnom=25                   version=3.24
+ tox=toxn_lvt25            toxm=toxn_lvt25           xj=1.9e-07
+ nch=3.28e+17              lln=1                     lwn=1
+ wln=1                     wwn=-1                    lint=3.5e-08
+ wint=1.5e-08              mobmod=1                  binunit=2
+ xl=-4e-08+dxl_lvt25       xw=1e-8+dxw_lvt25         dwg=0
+ dwb=0                     ldif=8e-08                hdif=hdifn_lvt25
+ rsh=6.6                   rd=0                      rs=0
+ vth0=dvthn_lvt25+0.3128033                          lvth0=3.4178410e-08
+ wvth0=1.3864215e-08       pvth0=-1.6443508e-14      k1=0.2873159
+ lk1=7.222878e-08          wk1=1.4232e-07            pk1=-4.911777e-14
+ k2=0.06058107             lk2=-4.307184e-08         wk2=-5.421678e-08
+ pk2=1.530346e-14          k3=0                      dvt0=0
+ dvt1=0                    dvt2=0                    dvt0w=0
+ dvt1w=0                   dvt2w=0                   nlx=0
+ w0=0                      k3b=0                     vfb=-0.9441584
+ vsat=8.9743280e+04        lvsat=-4.1645970e-03      wvsat=3.6322320e-03
+ pvsat=1.2686521e-09       ua=-6.752431e-10          lua=-1.422864e-16
+ wua=-1.84982e-16          pua=1.26302e-22           ub=1.051467e-18
+ lub=2.549035e-25          wub=3.918828e-25          pub=-2.173465e-31
+ uc=1.254729e-11           luc=1.067739e-17          wuc=8.520861e-18
+ puc=-1.014221e-23         rdsw=394.6879             lrdsw=-1.09367e-05
+ wrdsw=-1.605896e-05       prdsw=6.343288e-12        prwb=0
+ prwg=0                    wr=1                      u0=2.5317138e-02
+ lu0=7.9237190e-11         wu0=-6.5541130e-10        pu0=1.2908614e-15
+ a0=0.4477632              la0=-7.177867e-08         wa0=-2.665815e-07
+ pa0=1.726084e-13          keta=-0.02373895          lketa=9.351396e-10
+ wketa=-1.246967e-08       pketa=7.187307e-15        a1=0
+ a2=0.99                   ags=-0.1279505            lags=6.385729e-08
+ wags=9.401003e-08         pags=-5.173072e-14        b0=0
+ b1=0                      voff=-0.05857327          lvoff=-5.173757e-09
+ wvoff=-2.29044e-08        pvoff=6.381273e-15        nfactor=0.4612098
+ lnfactor=7.39138e-08      wnfactor=5.149832e-08     pnfactor=-4.287001e-14
+ cit=-8.857658e-05         lcit=2.056646e-10         wcit=2.244299e-10
+ pcit=-1.110428e-16        cdsc=0                    cdscb=0
+ cdscd=0                   eta0=-0.0003363262        leta0=3.507571e-10
+ weta0=4.811164e-11        peta0=3.524128e-18        etab=0.0003636001
+ letab=-3.806221e-10       wetab=-8.029477e-11       petab=3.171642e-17
+ dsub=0                    pclm=0.5569212            lpclm=1.31916e-07
+ wpclm=8.784298e-08        ppclm=4.380202e-14        pdiblc1=1e-06
+ pdiblc2=0.008337318       lpdiblc2=1.487573e-09     wpdiblc2=-4.011217e-09
+ ppdiblc2=2.362608e-15     pdiblcb=0.009997575       lpdiblcb=1.233512e-12
+ wpdiblcb=1.015252e-12     ppdiblcb=-3.439563e-19    drout=0
+ pscbe1=2.946294e+08       lpscbe1=21.66709          wpscbe1=-19.91765
+ ppscbe1=-4.819698e-08     pscbe2=1e-06              pvag=0
+ delta=0.01                alpha0=0                  alpha1=3.8824
+ beta0=18.9788             kt1=-0.288242             lkt1=-2.803317e-08
+ wkt1=-2.116478e-08        pkt1=4.301251e-14         kt2=-0.03237297
+ lkt2=1.575763e-09         wkt2=3.829161e-09         pkt2=-1.375254e-15
+ at=10000                  ute=-1.255246             lute=8.389021e-08
+ wute=3.963982e-08         pute=-6.093214e-14        ua1=1.738028e-09
+ lua1=5.443756e-18         wua1=-5.036539e-17        pua1=5.51501e-23
+ ub1=-2.017129e-18         lub1=2.032532e-25         wub1=8.54484e-26
+ pub1=-1.397599e-31        uc1=-5.469754e-11         luc1=7.513473e-18
+ wuc1=-2.043315e-17        puc1=1.369976e-23         kt1l=0
+ prt=0                     cj=cjn_lvt25              mj=0.2904575
+ pb=0.6842167              cjsw=cjswn_lvt25          mjsw=0.2
+ pbsw=0.6842167            cjswg=cjswgn_lvt25        mjswg=0.2
+ pbswg=0.6842167           tpb=1.89277e-3            tpbsw=1.89277e-3
+ tpbswg=1.89277e-3         tcj=1.042239e-3           tcjsw=7.570649e-4
+ tcjswg=7.570649e-4        js=3.03e-7                jsw=5.31e-12
+ n=1                       xti=3                     cgdo=cgon_lvt25
+ cgso=cgon_lvt25           capmod=3                  nqsmod=0
+ xpart=1                   cf=0                      tlev=1
+ tlevc=1                   dlc=3.0e-08               cgdl=cgln_lvt25
+ cgsl=cgln_lvt25           wwc=-0.018                dwc=0
+ noia=2.5e+19              noib=3.0e+4               noic=1.0e-13
+ em=4.1e+7                 ef=0.888                  noimod=2
+ sa0=0.35e-6               sb0=0.35e-6               kvsat=0.35
+ wlod=0.3e-6               tku0=0.03                 ku0=-5.95e-8
+ llodku0=1                 wlodku0=1                 lku0=1.0e-7
+ wku0=2.5e-7               pku0=0                    kvth0=7.2e-9
+ stk2=0                    steta0=-1.1e-10           lkvth0=-5.5e-08
+ wkvth0=3.5e-06            pkvth0=0                  llodvth=1.0
+ wlodvth=1                 lodk2=1                   lodeta0=2
+ minr=1e-60                imax=0.01                 imelt=0.01

     9: type=n
+ lmin=3.7e-07              lmax=5.05e-07-dxl_lvt25   wmin=6e-07-dxw_lvt25
+ wmax=1.2e-06-dxw_lvt25    tnom=25                   version=3.24
+ tox=toxn_lvt25            toxm=toxn_lvt25           xj=1.9e-07
+ nch=3.28e+17              lln=1                     lwn=1
+ wln=1                     wwn=-1                    lint=3.5e-08
+ wint=1.5e-08              mobmod=1                  binunit=2
+ xl=-4e-08+dxl_lvt25       xw=1e-8+dxw_lvt25         dwg=0
+ dwb=0                     ldif=8e-08                hdif=hdifn_lvt25
+ rsh=6.6                   rd=0                      rs=0
+ vth0=dvthn_lvt25+0.3827403                          lvth0=6.5532750e-09
+ wvth0=-1.8492539e-08      pvth0=-3.6625920e-15      k1=0.7234104
+ lk1=-1.000286e-07         wk1=9.285946e-08          pk1=-2.958085e-14
+ k2=-0.0522119             lk2=1.481375e-09          wk2=-5.663215e-08
+ pk2=1.625753e-14          k3=0                      dvt0=0
+ dvt1=0                    dvt2=0                    dvt0w=0
+ dvt1w=0                   dvt2w=0                   nlx=0
+ w0=0                      k3b=0                     vfb=-0.7707245
+ vsat=7.9199990e+04        wvsat=6.8440100e-03       ua=-3.220981e-09
+ lua=8.632799e-16          wua=1.927862e-15          pua=-7.082716e-22
+ ub=3.229613e-18           lub=-6.05464e-25          wub=-1.503665e-24
+ pub=5.313949e-31          uc=8.439516e-11           luc=-1.770251e-17
+ wuc=-3.623366e-17         puc=7.535823e-24          rdsw=367
+ prwb=0                    prwg=0                    wr=1
+ u0=1.4084544e-03          lu0=9.5231640e-09         wu0=1.8263687e-08
+ pu0=-6.1821820e-15        a0=1.426817               la0=-4.585051e-07
+ wa0=-1.047856e-06         pa0=4.812116e-13          keta=-0.0529984
+ lketa=1.249262e-08        wketa=2.972836e-09        pketa=1.087519e-15
+ a1=0                      a2=0.99                   ags=0.470204
+ lags=-1.724137e-07        wags=-4.983043e-07        pags=1.822334e-13
+ b0=0                      b1=0                      voff=-0.03126579
+ lvoff=-1.596021e-08       wvoff=2.871396e-08        pvoff=-1.400798e-14
+ nfactor=0.5550355         lnfactor=3.685266e-08     wnfactor=1.494248e-07
+ pnfactor=-8.155098e-14    cit=0.0005896387          lcit=-6.223042e-11
+ wcit=6.886244e-11         pcit=-4.959366e-17        cdsc=0
+ cdscb=0                   cdscd=0                   eta0=-0.004214944
+ leta0=1.882811e-09        weta0=-4.555821e-09       peta0=1.822078e-15
+ etab=0.001426944          letab=-8.006428e-10       wetab=-1.445601e-10
+ petab=5.710124e-17        dsub=0                    pclm=-0.1965591
+ lpclm=4.295407e-07        wpclm=1.093314e-06        ppclm=-3.533589e-13
+ pdiblc1=1e-06             pdiblc2=-0.00978798       lpdiblc2=8.647065e-09
+ wpdiblc2=7.917278e-09     ppdiblc2=-2.349147e-15    pdiblcb=0.002289167
+ lpdiblcb=3.046054e-09     wpdiblcb=9.213649e-09     ppdiblcb=-3.639334e-15
+ drout=0                   pscbe1=3.772213e+08       lpscbe1=-10.95672
+ wpscbe1=-52.77114         ppscbe1=1.292893e-05      pscbe2=1e-06
+ pvag=0                    delta=0.01                alpha0=0
+ alpha1=3.8824             beta0=18.9788             kt1=-0.539868
+ lkt1=7.13591e-08          wkt1=2.181757e-07         pkt1=-5.152698e-14
+ kt2=-0.05259364           lkt2=9.562927e-09         wkt2=7.198158e-09
+ pkt2=-2.706008e-15        at=-15398.33              lat=0.01003234
+ wat=0.0083839             pat=-3.311641e-09         ute=-0.9922474
+ lute=-1.999412e-08        wute=-2.486424e-07        pute=5.293934e-14
+ ua1=5.063202e-10          lua1=4.919685e-16         wua1=7.210253e-16
+ pua1=-2.495492e-22        ub1=-1.274437e-18         lub1=-9.011022e-26
+ wub1=-6.425217e-25        pub1=1.477882e-31         uc1=-7.139479e-11
+ luc1=1.410889e-17         wuc1=3.694893e-17         puc1=-8.966161e-24
+ kt1l=0                    prt=0                     cj=cjn_lvt25
+ mj=0.2904575              pb=0.6842167              cjsw=cjswn_lvt25
+ mjsw=0.2                  pbsw=0.6842167            cjswg=cjswgn_lvt25
+ mjswg=0.2                 pbswg=0.6842167           tpb=1.89277e-3
+ tpbsw=1.89277e-3          tpbswg=1.89277e-3         tcj=1.042239e-3
+ tcjsw=7.570649e-4         tcjswg=7.570649e-4        js=3.03e-7
+ jsw=5.31e-12              n=1                       xti=3
+ cgdo=cgon_lvt25           cgso=cgon_lvt25           capmod=3
+ nqsmod=0                  xpart=1                   cf=0
+ tlev=1                    tlevc=1                   dlc=3.0e-08
+ cgdl=cgln_lvt25           cgsl=cgln_lvt25           wwc=-0.018
+ dwc=0                     noia=2.5e+19              noib=3.0e+4
+ noic=1.0e-13              em=4.1e+7                 ef=0.888
+ noimod=2                  sa0=0.35e-6               sb0=0.35e-6
+ kvsat=0.35                wlod=0.3e-6               tku0=0.03
+ ku0=-5.95e-8              llodku0=1                 wlodku0=1
+ lku0=1.0e-7               wku0=2.5e-7               pku0=0
+ kvth0=7.2e-9              stk2=0                    steta0=-1.1e-10
+ lkvth0=-5.5e-08           wkvth0=3.5e-06            pkvth0=0
+ llodvth=1.0               wlodvth=1                 lodk2=1
+ lodeta0=2                 minr=1e-60                imax=0.01
+ imelt=0.01

     10: type=n
+ lmin=1.205e-06-dxl_lvt25  lmax=21e-06               wmin=1.5e-07
+ wmax=6e-07-dxw_lvt25      tnom=25                   version=3.24
+ tox=toxn_lvt25            toxm=toxn_lvt25           xj=1.9e-07
+ nch=3.28e+17              lln=1                     lwn=1
+ wln=1                     wwn=-1                    lint=3.5e-08
+ wint=1.5e-08              mobmod=1                  binunit=2
+ xl=-4e-08+dxl_lvt25       xw=1e-8+dxw_lvt25         dwg=0
+ dwb=0                     ldif=8e-08                hdif=hdifn_lvt25
+ rsh=6.6                   rd=0                      rs=0
+ vth0=dvthn_lvt25+0.3446315                          lvth0=2.719209e-08
+ wvth0=-5.368482e-09       pvth0=-1.154572e-14       k1=0.3995275
+ lk1=1.662187e-07          wk1=1.107583e-08          pk1=-3.118515e-14
+ k2=0.0118681              lk2=-6.760317e-08         wk2=-8.818683e-09
+ pk2=1.075832e-14          k3=0                      dvt0=0
+ dvt1=0                    dvt2=0                    dvt0w=0
+ dvt1w=0                   dvt2w=0                   nlx=0
+ w0=0                      k3b=0                     vfb=-1.028903
+ vsat=1.0133802e+05        lvsat=-1.0373162e-02      wvsat=-3.5704750e-04
+ pvsat=1.8740640e-09       ua=-4.429365e-10          lua=-7.723305e-16
+ wua=4.462516e-17          pua=9.276987e-23          ub=9.337934e-19
+ lub=9.770701e-25          wub=8.137011e-26          pub=-2.214572e-31
+ uc=7.304763e-13           luc=2.501126e-17          wuc=4.765571e-18
+ puc=-6.838959e-24         rdsw=367                  prwb=0
+ prwg=0                    wr=1                      u0=2.6701150e-02
+ lu0=-2.6497535e-09        wu0=1.0619043e-09         pu0=1.1422861e-16
+ a0=1.404992               la0=-1.303911e-06         wa0=-9.262294e-08
+ pa0=8.882464e-14          keta=-0.007380755         lketa=-2.996032e-08
+ wketa=-2.984629e-09       pketa=4.33147e-15         a1=0
+ a2=0.99                   ags=0.2612626             lags=-2.771732e-07
+ wags=1.20208e-08          pags=-1.134408e-14        b0=0
+ b1=0                      voff=-0.09571052          lvoff=-4.740103e-09
+ wvoff=-1.929335e-09       pvoff=6.747921e-15        nfactor=0.5294412
+ lnfactor=8.908767e-08     wnfactor=1.192413e-08     pnfactor=-5.167086e-14
+ cit=-4.163744e-05         lcit=4.907078e-10         wcit=9.427229e-12
+ pcit=-7.075099e-17        cdsc=0                    cdscb=0
+ cdscd=0                   eta0=7.9186540e-05        leta0=-8.2885770e-12
+ weta0=-5.5086210e-12      peta0=6.5927010e-18       etab=-3.027922e-05
+ letab=-6.278118e-11       wetab=-3.046016e-12       petab=1.293406e-17
+ dsub=0                    pclm=0.6262414            lpclm=3.662929e-07
+ wpclm=-4.307577e-08       ppclm=7.194141e-15        pdiblc1=1e-06
+ pdiblc2=0.0008587558      lpdiblc2=4.332522e-09     wpdiblc2=-1.193647e-10
+ ppdiblc2=1.200596e-15     pdiblcb=0.007826125       lpdiblcb=2.380168e-09
+ wpdiblcb=2.825987e-10     ppdiblcb=-3.093717e-16    drout=0
+ pscbe1=1.863192e+08       lpscbe1=78.20065          wpscbe1=2.161242
+ ppscbe1=1.177375e-05      pscbe2=1.362317e-06       lpscbe2=-3.967371e-13
+ wpscbe2=-4.710121e-14     ppscbe2=5.157583e-20      pvag=0
+ delta=0.01                alpha0=0                  alpha1=3.8824
+ beta0=18.9788             kt1=-0.3065531            lkt1=1.879909e-08
+ wkt1=6.805123e-09         pkt1=-3.147848e-15        kt2=-0.03169849
+ lkt2=5.251259e-09         wkt2=1.471131e-09         pkt2=-1.353361e-15
+ at=10443.43               lat=-0.004387736          wat=-0.0002571892
+ pat=2.544887e-09          ute=-1.198939             lute=-4.045242e-08
+ wute=1.287792e-08         pute=4.730705e-15         ua1=1.865391e-09
+ lua1=-1.340179e-16        wua1=-1.591081e-17        pua1=1.742233e-23
+ ub1=-1.910423e-18         lub1=7.420331e-26         wub1=1.939489e-26
+ pub1=-6.035183e-32        uc1=-7.947958e-11         luc1=1.51431e-17
+ wuc1=6.384305e-18         puc1=-4.351462e-24        kt1l=0
+ prt=0                     cj=cjn_lvt25              mj=0.2904575
+ pb=0.6842167              cjsw=cjswn_lvt25          mjsw=0.2
+ pbsw=0.6842167            cjswg=cjswgn_lvt25        mjswg=0.2
+ pbswg=0.6842167           tpb=1.89277e-3            tpbsw=1.89277e-3
+ tpbswg=1.89277e-3         tcj=1.042239e-3           tcjsw=7.570649e-4
+ tcjswg=7.570649e-4        js=3.03e-7                jsw=5.31e-12
+ n=1                       xti=3                     cgdo=cgon_lvt25
+ cgso=cgon_lvt25           capmod=3                  nqsmod=0
+ xpart=1                   cf=0                      tlev=1
+ tlevc=1                   dlc=3.0e-08               cgdl=cgln_lvt25
+ cgsl=cgln_lvt25           wwc=-0.018                dwc=0
+ noia=2.5e+19              noib=3.0e+4               noic=1.0e-13
+ em=4.1e+7                 ef=0.888                  noimod=2
+ sa0=0.35e-6               sb0=0.35e-6               kvsat=0.35
+ wlod=0.3e-6               tku0=0.03                 ku0=-5.95e-8
+ llodku0=1                 wlodku0=1                 lku0=1.0e-7
+ wku0=2.5e-7               pku0=0                    kvth0=7.2e-9
+ stk2=0                    steta0=-1.1e-10           lkvth0=-5.5e-08
+ wkvth0=3.5e-06            pkvth0=0                  llodvth=1.0
+ wlodvth=1                 lodk2=1                   lodeta0=2
+ minr=1e-60                imax=0.01                 imelt=0.01

     11: type=n
+ lmin=5.05e-07-dxl_lvt25   lmax=1.205e-06-dxl_lvt25  wmin=1.5e-07
+ wmax=6e-07-dxw_lvt25      tnom=25                   version=3.24
+ tox=toxn_lvt25            toxm=toxn_lvt25           xj=1.9e-07
+ nch=3.28e+17              lln=1                     lwn=1
+ wln=1                     wwn=-1                    lint=3.5e-08
+ wint=1.5e-08              mobmod=1                  binunit=2
+ xl=-4e-08+dxl_lvt25       xw=1e-8+dxw_lvt25         dwg=0
+ dwb=0                     ldif=8e-08                hdif=hdifn_lvt25
+ rsh=6.6                   rd=0                      rs=0
+ vth0=dvthn_lvt25+0.3657833                          lvth0=4.0308490e-09
+ wvth0=-1.6864183e-08      pvth0=1.0420777e-15       k1=0.5641519
+ lk1=-1.404498e-08         wk1=-1.824487e-08         pk1=9.210139e-16
+ k2=-0.03294823            lk2=-1.852928e-08         wk2=3.0221e-11
+ pk2=1.068773e-15          k3=0                      dvt0=0
+ dvt1=0                    dvt2=0                    dvt0w=0
+ dvt1w=0                   dvt2w=0                   nlx=0
+ w0=0                      k3b=0                     vfb=-1.023088
+ vsat=9.4353570e+04        lvsat=-2.7251947e-03      wvsat=9.5826360e-04
+ pvsat=4.3379810e-10       ua=-1.308827e-09          lua=1.758199e-16
+ wua=1.824969e-16          pua=-5.81997e-23          ub=2.005374e-18
+ lub=-1.96311e-25          wub=-1.613834e-25         pub=4.435792e-32
+ uc=3.456975e-11           luc=-1.204273e-17         wuc=-4.252165e-18
+ puc=3.035461e-24          rdsw=367                  prwb=0
+ prwg=0                    wr=1                      u0=2.1755682e-02
+ lu0=2.7655345e-09         wu0=1.4102328e-09         pu0=-2.6719112e-16
+ a0=-0.06180262            la0=3.022288e-07          wa0=2.896668e-08
+ pa0=-4.431601e-14         keta=-0.0460932           lketa=1.242981e-08
+ wketa=4.958032e-10        pketa=5.203971e-16        a1=0
+ a2=0.99                   ags=0.04219527            lags=-3.72945e-08
+ wags=-4.67454e-09         pags=6.937317e-15         b0=0
+ b1=0                      voff=-0.1074134           lvoff=8.074538e-09
+ wvoff=5.422867e-09        pvoff=-1.30274e-15        nfactor=0.6189232
+ lnfactor=-8.895124e-09    wnfactor=-3.997545e-08    pnfactor=5.159176e-15
+ cit=0.0003927978          lcit=1.500117e-11         wcit=-5.476731e-11
+ pcit=-4.579779e-19        cdsc=0                    cdscb=0
+ cdscd=0                   eta0=-1.3841083e-04       leta0=2.2998052e-10
+ weta0=-6.6679270e-11      peta0=7.3574570e-17       etab=0.0001458578
+ letab=-2.556512e-10       wetab=4.59957e-11         petab=-4.076662e-17
+ dsub=0                    pclm=0.7696757            lpclm=2.092323e-07
+ wpclm=-3.555468e-08       ppclm=-1.041438e-15       pdiblc1=1e-06
+ pdiblc2=0.0003078757      lpdiblc2=4.935736e-09     wpdiblc2=6.458607e-10
+ ppdiblc2=3.62674e-16      pdiblcb=0.01001411        lpdiblcb=-1.567905e-11
+ wpdiblcb=-8.576764e-12    ppdiblcb=9.465329e-18     drout=0
+ pscbe1=2.317566e+08       lpscbe1=28.44667          wpscbe1=16.54855
+ ppscbe1=-3.980353e-06     pscbe2=1e-06              pvag=0
+ delta=0.01                alpha0=0                  alpha1=3.8824
+ beta0=18.9788             kt1=-0.3421046            lkt1=5.772791e-08
+ wkt1=1.007551e-08         pkt1=-6.728917e-15        kt2=-0.02587449
+ lkt2=-1.126018e-09        wkt2=6.004372e-11         pkt2=1.917789e-16
+ at=5224.434               lat=0.001327065           wat=0.002769829
+ pat=-7.696979e-10         ute=-1.233199             lute=-2.938557e-09
+ wute=2.68525e-08          pute=-1.057146e-14        ua1=1.621441e-09
+ lua1=1.331068e-16         wua1=1.725521e-17         pua1=-1.889446e-23
+ ub1=-1.794061e-18         lub1=-5.32123e-26         wub1=-4.393104e-26
+ pub1=8.990075e-33         uc1=-1.021541e-10         luc1=3.997173e-17
+ wuc1=7.091672e-18         puc1=-5.126029e-24        kt1l=0
+ prt=0                     cj=cjn_lvt25              mj=0.2904575
+ pb=0.6842167              cjsw=cjswn_lvt25          mjsw=0.2
+ pbsw=0.6842167            cjswg=cjswgn_lvt25        mjswg=0.2
+ pbswg=0.6842167           tpb=1.89277e-3            tpbsw=1.89277e-3
+ tpbswg=1.89277e-3         tcj=1.042239e-3           tcjsw=7.570649e-4
+ tcjswg=7.570649e-4        js=3.03e-7                jsw=5.31e-12
+ n=1                       xti=3                     cgdo=cgon_lvt25
+ cgso=cgon_lvt25           capmod=3                  nqsmod=0
+ xpart=1                   cf=0                      tlev=1
+ tlevc=1                   dlc=3.0e-08               cgdl=cgln_lvt25
+ cgsl=cgln_lvt25           wwc=-0.018                dwc=0
+ noia=2.5e+19              noib=3.0e+4               noic=1.0e-13
+ em=4.1e+7                 ef=0.888                  noimod=2
+ sa0=0.35e-6               sb0=0.35e-6               kvsat=0.35
+ wlod=0.3e-6               tku0=0.03                 ku0=-5.95e-8
+ llodku0=1                 wlodku0=1                 lku0=1.0e-7
+ wku0=2.5e-7               pku0=0                    kvth0=7.2e-9
+ stk2=0                    steta0=-1.1e-10           lkvth0=-5.5e-08
+ wkvth0=3.5e-06            pkvth0=0                  llodvth=1.0
+ wlodvth=1                 lodk2=1                   lodeta0=2
+ minr=1e-60                imax=0.01                 imelt=0.01

     12: type=n
+ lmin=3.7e-07              lmax=5.05e-07-dxl_lvt25   wmin=1.5e-07
+ wmax=6e-07-dxw_lvt25      tnom=25                   version=3.24
+ tox=toxn_lvt25            toxm=toxn_lvt25           xj=1.9e-07
+ nch=3.28e+17              lln=1                     lwn=1
+ wln=1                     wwn=-1                    lint=3.5e-08
+ wint=1.5e-08              mobmod=1                  binunit=2
+ xl=-4e-08+dxl_lvt25       xw=1e-8+dxw_lvt25         dwg=0
+ dwb=0                     ldif=8e-08                hdif=hdifn_lvt25
+ rsh=6.6                   rd=0                      rs=0
+ vth0=dvthn_lvt25+0.3681791                          lvth0=3.0844787e-09
+ wvth0=-1.0047049e-08      pvth0=-1.6506895e-15      k1=0.9416191
+ lk1=-1.631446e-07         wk1=-3.370159e-08         pk1=7.026418e-15
+ k2=-0.1596789             lk2=3.152933e-08          wk2=5.698712e-09
+ pk2=-1.170281e-15         k3=0                      dvt0=0
+ dvt1=0                    dvt2=0                    dvt0w=0
+ dvt1w=0                   dvt2w=0                   nlx=0
+ w0=0                      k3b=0                     vfb=-0.8432227
+ vsat=8.7398700e+04        lvsat=2.1976957e-05       wvsat=2.0887565e-03
+ pvsat=-1.2746634e-11      ua=1.895398e-10           lua=-4.160351e-16
+ wua=-5.023947e-17         pua=3.373117e-23          ub=5.09612e-19
+ lub=3.945152e-25          wub=7.393535e-26          pub=-4.8593e-32
+ uc=6.756374e-12           luc=-1.05645e-18          wuc=8.796841e-18
+ puc=-2.118897e-24         rdsw=367                  prwb=0
+ prwg=0                    wr=1                      u0=3.3693340e-02
+ lu0=-1.9498381e-09        wu0=-4.6154210e-10        pu0=4.7215990e-16
+ a0=-0.5191821             la0=4.828937e-07          wa0=8.082413e-08
+ pa0=-6.47997e-14          keta=-0.05865234          lketa=1.739067e-08
+ wketa=6.252121e-09        pketa=-1.753348e-15       a1=0
+ a2=0.99                   ags=-0.4026658            lags=1.384256e-07
+ wags=7.960238e-09         pags=1.946579e-15         b0=0
+ b1=0                      voff=0.04786693           lvoff=-5.326119e-08
+ wvoff=-1.718303e-08       pvoff=7.626591e-15        nfactor=1.083453
+ lnfactor=-1.923844e-07    wnfactor=-1.570574e-07    pnfactor=5.140653e-14
+ cit=0.0009324652          lcit=-1.981674e-10        wcit=-1.299769e-10
+ pcit=2.924983e-17         cdsc=0                    cdscb=0
+ cdscd=0                   eta0=-0.01501045          leta0=6.104434e-09
+ weta0=1.705571e-09        peta0=-6.264641e-16       etab=0.001659307
+ letab=-8.534639e-10       wetab=-2.793311e-10       petab=8.773748e-17
+ dsub=0                    pclm=1.921926             lpclm=-2.459065e-07
+ wpclm=-1.354078e-07       ppclm=3.840053e-14        pdiblc1=1e-06
+ pdiblc2=0.008501258       lpdiblc2=1.69935e-09      wpdiblc2=-2.690481e-09
+ ppdiblc2=1.680529e-15     pdiblcb=0.03193061        lpdiblcb=-8.672696e-09
+ wpdiblcb=-7.978395e-09    ppdiblcb=3.157544e-15     drout=0
+ pscbe1=2.659482e+08       lpscbe1=14.94098          wpscbe1=11.76725
+ ppscbe1=-2.091737e-06     pscbe2=1e-06              pvag=0
+ delta=0.01                alpha0=0                  alpha1=3.8824
+ beta0=18.9788             kt1=-0.1376225            lkt1=-2.304251e-08
+ wkt1=-1.512669e-08        pkt1=3.225951e-15         kt2=-0.04506861
+ lkt2=6.455658e-09         wkt2=2.833641e-09         pkt2=-9.037922e-16
+ at=-2825.409              lat=0.004506753           wat=0.001091605
+ pat=-1.067991e-10         ute=-1.447604             lute=8.175148e-08
+ wute=1.546429e-08         pute=-6.073113e-15        ua1=1.732687e-09
+ lua1=8.916458e-17         wua1=9.732318e-18         pua1=-1.592291e-23
+ ub1=-2.083429e-18         lub1=6.108776e-26         wub1=-1.733067e-25
+ pub1=6.009345e-32         uc1=2.152684e-11          luc1=-8.882255e-18
+ wuc1=-1.694562e-17        puc1=4.368703e-24         kt1l=0
+ prt=0                     cj=cjn_lvt25              mj=0.2904575
+ pb=0.6842167              cjsw=cjswn_lvt25          mjsw=0.2
+ pbsw=0.6842167            cjswg=cjswgn_lvt25        mjswg=0.2
+ pbswg=0.6842167           tpb=1.89277e-3            tpbsw=1.89277e-3
+ tpbswg=1.89277e-3         tcj=1.042239e-3           tcjsw=7.570649e-4
+ tcjswg=7.570649e-4        js=3.03e-7                jsw=5.31e-12
+ n=1                       xti=3                     cgdo=cgon_lvt25
+ cgso=cgon_lvt25           capmod=3                  nqsmod=0
+ xpart=1                   cf=0                      tlev=1
+ tlevc=1                   dlc=3.0e-08               cgdl=cgln_lvt25
+ cgsl=cgln_lvt25           wwc=-0.018                dwc=0
+ noia=2.5e+19              noib=3.0e+4               noic=1.0e-13
+ em=4.1e+7                 ef=0.888                  noimod=2
+ sa0=0.35e-6               sb0=0.35e-6               kvsat=0.35
+ wlod=0.3e-6               tku0=0.03                 ku0=-5.95e-8
+ llodku0=1                 wlodku0=1                 lku0=1.0e-7
+ wku0=2.5e-7               pku0=0                    kvth0=7.2e-9
+ stk2=0                    steta0=-1.1e-10           lkvth0=-5.5e-08
+ wkvth0=3.5e-06            pkvth0=0                  llodvth=1.0
+ wlodvth=1                 lodk2=1                   lodeta0=2
+ minr=1e-60                imax=0.01                 imelt=0.01
//
//  *************************************************************
//                                                              *
//                 2.5V LOW Vt PMOS DEVICE MODEL                *
//                                                              *
//  *************************************************************
//
     }
model pch_lvt25 bsim3v3  {
     1: type=p
+ lmin=1.21e-6-dxl_lvt25    lmax=2.1e-05              wmin=1.0e-5-dxw_lvt25
+ wmax=0.0009001            tnom=25                   version=3.24
+ tox=toxp_lvt25            toxm=toxp_lvt25           xj=2.1e-07
+ nch=5.0106e+17            lln=1                     lwn=1
+ wln=1                     wwn=-1                    lint=4.358e-08
+ ll=0                      lw=0                      lwl=0
+ wint=1.5e-08              wl=0                      ww=0
+ wwl=0                     mobmod=1                  binunit=2
+ xl=-4e-08+dxl_lvt25       xw=1e-08+dxw_lvt25        dwg=0
+ dwb=0                     ldif=8e-08                hdif=hdifp_lvt25
+ rsh=7.2                   rd=0                      rs=0
+ vth0=-0.3835383+dvthp_lvt25                         lvth0=2.245623e-08
+ k1=0.6588699              lk1=2.678793e-08          k2=-0.08428726
+ lk2=-1.744752e-08         k3=0                      dvt0=0
+ dvt1=0                    dvt2=0                    dvt0w=0
+ dvt1w=0                   dvt2w=0                   nlx=0
+ w0=0                      k3b=0                     vfb=-1.186274
+ vsat=151000               ua=2.155462e-09           lua=-2.380102e-16
+ ub=5.06322e-19            lub=-1.269086e-27         uc=-5.080309e-12
+ luc=3.353319e-22          rdsw=674                  prwb=0
+ prwg=0                    wr=1                      u0=0.01594737
+ lu0=6.144635e-11          a0=0.953822               la0=-3.263548e-07
+ keta=-0.02698593          lketa=-2.221346e-08       a1=0
+ a2=0.99                   ags=0.3240156             lags=1.794854e-07
+ b0=0                      b1=0                      voff=-0.09785233
+ lvoff=2.024753e-08        nfactor=1                 cit=-0.001110397
+ lcit=1.043132e-10         cdsc=0                    cdscb=0
+ cdscd=0                   eta0=0.0001               etab=-1e-05
+ dsub=0                    pclm=0.5429353            lpclm=3.069956e-07
+ pdiblc1=0                 pdiblc2=-0.0002694357     lpdiblc2=6.347579e-09
+ pdiblcb=0.01839013        lpdiblcb=-1.845052e-07    drout=0
+ pscbe1=4.908216e+08       pscbe2=1e-20              pvag=0
+ delta=0.01                alpha0=0                  alpha1=0.1476
+ beta0=20.5                kt1=-0.1613               kt2=0.01023361
+ lkt2=7.388069e-09         at=-45103.43              lat=-0.04956928
+ ute=-0.8377483            lute=-9.123107e-08        ua1=1.670882e-09
+ lua1=-5.104973e-16        ub1=-2.059226e-18         uc1=2.50956e-11
+ luc1=-8.781355e-17        kt1l=0                    prt=0
+ cj=cjp_lvt25              mj=0.3576069              pb=0.8564895
+ cjsw=cjswp_lvt25          mjsw=0.2                  pbsw=0.8564895
+ cjswg=cjswgp_lvt25        mjswg=0.2                 pbswg=0.8564895
+ tcj=0.001012982           tcjsw=0.0006497512        tcjswg=0.0006497512
+ tpb=0.00202374            tpbsw=0.00202374          tpbswg=0.00202374
+ js=2.03e-7                jsw=1.3e-12               n=1
+ xti=3                     cgdo=cgop_lvt25           cgso=cgop_lvt25
+ capmod=3                  nqsmod=0                  xpart=1
+ cf=0                      tlev=1                    dlc=3.0e-08
+ tlevc=1                   cgdl=cglp_lvt25           cgsl=cglp_lvt25
+ wwc=-0.018                dwc=0                     noia=2.0e+19
+ noib=6.0e+3               noic=6.0e-12              em=1.0e+8
+ ef=1.262                  noimod=2                  sa0=0.35e-6
+ sb0=0.35e-6               kvsat=-1                  wlod=0.3e-6
+ tku0=0.03                 ku0=8.5e-08               llodku0=1
+ wlodku0=1                 lku0=8.0e-09              wku0=6.0e-07
+ pku0=0                    kvth0=1.1e-09             stk2=0
+ steta0=-3e-10             lkvth0=-1.0e-07           wkvth0=0
+ pkvth0=0                  llodvth=1                 wlodvth=1
+ lodk2=1                   lodeta0=1                 minr=1e-60
+ imax=0.01                 imelt=0.01

     2: type=p
+ lmin=5e-7-dxl_lvt25       lmax=1.21e-6-dxl_lvt25    wmin=1.0e-5-dxw_lvt25
+ wmax=0.0009001            tnom=25                   version=3.24
+ tox=toxp_lvt25            toxm=toxp_lvt25           xj=2.1e-07
+ nch=5.0106e+17            lln=1                     lwn=1
+ wln=1                     wwn=-1                    lint=4.358e-08
+ ll=0                      lw=0                      lwl=0
+ wint=1.5e-08              wl=0                      ww=0
+ wwl=0                     mobmod=1                  binunit=2
+ xl=-4e-08+dxl_lvt25       xw=1e-08+dxw_lvt25        dwg=0
+ dwb=0                     ldif=8e-08                hdif=hdifp_lvt25
+ rsh=7.2                   rd=0                      rs=0
+ vth0=-0.3782912+dvthp_lvt25                         lvth0=1.677454e-08
+ k1=0.7062972              lk1=-2.456824e-08         k2=-0.08937234
+ lk2=-1.194119e-08         k3=0                      dvt0=0
+ dvt1=0                    dvt2=0                    dvt0w=0
+ dvt1w=0                   dvt2w=0                   nlx=0
+ w0=0                      k3b=0                     vfb=-1.174776
+ vsat=151000               ua=2.059412e-09           lua=-1.340032e-16
+ ub=2.935173e-19           lub=2.291643e-25          uc=-7.222517e-12
+ luc=2.320003e-18          rdsw=674                  prwb=0
+ prwg=0                    wr=1                      u0=0.01600476
+ lu0=-6.923911e-13         a0=0.8025334              la0=-1.625334e-07
+ keta=-0.06486069          lketa=1.879885e-08        a1=0
+ a2=0.99                   ags=0.7417099             lags=-2.728107e-07
+ b0=0                      b1=0                      voff=-0.0859424
+ lvoff=7.350986e-09        nfactor=1                 cit=-0.001092485
+ lcit=8.491668e-11         cdsc=0                    cdscb=0
+ cdscd=0                   eta0=-0.0003726143        leta0=5.117656e-10
+ etab=0.0005916642         letab=-6.515059e-10       dsub=0
+ pclm=0.8230612            lpclm=3.663991e-09        pdiblc1=0
+ pdiblc2=-5.93816e-05      lpdiblc2=6.120124e-09     pdiblcb=-0.2318193
+ lpdiblcb=8.643151e-08     drout=0                   pscbe1=4.908216e+08
+ pscbe2=1e-20              pvag=0                    delta=0.01
+ alpha0=0                  alpha1=0.1476             beta0=20.5
+ kt1=-0.1613               kt2=0.02973644            lkt2=-1.373037e-08
+ at=-48807.64              lat=-0.0455582            ute=-0.8118809
+ lute=-1.192414e-07        ua1=1.474837e-09          lua1=-2.982111e-16
+ ub1=-2.059226e-18         uc1=-5.6e-11              kt1l=0
+ prt=0                     cj=cjp_lvt25              mj=0.3576069
+ pb=0.8564895              cjsw=cjswp_lvt25          mjsw=0.2
+ pbsw=0.8564895            cjswg=cjswgp_lvt25        mjswg=0.2
+ pbswg=0.8564895           tcj=0.001012982           tcjsw=0.0006497512
+ tcjswg=0.0006497512       tpb=0.00202374            tpbsw=0.00202374
+ tpbswg=0.00202374         js=2.03e-7                jsw=1.3e-12
+ n=1                       xti=3                     cgdo=cgop_lvt25
+ cgso=cgop_lvt25           capmod=3                  nqsmod=0
+ xpart=1                   cf=0                      dlc=3.0e-08
+ tlev=1                    tlevc=1                   cgdl=cglp_lvt25
+ cgsl=cglp_lvt25           wwc=-0.018                dwc=0
+ noia=2.0e+19              noib=6.0e+3               noic=6.0e-12
+ em=1.0e+8                 ef=1.262                  noimod=2
+ sa0=0.35e-6               sb0=0.35e-6               kvsat=-1
+ wlod=0.3e-6               tku0=0.03                 ku0=8.5e-08
+ llodku0=1                 wlodku0=1                 lku0=8.0e-09
+ wku0=6.0e-07              pku0=0                    kvth0=1.1e-09
+ stk2=0                    steta0=-3e-10             lkvth0=-1.0e-07
+ wkvth0=0                  pkvth0=0                  llodvth=1
+ wlodvth=1                 lodk2=1                   lodeta0=1
+ minr=1e-60                imax=0.01                 imelt=0.01

     3: type=p
+ lmin=3.7e-7               lmax=5e-7-dxl_lvt25       wmin=1.0e-5-dxw_lvt25
+ wmax=0.0009001            tnom=25                   version=3.24
+ tox=toxp_lvt25            toxm=toxp_lvt25           xj=2.1e-07
+ nch=5.0106e+17            lln=1                     lwn=1
+ wln=1                     wwn=-1                    lint=4.358e-08
+ ll=0                      lw=0                      lwl=0
+ wint=1.5e-08              wl=0                      ww=0
+ wwl=0                     mobmod=1                  binunit=2
+ xl=-4e-08+dxl_lvt25       xw=1e-08+dxw_lvt25        dwg=0
+ dwb=0                     ldif=8e-08                hdif=hdifp_lvt25
+ rsh=7.2                   rd=0                      rs=0
+ vth0=-0.4035368+dvthp_lvt25                         lvth0=2.618708e-08
+ k1=1.10723                lk1=-1.74052e-07          k2=-0.2218984
+ lk2=3.746983e-08          k3=0                      dvt0=0
+ dvt1=0                    dvt2=0                    dvt0w=0
+ dvt1w=0                   dvt2w=0                   nlx=0
+ w0=0                      k3b=0                     vsat=151000
+ ua=5.386926e-10           lua=4.329819e-16          ub=1.910593e-18
+ lub=-3.737464e-25         uc=2.980893e-11           luc=-1.14868e-17
+ rdsw=674                  prwb=0                    prwg=0
+ wr=1                      u0=0.01424166             lu0=6.56661e-10
+ a0=-1.954203              la0=8.652884e-07          keta=-0.07832187
+ lketa=2.381772e-08        a1=0                      a2=0.99
+ ags=0.01                  b0=0                      b1=0
+ voff=-0.07004911          lvoff=1.425334e-09        nfactor=1
+ cit=-0.001259837          lcit=1.473125e-10         cdsc=0
+ cdscb=0                   cdscd=0                   eta0=-0.008637013
+ leta0=3.593064e-09        etab=-0.0004351685        letab=-2.686616e-10
+ dsub=0                    pclm=0.634555             lpclm=7.394667e-08
+ pdiblc1=0                 pdiblc2=0.03569957        lpdiblc2=-7.212244e-09
+ pdiblcb=0                 drout=0                   pscbe1=4.908216e+08
+ pscbe2=1e-20              pvag=0                    delta=0.01
+ alpha0=0                  alpha1=0.1476             beta0=20.5
+ kt1=-0.1613               kt2=0.03226876            lkt2=-1.467452e-08
+ at=-171000                ute=-0.9673162            lute=-6.128889e-08
+ ua1=1.4689e-09            lua1=-2.959977e-16        ub1=-2.059226e-18
+ uc1=-5.6e-11              kt1l=0                    prt=0
+ cj=cjp_lvt25              mj=0.3576069              pb=0.8564895
+ cjsw=cjswp_lvt25          mjsw=0.2                  pbsw=0.8564895
+ cjswg=cjswgp_lvt25        mjswg=0.2                 pbswg=0.8564895
+ tcj=0.001012982           tcjsw=0.0006497512        tcjswg=0.0006497512
+ tpb=0.00202374            tpbsw=0.00202374          tpbswg=0.00202374
+ js=2.03e-7                jsw=1.3e-12               n=1
+ xti=3                     cgdo=cgop_lvt25           cgso=cgop_lvt25
+ capmod=3                  nqsmod=0                  xpart=1
+ cf=0                      tlev=1                    dlc=3.0e-08
+ tlevc=1                   cgdl=cglp_lvt25           cgsl=cglp_lvt25
+ wwc=-0.018                dwc=0                     noia=2.0e+19
+ noib=6.0e+3               noic=6.0e-12              em=1.0e+8
+ ef=1.262                  noimod=2                  sa0=0.35e-6
+ sb0=0.35e-6               kvsat=-1                  wlod=0.3e-6
+ tku0=0.03                 ku0=8.5e-08               llodku0=1
+ wlodku0=1                 lku0=8.0e-09              wku0=6.0e-07
+ pku0=0                    kvth0=1.1e-09             stk2=0
+ steta0=-3e-10             lkvth0=-1.0e-07           wkvth0=0
+ pkvth0=0                  llodvth=1                 wlodvth=1
+ lodk2=1                   lodeta0=1                 minr=1e-60
+ imax=0.01                 imelt=0.01

     4: type=p
+ lmin=1.21e-6-dxl_lvt25    lmax=2.1e-05              wmin=1.20e-6-dxw_lvt25
+ wmax=1.0e-5-dxw_lvt25     tnom=25                   version=3.24
+ tox=toxp_lvt25            toxm=toxp_lvt25           xj=2.1e-07
+ nch=5.0106e+17            lln=1                     lwn=1
+ wln=1                     wwn=-1                    lint=4.358e-08
+ ll=0                      lw=0                      lwl=0
+ wint=1.5e-08              wl=0                      ww=0
+ wwl=0                     mobmod=1                  binunit=2
+ xl=-4e-08+dxl_lvt25       xw=1e-08+dxw_lvt25        dwg=0
+ dwb=0                     ldif=8e-08                hdif=hdifp_lvt25
+ rsh=7.2                   rd=0                      rs=0
+ vth0=-0.3839642+dvthp_lvt25                         lvth0=2.161761e-08
+ wvth0=4.251067e-09        pvth0=8.369411e-15        k1=0.6627182
+ lk1=2.247444e-08          wk1=-3.840648e-08         pk1=4.304862e-14
+ k2=-0.08468857            lk2=-1.675725e-08         wk2=4.005075e-09
+ pk2=-6.888842e-15         k3=0                      dvt0=0
+ dvt1=0                    dvt2=0                    dvt0w=0
+ dvt1w=0                   dvt2w=0                   nlx=0
+ w0=0                      k3b=0                     vfb=-1.196183
+ vsat=151000               ua=2.183066e-09           lua=-2.61773e-16
+ wua=-2.754853e-16         pua=2.371522e-22          ub=5.403099e-19
+ lub=-1.57627e-26          wub=-3.39199e-25          pub=1.446462e-31
+ uc=-4.734588e-13          luc=-5.026334e-18         wuc=-4.597634e-17
+ puc=5.016613e-23          rdsw=674                  prwb=0
+ prwg=0                    wr=1                      u0=0.0162409
+ lu0=6.516855e-11          wu0=-2.929435e-09         pu0=-3.714752e-17
+ a0=0.953822               la0=-3.263548e-07         keta=-0.02768819
+ lketa=-2.145301e-08       wketa=7.008639e-09        pketa=-7.589233e-15
+ a1=0                      a2=0.99                   ags=0.3263683
+ lags=1.733775e-07         wags=-2.347986e-08        pags=6.095662e-14
+ b0=0                      b1=0                      voff=-0.09799273
+ lvoff=2.039932e-08        wvoff=1.401174e-09        pvoff=-1.514796e-15
+ nfactor=1                 cit=-0.00111081           lcit=1.08451e-10
+ wcit=4.116035e-12         pcit=-4.129544e-17        cdsc=0
+ cdscb=0                   cdscd=0                   eta0=0.0001
+ etab=-1e-05               dsub=0                    pclm=0.5736984
+ lpclm=2.264681e-07        wpclm=-3.070159e-07       ppclm=8.03664e-13
+ pdiblc1=0                 pdiblc2=-0.0002842414     lpdiblc2=6.496124e-09
+ wpdiblc2=1.47762e-10      ppdiblc2=-1.482472e-15    pdiblcb=0.01839013
+ lpdiblcb=-1.845052e-07    drout=0                   pscbe1=4.908216e+08
+ pscbe2=1e-20              pvag=0                    delta=0.01
+ alpha0=0                  alpha1=0.1476             beta0=20.5
+ kt1=-0.1613               kt2=0.01023361            lkt2=7.388069e-09
+ at=-45103.43              lat=-0.04956928           ute=-0.8850012
+ lute=-6.148346e-08        wute=4.715841e-07         pute=-2.968809e-13
+ ua1=1.526418e-09          lua1=-4.06418e-16         wua1=1.441759e-15
+ pua1=-1.038711e-21        ub1=-2.059226e-18         uc1=2.50956e-11
+ luc1=-8.781355e-17        kt1l=0                    prt=0
+ cj=cjp_lvt25              mj=0.3576069              pb=0.8564895
+ cjsw=cjswp_lvt25          mjsw=0.2                  pbsw=0.8564895
+ cjswg=cjswgp_lvt25        mjswg=0.2                 pbswg=0.8564895
+ tcj=0.001012982           tcjsw=0.0006497512        tcjswg=0.0006497512
+ tpb=0.00202374            tpbsw=0.00202374          tpbswg=0.00202374
+ js=2.03e-7                jsw=1.3e-12               n=1
+ xti=3                     cgdo=cgop_lvt25           cgso=cgop_lvt25
+ capmod=3                  nqsmod=0                  xpart=1
+ cf=0                      tlev=1                    dlc=3.0e-08
+ tlevc=1                   cgdl=cglp_lvt25           cgsl=cglp_lvt25
+ wwc=-0.018                dwc=0                     noia=2.0e+19
+ noib=6.0e+3               noic=6.0e-12              em=1.0e+8
+ ef=1.262                  noimod=2                  sa0=0.35e-6
+ sb0=0.35e-6               kvsat=-1                  wlod=0.3e-6
+ tku0=0.03                 ku0=8.5e-08               llodku0=1
+ wlodku0=1                 lku0=8.0e-09              wku0=6.0e-07
+ pku0=0                    kvth0=1.1e-09             stk2=0
+ steta0=-3e-10             lkvth0=-1.0e-07           wkvth0=0
+ pkvth0=0                  llodvth=1                 wlodvth=1
+ lodk2=1                   lodeta0=1                 minr=1e-60
+ imax=0.01                 imelt=0.01

     5: type=p
+ lmin=5e-7-dxl_lvt25       lmax=1.21e-6-dxl_lvt25    wmin=1.20e-6-dxw_lvt25
+ wmax=1.0e-5-dxw_lvt25     tnom=25                   version=3.24
+ tox=toxp_lvt25            toxm=toxp_lvt25           xj=2.1e-07
+ nch=5.0106e+17            lln=1                     lwn=1
+ wln=1                     wwn=-1                    lint=4.358e-08
+ ll=0                      lw=0                      lwl=0
+ wint=1.5e-08              wl=0                      ww=0
+ wwl=0                     mobmod=1                  binunit=2
+ xl=-4e-08+dxl_lvt25       xw=1e-08+dxw_lvt25        dwg=0
+ dwb=0                     ldif=8e-08                hdif=hdifp_lvt25
+ rsh=7.2                   rd=0                      rs=0
+ vth0=-0.37977+dvthp_lvt25 lvth0=1.707589e-08        wvth0=1.475763e-08
+ pvth0=-3.007514e-15       k1=0.7050192              lk1=-2.333079e-08
+ wk1=1.275381e-08          pk1=-1.234977e-14         k2=-0.08865307
+ lk2=-1.246434e-08         wk2=-7.178314e-09         pk2=5.220979e-15
+ k3=0                      dvt0=0                    dvt1=0
+ dvt2=0                    dvt0w=0                   dvt1w=0
+ dvt2w=0                   nlx=0                     w0=0
+ k3b=0                     vfb=-1.165333             vsat=151000
+ ua=2.07722e-09            lua=-1.471588e-16         wua=-1.777241e-16
+ pua=1.312924e-22          ub=3.072541e-19           lub=2.365994e-25
+ wub=-1.370928e-25         pub=-7.420248e-32         uc=-7.276225e-12
+ luc=2.339973e-18          wuc=5.360018e-19          puc=-1.992949e-25
+ rdsw=674                  prwb=0                    prwg=0
+ wr=1                      u0=0.01631391             lu0=-1.388804e-11
+ wu0=-3.085358e-09         pu0=1.316934e-16          a0=0.7881335
+ la0=-1.469407e-07         wa0=1.437101e-07          pa0=-1.556151e-13
+ keta=-0.06612958          lketa=2.017286e-08        wketa=1.26635e-08
+ pketa=-1.371254e-14       a1=0                      a2=0.99
+ ags=0.7366954             lags=-2.709411e-07        wags=5.004464e-08
+ pags=-1.865864e-14        b0=0                      b1=0
+ voff=-0.0860112           lvoff=7.425243e-09        wvoff=6.86652e-10
+ pvoff=-7.410837e-16       nfactor=1                 cit=-0.001085083
+ lcit=8.059294e-11         wcit=-7.386994e-11        pcit=4.315089e-17
+ cdsc=0                    cdscb=0                   cdscd=0
+ eta0=-0.0003726141        leta0=5.117655e-10        etab=0.0006120667
+ letab=-6.735987e-10       wetab=-2.036185e-10       petab=2.204863e-16
+ dsub=0                    pclm=0.7647421            lpclm=1.959833e-08
+ wpclm=5.820248e-07        ppclm=-1.590249e-13       pdiblc1=0
+ pdiblc2=-1.076163e-05     lpdiblc2=6.199989e-09     wpdiblc2=-4.852191e-10
+ ppdiblc2=-7.970535e-16    pdiblcb=-0.2318193        lpdiblcb=8.64315e-08
+ drout=0                   pscbe1=4.908216e+08       pscbe2=1e-20
+ pvag=0                    delta=0.01                alpha0=0
+ alpha1=0.1476             beta0=20.5                kt1=-0.1613
+ kt2=0.03032961            lkt2=-1.437268e-08        wkt2=-5.919874e-09
+ pkt2=6.410275e-15         at=-48807.64              lat=-0.0455582
+ ute=-0.8261154            lute=-1.252474e-07        wute=1.420606e-07
+ pute=5.994029e-14         ua1=1.424689e-09          lua1=-2.962622e-16
+ wua1=5.004744e-16         pua1=-1.945043e-23        ub1=-2.059226e-18
+ uc1=-5.6e-11              kt1l=0                    prt=0
+ cj=cjp_lvt25              mj=0.3576069              pb=0.8564895
+ cjsw=cjswp_lvt25          mjsw=0.2                  pbsw=0.8564895
+ cjswg=cjswgp_lvt25        mjswg=0.2                 pbswg=0.8564895
+ tcj=0.001012982           tcjsw=0.0006497512        tcjswg=0.0006497512
+ tpb=0.00202374            tpbsw=0.00202374          tpbswg=0.00202374
+ js=2.03e-7                jsw=1.3e-12               n=1
+ xti=3                     cgdo=cgop_lvt25           cgso=cgop_lvt25
+ capmod=3                  nqsmod=0                  xpart=1
+ cf=0                      dlc=3.0e-08               tlev=1
+ tlevc=1                   cgdl=cglp_lvt25           cgsl=cglp_lvt25
+ wwc=-0.018                dwc=0                     noia=2.0e+19
+ noib=6.0e+3               noic=6.0e-12              em=1.0e+8
+ ef=1.262                  noimod=2                  sa0=0.35e-6
+ sb0=0.35e-6               kvsat=-1                  wlod=0.3e-6
+ tku0=0.03                 ku0=8.5e-08               llodku0=1
+ wlodku0=1                 lku0=8.0e-09              wku0=6.0e-07
+ pku0=0                    kvth0=1.1e-09             stk2=0
+ steta0=-3e-10             lkvth0=-1.0e-07           wkvth0=0
+ pkvth0=0                  llodvth=1                 wlodvth=1
+ lodk2=1                   lodeta0=1                 minr=1e-60
+ imax=0.01                 imelt=0.01

     6: type=p
+ lmin=3.7e-07              lmax=5e-7-dxl_lvt25       wmin=1.20e-6-dxw_lvt25
+ wmax=1.0e-5-dxw_lvt25     tnom=25                   version=3.24
+ tox=toxp_lvt25            toxm=toxp_lvt25           xj=2.1e-07
+ nch=5.0106e+17            lln=1                     lwn=1
+ wln=1                     wwn=-1                    lint=4.358e-08
+ ll=0                      lw=0                      lwl=0
+ wint=1.5e-08              wl=0                      ww=0
+ wwl=0                     mobmod=1                  binunit=2
+ xl=-4e-08+dxl_lvt25       xw=1e-08+dxw_lvt25        dwg=0
+ dwb=0                     ldif=8e-08                hdif=hdifp_lvt25
+ rsh=7.2                   rd=0                      rs=0
+ vth0=-0.4042627+dvthp_lvt25                         lvth0=2.620776e-08
+ wvth0=7.244592e-09        pvth0=-2.063541e-16       k1=1.106813
+ lk1=-1.731358e-07         wk1=4.155578e-09          pk1=-9.144004e-15
+ k2=-0.2209646             lk2=3.686668e-08          wk2=-9.319749e-09
+ pk2=6.019391e-15          k3=0                      dvt0=0
+ dvt1=0                    dvt2=0                    dvt0w=0
+ dvt1w=0                   dvt2w=0                   nlx=0
+ w0=0                      k3b=0                     vfb=-0.9752401
+ vsat=151000               ua=5.044291e-10           lua=4.392407e-16
+ wua=3.419515e-16          pua=-6.246343e-23         ub=2.007711e-18
+ lub=-3.973991e-25         wub=-9.692364e-25         pub=2.360539e-31
+ uc=3.295369e-11           luc=-1.265935e-17         wuc=-3.138474e-17
+ puc=1.170204e-23          rdsw=674                  prwb=0
+ prwg=0                    wr=1                      u0=0.01436143
+ lu0=7.14076e-10           wu0=-1.195283e-09         pu0=-5.730022e-16
+ a0=-2.135083              la0=9.429513e-07          wa0=1.805176e-06
+ pa0=-7.750763e-13         keta=-0.07674707          lketa=2.413148e-08
+ wketa=-1.571648e-08       pketa=-3.13135e-15        a1=0
+ a2=0.99                   ags=0.01                  b0=0
+ b1=0                      voff=-0.07026593          lvoff=1.554774e-09
+ wvoff=2.163777e-09        pvoff=-1.291815e-15       nfactor=1
+ cit=-0.001250451          lcit=1.422488e-10         wcit=-9.367474e-11
+ pcit=5.05349e-17          cdsc=0                    cdscb=0
+ cdscd=0                   eta0=-0.008507479         leta0=3.544769e-09
+ weta0=-1.292742e-09       peta0=4.819861e-16        etab=-0.0004080755
+ letab=-2.932488e-10       wetab=-2.703877e-10       petab=2.453806e-16
+ dsub=0                    pclm=0.533783             lpclm=1.057091e-07
+ wpclm=1.005704e-06        ppclm=-3.169895e-13       pdiblc1=0
+ pdiblc2=0.03688385        lpdiblc2=-7.555797e-09    wpdiblc2=-1.181906e-08
+ ppdiblc2=3.428655e-15     pdiblcb=0                 drout=0
+ pscbe1=4.908216e+08       pscbe2=1e-20              pvag=0
+ delta=0.01                alpha0=0                  alpha1=0.1476
+ beta0=20.5                kt1=-0.1613               kt2=0.03857622
+ lkt2=-1.744735e-08        wkt2=-6.294842e-08        pkt2=2.76728e-14
+ at=-171000                ute=-0.9851395            lute=-6.595686e-08
+ wute=1.778777e-07         pute=4.658624e-14         ua1=1.468681e-09
+ lua1=-3.12664e-16         wua1=2.18918e-18          pua1=1.663302e-22
+ ub1=-1.997826e-18         lub1=-2.289248e-26        wub1=-6.127751e-25
+ pub1=2.284671e-31         uc1=-5.6e-11              kt1l=0
+ prt=0                     cj=cjp_lvt25              mj=0.3576069
+ pb=0.8564895              cjsw=cjswp_lvt25          mjsw=0.2
+ pbsw=0.8564895            cjswg=cjswgp_lvt25        mjswg=0.2
+ pbswg=0.8564895           tcj=0.001012982           tcjsw=0.0006497512
+ tcjswg=0.0006497512       tpb=0.00202374            tpbsw=0.00202374
+ tpbswg=0.00202374         js=2.03e-7                jsw=1.3e-12
+ n=1                       xti=3                     cgdo=cgop_lvt25
+ cgso=cgop_lvt25           capmod=3                  nqsmod=0
+ xpart=1                   cf=0                      dlc=3.0e-08
+ tlev=1                    tlevc=1                   cgdl=cglp_lvt25
+ cgsl=cglp_lvt25           wwc=-0.018                dwc=0
+ noia=2.0e+19              noib=6.0e+3               noic=6.0e-12
+ em=1.0e+8                 ef=1.262                  noimod=2
+ sa0=0.35e-6               sb0=0.35e-6               kvsat=-1
+ wlod=0.3e-6               tku0=0.03                 ku0=8.5e-08
+ llodku0=1                 wlodku0=1                 lku0=8.0e-09
+ wku0=6.0e-07              pku0=0                    kvth0=1.1e-09
+ stk2=0                    steta0=-3e-10             lkvth0=-1.0e-07
+ wkvth0=0                  pkvth0=0                  llodvth=1
+ wlodvth=1                 lodk2=1                   lodeta0=1
+ minr=1e-60                imax=0.01                 imelt=0.01

     7: type=p
+ lmin=1.21e-6-dxl_lvt25    lmax=2.1e-05              wmin=5.8e-7-dxw_lvt25
+ wmax=1.20e-6-dxw_lvt25    tnom=25                   version=3.24
+ tox=toxp_lvt25            toxm=toxp_lvt25           xj=2.1e-07
+ nch=5.0106e+17            lln=1                     lwn=1
+ wln=1                     wwn=-1                    lint=4.358e-08
+ ll=0                      lw=0                      lwl=0
+ wint=1.5e-08              wl=0                      ww=0
+ wwl=0                     mobmod=1                  binunit=2
+ xl=-4e-08+dxl_lvt25       xw=1e-08+dxw_lvt25        dwg=0
+ dwb=0                     ldif=8e-08                hdif=hdifp_lvt25
+ rsh=7.2                   rd=0                      rs=0
+ vth0=-0.3885612+dvthp_lvt25                         lvth0=3.3043390e-08
+ wvth0=9.6755010e-09       pvth0=-5.1130840e-15      k1=0.6819998
+ lk1=4.791411e-08          wk1=-6.11587e-08          pk1=1.302981e-14
+ k2=-0.09420194            lk2=-1.483996e-08         wk2=1.523086e-08
+ pk2=-9.151241e-15         k3=0                      dvt0=0
+ dvt1=0                    dvt2=0                    dvt0w=0
+ dvt1w=0                   dvt2w=0                   nlx=0
+ w0=0                      k3b=0                     vfb=-1.156694
+ vsat=1.4990720e+05        lvsat=1.0963790e-02       wvsat=1.2894926e-03
+ pvsat=-1.2937274e-08      ua=2.152495e-09           lua=-3.424896e-16
+ wua=-2.394117e-16         pua=3.323978e-22          ub=2.544129e-19
+ lub=1.457188e-25          wub=-1.840577e-27         pub=-4.590202e-32
+ uc=-2.662969e-11          luc=3.795023e-17          wuc=-1.511199e-17
+ puc=-5.462098e-25         rdsw=674                  prwb=0
+ prwg=0                    wr=1                      u0=1.4673601e-02
+ lu0=-5.0626200e-12        wu0=-1.0800212e-09        pu0=4.5727460e-17
+ a0=0.9614633              la0=-4.030182e-07         wa0=-9.016706e-09
+ pa0=9.04629e-14           keta=-0.0216913           lketa=-2.846017e-08
+ wketa=-6.769795e-11       pketa=6.79205e-16         a1=0
+ a2=0.99                   ags=0.3128099             lags=1.614294e-07
+ wags=-7.480972e-09        pags=7.505539e-14         b0=0
+ b1=0                      voff=-0.09051284          lvoff=1.773431e-08
+ wvoff=-7.425088e-09       pvoff=1.629912e-15        nfactor=1
+ cit=-0.0006685374         lcit=-3.424923e-10        wcit=-5.177652e-10
+ pcit=4.908177e-16         cdsc=0                    cdscb=0
+ cdscd=0                   eta0=0.0001               etab=-1e-05
+ dsub=0                    pclm=0.1042367            lpclm=8.525682e-07
+ wpclm=2.46949e-07         ppclm=6.486587e-14        pdiblc1=0
+ pdiblc2=-0.000235732      lpdiblc2=6.009437e-09     wpdiblc2=9.052103e-11
+ ppdiblc2=-9.081815e-16    pdiblcb=0.03500053        lpdiblcb=-3.511551e-07
+ wpdiblcb=-1.960031e-08    ppdiblcb=1.966469e-13     drout=0
+ pscbe1=4.908216e+08       pscbe2=1e-20              pvag=0
+ delta=0.01                alpha0=0                  alpha1=0.1476
+ beta0=20.5                kt1=-0.1613               kt2=0.009301652
+ lkt2=1.673827e-08         wkt2=1.099712e-09         pkt2=-1.103323e-14
+ at=-49915.15              lat=-0.001693858          wat=0.005677841
+ pat=-5.6493e-08           ute=-0.3899921            lute=-5.678347e-07
+ wute=-1.125267e-07        pute=3.006135e-13         ua1=3.221025e-09
+ lua1=-2.042745e-15        wua1=-5.578784e-16        pua1=8.921557e-22
+ ub1=-2.059226e-18         uc1=2.509559e-11          luc1=-8.781355e-17
+ kt1l=0                    prt=0                     cj=cjp_lvt25
+ mj=0.3576069              pb=0.8564895              cjsw=cjswp_lvt25
+ mjsw=0.2                  pbsw=0.8564895            cjswg=cjswgp_lvt25
+ mjswg=0.2                 pbswg=0.8564895           tcj=0.001012982
+ tcjsw=0.0006497512        tcjswg=0.0006497512       tpb=0.00202374
+ tpbsw=0.00202374          tpbswg=0.00202374         js=2.03e-7
+ jsw=1.3e-12               n=1                       xti=3
+ cgdo=cgop_lvt25           cgso=cgop_lvt25           capmod=3
+ nqsmod=0                  xpart=1                   cf=0
+ tlev=1                    tlevc=1                   dlc=3.0e-08
+ cgdl=cglp_lvt25           cgsl=cglp_lvt25           wwc=-0.018
+ dwc=0                     noia=2.0e+19              noib=6.0e+3
+ noic=6.0e-12              em=1.0e+8                 ef=1.262
+ noimod=2                  sa0=0.35e-6               sb0=0.35e-6
+ kvsat=-1                  wlod=0.3e-6               tku0=0.03
+ ku0=8.5e-08               llodku0=1                 wlodku0=1
+ lku0=8.0e-09              wku0=6.0e-07              pku0=0
+ kvth0=1.1e-09             stk2=0                    steta0=-3e-10
+ lkvth0=-1.0e-07           wkvth0=0                  pkvth0=0
+ llodvth=1                 wlodvth=1                 lodk2=1
+ lodeta0=1                 minr=1e-60                imax=0.01
+ imelt=0.01

     8: type=p
+ lmin=5e-7-dxl_lvt25       lmax=1.21e-6-dxl_lvt25    wmin=5.8e-7-dxw_lvt25
+ wmax=1.20e-6-dxw_lvt25    tnom=25                   version=3.24
+ tox=toxp_lvt25            toxm=toxp_lvt25           xj=2.1e-07
+ nch=5.0106e+17            lln=1                     lwn=1
+ wln=1                     wwn=-1                    lint=4.358e-08
+ ll=0                      lw=0                      lwl=0
+ wint=1.5e-08              wl=0                      ww=0
+ wwl=0                     mobmod=1                  binunit=2
+ xl=-4e-08+dxl_lvt25       xw=1e-08+dxw_lvt25        dwg=0
+ dwb=0                     ldif=8e-08                hdif=hdifp_lvt25
+ rsh=7.2                   rd=0                      rs=0
+ vth0=-0.3702509+dvthp_lvt25                         lvth0=1.3216305e-08
+ wvth0=3.5251200e-09       pvth0=1.5467975e-15       k1=0.7607205
+ lk1=-3.732786e-08         wk1=-5.297371e-08         pk1=4.166779e-15
+ k2=-0.09738045            lk2=-1.139815e-08         wk2=3.119994e-09
+ pk2=3.962883e-15          k3=0                      dvt0=0
+ dvt1=0                    dvt2=0                    dvt0w=0
+ dvt1w=0                   dvt2w=0                   nlx=0
+ w0=0                      k3b=0                     vfb=-1.13432
+ vsat=1.7151050e+05        lvsat=-1.2429117e-02      wvsat=-2.4202388e-02
+ pvsat=1.4666360e-08       ua=1.965406e-09           lua=-1.399024e-16
+ wua=-4.578384e-17         pua=1.2273e-22            ub=1.647633e-19
+ lub=2.427951e-25          wub=3.104641e-26          pub=-8.151339e-32
+ uc=9.416496e-12           luc=-1.082032e-18         wuc=-1.916141e-17
+ puc=3.838672e-24          rdsw=674                  prwb=0
+ prwg=0                    wr=1                      u0=1.4433551e-02
+ lu0=2.5487235e-10         wu0=-8.6653500e-10        pu0=-1.8544394e-16
+ a0=0.7416299              la0=-1.649738e-07         wa0=1.985845e-07
+ pa0=-1.34336e-13          keta=-0.05842841          lketa=1.132025e-08
+ wketa=3.576124e-09        pketa=-3.266472e-15       a1=0
+ a2=0.99                   ags=0.6991889             lags=-2.569572e-07
+ wags=9.430239e-08         pags=-3.51597e-14         b0=0
+ b1=0                      voff=-0.07758927          lvoff=3.740139e-09
+ wvoff=-9.251236e-09       pvoff=3.60734e-15         nfactor=1
+ cit=-0.001029325          lcit=4.818287e-11         wcit=-1.39664e-10
+ pcit=8.139478e-17         cdsc=0                    cdscb=0
+ cdscd=0                   eta0=-0.000281737         leta0=4.1336e-10
+ weta0=-1.072353e-10       peta0=1.161187e-16        etab=0.0005560081
+ letab=-6.128962e-10       wetab=-1.374695e-10       petab=1.488574e-16
+ dsub=0                    pclm=0.9502288            lpclm=-6.350592e-08
+ wpclm=3.631506e-07        ppclm=-6.096188e-14       pdiblc1=0
+ pdiblc2=0.001635744       lpdiblc2=3.982925e-09     wpdiblc2=-2.428099e-09
+ ppdiblc2=1.819083e-15     pdiblcb=-0.4412043        lpdiblcb=1.644986e-07
+ wpdiblcb=2.470744e-07     ppdiblcb=-9.211922e-14    drout=0
+ pscbe1=4.908216e+08       pscbe2=1e-20              pvag=0
+ delta=0.01                alpha0=0                  alpha1=0.1476
+ beta0=20.5                kt1=-0.1613               kt2=0.03737658
+ lkt2=-1.36624e-08         wkt2=-1.423531e-08        pkt2=5.572145e-15
+ at=11284.01               lat=-0.06796277           wat=-0.07090817
+ pat=2.643741e-08          ute=-0.8404544            lute=-8.005608e-08
+ wute=1.589806e-07         pute=6.614498e-15         ua1=1.499035e-09
+ lua1=-1.781056e-16        wua1=4.127461e-16         pua1=-1.588753e-22
+ ub1=-2.059226e-18         uc1=-5.6e-11              kt1l=0
+ prt=0                     cj=cjp_lvt25              mj=0.3576069
+ pb=0.8564895              cjsw=cjswp_lvt25          mjsw=0.2
+ pbsw=0.8564895            cjswg=cjswgp_lvt25        mjswg=0.2
+ pbswg=0.8564895           tcj=0.001012982           tcjsw=0.0006497512
+ tcjswg=0.0006497512       tpb=0.00202374            tpbsw=0.00202374
+ tpbswg=0.00202374         js=2.03e-7                jsw=1.3e-12
+ n=1                       xti=3                     cgdo=cgop_lvt25
+ cgso=cgop_lvt25           capmod=3                  nqsmod=0
+ xpart=1                   cf=0                      tlev=1
+ tlevc=1                   dlc=3.0e-08               cgdl=cglp_lvt25
+ cgsl=cglp_lvt25           wwc=-0.018                dwc=0
+ noia=2.0e+19              noib=6.0e+3               noic=6.0e-12
+ em=1.0e+8                 ef=1.262                  noimod=2
+ sa0=0.35e-6               sb0=0.35e-6               kvsat=-1
+ wlod=0.3e-6               tku0=0.03                 ku0=8.5e-08
+ llodku0=1                 wlodku0=1                 lku0=8.0e-09
+ wku0=6.0e-07              pku0=0                    kvth0=1.1e-09
+ stk2=0                    steta0=-3e-10             lkvth0=-1.0e-07
+ wkvth0=0                  pkvth0=0                  llodvth=1
+ wlodvth=1                 lodk2=1                   lodeta0=1
+ minr=1e-60                imax=0.01                 imelt=0.01

     9: type=p
+ lmin=3.7e-07              lmax=5e-7-dxl_lvt25       wmin=5.8e-7-dxw_lvt25
+ wmax=1.20e-6-dxw_lvt25    tnom=25                   version=3.24
+ tox=toxp_lvt25            toxm=toxp_lvt25           xj=2.1e-07
+ nch=5.0106e+17            lln=1                     lwn=1
+ wln=1                     wwn=-1                    lint=4.358e-08
+ ll=0                      lw=0                      lwl=0
+ wint=1.5e-08              wl=0                      ww=0
+ wwl=0                     mobmod=1                  binunit=2
+ xl=-4e-08+dxl_lvt25       xw=1e-08+dxw_lvt25        dwg=0
+ dwb=0                     ldif=8e-08                hdif=hdifp_lvt25
+ rsh=7.2                   rd=0                      rs=0
+ vth0=-0.4067170+dvthp_lvt25                         lvth0=2.6812332e-08
+ wvth0=1.0140631e-08       pvth0=-9.1972940e-16      k1=1.163442
+ lk1=-1.874786e-07         wk1=-6.266622e-08         pk1=7.780545e-15
+ k2=-0.2475377             lk2=4.458649e-08          wk2=2.203658e-08
+ pk2=-3.089982e-15         k3=0                      dvt0=0
+ dvt1=0                    dvt2=0                    dvt0w=0
+ dvt1w=0                   dvt2w=0                   nlx=0
+ w0=0                      k3b=0                     vfb=-0.8817574
+ vsat=1.3648692e+05        lvsat=6.2907490e-04       wvsat=1.7125441e-02
+ pvsat=-7.4230860e-10      ua=1.195577e-10           lua=5.483038e-16
+ wua=7.960996e-16          pua=-1.911579e-22         ub=1.593939e-18
+ lub=-2.900586e-25         wub=-4.809846e-25         pub=1.093922e-31
+ uc=5.870042e-12           luc=2.402266e-19          wuc=5.739569e-19
+ puc=-3.519462e-24         rdsw=674                  prwb=0
+ prwg=0                    wr=1                      u0=1.4126849e-02
+ lu0=3.6922310e-10         wu0=-9.1848920e-10        pu0=-1.6607332e-16
+ a0=-1.041056              la0=4.996827e-07          wa0=5.14225e-07
+ pa0=-2.520194e-13         keta=-0.1106989           lketa=3.080879e-08
+ wketa=2.434669e-08        pketa=-1.101057e-14       a1=0
+ a2=0.99                   ags=0.01                  b0=0
+ b1=0                      voff=-0.06568749          lvoff=-6.973183e-10
+ wvoff=-3.238775e-09       pvoff=1.365654e-15        nfactor=1
+ cit=-0.001575053          lcit=2.516521e-10         wcit=2.893558e-10
+ pcit=-7.856098e-17        cdsc=0                    cdscb=0
+ cdscd=0                   eta0=-0.01063095          leta0=4.27196e-09
+ weta0=1.212951e-09        peta0=-3.760996e-16       etab=-0.0007691921
+ letab=-1.188086e-10       wetab=1.557298e-10        petab=3.954101e-17
+ dsub=0                    pclm=1.408507             lpclm=-2.343704e-07
+ wpclm=-2.647015e-08       ppclm=8.430432e-14        pdiblc1=0
+ pdiblc2=0.02326492        lpdiblc2=-4.081296e-09    wpdiblc2=4.251277e-09
+ ppdiblc2=-6.712558e-16    pdiblcb=0                 drout=0
+ pscbe1=4.908216e+08       pscbe2=1e-20              pvag=0
+ delta=0.01                alpha0=0                  alpha1=0.1476
+ beta0=20.5                kt1=-0.1613               kt2=-0.02442883
+ lkt2=9.381131e-09         wkt2=1.139753e-08         pkt2=-3.984801e-15
+ at=-171000                ute=-0.9508262            lute=-3.890506e-08
+ wute=1.373879e-07         pute=1.466512e-14         ua1=1.470533e-09
+ lua1=-1.674788e-16        pua1=-4.988391e-24        ub1=-2.517127e-18
+ lub1=1.707237e-25         uc1=-5.6e-11              kt1l=0
+ prt=0                     cj=cjp_lvt25              mj=0.3576069
+ pb=0.8564895              cjsw=cjswp_lvt25          mjsw=0.2
+ pbsw=0.8564895            cjswg=cjswgp_lvt25        mjswg=0.2
+ pbswg=0.8564895           tcj=0.001012982           tcjsw=0.0006497512
+ tcjswg=0.0006497512       tpb=0.00202374            tpbsw=0.00202374
+ tpbswg=0.00202374         js=2.03e-7                jsw=1.3e-12
+ n=1                       xti=3                     cgdo=cgop_lvt25
+ cgso=cgop_lvt25           capmod=3                  nqsmod=0
+ xpart=1                   cf=0                      tlev=1
+ tlevc=1                   dlc=3.0e-08               cgdl=cglp_lvt25
+ cgsl=cglp_lvt25           wwc=-0.018                dwc=0
+ noia=2.0e+19              noib=6.0e+3               noic=6.0e-12
+ em=1.0e+8                 ef=1.262                  noimod=2
+ sa0=0.35e-6               sb0=0.35e-6               kvsat=-1
+ wlod=0.3e-6               tku0=0.03                 ku0=8.5e-08
+ llodku0=1                 wlodku0=1                 lku0=8.0e-09
+ wku0=6.0e-07              pku0=0                    kvth0=1.1e-09
+ stk2=0                    steta0=-3e-10             lkvth0=-1.0e-07
+ wkvth0=0                  pkvth0=0                  llodvth=1
+ wlodvth=1                 lodk2=1                   lodeta0=1
+ minr=1e-60                imax=0.01                 imelt=0.01

     10: type=p
+ lmin=1.21e-6-dxl_lvt25    lmax=2.1e-05              wmin=1.5e-07
+ wmax=5.8e-7-dxw_lvt25     tnom=25                   version=3.24
+ tox=toxp_lvt25            toxm=toxp_lvt25           xj=2.1e-07
+ nch=5.0106e+17            lln=1                     lwn=1
+ wln=1                     wwn=-1                    lint=4.358e-08
+ ll=0                      lw=0                      lwl=0
+ wint=1.5e-08              wl=0                      ww=0
+ wwl=0                     mobmod=1                  binunit=2
+ xl=-4e-08+dxl_lvt25       xw=1e-08+dxw_lvt25        dwg=0
+ dwb=0                     ldif=8e-08                hdif=hdifp_lvt25
+ rsh=7.2                   rd=0                      rs=0
+ vth0=-0.3800694+dvthp_lvt25                         lvth0=2.5917720e-08
+ wvth0=4.9200960e-09       pvth0=-1.1227137e-15      k1=0.5984753
+ lk1=8.488056e-08          wk1=-1.4385e-08           pk1=-7.671394e-15
+ k2=-0.07085884            lk2=-3.743363e-08         wk2=2.15872e-09
+ pk2=3.501205e-15          k3=0                      dvt0=0
+ dvt1=0                    dvt2=0                    dvt0w=0
+ dvt1w=0                   dvt2w=0                   nlx=0
+ w0=0                      k3b=0                     vfb=-1.0592
+ vsat=1.5246592e+05        lvsat=-1.4707326e-02      wvsat=-1.4338404e-04
+ pvsat=1.4385508e-09       ua=1.999559e-09           lua=3.07975e-16
+ wua=-1.537674e-16         pua=-3.186235e-23         ub=2.796782e-19
+ lub=5.774054e-26          wub=-1.598912e-26         pub=3.365829e-33
+ uc=-5.844156e-11          luc=4.223287e-17          wuc=2.702658e-18
+ puc=-2.94449e-24          rdsw=674                  prwb=0
+ prwg=0                    wr=1                      u0=1.3006170e-02
+ lu0=2.5365454e-10         wu0=-1.4626059e-10        pu0=-9.9154130e-17
+ a0=0.8976998              la0=-1.982719e-07         wa0=2.669081e-08
+ pa0=-2.419507e-14         keta=-0.02531755          lketa=-2.882861e-08
+ wketa=1.963003e-09        pketa=8.855332e-16        a1=0
+ a2=0.99                   ags=0.3098276             lags=3.255564e-07
+ wags=-5.810876e-09        pags=-1.685574e-14        b0=0
+ b1=0                      voff=-0.1057689           lvoff=2.001167e-08
+ wvoff=1.118317e-09        pvoff=3.545903e-16        nfactor=1
+ cit=-0.0017422            lcit=6.954001e-10         wcit=8.348602e-11
+ pcit=-9.040201e-17        cdsc=0                    cdscb=0
+ cdscd=0                   eta0=0.0001               etab=-1e-05
+ dsub=0                    pclm=0.2353081            lpclm=1.51378e-06
+ wpclm=1.735491e-07        ppclm=-3.054128e-13       pdiblc1=0
+ pdiblc2=-0.0001203587     lpdiblc2=4.43711e-09      wpdiblc2=2.591181e-11
+ ppdiblc2=-2.767843e-17    pdiblcb=0                 drout=0
+ pscbe1=4.908216e+08       pscbe2=1e-20              pvag=0
+ delta=0.01                alpha0=0                  alpha1=0.1476
+ beta0=20.5                kt1=-0.1613               kt2=0.01314171
+ lkt2=-5.147999e-09        wkt2=-1.050721e-09        pkt2=1.223076e-15
+ at=-37330.32              lat=-0.1271248            wat=-0.001369664
+ pat=1.374831e-08          ute=-0.5744605            lute=-3.871443e-08
+ wute=-9.22444e-09         pute=4.306185e-15         ua1=2.247716e-09
+ lua1=-5.277266e-16        wua1=-1.282531e-17        pua1=4.37452e-23
+ ub1=-2.059226e-18         uc1=2.509559e-11          luc1=-8.781355e-17
+ kt1l=0                    prt=0                     cj=cjp_lvt25
+ mj=0.3576069              pb=0.8564895              cjsw=cjswp_lvt25
+ mjsw=0.2                  pbsw=0.8564895            cjswg=cjswgp_lvt25
+ mjswg=0.2                 pbswg=0.8564895           tcj=0.001012982
+ tcjsw=0.0006497512        tcjswg=0.0006497512       tpb=0.00202374
+ tpbsw=0.00202374          tpbswg=0.00202374         js=2.03e-7
+ jsw=1.3e-12               n=1                       xti=3
+ cgdo=cgop_lvt25           cgso=cgop_lvt25           capmod=3
+ nqsmod=0                  xpart=1                   cf=0
+ tlev=1                    tlevc=1                   dlc=3.0e-08
+ cgdl=cglp_lvt25           cgsl=cglp_lvt25           wwc=-0.018
+ dwc=0                     noia=2.0e+19              noib=6.0e+3
+ noic=6.0e-12              em=1.0e+8                 ef=1.262
+ noimod=2                  sa0=0.35e-6               sb0=0.35e-6
+ kvsat=-1                  wlod=0.3e-6               tku0=0.03
+ ku0=8.5e-08               llodku0=1                 wlodku0=1
+ lku0=8.0e-09              wku0=6.0e-07              pku0=0
+ kvth0=1.1e-09             stk2=0                    steta0=-3e-10
+ lkvth0=-1.0e-07           wkvth0=0                  pkvth0=0
+ llodvth=1                 wlodvth=1                 lodk2=1
+ lodeta0=1                 minr=1e-60                imax=0.01
+ imelt=0.01

     11: type=p
+ lmin=5e-7-dxl_lvt25       lmax=1.21e-6-dxl_lvt25    wmin=1.5e-07
+ wmax=5.8e-7-dxw_lvt25     tnom=25                   version=3.24
+ tox=toxp_lvt25            toxm=toxp_lvt25           xj=2.1e-07
+ nch=5.0106e+17            lln=1                     lwn=1
+ wln=1                     wwn=-1                    lint=4.358e-08
+ ll=0                      lw=0                      lwl=0
+ wint=1.5e-08              wl=0                      ww=0
+ wwl=0                     mobmod=1                  binunit=2
+ xl=-4e-08+dxl_lvt25       xw=1e-08+dxw_lvt25        dwg=0
+ dwb=0                     ldif=8e-08                hdif=hdifp_lvt25
+ rsh=7.2                   rd=0                      rs=0
+ vth0=-0.3710917+dvthp_lvt25                         lvth0=1.6196365e-08
+ wvth0=3.9959720e-09       pvth0=-1.2203598e-16      k1=0.7175485
+ lk1=-4.40566e-08          wk1=-2.879734e-08         pk1=7.934867e-15
+ k2=-0.1048836             lk2=-5.902162e-10         wk2=7.321778e-09
+ pk2=-2.089562e-15         k3=0                      dvt0=0
+ dvt1=0                    dvt2=0                    dvt0w=0
+ dvt1w=0                   dvt2w=0                   nlx=0
+ w0=0                      k3b=0                     vfb=-1.13432
+ vsat=1.2088939e+05        lvsat=1.9485002e-02       wvsat=4.1454300e-03
+ pvsat=-3.2055480e-09      ua=2.229303e-09           lua=5.919905e-17
+ wua=-1.93566e-16          pua=1.123315e-23          ub=2.209751e-19
+ lub=1.213066e-25          wub=-4.321945e-28         pub=-1.347984e-32
+ uc=-2.511994e-11          luc=6.150891e-18          wuc=1.789924e-19
+ puc=-2.117644e-25         rdsw=674                  prwb=0
+ prwg=0                    wr=1                      u0=1.3282422e-02
+ lu0=-4.5480420e-11        wu0=-2.2190215e-10        pu0=-1.7246383e-17
+ a0=1.106872               la0=-4.247714e-07         wa0=-5.950846e-09
+ pa0=1.115061e-14          keta=-0.05765576          lketa=6.188496e-09
+ wketa=3.143439e-09        pketa=-3.926896e-16       a1=0
+ a2=0.99                   ags=0.9258054             lags=-3.414489e-07
+ wags=-3.260281e-08        pags=1.215563e-14         b0=0
+ b1=0                      voff=-0.09755978          lvoff=1.112247e-08
+ wvoff=1.93225e-09         pvoff=-5.267679e-16       nfactor=1
+ cit=-0.001325405          lcit=2.440775e-10         wcit=2.614071e-11
+ pcit=-2.83062e-17         cdsc=0                    cdscb=0
+ cdscd=0                   eta0=-0.0004575361        leta0=6.037223e-10
+ weta0=-8.787798e-12       peta0=9.515791e-18        etab=0.0003229585
+ letab=-3.605407e-10       wetab=-6.96165e-12        petab=7.538345e-18
+ dsub=0                    pclm=1.862239             lpclm=-2.479261e-07
+ wpclm=-1.475751e-07       ppclm=4.231342e-14        pdiblc1=0
+ pdiblc2=-0.003695457      lpdiblc2=8.308368e-09     wpdiblc2=5.573719e-10
+ ppdiblc2=-6.031647e-16    pdiblcb=0                 drout=0
+ pscbe1=4.908216e+08       pscbe2=1e-20              pvag=0
+ delta=0.01                alpha0=0                  alpha1=0.1476
+ beta0=20.5                kt1=-0.1613               kt2=0.01147925
+ lkt2=-3.347825e-09        wkt2=2.67196e-10          pkt2=-2.040165e-16
+ at=-146185.8              lat=-0.009251735          wat=0.0172749
+ pat=-6.440775e-09         ute=-0.5817512            lute=-3.081976e-08
+ wute=1.410683e-08         pute=-2.095785e-14        ua1=2.12101e-09
+ lua1=-3.905236e-16        wua1=6.444033e-17         pua1=-3.992115e-23
+ ub1=-2.059226e-18         uc1=-5.6e-11              kt1l=0
+ prt=0                     cj=cjp_lvt25              mj=0.3576069
+ pb=0.8564895              cjsw=cjswp_lvt25          mjsw=0.2
+ pbsw=0.8564895            cjswg=cjswgp_lvt25        mjswg=0.2
+ pbswg=0.8564895           tcj=0.001012982           tcjsw=0.0006497512
+ tcjswg=0.0006497512       tpb=0.00202374            tpbsw=0.00202374
+ tpbswg=0.00202374         js=2.03e-7                jsw=1.3e-12
+ n=1                       xti=3                     cgdo=cgop_lvt25
+ cgso=cgop_lvt25           capmod=3                  nqsmod=0
+ xpart=1                   cf=0                      tlev=1
+ tlevc=1                   dlc=3.0e-08               cgdl=cglp_lvt25
+ cgsl=cglp_lvt25           wwc=-0.018                dwc=0
+ noia=2.0e+19              noib=6.0e+3               noic=6.0e-12
+ em=1.0e+8                 ef=1.262                  noimod=2
+ sa0=0.35e-6               sb0=0.35e-6               kvsat=-1
+ wlod=0.3e-6               tku0=0.03                 ku0=8.5e-08
+ llodku0=1                 wlodku0=1                 lku0=8.0e-09
+ wku0=6.0e-07              pku0=0                    kvth0=1.1e-09
+ stk2=0                    steta0=-3e-10             lkvth0=-1.0e-07
+ wkvth0=0                  pkvth0=0                  llodvth=1
+ wlodvth=1                 lodk2=1                   lodeta0=1
+ minr=1e-60                imax=0.01                 imelt=0.01

     12: type=p
+ lmin=3.7e-07              lmax=5e-07-dxl_lvt25      wmin=1.5e-07
+ wmax=5.8e-07-dxw_lvt25    tnom=25                   version=3.24
+ tox=toxp_lvt25            toxm=toxp_lvt25           xj=2.1e-07
+ nch=5.0106e+17            lln=1                     lwn=1
+ wln=1                     wwn=-1                    lint=4.358e-08
+ ll=0                      lw=0                      lwl=0
+ wint=1.5e-08              wl=0                      ww=0
+ wwl=0                     mobmod=1                  binunit=2
+ xl=-4e-08+dxl_lvt25       xw=1e-08+dxw_lvt25        dwg=0
+ dwb=0                     ldif=8e-08                hdif=hdifp_lvt25
+ rsh=7.2                   rd=0                      rs=0
+ vth0=-0.3901487+dvthp_lvt25                         lvth0=2.3301578e-08
+ wvth0=8.6237430e-10       pvth0=1.0462947e-15       k1=1.116411
+ lk1=-1.927685e-07         wk1=-3.632884e-08         pk1=1.074291e-14
+ k2=-0.2232544             lk2=4.354316e-08          wk2=8.437962e-09
+ pk2=-2.50572e-15          k3=0                      dvt0=0
+ dvt1=0                    dvt2=0                    dvt0w=0
+ dvt1w=0                   dvt2w=0                   nlx=0
+ w0=0                      k3b=0                     vfb=-0.9722669
+ vsat=1.7558323e+05        lvsat=-9.0704510e-04      wvsat=-4.7684950e-03
+ pvsat=1.1791870e-10       ua=1.639426e-09           lua=2.791287e-16
+ wua=-5.502672e-17         pua=-4.041985e-23         ub=8.9743e-19
+ lub=-1.309029e-25         wub=-9.093981e-26         pub=2.026503e-32
+ uc=8.267921e-12           luc=-6.297441e-18         wuc=-7.68858e-19
+ puc=1.416322e-25          rdsw=674                  prwb=0
+ prwg=0                    wr=1                      u0=1.2538307e-02
+ lu0=2.3195521e-10         wu0=-2.8905305e-11        pu0=-8.9203340e-17
+ a0=-0.2291291             la0=7.334314e-08          wa0=5.9546e-08
+ pa0=-1.326923e-14         keta=-0.07105696          lketa=1.1185e-08
+ wketa=2.147188e-09        pketa=-2.124717e-17       a1=0
+ a2=0.99                   ags=0.01                  b0=0
+ b1=0                      voff=-0.06989231          lvoff=8.069355e-10
+ wvoff=-8.840776e-10       pvoff=5.232717e-16        nfactor=1
+ cit=-0.0009029703         lcit=8.657693e-11         wcit=-8.701063e-11
+ pcit=1.388115e-17         cdsc=0                    cdscb=0
+ cdscd=0                   eta0=-0.009688953         leta0=4.045564e-09
+ weta0=6.854338e-10        peta0=-2.493179e-16       etab=-0.0005459113
+ letab=-3.659129e-11       wetab=3.069257e-11        petab=-6.500653e-18
+ dsub=0                    pclm=1.493221             lpclm=-1.103415e-07
+ wpclm=-7.391006e-08       ppclm=1.484814e-14        pdiblc1=0
+ pdiblc2=0.03742132        lpdiblc2=-7.02161e-09     wpdiblc2=-3.676308e-09
+ ppdiblc2=9.753203e-16     pdiblcb=0                 drout=0
+ pscbe1=4.908216e+08       pscbe2=1e-20              pvag=0
+ delta=0.01                alpha0=0                  alpha1=0.1476
+ beta0=20.5                kt1=-0.1613               kt2=-0.003891298
+ lkt2=2.382932e-09         wkt2=-1.03491e-10         pkt2=-6.580961e-17
+ at=-171000                ute=-0.6318787            lute=-1.213023e-08
+ wute=-4.122269e-08        pute=-3.287864e-16        ua1=1.609753e-09
+ lua1=-1.999067e-16        wua1=-7.795958e-17        pua1=1.317123e-23
+ ub1=-2.517127e-18         lub1=1.707237e-25         uc1=-5.6e-11
+ kt1l=0                    prt=0                     cj=cjp_lvt25
+ mj=0.3576069              pb=0.8564895              cjsw=cjswp_lvt25
+ mjsw=0.2                  pbsw=0.8564895            cjswg=cjswgp_lvt25
+ mjswg=0.2                 pbswg=0.8564895           tcj=0.001012982
+ tcjsw=0.0006497512        tcjswg=0.0006497512       tpb=0.00202374
+ tpbsw=0.00202374          tpbswg=0.00202374         js=2.03e-7
+ jsw=1.3e-12               n=1                       xti=3
+ cgdo=cgop_lvt25           cgso=cgop_lvt25           capmod=3
+ nqsmod=0                  xpart=1                   cf=0
+ tlev=1                    tlevc=1                   dlc=3.0e-08
+ cgdl=cglp_lvt25           cgsl=cglp_lvt25           wwc=-0.018
+ dwc=0                     noia=2.0e+19              noib=6.0e+3
+ noic=6.0e-12              em=1.0e+8                 ef=1.262
+ noimod=2                  sa0=0.35e-6               sb0=0.35e-6
+ kvsat=-1                  wlod=0.3e-6               tku0=0.03
+ ku0=8.5e-08               llodku0=1                 wlodku0=1
+ lku0=8.0e-09              wku0=6.0e-07              pku0=0
+ kvth0=1.1e-09             stk2=0                    steta0=-3e-10
+ lkvth0=-1.0e-07           wkvth0=0                  pkvth0=0
+ llodvth=1                 wlodvth=1                 lodk2=1
+ lodeta0=1                 minr=1e-60                imax=0.01
+ imelt=0.01
//
     }
endsection mos_lvt25
//
//
//  *************************************************************
//                                                              *
//              1.2V HIGH Vt DEVICES MODEL                      *
//                                                              *
//  *************************************************************
//
section mos_hvt
//
// **************************************************************
//                                                              *
//              1.2V HIGH Vt NMOS DEVICES MODEL                 *
//                                                              *
// **************************************************************
//  ********************************
//        Mismatch   model         *
//  ********************************
inline subckt nch_hvt_mis ( d g s b )
parameters l=1u w=1u factor=1 multi=1 sa=0.35u sb=0.35u ad=2 * hdifn_hvt / factor *
+ w as=2 * hdifn_hvt / factor * w pd=2 * (2 * hdifn_hvt / factor + w) ps=2 * (2 *
+ hdifn_hvt / factor + w) nrd=hdifn_hvt / factor / w nrs=hdifn_hvt / factor / w temp1=parn1_hvt
+ temp2=parn2_hvt fac1=0.716 * temp1 + 0.699 * temp2 fac2=0.716 * temp1 - 0.699
+ * temp2 lef=l - 2.0e-8 wef=w + 1.5e-8 geo_fac=1 / sqrt(multi * lef * wef * 1e12)
+ vthmis=0.003033 * geo_fac * fac1 dlmis=0.002080 * geo_fac * lef * fac2 dwmis=
+ - 0.002080 * geo_fac * wef * fac2 toxmis=0.002080 * geo_fac * toxn_hvt * fac2
nch_hvt_mis ( d g s b ) nch_hvt w=w l=l ad=ad as=as pd=pd ps=ps nrd=nrd nrs=nrs m=multi sa=sa
+ sb=sb
model nch_hvt bsim3v3  {
     1: type=n
+ lmin=8e-07-(dxl_hvt+dlmis)        lmax=2.1e-05              wmin=9.985e-06-(dxw_hvt+dwmis)
+ wmax=0.0009001            tnom=25                   version=3.24
+ tox= (toxn_hvt+toxmis)              toxm= (toxn_hvt+toxmis)             xj=1.9e-07
+ nch=1.81e+18              lln=1                     lwn=1
+ wln=1                     wwn=-1                    lint=2.5e-09
+ ll=0                      lw=0                      lwl=0
+ wint=1e-08                wl=0                      ww=0
+ wwl=0                     mobmod=1                  binunit=2
+ xl=-2e-08 +(dxl_hvt+dlmis)         xw=1.5e-08+(dxw_hvt+dwmis)        dwg=0
+ dwb=0                     ldif=8e-08                hdif=hdifn_hvt
+ rsh=rshn_hvt              rd=0                      rs=0
+ rsc=0                     rdc=0                     vth0=0.4194089+(dvthn_hvt+vthmis)
+ lvth0=4.579556e-08+dlvthn_hvt                       pvth0=0+dpvthn_hvt
+ k1=0.5080414              lk1=1.953662e-08          k2=-0.01284293+dk2n_hvt
+ lk2=-6.554226e-09+dlk2n_hvt                         k3=0
+ dvt0=0                    dvt1=0                    dvt2=0
+ dvt0w=0                   dvt1w=0                   dvt2w=0
+ nlx=0                     w0=0                      k3b=0
+ vfb=-1.012111             vsat=71084.24             pvsat=0+dpvsatn_hvt
+ lvsat=-0.0008402853+dlvsatn_hvt                     ua=3.206739e-10
+ lua=-6.722274e-18         ub=1.787957e-18           lub=4.033374e-26
+ uc=1.32e-10               rdsw=83.7                 prwb=0
+ prwg=0                    wr=1                      u0=0.0499
+ a0=1.687908               la0=-3.781284e-07         keta=-0.001
+ a1=0                      a2=0.99                   ags=0.480042
+ lags=1.990804e-07         b0=0                      b1=0
+ voff=-0.111               nfactor=0.5025515         lnfactor=1.740483e-07
+ cit=0                     cdsc=0                    cdscb=0
+ cdscd=0                   eta0=-2.214687e-05        leta0=1.218414e-09
+ etab=3.478285e-05         letab=-1.344457e-09       dsub=0
+ pclm=0.4880001            pdiblc1=0                 pdiblc2=0.001
+ pdiblcb=0                 drout=0                   pscbe1=1.458e+08
+ pscbe2=5e-08              pvag=0                    delta=0.01
+ alpha0=0                  alpha1=0.2388             beta0=8.6035
+ kt1=-0.1776848            lkt1=1.680571e-08         kt2=-0.02910761
+ lkt2=7.058397e-09         at=35000                  ute=-1.6
+ ua1=1.808424e-09          lua1=-8.402854e-17        ub1=-2.696663e-18
+ lub1=-3.125862e-25        uc1=-1.251399e-10         luc1=-6.344154e-17
+ kt1l=0                    prt=0                     cj=cjn_hvt
+ mj=0.4774564              pb=0.8578199              cjsw=cjswn_hvt
+ mjsw=0.2551013            pbsw=0.8578199            cjswg=cjswgn_hvt
+ mjswg=0.2551013           pbswg=0.8578199           tcj=0.0007251995
+ tcjsw=0.0003603971        tcjswg=0.0003603971       tpb=0.001168276
+ tpbsw=0.001168276         tpbswg=0.001168276        js=2.50e-6
+ jsw=jswn_hvt              cgdo=cgon_hvt             cgso=cgon_hvt
+ capmod=3                  nqsmod=0                  xpart=1
+ cf=0                      tlev=1                    tlevc=1
+ xti=3                     n=1                       dlc=1.8e-8
+ cgbo=0                    wvth0=0+dwvthn_hvt        cgdl=cgln_hvt
+ cgsl=cgln_hvt             wwc=-4.5e-2               dwc=0
+ noia=5.0e+19              noib=8.0e+4               noic=4.0e-13
+ em=4.1e+7                 ef=1.146                  noimod=2
+ sa0=0.35e-6               sb0=0.35e-6               kvsat=0.4
+ wlod=0.5e-6               tku0=0.03                 ku0=-0.58e-7
+ llodku0=1                 wlodku0=1                 lku0=2.0e-7
+ wku0=0.7e-6               pku0=-0.5e-13             kvth0=5.2e-9
+ stk2=2.5e-9               steta0=-1.1e-10           lkvth0=-1.0e-8
+ wkvth0=2.2e-6             pkvth0=-5e-14             llodvth=1.0
+ wlodvth=1                 lodk2=1                   lodeta0=2
+ minr=1e-3                 imax=0.01                 imelt=0.01

     2: type=n
+ lmin=3.5e-07-(dxl_hvt+dlmis)      lmax=8e-07-(dxl_hvt+dlmis)        wmin=9.985e-06-(dxw_hvt+dwmis)
+ wmax=0.0009001            tnom=25                   version=3.24
+ tox= (toxn_hvt+toxmis)              toxm= (toxn_hvt+toxmis)             xj=1.9e-07
+ nch=1.81e+18              lln=1                     lwn=1
+ wln=1                     wwn=-1                    lint=2.5e-09
+ ll=0                      lw=0                      lwl=0
+ wint=1e-08                wl=0                      ww=0
+ wwl=0                     mobmod=1                  binunit=2
+ xl=-2e-08 +(dxl_hvt+dlmis)         xw=1.5e-08+(dxw_hvt+dwmis)        dwg=0
+ dwb=0                     ldif=8e-08                hdif=hdifn_hvt
+ rsh=rshn_hvt              rd=0                      rs=0
+ rsc=0                     rdc=0                     vth0=0.4632611+(dvthn_hvt+vthmis)
+ lvth0=1.181013e-08+dlvthn_hvt                       pvth0=0+dpvthn_hvt
+ k1=0.4904583              lk1=3.316354e-08          k2=-0.01104444+dk2n_hvt
+ lk2=-7.948056e-09+dlk2n_hvt                         k3=0
+ dvt0=0                    dvt1=0                    dvt2=0
+ dvt0w=0                   dvt1w=0                   dvt2w=0
+ nlx=0                     w0=0                      k3b=0
+ vfb=-1.049257             vsat=70722.22             pvsat=0+dpvsatn_hvt
+ lvsat=-0.0005597223+dlvsatn_hvt                     ua=3.697778e-10
+ lua=-4.477778e-17         ub=1.84e-18               uc=9.733332e-11
+ luc=2.686667e-17          rdsw=83.7                 prwb=0
+ prwg=0                    wr=1                      u0=0.0499
+ a0=1.344445               la0=-1.119445e-07         keta=-0.001
+ a1=0                      a2=0.99                   ags=0.5469177
+ lags=1.472517e-07         b0=0                      b1=0
+ voff=-0.1153333           lvoff=3.358336e-09        nfactor=0.6622239
+ lnfactor=5.030223e-08     cit=0                     cdsc=0
+ cdscb=0                   cdscd=0                   eta0=0.0008494442
+ leta0=5.429307e-10        etab=-0.001801111         letab=7.836113e-11
+ dsub=0                    pclm=0.449                lpclm=3.0225e-08
+ pdiblc1=0                 pdiblc2=0.001             pdiblcb=0
+ drout=0                   pscbe1=1.458e+08          pscbe2=5e-08
+ pvag=0                    delta=0.01                alpha0=0
+ alpha1=0.2388             beta0=8.6035              kt1=-0.1531111
+ lkt1=-2.238885e-09        kt2=-0.0239               lkt2=3.022501e-09
+ at=35000                  ute=-1.6                  ua1=1.858889e-09
+ lua1=-1.231389e-16        ub1=-3.032833e-18         lub1=-5.205424e-26
+ uc1=-1.766666e-10         luc1=-2.350834e-17        kt1l=0
+ prt=0                     cj=cjn_hvt                mj=0.4774564
+ pb=0.8578199              cjsw=cjswn_hvt            mjsw=0.2551013
+ pbsw=0.8578199            cjswg=cjswgn_hvt          mjswg=0.2551013
+ pbswg=0.8578199           tcj=0.0007251995          tcjsw=0.0003603971
+ tcjswg=0.0003603971       tpb=0.001168276           tpbsw=0.001168276
+ tpbswg=0.001168276        js=2.50e-6                jsw=jswn_hvt
+ cgdo=cgon_hvt             cgso=cgon_hvt             capmod=3
+ nqsmod=0                  xpart=1                   cf=0
+ tlev=1                    tlevc=1                   xti=3
+ n=1                       dlc=1.8e-8                cgbo=0
+ wvth0=0+dwvthn_hvt        cgdl=cgln_hvt             cgsl=cgln_hvt
+ wwc=-4.5e-2               dwc=0                     noia=5.0e+19
+ noib=8.0e+4               noic=4.0e-13              em=4.1e+7
+ ef=1.146                  noimod=2                  sa0=0.35e-6
+ sb0=0.35e-6               kvsat=0.4                 wlod=0.5e-6
+ tku0=0.03                 ku0=-0.58e-7              llodku0=1
+ wlodku0=1                 lku0=2.0e-7               wku0=0.7e-6
+ pku0=-0.5e-13             kvth0=5.2e-9              stk2=2.5e-9
+ steta0=-1.1e-10           lkvth0=-1.0e-8            wkvth0=2.2e-6
+ pkvth0=-5e-14             llodvth=1.0               wlodvth=1
+ lodk2=1                   lodeta0=2                 minr=1e-3
+ imax=0.01                 imelt=0.01

     3: type=n
+ lmin=1.3e-07              lmax=3.5e-07-(dxl_hvt+dlmis)      wmin=9.985e-06-(dxw_hvt+dwmis)
+ wmax=0.0009001            tnom=25                   version=3.24
+ tox= (toxn_hvt+toxmis)              toxm= (toxn_hvt+toxmis)             xj=1.9e-07
+ nch=1.81e+18              lln=1                     lwn=1
+ wln=1                     wwn=-1                    lint=2.5e-09
+ ll=0                      lw=0                      lwl=0
+ wint=1e-08                wl=0                      ww=0
+ wwl=0                     mobmod=1                  binunit=2
+ xl=-2e-08 +(dxl_hvt+dlmis)         xw=1.5e-08+(dxw_hvt+dwmis)        dwg=0
+ dwb=0                     ldif=8e-08                hdif=hdifn_hvt
+ rsh=rshn_hvt              rd=0                      rs=0
+ rsc=0                     rdc=0                     vth0=0.4850909+(dvthn_hvt+vthmis)
+ lvth0=4.715451e-09+dlvthn_hvt                       pvth0=0+dpvthn_hvt
+ k1=0.5119601              lk1=2.617544e-08          k2=-0.008844323+dk2n_hvt
+ lk2=-8.663094e-09+dlk2n_hvt                         k3=0
+ dvt0=0                    dvt1=0                    dvt2=0
+ dvt0w=0                   dvt1w=0                   dvt2w=0
+ nlx=0                     w0=0                      k3b=0
+ vfb=-1.184747             vsat=62318.18             pvsat=0+dpvsatn_hvt
+ lvsat=0.002171591+dlvsatn_hvt                       ua=2.463182e-10
+ lua=-4.653409e-18         ub=2.030623e-18           lub=-6.195237e-26
+ uc=1.440757e-10           luc=1.16754e-17           rdsw=83.7
+ prwb=0                    prwg=0                    wr=1
+ u0=0.04982841             lu0=2.326752e-11          a0=1
+ keta=-0.001               a1=0                      a2=0.99
+ ags=1                     b0=0                      b1=0
+ voff=-0.1064461           lvoff=4.699934e-10        nfactor=0.5864773
+ lnfactor=7.491988e-08     cit=0                     cdsc=0
+ cdscb=0                   cdscd=0                   eta0=-0.0002059428
+ leta0=8.859315e-10        etab=0.000344318          letab=-6.189033e-10
+ dsub=0                    pclm=0.2279546            lpclm=1.020648e-07
+ pdiblc1=0                 pdiblc2=0.0004511364      lpdiblc2=1.783807e-10
+ pdiblcb=0                 drout=0                   pscbe1=1.500955e+08
+ lpscbe1=-1.396023         pscbe2=5e-08              pvag=0
+ delta=0.01                alpha0=0                  alpha1=0.2388
+ beta0=8.6035              kt1=-0.1391909            lkt1=-6.762956e-09
+ kt2=-0.01390795           lkt2=-2.249148e-10        at=35000
+ ute=-1.6                  ua1=1.48e-09              ub1=-3.296568e-18
+ lub1=3.365967e-26         uc1=-2.303864e-10         luc1=-6.049431e-18
+ kt1l=0                    prt=0                     cj=cjn_hvt
+ mj=0.4774564              pb=0.8578199              cjsw=cjswn_hvt
+ mjsw=0.2551013            pbsw=0.8578199            cjswg=cjswgn_hvt
+ mjswg=0.2551013           pbswg=0.8578199           tcj=0.0007251995
+ tcjsw=0.0003603971        tcjswg=0.0003603971       tpb=0.001168276
+ tpbsw=0.001168276         tpbswg=0.001168276        js=2.50e-6
+ jsw=jswn_hvt              cgdo=cgon_hvt             cgso=cgon_hvt
+ capmod=3                  nqsmod=0                  xpart=1
+ cf=0                      tlev=1                    tlevc=1
+ xti=3                     n=1                       dlc=1.8e-8
+ cgbo=0                    wvth0=0+dwvthn_hvt        cgdl=cgln_hvt
+ cgsl=cgln_hvt             wwc=-4.5e-2               dwc=0
+ noia=5.0e+19              noib=8.0e+4               noic=4.0e-13
+ em=4.1e+7                 ef=1.146                  noimod=2
+ sa0=0.35e-6               sb0=0.35e-6               kvsat=0.4
+ wlod=0.5e-6               tku0=0.03                 ku0=-0.58e-7
+ llodku0=1                 wlodku0=1                 lku0=2.0e-7
+ wku0=0.7e-6               pku0=-0.5e-13             kvth0=5.2e-9
+ stk2=2.5e-9               steta0=-1.1e-10           lkvth0=-1.0e-8
+ wkvth0=2.2e-6             pkvth0=-5e-14             llodvth=1.0
+ wlodvth=1                 lodk2=1                   lodeta0=2
+ minr=1e-3                 imax=0.01                 imelt=0.01

     4: type=n
+ lmin=8e-07-(dxl_hvt+dlmis)        lmax=2.1e-05              wmin=1.185e-06-(dxw_hvt+dwmis)
+ wmax=9.985e-06-(dxw_hvt+dwmis)     tnom=25                   version=3.24
+ tox= (toxn_hvt+toxmis)              toxm= (toxn_hvt+toxmis)             xj=1.9e-07
+ nch=1.81e+18              lln=1                     lwn=1
+ wln=1                     wwn=-1                    lint=2.5e-09
+ ll=0                      lw=0                      lwl=0
+ wint=1e-08                wl=0                      ww=0
+ wwl=0                     mobmod=1                  binunit=2
+ xl=-2e-08 +(dxl_hvt+dlmis)         xw=1.5e-08+(dxw_hvt+dwmis)        dwg=0
+ dwb=0                     ldif=8e-08                hdif=hdifn_hvt
+ rsh=rshn_hvt              rd=0                      rs=0
+ rsc=0                     rdc=0                     vth0=0.4196926+(dvthn_hvt+vthmis)
+ lvth0=4.697865e-08+dlvthn_hvt                       wvth0=-2.830991e-09+dwvthn_hvt
+ pvth0=-1.180719e-14+dpvthn_hvt                      k1=0.5080408
+ lk1=1.954225e-08          pk1=-5.616695e-17         k2=-0.01284293+dk2n_hvt
+ lk2=-6.554226e-09+dlk2n_hvt                         k3=0
+ dvt0=0                    dvt1=0                    dvt2=0
+ dvt0w=0                   dvt1w=0                   dvt2w=0
+ nlx=0                     w0=0                      k3b=0
+ vfb=-1.012111             vsat=70559.58             lvsat=-0.0009570163+dlvsatn_hvt
+ wvsat=0.00523612          pvsat=1.164974e-09+dpvsatn_hvt
+ ua=2.777304e-10           lua=8.601493e-18          wua=4.285761e-16
+ pua=-1.529311e-22         ub=1.793262e-18           lub=3.10178e-26
+ wub=-5.294684e-26         pub=9.297308e-32          uc=1.253382e-10
+ luc=-7.60553e-19          wuc=6.648499e-17          puc=7.59033e-24
+ rdsw=83.7                 prwb=0                    prwg=0
+ wr=1                      u0=0.0499                 a0=1.731577
+ la0=-4.365388e-07         wa0=-4.358198e-07         pa0=5.82937e-13
+ keta=-0.001               a1=0                      a2=0.99
+ ags=0.4709562             lags=1.943172e-07         wags=9.067678e-08
+ pags=4.75368e-14          b0=0                      b1=0
+ voff=-0.1074912           lvoff=6.32106e-10         wvoff=-3.501795e-08
+ pvoff=-6.30841e-15        nfactor=0.5025512         lnfactor=1.740517e-07
+ pnfactor=-3.371357e-17    cit=0                     cdsc=0
+ cdscb=0                   cdscd=0                   eta0=-5.016758e-05
+ leta0=1.297286e-09        weta0=2.79646e-10         peta0=-7.871451e-16
+ etab=8.2784e-05           letab=-1.455441e-09       wetab=-4.790526e-10
+ petab=1.107625e-15        dsub=0                    pclm=0.4880001
+ pdiblc1=0                 pdiblc2=0.001             pdiblcb=0
+ drout=0                   pscbe1=1.458e+08          pscbe2=5e-08
+ pvag=0                    delta=0.01                alpha0=0
+ alpha1=0.2388             beta0=8.6035              kt1=-0.1797587
+ lkt1=2.090706e-08         wkt1=2.069743e-08         pkt1=-4.093155e-14
+ kt2=-0.02937345           lkt2=7.784022e-09         wkt2=2.653036e-09
+ pkt2=-7.241734e-15        at=35000                  ute=-1.6
+ ua1=1.777204e-09          lua1=-1.471263e-16        wua1=3.115741e-16
+ pua1=6.29716e-22          ub1=-2.634751e-18         lub1=-2.252633e-25
+ wub1=-6.178793e-25        pub1=-8.714819e-31        uc1=-1.438549e-10
+ luc1=-3.927284e-17        wuc1=1.867754e-16         puc1=-2.412037e-22
+ kt1l=0                    prt=0                     cj=cjn_hvt
+ mj=0.4774564              pb=0.8578199              cjsw=cjswn_hvt
+ mjsw=0.2551013            pbsw=0.8578199            cjswg=cjswgn_hvt
+ mjswg=0.2551013           pbswg=0.8578199           tcj=0.0007251995
+ tcjsw=0.0003603971        tcjswg=0.0003603971       tpb=0.001168276
+ tpbsw=0.001168276         tpbswg=0.001168276        js=2.50e-6
+ jsw=jswn_hvt              cgdo=cgon_hvt             cgso=cgon_hvt
+ capmod=3                  nqsmod=0                  xpart=1
+ cf=0                      tlev=1                    tlevc=1
+ xti=3                     n=1                       dlc=1.8e-8
+ cgbo=0                    cgdl=cgln_hvt             cgsl=cgln_hvt
+ wwc=-4.5e-2               dwc=0                     noia=5.0e+19
+ noib=8.0e+4               noic=4.0e-13              em=4.1e+7
+ ef=1.146                  noimod=2                  sa0=0.35e-6
+ sb0=0.35e-6               kvsat=0.4                 wlod=0.5e-6
+ tku0=0.03                 ku0=-0.58e-7              llodku0=1
+ wlodku0=1                 lku0=2.0e-7               wku0=0.7e-6
+ pku0=-0.5e-13             kvth0=5.2e-9              stk2=2.5e-9
+ steta0=-1.1e-10           lkvth0=-1.0e-8            wkvth0=2.2e-6
+ pkvth0=-5e-14             llodvth=1.0               wlodvth=1
+ lodk2=1                   lodeta0=2                 minr=1e-3
+ imax=0.01                 imelt=0.01

     5: type=n
+ lmin=3.5e-07-(dxl_hvt+dlmis)      lmax=8e-07-(dxl_hvt+dlmis)        wmin=1.185e-06-(dxw_hvt+dwmis)
+ wmax=9.985e-06-(dxw_hvt+dwmis)     tnom=25                   version=3.24
+ tox= (toxn_hvt+toxmis)              toxm= (toxn_hvt+toxmis)             xj=1.9e-07
+ nch=1.81e+18              lln=1                     lwn=1
+ wln=1                     wwn=-1                    lint=2.5e-09
+ ll=0                      lw=0                      lwl=0
+ wint=1e-08                wl=0                      ww=0
+ wwl=0                     mobmod=1                  binunit=2
+ xl=-2e-08 +(dxl_hvt+dlmis)         xw=1.5e-08+(dxw_hvt+dwmis)        dwg=0
+ dwb=0                     ldif=8e-08                hdif=hdifn_hvt
+ rsh=rshn_hvt              rd=0                      rs=0
+ rsc=0                     rdc=0                     vth0=0.4655943+(dvthn_hvt+vthmis)
+ lvth0=1.140484e-08+dlvthn_hvt                       wvth0=-2.328516e-08+dwvthn_hvt
+ pvth0=4.044794e-15+dpvthn_hvt                       k1=0.4996458
+ lk1=2.604846e-08          wk1=-9.169081e-08         pk1=7.100858e-14
+ k2=-0.01396853+dk2n_hvt   lk2=-5.681887e-09+dlk2n_hvt
+ wk2=2.918243e-08          pk2=-2.261638e-14         k3=0
+ dvt0=0                    dvt1=0                    dvt2=0
+ dvt0w=0                   dvt1w=0                   dvt2w=0
+ nlx=0                     w0=0                      k3b=0
+ vfb=-1.049257             vsat=71053.34             lvsat=-0.00133968+dlvsatn_hvt
+ wvsat=-0.00330453         pvsat=7.783979e-09+dpvsatn_hvt
+ ua=3.810057e-10           lua=-7.143684e-17         wua=-1.120543e-16
+ pua=2.660575e-22          ub=1.771491e-18           lub=4.789024e-26
+ wub=6.837212e-25          pub=-4.779446e-31         uc=9.143331e-11
+ luc=2.551571e-17          wuc=5.888202e-17          puc=1.348263e-23
+ rdsw=83.7                 prwb=0                    prwg=0
+ wr=1                      u0=0.04952231             lu0=2.927093e-10
+ wu0=3.769341e-09          pu0=-2.921239e-15         a0=1.289852
+ la0=-9.420179e-08         wa0=5.44837e-07           pa0=-1.77072e-13
+ keta=-0.001               a1=0                      a2=0.99
+ ags=0.520685              lags=1.557774e-07         wags=2.618029e-07
+ pags=-8.508595e-14        b0=0                      b1=0
+ voff=-0.1119895           lvoff=4.118255e-09        wvoff=-3.337204e-08
+ pvoff=-7.583989e-15       nfactor=0.6756814         lnfactor=3.987578e-08
+ wnfactor=-1.34306e-07     pnfactor=1.04056e-13      cit=0
+ cdsc=0                    cdscb=0                   cdscd=0
+ eta0=0.0008360352         leta0=6.10479e-10         weta0=1.338228e-10
+ peta0=-6.741321e-16       etab=-0.001957327         letab=1.256449e-10
+ wetab=1.559035e-09        petab=-4.718925e-16       dsub=0
+ pclm=0.449                lpclm=3.0225e-08          pdiblc1=0
+ pdiblc2=0.001             pdiblcb=0                 drout=0
+ pscbe1=1.458e+08          pscbe2=5e-08              pvag=0
+ delta=0.01                alpha0=0                  alpha1=0.2388
+ beta0=8.6035              kt1=-0.1456318            lkt1=-5.541247e-09
+ wkt1=-7.464336e-08        pkt1=3.295757e-14         kt2=-0.02229985
+ lkt2=2.301985e-09         wkt2=-1.596952e-08        pkt2=7.190742e-15
+ at=35000                  ute=-1.6                  ua1=1.682336e-09
+ lua1=-7.36035e-17         wua1=1.761999e-15         pua1=-4.943635e-22
+ ub1=-2.783193e-18         lub1=-1.102209e-25        wub1=-2.491408e-24
+ pub1=5.805028e-31         uc1=-1.7175e-10           luc1=-1.765416e-17
+ wuc1=-4.906832e-17        puc1=-5.842478e-23        kt1l=0
+ prt=0                     cj=cjn_hvt                mj=0.4774564
+ pb=0.8578199              cjsw=cjswn_hvt            mjsw=0.2551013
+ pbsw=0.8578199            cjswg=cjswgn_hvt          mjswg=0.2551013
+ pbswg=0.8578199           tcj=0.0007251995          tcjsw=0.0003603971
+ tcjswg=0.0003603971       tpb=0.001168276           tpbsw=0.001168276
+ tpbswg=0.001168276        js=2.50e-6                jsw=jswn_hvt
+ cgdo=cgon_hvt             cgso=cgon_hvt             capmod=3
+ nqsmod=0                  xpart=1                   cf=0
+ tlev=1                    tlevc=1                   xti=3
+ n=1                       dlc=1.8e-8                cgbo=0
+ cgdl=cgln_hvt             cgsl=cgln_hvt             wwc=-4.5e-2
+ dwc=0                     noia=5.0e+19              noib=8.0e+4
+ noic=4.0e-13              em=4.1e+7                 ef=1.146
+ noimod=2                  sa0=0.35e-6               sb0=0.35e-6
+ kvsat=0.4                 wlod=0.5e-6               tku0=0.03
+ ku0=-0.58e-7              llodku0=1                 wlodku0=1
+ lku0=2.0e-7               wku0=0.7e-6               pku0=-0.5e-13
+ kvth0=5.2e-9              stk2=2.5e-9               steta0=-1.1e-10
+ lkvth0=-1.0e-8            wkvth0=2.2e-6             pkvth0=-5e-14
+ llodvth=1.0               wlodvth=1                 lodk2=1
+ lodeta0=2                 minr=1e-3                 imax=0.01
+ imelt=0.01

     6: type=n
+ lmin=1.3e-07              lmax=3.5e-07-(dxl_hvt+dlmis)      wmin=1.185e-06-(dxw_hvt+dwmis)
+ wmax=9.985e-06-(dxw_hvt+dwmis)     tnom=25                   version=3.24
+ tox= (toxn_hvt+toxmis)              toxm= (toxn_hvt+toxmis)             xj=1.9e-07
+ nch=1.81e+18              lln=1                     lwn=1
+ wln=1                     wwn=-1                    lint=2.5e-09
+ ll=0                      lw=0                      lwl=0
+ wint=1e-08                wl=0                      ww=0
+ wwl=0                     mobmod=1                  binunit=2
+ xl=-2e-08 +(dxl_hvt+dlmis)         xw=1.5e-08+(dxw_hvt+dwmis)        dwg=0
+ dwb=0                     ldif=8e-08                hdif=hdifn_hvt
+ rsh=rshn_hvt              rd=0                      rs=0
+ rsc=0                     rdc=0                     vth0=0.4871306+(dvthn_hvt+vthmis)
+ lvth0=4.405539e-09+dlvthn_hvt                       wvth0=-2.03563e-08+dwvthn_hvt
+ pvth0=3.092914e-15+dpvthn_hvt                       k1=0.4959911
+ lk1=2.723621e-08          wk1=1.593709e-07          pk1=-1.058647e-14
+ k2=-0.004696771+dk2n_hvt  lk2=-8.695208e-09+dlk2n_hvt
+ wk2=-4.139257e-08         pk2=3.204968e-16          k3=0
+ dvt0=0                    dvt1=0                    dvt2=0
+ dvt0w=0                   dvt1w=0                   dvt2w=0
+ nlx=0                     w0=0                      k3b=0
+ vfb=-1.184747             vsat=59262.07             lvsat=0.002492483+dlvsatn_hvt
+ wvsat=0.03050003          pvsat=-3.202503e-09+dpvsatn_hvt
+ ua=1.51327e-10            lua=3.208733e-18          wua=9.480123e-16
+ pua=-7.846421e-23         ub=2.142709e-18           lub=-7.275554e-26
+ wub=-1.118618e-24         pub=1.078156e-31          uc=1.251699e-10
+ luc=1.455133e-17          wuc=1.8868e-16            puc=-2.870171e-23
+ rdsw=83.7                 prwb=0                    prwg=0
+ wr=1                      u0=0.05060095             lu0=-5.784986e-11
+ wu0=-7.710014e-09         pu0=8.095516e-16          a0=1
+ keta=-0.001               a1=0                      a2=0.99
+ ags=1                     b0=0                      b1=0
+ voff=-0.1027899           lvoff=1.128396e-09        wvoff=-3.648937e-08
+ pvoff=-6.570858e-15       nfactor=0.5275993         lnfactor=8.800245e-08
+ wnfactor=5.87602e-07      pnfactor=-1.30564e-13     cit=0
+ cdsc=0                    cdscb=0                   cdscd=0
+ eta0=0.0002239055         leta0=8.094211e-10        weta0=-4.289885e-09
+ peta0=7.635731e-16        etab=0.0003995083         letab=-6.403265e-10
+ wetab=-5.508022e-10       petab=2.138045e-16        dsub=0
+ pclm=0.2328517            lpclm=1.004732e-07        wpclm=-4.887326e-08
+ ppclm=1.588381e-14        pdiblc1=0                 pdiblc2=0.0004511364
+ lpdiblc2=1.783807e-10     pdiblcb=0                 drout=0
+ pscbe1=1.509709e+08       lpscbe1=-1.680557         wpscbe1=-8.737407
+ ppscbe1=2.839658e-06      pscbe2=5e-08              pvag=0
+ delta=0.01                alpha0=0                  alpha1=0.2388
+ beta0=8.6035              kt1=-0.1397224            lkt1=-7.461813e-09
+ wkt1=5.304243e-09         pkt1=6.974598e-15         kt2=-0.01436798
+ lkt2=-2.758731e-10        wkt2=4.591032e-09         pkt2=5.085645e-16
+ at=35000                  ute=-1.6                  ua1=1.420025e-09
+ lua1=1.164762e-17         wua1=5.985526e-16         pua1=-1.162433e-22
+ ub1=-3.237806e-18         lub1=3.752835e-26         wub1=-5.864474e-25
+ pub1=-3.860943e-32        uc1=-2.068809e-10         luc1=-6.236624e-18
+ wuc1=-2.345852e-16        puc1=1.868195e-24         kt1l=0
+ prt=0                     cj=cjn_hvt                mj=0.4774564
+ pb=0.8578199              cjsw=cjswn_hvt            mjsw=0.2551013
+ pbsw=0.8578199            cjswg=cjswgn_hvt          mjswg=0.2551013
+ pbswg=0.8578199           tcj=0.0007251995          tcjsw=0.0003603971
+ tcjswg=0.0003603971       tpb=0.001168276           tpbsw=0.001168276
+ tpbswg=0.001168276        js=2.50e-6                jsw=jswn_hvt
+ cgdo=cgon_hvt             cgso=cgon_hvt             capmod=3
+ nqsmod=0                  xpart=1                   cf=0
+ tlev=1                    tlevc=1                   xti=3
+ n=1                       dlc=1.8e-8                cgbo=0
+ cgdl=cgln_hvt             cgsl=cgln_hvt             wwc=-4.5e-2
+ dwc=0                     noia=5.0e+19              noib=8.0e+4
+ noic=4.0e-13              em=4.1e+7                 ef=1.146
+ noimod=2                  sa0=0.35e-6               sb0=0.35e-6
+ kvsat=0.4                 wlod=0.5e-6               tku0=0.03
+ ku0=-0.58e-7              llodku0=1                 wlodku0=1
+ lku0=2.0e-7               wku0=0.7e-6               pku0=-0.5e-13
+ kvth0=5.2e-9              stk2=2.5e-9               steta0=-1.1e-10
+ lkvth0=-1.0e-8            wkvth0=2.2e-6             pkvth0=-5e-14
+ llodvth=1.0               wlodvth=1                 lodk2=1
+ lodeta0=2                 minr=1e-3                 imax=0.01
+ imelt=0.01

     7: type=n
+ lmin=8e-07-(dxl_hvt+dlmis)        lmax=2.1e-05              wmin=5.85e-07-(dxw_hvt+dwmis)
+ wmax=1.185e-06-(dxw_hvt+dwmis)     tnom=25                   version=3.24
+ tox= (toxn_hvt+toxmis)              toxm= (toxn_hvt+toxmis)             xj=1.9e-07
+ nch=1.81e+18              lln=1                     lwn=1
+ wln=1                     wwn=-1                    lint=2.5e-09
+ ll=0                      lw=0                      lwl=0
+ wint=1e-08                wl=0                      ww=0
+ wwl=0                     mobmod=1                  binunit=2
+ xl=-2e-08 +(dxl_hvt+dlmis)         xw=1.5e-08+(dxw_hvt+dwmis)        dwg=0
+ dwb=0                     ldif=8e-08                hdif=hdifn_hvt
+ rsh=rshn_hvt              rd=0                      rs=0
+ rsc=0                     rdc=0                     vth0=0.4547555+(dvthn_hvt+vthmis)
+ lvth0=3.3561020e-08+dlvthn_hvt                      wvth0=-4.4205170e-08+dwvthn_hvt
+ pvth0=4.0256190e-15+dpvthn_hvt                      k1=0.5080456
+ lk1=1.949465e-08          k2=-0.01284293+dk2n_hvt   lk2=-6.554225e-09+dlk2n_hvt
+ k3=0                      dvt0=0                    dvt1=0
+ dvt2=0                    dvt0w=0                   dvt1w=0
+ dvt2w=0                   nlx=0                     w0=0
+ k3b=0                     vfb=-1.025562             vsat=7.1730010e+04
+ lvsat=4.4620270e-03+dlvsatn_hvt                     wvsat=3.8550080e-03
+ pvsat=-5.2294970e-09+dpvsatn_hvt                    ua=5.995803e-10
+ lua=-2.022287e-16         wua=4.879323e-17          pua=9.584857e-23
+ ub=1.774497e-18           lub=7.114451e-25          wub=-3.080448e-26
+ pub=-7.099311e-31         uc=1.51402e-10            luc=8.834131e-17
+ wuc=3.572962e-17          puc=-9.754987e-23         rdsw=83.7
+ prwb=0                    prwg=0                    wr=1
+ u0=5.4369150e-02          lu0=3.0541589e-09         wu0=-5.2735990e-09
+ pu0=-3.6039070e-15        a0=1.342988               la0=2.494976e-07
+ wa0=2.27154e-08           pa0=-2.26586e-13          keta=-0.001
+ a1=0                      a2=0.99                   ags=0.5159972
+ lags=2.761173e-07         wags=3.752843e-08         pags=-4.898727e-14
+ b0=0                      b1=0                      voff=-0.1318636
+ lvoff=-4.531733e-09       wvoff=-6.258501e-09       pvoff=-2.150806e-16
+ nfactor=0.5052331         lnfactor=1.472993e-07     wnfactor=-3.161303e-09
+ pnfactor=3.153414e-14     cit=0                     cdsc=0
+ cdscb=0                   cdscd=0                   eta0=0.0003123101
+ leta0=-8.86711e-10        weta0=-1.480774e-10       peta0=1.789972e-15
+ etab=-0.0005715185        letab=-6.914148e-10       wetab=2.930242e-10
+ petab=2.060744e-16        dsub=0                    pclm=0.507055
+ lpclm=-1.900727e-07       wpclm=-2.24848e-08        ppclm=2.242857e-13
+ pdiblc1=0                 pdiblc2=0.001             pdiblcb=0
+ drout=0                   pscbe1=1.458e+08          pscbe2=5e-08
+ pvag=0                    delta=0.01                alpha0=0
+ alpha1=0.2388             beta0=8.6035              kt1=-0.1220482
+ lkt1=-6.349197e-08        wkt1=-4.740091e-08        pkt1=5.865932e-14
+ kt2=-0.03401272           lkt2=3.23902e-09          wkt2=8.127375e-09
+ pkt2=-1.878632e-15        at=35000                  ute=-1.6
+ ua1=2.046924e-09          lua1=1.101334e-15         wua1=-6.695142e-18
+ pua1=-8.434673e-22        ub1=-3.214809e-18         lub1=-1.895488e-24
+ wub1=6.658947e-26         pub1=1.099383e-30         uc1=3.305924e-10
+ luc1=-6.010841e-16        wuc1=-3.730724e-16        puc1=4.217336e-22
+ kt1l=0                    prt=0                     cj=cjn_hvt
+ mj=0.4774564              pb=0.8578199              cjsw=cjswn_hvt
+ mjsw=0.2551013            pbsw=0.8578199            cjswg=cjswgn_hvt
+ mjswg=0.2551013           pbswg=0.8578199           tcj=0.0007251995
+ tcjsw=0.0003603971        tcjswg=0.0003603971       tpb=0.001168276
+ tpbsw=0.001168276         tpbswg=0.001168276        js=2.50e-6
+ jsw=jswn_hvt              cgdo=cgon_hvt             cgso=cgon_hvt
+ capmod=3                  nqsmod=0                  xpart=1
+ cf=0                      tlev=1                    tlevc=1
+ xti=3                     n=1                       dlc=1.8e-8
+ cgbo=0                    cgdl=cgln_hvt             cgsl=cgln_hvt
+ wwc=-4.5e-2               dwc=0                     noia=5.0e+19
+ noib=8.0e+4               noic=4.0e-13              em=4.1e+7
+ ef=1.146                  noimod=2                  sa0=0.35e-6
+ sb0=0.35e-6               kvsat=0.4                 wlod=0.5e-6
+ tku0=0.03                 ku0=-0.58e-7              llodku0=1
+ wlodku0=1                 lku0=2.0e-7               wku0=0.7e-6
+ pku0=-0.5e-13             kvth0=5.2e-9              stk2=2.5e-9
+ steta0=-1.1e-10           lkvth0=-1.0e-8            wkvth0=2.2e-6
+ pkvth0=-5e-14             llodvth=1.0               wlodvth=1
+ lodk2=1                   lodeta0=2                 minr=1e-3
+ imax=0.01                 imelt=0.01

     8: type=n
+ lmin=3.5e-07-(dxl_hvt+dlmis)      lmax=8e-07-(dxl_hvt+dlmis)        wmin=5.85e-07-(dxw_hvt+dwmis)
+ wmax=1.185e-06-(dxw_hvt+dwmis)     tnom=25                   version=3.24
+ tox= (toxn_hvt+toxmis)              toxm= (toxn_hvt+toxmis)             xj=1.9e-07
+ nch=1.81e+18              lln=1                     lwn=1
+ wln=1                     wwn=-1                    lint=2.5e-09
+ ll=0                      lw=0                      lwl=0
+ wint=1e-08                wl=0                      ww=0
+ wwl=0                     mobmod=1                  binunit=2
+ xl=-2e-08 +(dxl_hvt+dlmis)         xw=1.5e-08+(dxw_hvt+dwmis)        dwg=0
+ dwb=0                     ldif=8e-08                hdif=hdifn_hvt
+ rsh=rshn_hvt              rd=0                      rs=0
+ rsc=0                     rdc=0                     vth0=0.4886952+(dvthn_hvt+vthmis)
+ lvth0=7.2577100e-09+dlvthn_hvt                      wvth0=-5.0544250e-08+dwvthn_hvt
+ pvth0=8.9384100e-15+dpvthn_hvt                      k1=0.355792
+ lk1=1.374912e-07          wk1=7.805652e-08          pk1=-6.049379e-14
+ k2=0.02688538+dk2n_hvt    lk2=-3.734366e-08+dlk2n_hvt
+ wk2=-1.902518e-08         pk2=1.474452e-14          k3=0
+ dvt0=0                    dvt1=0                    dvt2=0
+ dvt0w=0                   dvt1w=0                   dvt2w=0
+ nlx=0                     w0=0                      k3b=0
+ vfb=-1.150501             vsat=6.7079570e+04        lvsat=8.0661210e-03+dlvsatn_hvt
+ wvsat=1.3845166e-03       pvsat=-3.3148660e-09+dpvsatn_hvt
+ ua=-2.526985e-10          lua=4.582872e-16          wua=6.357165e-16
+ pua=-3.590169e-22         ub=4.024672e-18           lub=-1.03244e-24
+ wub=-1.975032e-24         pub=7.968449e-31          uc=2.572987e-10
+ luc=6.271398e-18          wuc=-1.368392e-16         puc=3.619092e-23
+ rdsw=83.7                 prwb=0                    prwg=0
+ wr=1                      u0=6.8247790e-02          lu0=-7.7017780e-09
+ wu0=-1.8326716e-08        pu0=6.5122570e-15         a0=2.14514
+ la0=-3.721706e-07         wa0=-4.644036e-07         pa0=1.509312e-13
+ keta=-0.00123737          lketa=1.83962e-10         wketa=2.80097e-10
+ pketa=-2.170752e-16       a1=0                      a2=0.99
+ ags=0.7800335             lags=7.148913e-08         wags=-4.422832e-08
+ pags=1.43742e-14          b0=0                      b1=0
+ voff=-0.140331            lvoff=2.030486e-09        wvoff=7.097068e-11
+ pvoff=-5.120421e-15       nfactor=0.3440476         lnfactor=2.72218e-07
+ wnfactor=2.570219e-07     pnfactor=-1.701078e-13    cit=0
+ cdsc=0                    cdscb=0                   cdscd=0
+ eta0=-0.001556102         leta0=5.613081e-10        weta0=2.956545e-09
+ peta0=-6.161105e-16       etab=-0.001849815         letab=2.992648e-10
+ wetab=1.43217e-09         petab=-6.767639e-16       dsub=0
+ pclm=0.03011088           lpclm=1.79559e-07         wpclm=4.942892e-07
+ ppclm=-1.762141e-13       pdiblc1=0                 pdiblc2=0.001
+ pdiblcb=0                 drout=0                   pscbe1=1.458e+08
+ pscbe2=5e-08              pvag=0                    delta=0.01
+ alpha0=0                  alpha1=0.2388             beta0=8.6035
+ kt1=-0.2292319            lkt1=1.957536e-08         wkt1=2.40047e-08
+ pkt1=3.319973e-15         kt2=-0.0511389            lkt2=1.651181e-08
+ wkt2=1.806056e-08         pkt2=-9.576849e-15        at=35000
+ ute=-1.6                  ua1=4.536408e-09          lua1=-8.280158e-16
+ wua1=-1.605805e-15        pua1=3.958431e-22         ub1=-6.629293e-18
+ lub1=7.50737e-25          wub1=2.04699e-24          pub1=-4.354275e-31
+ uc1=-3.792778e-10         luc1=-5.093474e-17        wuc1=1.958145e-16
+ puc1=-1.91537e-23         kt1l=0                    prt=0
+ cj=cjn_hvt                mj=0.4774564              pb=0.8578199
+ cjsw=cjswn_hvt            mjsw=0.2551013            pbsw=0.8578199
+ cjswg=cjswgn_hvt          mjswg=0.2551013           pbswg=0.8578199
+ tcj=0.0007251995          tcjsw=0.0003603971        tcjswg=0.0003603971
+ tpb=0.001168276           tpbsw=0.001168276         tpbswg=0.001168276
+ js=2.50e-6                jsw=jswn_hvt              cgdo=cgon_hvt
+ cgso=cgon_hvt             capmod=3                  nqsmod=0
+ xpart=1                   cf=0                      tlev=1
+ tlevc=1                   xti=3                     n=1
+ dlc=1.8e-8                cgbo=0                    cgdl=cgln_hvt
+ cgsl=cgln_hvt             wwc=-4.5e-2               dwc=0
+ noia=5.0e+19              noib=8.0e+4               noic=4.0e-13
+ em=4.1e+7                 ef=1.146                  noimod=2
+ sa0=0.35e-6               sb0=0.35e-6               kvsat=0.4
+ wlod=0.5e-6               tku0=0.03                 ku0=-0.58e-7
+ llodku0=1                 wlodku0=1                 lku0=2.0e-7
+ wku0=0.7e-6               pku0=-0.5e-13             kvth0=5.2e-9
+ stk2=2.5e-9               steta0=-1.1e-10           lkvth0=-1.0e-8
+ wkvth0=2.2e-6             pkvth0=-5e-14             llodvth=1.0
+ wlodvth=1                 lodk2=1                   lodeta0=2
+ minr=1e-3                 imax=0.01                 imelt=0.01

     9: type=n
+ lmin=1.3e-07              lmax=3.5e-07-(dxl_hvt+dlmis)      wmin=5.85e-07-(dxw_hvt+dwmis)
+ wmax=1.185e-06-(dxw_hvt+dwmis)     tnom=25                   version=3.24
+ tox= (toxn_hvt+toxmis)              toxm= (toxn_hvt+toxmis)             xj=1.9e-07
+ nch=1.81e+18              lln=1                     lwn=1
+ wln=1                     wwn=-1                    lint=2.5e-09
+ ll=0                      lw=0                      lwl=0
+ wint=1e-08                wl=0                      ww=0
+ wwl=0                     mobmod=1                  binunit=2
+ xl=-2e-08 +(dxl_hvt+dlmis)         xw=1.5e-08+(dxw_hvt+dwmis)        dwg=0
+ dwb=0                     ldif=8e-08                hdif=hdifn_hvt
+ rsh=rshn_hvt              rd=0                      rs=0
+ rsc=0                     rdc=0                     vth0=0.4831316+(dvthn_hvt+vthmis)
+ lvth0=9.0658830e-09+dlvthn_hvt                      wvth0=-1.5637474e-08+dwvthn_hvt
+ pvth0=-2.4062921e-15+dpvthn_hvt                     k1=0.734523
+ lk1=1.440358e-08          wk1=-1.220968e-07         pk1=4.556031e-15
+ k2=-0.06168143+dk2n_hvt   lk2=-8.559448e-09+dlk2n_hvt
+ wk2=2.584932e-08          pk2=1.603009e-16          k3=0
+ dvt0=0                    dvt1=0                    dvt2=0
+ dvt0w=0                   dvt1w=0                   dvt2w=0
+ nlx=0                     w0=0                      k3b=0
+ vfb=-1.220956             vsat=9.3792410e+04        lvsat=-6.1555290e-04+dlvsatn_hvt
+ wvsat=-1.0245780e-02      pvsat=4.6497980e-10+dpvsatn_hvt
+ ua=1.519674e-09           lua=-1.177337e-16         wua=-6.666368e-16
+ pua=6.42479e-23           ub=5.978106e-19           lub=8.128989e-26
+ wub=7.043617e-25          pub=-7.395798e-32         uc=3.072817e-10
+ luc=-9.973081e-18         wuc=-2.621199e-17         puc=2.370897e-25
+ rdsw=83.7                 prwb=0                    prwg=0
+ wr=1                      u0=4.0831570e-02          lu0=1.2084909e-09
+ wu0=3.8178640e-09         pu0=-6.8473080e-16        a0=1
+ keta=-0.0005144699        lketa=-5.098066e-11       wketa=-5.729256e-10
+ pketa=6.015719e-17        a1=0                      a2=0.99
+ ags=1                     b0=0                      b1=0
+ voff=-0.1175379           lvoff=-5.377271e-09       wvoff=-1.908672e-08
+ pvoff=1.10583e-15         nfactor=1.261301          lnfactor=-2.588921e-08
+ wnfactor=-2.781656e-07    pnfactor=3.828123e-15     cit=0
+ cdsc=0                    cdscb=0                   cdscd=0
+ eta0=-0.005551659         leta0=1.859864e-09        weta0=2.525281e-09
+ peta0=-4.759496e-16       etab=0.00130034           letab=-7.245357e-10
+ wetab=-1.613784e-09       petab=3.131713e-16        dsub=0
+ pclm=0.3692801            lpclm=6.932898e-08        wpclm=-2.098588e-07
+ ppclm=5.2634e-14          pdiblc1=0                 pdiblc2=0.0004511365
+ lpdiblc2=1.783807e-10     pdiblcb=0                 drout=0
+ pscbe1=1.277554e+08       lpscbe1=5.864484          wpscbe1=18.6569
+ ppscbe1=-6.063492e-06     pscbe2=5e-08              pvag=0
+ delta=0.01                alpha0=0                  alpha1=0.2388
+ beta0=8.6035              kt1=-0.1843427            lkt1=4.986384e-09
+ wkt1=5.795624e-08         pkt1=-7.714275e-15        kt2=-0.00127197
+ lkt2=3.050569e-10         wkt2=-1.086226e-08        pkt2=-1.76933e-16
+ at=35000                  ute=-1.6                  ua1=2.643485e-09
+ lua1=-2.128159e-16        wua1=-8.451304e-16        pua1=1.486237e-22
+ ub1=-4.620174e-18         lub1=9.777326e-26         wub1=1.044747e-24
+ pub1=-1.096984e-31        uc1=-5.078409e-10         luc1=-9.151705e-18
+ wuc1=1.205478e-16         puc1=5.307989e-24         kt1l=0
+ prt=0                     cj=cjn_hvt                mj=0.4774564
+ pb=0.8578199              cjsw=cjswn_hvt            mjsw=0.2551013
+ pbsw=0.8578199            cjswg=cjswgn_hvt          mjswg=0.2551013
+ pbswg=0.8578199           tcj=0.0007251995          tcjsw=0.0003603971
+ tcjswg=0.0003603971       tpb=0.001168276           tpbsw=0.001168276
+ tpbswg=0.001168276        js=2.50e-6                jsw=jswn_hvt
+ cgdo=cgon_hvt             cgso=cgon_hvt             capmod=3
+ nqsmod=0                  xpart=1                   cf=0
+ tlev=1                    tlevc=1                   xti=3
+ n=1                       dlc=1.8e-8                cgbo=0
+ cgdl=cgln_hvt             cgsl=cgln_hvt             wwc=-4.5e-2
+ dwc=0                     noia=5.0e+19              noib=8.0e+4
+ noic=4.0e-13              em=4.1e+7                 ef=1.146
+ noimod=2                  sa0=0.35e-6               sb0=0.35e-6
+ kvsat=0.4                 wlod=0.5e-6               tku0=0.03
+ ku0=-0.58e-7              llodku0=1                 wlodku0=1
+ lku0=2.0e-7               wku0=0.7e-6               pku0=-0.5e-13
+ kvth0=5.2e-9              stk2=2.5e-9               steta0=-1.1e-10
+ lkvth0=-1.0e-8            wkvth0=2.2e-6             pkvth0=-5e-14
+ llodvth=1.0               wlodvth=1                 lodk2=1
+ lodeta0=2                 minr=1e-3                 imax=0.01
+ imelt=0.01

     10: type=n
+ lmin=8e-07-(dxl_hvt+dlmis)        lmax=2.1e-05              wmin=1.5e-07
+ wmax=5.85e-07-(dxw_hvt+dwmis)      tnom=25                   version=3.24
+ tox= (toxn_hvt+toxmis)              toxm= (toxn_hvt+toxmis)             xj=1.9e-07
+ nch=1.81e+18              lln=1                     lwn=1
+ wln=1                     wwn=-1                    lint=2.5e-09
+ ll=0                      lw=0                      lwl=0
+ wint=1e-08                wl=0                      ww=0
+ wwl=0                     mobmod=1                  binunit=2
+ xl=-2e-08 +(dxl_hvt+dlmis)         xw=1.5e-08+(dxw_hvt+dwmis)        dwg=0
+ dwb=0                     ldif=8e-08                hdif=hdifn_hvt
+ rsh=rshn_hvt              rd=0                      rs=0
+ rsc=0                     rdc=0                     vth0=0.4009124+(dvthn_hvt+vthmis)
+ lvth0=4.2103880e-08+dlvthn_hvt                      wvth0=-1.2976179e-08+dwvthn_hvt
+ pvth0=-9.2924260e-16+dpvthn_hvt                     k1=0.4660896
+ lk1=7.059336e-08          wk1=2.433449e-08          pk1=-2.963724e-14
+ k2=0.01107495+dk2n_hvt    lk2=-2.468758e-08+dlk2n_hvt
+ wk2=-1.387237e-08         pk2=1.051735e-14          k3=0
+ dvt0=0                    dvt1=0                    dvt2=0
+ dvt0w=0                   dvt1w=0                   dvt2w=0
+ nlx=0                     w0=0                      k3b=0
+ vfb=-1.060561             vsat=7.6496510e+04        lvsat=-3.3211810e-03+dlvsatn_hvt
+ wvsat=1.0904408e-03       pvsat=-7.1523600e-10+dpvsatn_hvt
+ ua=7.307108e-10           lua=1.333225e-18          wua=-2.726247e-17
+ pua=-2.221737e-23         ub=1.733493e-18           lub=-5.730041e-25
+ wub=-7.022334e-27         pub=3.504938e-32          uc=2.164979e-10
+ luc=-8.299294e-17         wuc=-2.025969e-18         puc=1.823992e-24
+ rdsw=83.7                 prwb=0                    prwg=0
+ wr=1                      u0=4.5677360e-02          lu0=-5.1384870e-09
+ wu0=-2.3235994e-10        pu0=1.1478274e-15         a0=1.386046
+ la0=-1.800078e-07         wa0=-2.258359e-09         pa0=2.252711e-14
+ keta=-0.001               a1=0                      a2=0.99
+ ags=0.589658              lags=1.847151e-07         wags=-5.194869e-09
+ pags=4.026023e-15         b0=0                      b1=0
+ voff=-0.1539544           lvoff=-4.872073e-09       wvoff=6.554135e-09
+ pvoff=-1.768405e-17       nfactor=0.5623719         lnfactor=2.516505e-07
+ wnfactor=-3.630177e-08    pnfactor=-2.898959e-14    cit=0
+ cdsc=0                    cdscb=0                   cdscd=0
+ eta0=-0.001370972         leta0=2.834842e-09        weta0=8.282264e-10
+ peta0=-3.685295e-16       etab=0.0002131643         letab=-5.303135e-10
+ wetab=-1.620918e-10       petab=1.126356e-16        dsub=0
+ pclm=0.4625935            lpclm=2.534301e-07        wpclm=3.302853e-09
+ ppclm=-3.294593e-14       pdiblc1=0                 pdiblc2=0.001
+ pdiblcb=0                 drout=0                   pscbe1=1.458e+08
+ pscbe2=5e-08              pvag=0                    delta=0.01
+ alpha0=0                  alpha1=0.2388             beta0=8.6035
+ kt1=-0.1972071            lkt1=4.706345e-08         wkt1=-3.808792e-09
+ pkt1=-5.462826e-15        kt2=-0.02567298           lkt2=3.277114e-09
+ wkt2=3.290327e-09         pkt2=-1.900726e-15        at=35000
+ ute=-1.6                  ua1=2.13847e-09           lua1=-4.014696e-16
+ wua1=-5.979183e-17        pua1=2.815888e-23         ub1=-2.990002e-18
+ lub1=-2.039093e-25        wub1=-6.379861e-26        pub1=1.182674e-31
+ uc1=-2.92858e-10          luc1=1.362383e-16         wuc1=-1.147118e-17
+ puc1=-5.913372e-24        kt1l=0                    prt=0
+ cj=cjn_hvt                mj=0.4774564              pb=0.8578199
+ cjsw=cjswn_hvt            mjsw=0.2551013            pbsw=0.8578199
+ cjswg=cjswgn_hvt          mjswg=0.2551013           pbswg=0.8578199
+ tcj=0.0007251995          tcjsw=0.0003603971        tcjswg=0.0003603971
+ tpb=0.001168276           tpbsw=0.001168276         tpbswg=0.001168276
+ js=2.50e-6                jsw=jswn_hvt              cgdo=cgon_hvt
+ cgso=cgon_hvt             capmod=3                  nqsmod=0
+ xpart=1                   cf=0                      tlev=1
+ tlevc=1                   xti=3                     n=1
+ dlc=1.8e-8                cgbo=0                    cgdl=cgln_hvt
+ cgsl=cgln_hvt             wwc=-4.5e-2               dwc=0
+ noia=5.0e+19              noib=8.0e+4               noic=4.0e-13
+ em=4.1e+7                 ef=1.146                  noimod=2
+ sa0=0.35e-6               sb0=0.35e-6               kvsat=0.4
+ wlod=0.5e-6               tku0=0.03                 ku0=-0.58e-7
+ llodku0=1                 wlodku0=1                 lku0=2.0e-7
+ wku0=0.7e-6               pku0=-0.5e-13             kvth0=5.2e-9
+ stk2=2.5e-9               steta0=-1.1e-10           lkvth0=-1.0e-8
+ wkvth0=2.2e-6             pkvth0=-5e-14             llodvth=1.0
+ wlodvth=1                 lodk2=1                   lodeta0=2
+ minr=1e-3                 imax=0.01                 imelt=0.01

     11: type=n
+ lmin=3.5e-07-(dxl_hvt+dlmis)      lmax=8e-07-(dxl_hvt+dlmis)        wmin=1.5e-07
+ wmax=5.85e-07-(dxw_hvt+dwmis)      tnom=25                   version=3.24
+ tox= (toxn_hvt+toxmis)              toxm= (toxn_hvt+toxmis)             xj=1.9e-07
+ nch=1.81e+18              lln=1                     lwn=1
+ wln=1                     wwn=-1                    lint=2.5e-09
+ ll=0                      lw=0                      lwl=0
+ wint=1e-08                wl=0                      ww=0
+ wwl=0                     mobmod=1                  binunit=2
+ xl=-2e-08 +(dxl_hvt+dlmis)         xw=1.5e-08+(dxw_hvt+dwmis)        dwg=0
+ dwb=0                     ldif=8e-08                hdif=hdifn_hvt
+ rsh=rshn_hvt              rd=0                      rs=0
+ rsc=0                     rdc=0                     vth0=0.4186040+(dvthn_hvt+vthmis)
+ lvth0=2.8392856e-08+dlvthn_hvt                      wvth0=-9.8913640e-09+dwvthn_hvt
+ pvth0=-3.3199740e-15+dpvthn_hvt                     k1=0.5094053
+ lk1=3.702373e-08          wk1=-1.103913e-08         pk1=-2.222689e-15
+ k2=-0.003018141+dk2n_hvt  lk2=-1.376544e-08+dlk2n_hvt
+ wk2=-1.681141e-09         pk2=1.069144e-15          k3=0
+ dvt0=0                    dvt1=0                    dvt2=0
+ dvt0w=0                   dvt1w=0                   dvt2w=0
+ nlx=0                     w0=0                      k3b=0
+ vfb=-1.079557             vsat=7.1702340e+04        lvsat=3.9429350e-04+dlvsatn_hvt
+ wvsat=-1.2966939e-03      pvsat=1.1347935e-09+dpvsatn_hvt
+ ua=1.057829e-09           lua=-2.52183e-16          wua=-1.243892e-16
+ pua=5.305582e-23          ub=3.91254e-19            lub=4.672314e-25
+ wub=1.323503e-25          pub=-7.296442e-32         uc=-3.44634e-13
+ luc=8.506001e-17          wuc=1.259399e-17          puc=-9.506475e-24
+ rdsw=83.7                 prwb=0                    prwg=0
+ wr=1                      u0=3.3025610e-02          lu0=4.6666220e-09
+ wu0=2.1021476e-09         pu0=-6.6141570e-16        a0=1.26484
+ la0=-8.607289e-08         wa0=4.617086e-08          pa0=-1.500553e-14
+ keta=-0.0006835063        lketa=-2.452827e-10       wketa=-4.11442e-11
+ pketa=3.188675e-17        a1=0                      a2=0.99
+ ags=0.7037777             lags=9.627224e-08         b0=0
+ b1=0                      voff=-0.1459491           lvoff=-1.107618e-08
+ wvoff=3.329452e-09        pvoff=2.481446e-15        nfactor=0.934571
+ lnfactor=-3.680383e-08    wnfactor=-8.548172e-08    pnfactor=9.124866e-15
+ cit=0                     cdsc=0                    cdscb=0
+ cdscd=0                   eta0=0.002577543          leta0=-2.25257e-10
+ weta0=5.590306e-10        peta0=-1.599027e-16       etab=0.000992593
+ letab=-1.134371e-09       wetab=-2.16426e-10        petab=1.547446e-16
+ dsub=0                    pclm=1.007519             lpclm=-1.68887e-07
+ wpclm=-7.260745e-08       ppclm=2.588456e-14        pdiblc1=0
+ pdiblc2=0.001             pdiblcb=0                 drout=0
+ pscbe1=1.458e+08          pscbe2=5e-08              pvag=0
+ delta=0.01                alpha0=0                  alpha1=0.2388
+ beta0=8.6035              kt1=-0.1635328            lkt1=2.096595e-08
+ wkt1=-1.410073e-08        pkt1=2.513426e-15         kt2=-0.02186173
+ lkt2=3.23395e-10          wkt2=1.079803e-09         pkt2=-1.875691e-16
+ at=35000                  ute=-1.6                  ua1=1.80405e-09
+ lua1=-1.422939e-16        wua1=-2.103753e-17        pua1=-1.875692e-24
+ ub1=-3.428371e-18         lub1=1.35826e-25          wub1=1.904549e-25
+ pub1=-7.877907e-32        uc1=1.50519e-11           luc1=-1.023919e-16
+ wuc1=-3.289675e-17        puc1=1.069145e-23         kt1l=0
+ prt=0                     cj=cjn_hvt                mj=0.4774564
+ pb=0.8578199              cjsw=cjswn_hvt            mjsw=0.2551013
+ pbsw=0.8578199            cjswg=cjswgn_hvt          mjswg=0.2551013
+ pbswg=0.8578199           tcj=0.0007251995          tcjsw=0.0003603971
+ tcjswg=0.0003603971       tpb=0.001168276           tpbsw=0.001168276
+ tpbswg=0.001168276        js=2.50e-6                jsw=jswn_hvt
+ cgdo=cgon_hvt             cgso=cgon_hvt             capmod=3
+ nqsmod=0                  xpart=1                   cf=0
+ tlev=1                    tlevc=1                   xti=3
+ n=1                       dlc=1.8e-8                cgbo=0
+ cgdl=cgln_hvt             cgsl=cgln_hvt             wwc=-4.5e-2
+ dwc=0                     noia=5.0e+19              noib=8.0e+4
+ noic=4.0e-13              em=4.1e+7                 ef=1.146
+ noimod=2                  sa0=0.35e-6               sb0=0.35e-6
+ kvsat=0.4                 wlod=0.5e-6               tku0=0.03
+ ku0=-0.58e-7              llodku0=1                 wlodku0=1
+ lku0=2.0e-7               wku0=0.7e-6               pku0=-0.5e-13
+ kvth0=5.2e-9              stk2=2.5e-9               steta0=-1.1e-10
+ lkvth0=-1.0e-8            wkvth0=2.2e-6             pkvth0=-5e-14
+ llodvth=1.0               wlodvth=1                 lodk2=1
+ lodeta0=2                 minr=1e-3                 imax=0.01
+ imelt=0.01

     12: type=n
+ lmin=1.3e-07              lmax=3.5e-07-(dxl_hvt+dlmis)      wmin=1.5e-07
+ wmax=5.85e-07-(dxw_hvt+dwmis)      tnom=25                   version=3.24
+ tox= (toxn_hvt+toxmis)              toxm= (toxn_hvt+toxmis)             xj=1.9e-07
+ nch=1.81e+18              lln=1                     lwn=1
+ wln=1                     wwn=-1                    lint=2.5e-09
+ ll=0                      lw=0                      lwl=0
+ wint=1e-08                wl=0                      ww=0
+ wwl=0                     mobmod=1                  binunit=2
+ xl=-2e-08 +(dxl_hvt+dlmis)         xw=1.5e-08+(dxw_hvt+dwmis)        dwg=0
+ dwb=0                     ldif=8e-08                hdif=hdifn_hvt
+ rsh=rshn_hvt              rd=0                      rs=0
+ rsc=0                     rdc=0                     vth0=0.4878460+(dvthn_hvt+vthmis)
+ lvth0=5.8892110e-09+dlvthn_hvt                      wvth0=-1.8371834e-08+dwvthn_hvt
+ pvth0=-5.6382190e-16+dpvthn_hvt                     k1=0.5387033
+ lk1=2.750188e-08          wk1=-8.521324e-09         pk1=-3.040978e-15
+ k2=-0.01611192+dk2n_hvt   lk2=-9.509958e-09+dlk2n_hvt
+ wk2=-5.809955e-10         pk2=7.115967e-16          k3=0
+ dvt0=0                    dvt1=0                    dvt2=0
+ dvt0w=0                   dvt1w=0                   dvt2w=0
+ nlx=0                     w0=0                      k3b=0
+ vfb=-1.079557             vsat=7.3378290e+04        lvsat=-1.5038745e-04+dlvsatn_hvt
+ wvsat=1.5944125e-03       pvsat=1.9518381e-10+dpvsatn_hvt
+ ua=2.698758e-10           lua=3.901649e-18          wua=5.824604e-17
+ pua=-6.300626e-24         ub=2.035075e-18           lub=-6.701054e-26
+ wub=-1.292518e-25         pub=1.205628e-32          uc=2.952092e-10
+ luc=-1.099499e-17         wuc=-1.920992e-17         puc=8.297976e-25
+ rdsw=83.7                 prwb=0                    prwg=0
+ wr=1                      u0=4.7351180e-02          lu0=1.0811668e-11
+ wu0=3.6489120e-11         pu0=9.9232600e-18         a0=1
+ keta=-0.001647374         lketa=6.797422e-11        wketa=8.415858e-11
+ pketa=-8.836651e-18       a1=0                      a2=0.99
+ ags=1                     b0=0                      b1=0
+ voff=-0.1683576           lvoff=-3.793393e-09       wvoff=1.038873e-08
+ pvoff=1.871806e-16        nfactor=0.9561155         lnfactor=-4.380577e-08
+ wnfactor=-1.011582e-07    pnfactor=1.421973e-14     cit=0
+ cdsc=0                    cdscb=0                   cdscd=0
+ eta0=-0.001962688         leta0=1.250318e-09        weta0=4.436779e-10
+ peta0=-1.224131e-16       etab=-0.002377304         letab=-3.915411e-11
+ wetab=5.192497e-10        petab=-8.435005e-17       dsub=0
+ pclm=-0.04214924          lpclm=1.722552e-07        wpclm=2.877025e-08
+ ppclm=-7.063204e-15       pdiblc1=0                 pdiblc2=0.0004511365
+ lpdiblc2=1.783807e-10     pdiblcb=0                 drout=0
+ pscbe1=1.608736e+08       lpscbe1=-4.898915         wpscbe1=-0.5516306
+ ppscbe1=1.792798e-07      pscbe2=5e-08              pvag=0
+ delta=0.01                alpha0=0                  alpha1=0.2388
+ beta0=8.6035              kt1=-0.06323737           lkt1=-1.163007e-08
+ wkt1=-1.228487e-08        pkt1=1.923271e-15         kt2=-0.01990152
+ lkt2=-3.136742e-10        wkt2=-5.712102e-11        pkt2=1.81931e-16
+ at=35000                  ute=-1.6                  ua1=1.171919e-09
+ lua1=6.314848e-17         wua1=8.377775e-18         pua1=-1.143567e-23
+ ub1=-2.605378e-18         lub1=-1.316467e-25        wub1=-1.23835e-25
+ pub1=2.336515e-32         uc1=-2.917273e-10         luc1=-2.688636e-18
+ wuc1=-4.798182e-18        puc1=1.559409e-24         kt1l=0
+ prt=0                     cj=cjn_hvt                mj=0.4774564
+ pb=0.8578199              cjsw=cjswn_hvt            mjsw=0.2551013
+ pbsw=0.8578199            cjswg=cjswgn_hvt          mjswg=0.2551013
+ pbswg=0.8578199           tcj=0.0007251995          tcjsw=0.0003603971
+ tcjswg=0.0003603971       tpb=0.001168276           tpbsw=0.001168276
+ tpbswg=0.001168276        js=2.50e-6                jsw=jswn_hvt
+ cgdo=cgon_hvt             cgso=cgon_hvt             capmod=3
+ nqsmod=0                  xpart=1                   cf=0
+ tlev=1                    tlevc=1                   xti=3
+ n=1                       dlc=1.8e-8                cgbo=0
+ cgdl=cgln_hvt             cgsl=cgln_hvt             wwc=-4.5e-2
+ dwc=0                     noia=5.0e+19              noib=8.0e+4
+ noic=4.0e-13              em=4.1e+7                 ef=1.146
+ noimod=2                  sa0=0.35e-6               sb0=0.35e-6
+ kvsat=0.4                 wlod=0.5e-6               tku0=0.03
+ ku0=-0.58e-7              llodku0=1                 wlodku0=1
+ lku0=2.0e-7               wku0=0.7e-6               pku0=-0.5e-13
+ kvth0=5.2e-9              stk2=2.5e-9               steta0=-1.1e-10
+ lkvth0=-1.0e-8            wkvth0=2.2e-6             pkvth0=-5e-14
+ llodvth=1.0               wlodvth=1                 lodk2=1
+ lodeta0=2                 minr=1e-3                 imax=0.01
+ imelt=0.01
//
// **************************************************************
//                                                              *
//               1.2V HIGH Vt PMOS DEVICES MODEL                *
//                                                              *
// **************************************************************
//
     }
ends nch_hvt_mis
//  ********************************
//        Mismatch   model         *
//  ********************************
inline subckt pch_hvt_mis ( d g s b )
parameters l=1u w=1u factor=1 multi=1 sa=0.35u sb=0.35u ad=2 * hdifp_hvt / factor *
+ w as=2 * hdifp_hvt / factor * w pd=2 * (2 * hdifp_hvt / factor + w) ps=2 * (2 *
+ hdifp_hvt / factor + w) nrd=hdifp_hvt / factor / w nrs=hdifp_hvt / factor / w temp1=parp1_hvt
+ temp2=parp2_hvt fac1=0.802 * temp1 + 0.598 * temp2 fac2=0.802 * temp1 - 0.598
+ * temp2 lef=l - 2.0e-8 wef=w + 1.5e-8 geo_fac=1 / sqrt(multi * lef * wef * 1e12)
+ vthmis=0.002462 * geo_fac * fac1 dlmis=0.002007 * geo_fac * lef * fac2 dwmis=
+ - 0.002007 * geo_fac * wef * fac2 toxmis=0.002007 * geo_fac * toxp_hvt * fac2
pch_hvt_mis ( d g s b ) pch_hvt w=w l=l ad=ad as=as pd=pd ps=ps nrd=nrd nrs=nrs m=multi sa=sa
+ sb=sb
model pch_hvt bsim3v3  {
     1: type=p
+ wmax=0.0009001            wmin=1.009e-05-(dxw_hvt+dwmis)     xw=1.5e-08+(dxw_hvt+dwmis)
+ lmax=2.1e-05              lmin=7.98e-07-(dxl_hvt+dlmis)     xl=-2e-08 +(dxl_hvt+dlmis)
+ tnom=25                   version=3.24              tox=toxp_hvt
+ toxm=toxp_hvt             xj=2.1e-07                nch=9.52e+17
+ lln=1                     lwn=1                     wln=1
+ wwn=-1                    lint=6.1e-09              ll=0
+ lw=0                      lwl=0                     wint=-1.045e-08
+ wl=0                      ww=0                      wwl=0
+ mobmod=1                  binunit=2                 dwg=0
+ dwb=0                     ldif=8e-08                hdif=hdifp_hvt
+ rsh=rshp_hvt              rd=0                      rs=0
+ rsc=0                     rdc=0                     vth0=-0.411869+dvthp_hvt
+ lvth0=-9.124971e-09+dlvthp_hvt                      wvth0=0+dwvthp_hvt
+ pvth0=0+dpvthp_hvt        k1=0.921794               k2=-0.1181389+dk2p_hvt
+ lk2=0+dlk2p_hvt           k3=0                      dvt0=0
+ dvt1=0                    dvt2=0                    dvt0w=0
+ dvt1w=0                   dvt2w=0                   nlx=0
+ w0=0                      k3b=0                     vfb=-1.390157
+ vsat=101664.8             pvsat=0+dpvsatp_hvt       lvsat=-0.01659089+dlvsatp_hvt
+ ua=1.608324e-10           lua=-8.295446e-18         ub=1.2e-18
+ uc=-3.167163e-11          luc=9.124988e-18          rdsw=445
+ prwb=0                    prwg=0                    wr=1
+ u0=0.009108437            lu0=9.12499e-10           a0=1.245838
+ la0=4.147719e-08          keta=0.02383239           lketa=-8.295444e-09
+ a1=0                      a2=1                      ags=0.4916761
+ lags=8.295446e-08         b0=0                      b1=0
+ voff=-0.1308324           lvoff=8.295443e-09        nfactor=1.3
+ cit=0.0001                cdsc=0                    cdscb=0
+ cdscd=0                   eta0=0.0002833522         leta0=1.659089e-10
+ etab=-0.0004025028        letab=-2.488633e-11       dsub=0
+ pclm=1.024972             lpclm=-2.488634e-07       pdiblc1=0.0003
+ pdiblc2=0.0003083239      lpdiblc2=-8.295446e-11    pdiblcb=0
+ drout=0                   pscbe1=4.24e+08           pscbe2=1e-07
+ pvag=0                    delta=0.004167609         ldelta=8.295444e-09
+ alpha0=0                  alpha1=0.0105319          beta0=11.7442
+ kt1=-0.2716648            lkt1=1.65909e-08          kt2=-0.02249717+dkt2p_hvt
+ lkt2=2.488633e-08         at=10000                  ute=-0.9583239
+ lute=8.295442e-08         ua1=2.395838e-09          lua1=4.147723e-17
+ ub1=-2.84e-18             uc1=-3.377e-10            kt1l=0
+ prt=0                     cj=cjp_hvt                mj=0.4107588
+ pb=0.8465904              cjsw=cjswp_hvt            mjsw=0.1813912
+ pbsw=0.8465904            cjswg=cjswgp_hvt          mjswg=0.1813912
+ pbswg=0.8465904           tcj=0.0008024992          tcjsw=0.0004114948
+ tcjswg=0.0004114948       tpb=0.001514677           tpbsw=0.001514677
+ tpbswg=0.001514677        cgdo=cgop_hvt             cgso=cgop_hvt
+ cgbo=1e-13                js=1.49e-7                jsw=jswp_hvt
+ capmod=3                  xti=3                     n=1
+ nqsmod=0                  xpart=1                   cf=0
+ tlev=1                    tlevc=1                   paramchk=1
+ dlc=1.5e-8                cgdl=cglp_hvt             cgsl=cglp_hvt
+ wwc=-4e-2                 dwc=0                     noia=3.0e+19
+ noib=4.0e+3               noic=1.0e-11              em=4.1e+7
+ ef=1.059                  noimod=2                  sa0=0.35e-6
+ sb0=0.35e-6               kvsat=-0.6                wlod=0.3e-6
+ tku0=0.03                 ku0=1.14e-7               llodku0=1
+ wlodku0=1                 lku0=8.4e-8               wku0=3.0e-7
+ pku0=1.4e-14              kvth0=-2.3e-9             stk2=0e-9
+ steta0=0                  lkvth0=1e-8               wkvth0=2.5e-7
+ pkvth0=4e-14              llodvth=1                 wlodvth=1
+ lodk2=1                   lodeta0=1                 minr=1e-3
+ imax=0.01                 imelt=0.01

     2: type=p
+ wmax=0.0009001            wmin=1.009e-05-(dxw_hvt+dwmis)     xw=1.5e-08+(dxw_hvt+dwmis)
+ lmax=7.98e-07-(dxl_hvt+dlmis)     lmin=3.48e-07-(dxl_hvt+dlmis)     xl=-2e-08 +(dxl_hvt+dlmis)
+ tnom=25                   version=3.24              tox=toxp_hvt
+ toxm=toxp_hvt             xj=2.1e-07                nch=9.52e+17
+ lln=1                     lwn=1                     wln=1
+ wwn=-1                    lint=6.1e-09              ll=0
+ lw=0                      lwl=0                     wint=-1.045e-08
+ wl=0                      ww=0                      wwl=0
+ mobmod=1                  binunit=2                 dwg=0
+ dwb=0                     ldif=8e-08                hdif=hdifp_hvt
+ rsh=rshp_hvt              rd=0                      rs=0
+ rsc=0                     rdc=0                     vth0=-0.404837+dvthp_hvt
+ lvth0=-1.451038e-08+dlvthp_hvt                      wvth0=0+dwvthp_hvt
+ pvth0=0+dpvthp_hvt        k1=0.9288118              lk1=-5.374209e-09
+ k2=-0.1181389+dk2p_hvt    lk2=0+dlk2p_hvt           k3=0
+ dvt0=0                    dvt1=0                    dvt2=0
+ dvt0w=0                   dvt1w=0                   dvt2w=0
+ nlx=0                     w0=0                      k3b=0
+ vfb=-1.353496             vsat=65964.45             pvsat=0+dpvsatp_hvt
+ lvsat=0.01074843+dlvsatp_hvt                        ua=1.640356e-10
+ lua=-1.074843e-17         ub=1.2e-18                uc=-1.273823e-11
+ luc=-5.374214e-18         rdsw=445                  prwb=0
+ prwg=0                    wr=1                      u0=0.009808755
+ lu0=3.76195e-10           a0=1.335089               la0=-2.687105e-08
+ keta=-0.02208889          lketa=2.687107e-08        a1=0
+ a2=1                      ags=0.6                   b0=0
+ b1=0                      voff=-0.1129822           lvoff=-5.374213e-09
+ nfactor=1.229822          lnfactor=5.374216e-08     cit=0.0001
+ cdsc=0                    cdscb=0                   cdscd=0
+ eta0=0.0005               etab=0.0009089042         letab=-1.029162e-09
+ dsub=0                    pclm=0.6298222            lpclm=5.374216e-08
+ pdiblc1=0.0001596445      lpdiblc1=1.074843e-10     pdiblc2=-1.053331e-05
+ lpdiblc2=1.612264e-10     pdiblcb=0                 drout=0
+ pscbe1=4.24e+08           pscbe2=1e-07              pvag=0
+ delta=0.015               alpha0=0                  alpha1=0.0105319
+ beta0=11.7442             kt1=-0.25                 kt2=0.01+dkt2p_hvt
+ at=10000                  ute=-0.8850889            lute=2.687108e-08
+ ua1=2.414911e-09          lua1=2.687107e-17         ub1=-2.84e-18
+ uc1=-3.377e-10            kt1l=0                    prt=0
+ cj=cjp_hvt                mj=0.4107588              pb=0.8465904
+ cjsw=cjswp_hvt            mjsw=0.1813912            pbsw=0.8465904
+ cjswg=cjswgp_hvt          mjswg=0.1813912           pbswg=0.8465904
+ tcj=0.0008024992          tcjsw=0.0004114948        tcjswg=0.0004114948
+ tpb=0.001514677           tpbsw=0.001514677         tpbswg=0.001514677
+ cgdo=cgop_hvt             cgso=cgop_hvt             cgbo=1e-13
+ js=1.49e-7                jsw=jswp_hvt              capmod=3
+ xti=3                     n=1                       nqsmod=0
+ xpart=1                   cf=0                      tlev=1
+ tlevc=1                   paramchk=1                dlc=1.5e-8
+ cgdl=cglp_hvt             cgsl=cglp_hvt             wwc=-4e-2
+ dwc=0                     noia=3.0e+19              noib=4.0e+3
+ noic=1.0e-11              em=4.1e+7                 ef=1.059
+ noimod=2                  sa0=0.35e-6               sb0=0.35e-6
+ kvsat=-0.6                wlod=0.3e-6               tku0=0.03
+ ku0=1.14e-7               llodku0=1                 wlodku0=1
+ lku0=8.4e-8               wku0=3.0e-7               pku0=1.4e-14
+ kvth0=-2.3e-9             stk2=0e-9                 steta0=0
+ lkvth0=1e-8               wkvth0=2.5e-7             pkvth0=4e-14
+ llodvth=1                 wlodvth=1                 lodk2=1
+ lodeta0=1                 minr=1e-3                 imax=0.01
+ imelt=0.01

     3: type=p
+ wmax=0.0009001            wmin=1.009e-05-(dxw_hvt+dwmis)     xw=1.5e-08+(dxw_hvt+dwmis)
+ lmax=3.48e-07-(dxl_hvt+dlmis)     lmin=1.3e-07              xl=-2e-08 +(dxl_hvt+dlmis)
+ tnom=25                   version=3.24              tox=toxp_hvt
+ toxm=toxp_hvt             xj=2.1e-07                nch=9.52e+17
+ lln=1                     lwn=1                     wln=1
+ wwn=-1                    lint=6.1e-09              ll=0
+ lw=0                      lwl=0                     wint=-1.045e-08
+ wl=0                      ww=0                      wwl=0
+ mobmod=1                  binunit=2                 dwg=0
+ dwb=0                     ldif=8e-08                hdif=hdifp_hvt
+ rsh=rshp_hvt              rd=0                      rs=0
+ rsc=0                     rdc=0                     vth0=-0.42248+dvthp_hvt
+ lvth0=-8.938579e-09+dlvthp_hvt                      wvth0=0+dwvthp_hvt
+ pvth0=0+dpvthp_hvt        k1=0.9074395              lk1=1.375164e-09
+ k2=-0.1181389+dk2p_hvt    lk2=0+dlk2p_hvt           k3=0
+ dvt0=0                    dvt1=0                    dvt2=0
+ dvt0w=0                   dvt1w=0                   dvt2w=0
+ nlx=0                     w0=0                      k3b=0
+ vfb=-1.298158             vsat=100000               pvsat=0+dpvsatp_hvt
+ lvsat=0+dlvsatp_hvt       ua=1.234682e-10           lua=2.062748e-18
+ ub=1.147833e-18           lub=1.647447e-26          uc=-4.957441e-11
+ luc=6.258653e-18          rdsw=445                  prwb=0
+ prwg=0                    wr=1                      u0=0.01024166
+ lu0=2.394853e-10          a0=1.247823               la0=6.87582e-10
+ keta=0.07253645           lketa=-3.011613e-09       a1=0
+ a2=1                      ags=0.6870909             lags=-2.750331e-08
+ b0=0                      b1=0                      voff=-0.1212909
+ lvoff=-2.750332e-09       nfactor=1.312909          lnfactor=2.750331e-08
+ cit=0.0001                cdsc=0                    cdscb=0
+ cdscd=0                   eta0=-0.0003709087        leta0=2.750331e-10
+ etab=-0.0006081827        letab=-5.500661e-10       dsub=0
+ pclm=0.8                  pdiblc1=0.0003693637      lpdiblc1=4.125496e-11
+ pdiblc2=0.0003693637      lpdiblc2=4.125496e-11     pdiblcb=0
+ drout=0                   pscbe1=4.24e+08           pscbe2=1e-07
+ pvag=0                    delta=0.01848364          ldelta=-1.100132e-09
+ alpha0=0                  alpha1=0.0105319          beta0=11.7442
+ kt1=-0.2412909            lkt1=-2.750332e-09        kt2=0.02306363+dkt2p_hvt
+ lkt2=-4.125496e-09        at=10000                  ute=-0.7651637
+ lute=-1.100132e-08        ua1=2.565318e-09          lua1=-2.062748e-17
+ ub1=-3.014182e-18         lub1=5.500661e-26         uc1=-3.377e-10
+ kt1l=0                    prt=0                     cj=cjp_hvt
+ mj=0.4107588              pb=0.8465904              cjsw=cjswp_hvt
+ mjsw=0.1813912            pbsw=0.8465904            cjswg=cjswgp_hvt
+ mjswg=0.1813912           pbswg=0.8465904           tcj=0.0008024992
+ tcjsw=0.0004114948        tcjswg=0.0004114948       tpb=0.001514677
+ tpbsw=0.001514677         tpbswg=0.001514677        cgdo=cgop_hvt
+ cgso=cgop_hvt             cgbo=1e-13                js=1.49e-7
+ jsw=jswp_hvt              capmod=3                  xti=3
+ n=1                       nqsmod=0                  xpart=1
+ cf=0                      tlev=1                    tlevc=1
+ paramchk=1                dlc=1.5e-8                cgdl=cglp_hvt
+ cgsl=cglp_hvt             wwc=-4e-2                 dwc=0
+ noia=3.0e+19              noib=4.0e+3               noic=1.0e-11
+ em=4.1e+7                 ef=1.059                  noimod=2
+ sa0=0.35e-6               sb0=0.35e-6               kvsat=-0.6
+ wlod=0.3e-6               tku0=0.03                 ku0=1.14e-7
+ llodku0=1                 wlodku0=1                 lku0=8.4e-8
+ wku0=3.0e-7               pku0=1.4e-14              kvth0=-2.3e-9
+ stk2=0e-9                 steta0=0                  lkvth0=1e-8
+ wkvth0=2.5e-7             pkvth0=4e-14              llodvth=1
+ wlodvth=1                 lodk2=1                   lodeta0=1
+ minr=1e-3                 imax=0.01                 imelt=0.01

     4: type=p
+ wmax=1.009e-05-(dxw_hvt+dwmis)     wmin=1.182e-06-(dxw_hvt+dwmis)     xw=1.5e-08+(dxw_hvt+dwmis)
+ lmax=2.1e-05              lmin=7.98e-07-(dxl_hvt+dlmis)     xl=-2e-08 +(dxl_hvt+dlmis)
+ tnom=25                   version=3.24              tox=toxp_hvt
+ toxm=toxp_hvt             xj=2.1e-07                nch=9.52e+17
+ lln=1                     lwn=1                     wln=1
+ wwn=-1                    lint=6.1e-09              ll=0
+ lw=0                      lwl=0                     wint=-1.045e-08
+ wl=0                      ww=0                      wwl=0
+ mobmod=1                  binunit=2                 dwg=0
+ dwb=0                     ldif=8e-08                hdif=hdifp_hvt
+ rsh=rshp_hvt              rd=0                      rs=0
+ rsc=0                     rdc=0                     vth0=-0.41603+dvthp_hvt
+ lvth0=-8.137578e-09+dlvthp_hvt                      wvth0=4.212857e-08+dwvthp_hvt
+ pvth0=-9.998241e-15+dpvthp_hvt                      k1=0.9258956
+ wk1=-4.15323e-08          k2=-0.1181389+dk2p_hvt    lk2=0+dlk2p_hvt
+ k3=0                      dvt0=0                    dvt1=0
+ dvt2=0                    dvt0w=0                   dvt1w=0
+ dvt2w=0                   nlx=0                     w0=0
+ k3b=0                     vfb=-1.382174             vsat=101892.4
+ lvsat=-0.01885919+dlvsatp_hvt                       wvsat=-0.002304744
+ pvsat=2.296861e-08+dpvsatp_hvt                      ua=1.608324e-10
+ lua=-8.295446e-18         ub=1.197724e-18           lub=2.268304e-26
+ wub=2.304745e-26          pub=-2.296861e-31         uc=-3.090775e-11
+ luc=1.377501e-17          wuc=-7.734977e-18         puc=-4.708565e-23
+ rdsw=445                  prwb=0                    prwg=0
+ wr=1                      u0=0.009233776            lu0=1.025914e-09
+ wu0=-1.269174e-09         pu0=-1.148431e-15         a0=1.242081
+ la0=6.529437e-08          wa0=3.80439e-08           pa0=-2.411703e-13
+ keta=0.02556376           lketa=-1.192473e-08       wketa=-1.75317e-08
+ pketa=3.674978e-14        a1=0                      a2=1
+ ags=0.4916761             lags=8.295447e-08         b0=0
+ b1=0                      voff=-0.1309462           lvoff=9.429596e-09
+ wvoff=1.152371e-09        pvoff=-1.14843e-14        nfactor=1.325068
+ lnfactor=2.268303e-08     wnfactor=-2.538347e-07    pnfactor=-2.296862e-13
+ cit=0.0001296201          lcit=-2.268304e-11        wcit=-2.999297e-10
+ pcit=2.296861e-16         cdsc=0                    cdscb=0
+ cdscd=0                   eta0=0.000215569          leta0=2.282873e-10
+ weta0=6.863655e-10        peta0=-6.316369e-16       etab=-0.0004055756
+ letab=5.735773e-12        wetab=3.111406e-11        petab=-3.100763e-16
+ dsub=0                    pclm=1.039782             lpclm=-2.602049e-07
+ wpclm=-1.499648e-07       ppclm=1.148431e-13        pdiblc1=0.00028519
+ lpdiblc1=1.134151e-11     wpdiblc1=1.499648e-10     ppdiblc1=-1.14843e-16
+ pdiblc2=0.0002935139      lpdiblc2=-7.161296e-11    wpdiblc2=1.499648e-10
+ ppdiblc2=-1.14843e-16     pdiblcb=0                 drout=0
+ pscbe1=4.24e+08           pscbe2=1e-07              pvag=0
+ delta=0.003814505         ldelta=9.089351e-09       wdelta=3.575484e-09
+ pdelta=-8.039015e-15      alpha0=0                  alpha1=0.0105319
+ beta0=11.7442             kt1=-0.2775888            lkt1=2.112751e-08
+ wkt1=5.998594e-08         pkt1=-4.593724e-14        kt2=-0.02694018+dkt2p_hvt
+ lkt2=2.828879e-08         wkt2=4.498945e-08         pkt2=-3.445292e-14
+ at=10000                  ute=-0.9672099            lute=8.975933e-08
+ wute=8.99789e-08          pute=-6.890585e-14        ua1=2.435147e-09
+ lua1=5.848951e-17         wua1=-3.980378e-16        pua1=-1.722646e-22
+ ub1=-2.84e-18             uc1=-3.377e-10            kt1l=0
+ prt=0                     cj=cjp_hvt                mj=0.4107588
+ pb=0.8465904              cjsw=cjswp_hvt            mjsw=0.1813912
+ pbsw=0.8465904            cjswg=cjswgp_hvt          mjswg=0.1813912
+ pbswg=0.8465904           tcj=0.0008024992          tcjsw=0.0004114948
+ tcjswg=0.0004114948       tpb=0.001514677           tpbsw=0.001514677
+ tpbswg=0.001514677        cgdo=cgop_hvt             cgso=cgop_hvt
+ cgbo=1e-13                js=1.49e-7                jsw=jswp_hvt
+ capmod=3                  xti=3                     n=1
+ nqsmod=0                  xpart=1                   cf=0
+ tlev=1                    tlevc=1                   paramchk=1
+ dlc=1.5e-8                cgdl=cglp_hvt             cgsl=cglp_hvt
+ wwc=-4e-2                 dwc=0                     noia=3.0e+19
+ noib=4.0e+3               noic=1.0e-11              em=4.1e+7
+ ef=1.059                  noimod=2                  sa0=0.35e-6
+ sb0=0.35e-6               kvsat=-0.6                wlod=0.3e-6
+ tku0=0.03                 ku0=1.14e-7               llodku0=1
+ wlodku0=1                 lku0=8.4e-8               wku0=3.0e-7
+ pku0=1.4e-14              kvth0=-2.3e-9             stk2=0e-9
+ steta0=0                  lkvth0=1e-8               wkvth0=2.5e-7
+ pkvth0=4e-14              llodvth=1                 wlodvth=1
+ lodk2=1                   lodeta0=1                 minr=1e-3
+ imax=0.01                 imelt=0.01

     5: type=p
+ wmax=1.009e-05-(dxw_hvt+dwmis)     wmin=1.182e-06-(dxw_hvt+dwmis)     xw=1.5e-08+(dxw_hvt+dwmis)
+ lmax=7.98e-07-(dxl_hvt+dlmis)     lmin=3.48e-07-(dxl_hvt+dlmis)     xl=-2e-08 +(dxl_hvt+dlmis)
+ tnom=25                   version=3.24              tox=toxp_hvt
+ toxm=toxp_hvt             xj=2.1e-07                nch=9.52e+17
+ lln=1                     lwn=1                     wln=1
+ wwn=-1                    lint=6.1e-09              ll=0
+ lw=0                      lwl=0                     wint=-1.045e-08
+ wl=0                      ww=0                      wwl=0
+ mobmod=1                  binunit=2                 dwg=0
+ dwb=0                     ldif=8e-08                hdif=hdifp_hvt
+ rsh=rshp_hvt              rd=0                      rs=0
+ rsc=0                     rdc=0                     vth0=-0.407324+dvthp_hvt
+ lvth0=-1.480429e-08+dlvthp_hvt                      wvth0=2.518643e-08+dwvthp_hvt
+ pvth0=2.976056e-15+dpvthp_hvt                       k1=0.9352161
+ lk1=-7.137634e-09         wk1=-6.484946e-08         pk1=1.785628e-14
+ k2=-0.1181389+dk2p_hvt    lk2=0+dlk2p_hvt           k3=0
+ dvt0=0                    dvt1=0                    dvt2=0
+ dvt0w=0                   dvt1w=0                   dvt2w=0
+ nlx=0                     w0=0                      k3b=0
+ vfb=-1.3727               vsat=61311.11             lvsat=0.01221795+dlvsatp_hvt
+ wvsat=0.0471192           pvsat=-1.488024e-08+dpvsatp_hvt
+ ua=1.659545e-10           lua=-1.221795e-17         wua=-1.943099e-17
+ pua=1.488025e-23          ub=1.246533e-18           lub=-1.469522e-26
+ wub=-4.711919e-25         pub=1.488024e-31          uc=-1.104899e-12
+ luc=-9.048018e-18         wuc=-1.17798e-16          puc=3.720061e-23
+ rdsw=445                  prwb=0                    prwg=0
+ wr=1                      u0=0.01013976             lu0=3.321093e-10
+ wu0=-3.351752e-09         pu0=4.464078e-16          a0=1.386419
+ la0=-4.524006e-08         wa0=-5.197692e-07         pa0=1.86003e-13
+ keta=-0.02912649          lketa=2.995707e-08        wketa=7.12621e-08
+ pketa=-3.124851e-14       a1=0                      a2=1
+ ags=0.5952027             lags=3.673806e-09         wags=4.857746e-08
+ pags=-3.720062e-14        b0=0                      b1=0
+ voff=-0.1106556           lvoff=-6.108974e-09       wvoff=-2.35596e-08
+ pvoff=7.440121e-15        nfactor=1.294105          lnfactor=4.639456e-08
+ wnfactor=-6.509193e-07    pnfactor=7.440122e-14     cit=0.0001
+ cdsc=0                    cdscb=0                   cdscd=0
+ eta0=0.0005232667         leta0=-7.347612e-12       weta0=-2.355961e-10
+ peta0=7.440124e-17        etab=0.0009717243         letab=-1.049001e-09
+ wetab=-6.361092e-10       petab=2.008833e-16        dsub=0
+ pclm=0.6298222            lpclm=5.374216e-08        pdiblc1=0.0001596445
+ lpdiblc1=1.074843e-10     pdiblc2=-1.053331e-05     lpdiblc2=1.612264e-10
+ pdiblcb=0                 drout=0                   pscbe1=4.24e+08
+ pscbe2=1e-07              pvag=0                    delta=0.01616333
+ ldelta=-3.673805e-10      wdelta=-1.17798e-08       pdelta=3.720061e-15
+ alpha0=0                  alpha1=0.0105319          beta0=11.7442
+ kt1=-0.25                 kt2=0.01+dkt2p_hvt        at=10000
+ ute=-0.8850889            lute=2.687108e-08         ua1=2.505219e-09
+ lua1=4.82825e-18          wua1=-9.144498e-16        pua1=2.232037e-22
+ ub1=-2.84e-18             uc1=-3.377e-10            kt1l=0
+ prt=0                     cj=cjp_hvt                mj=0.4107588
+ pb=0.8465904              cjsw=cjswp_hvt            mjsw=0.1813912
+ pbsw=0.8465904            cjswg=cjswgp_hvt          mjswg=0.1813912
+ pbswg=0.8465904           tcj=0.0008024992          tcjsw=0.0004114948
+ tcjswg=0.0004114948       tpb=0.001514677           tpbsw=0.001514677
+ tpbswg=0.001514677        cgdo=cgop_hvt             cgso=cgop_hvt
+ cgbo=1e-13                js=1.49e-7                jsw=jswp_hvt
+ capmod=3                  xti=3                     n=1
+ nqsmod=0                  xpart=1                   cf=0
+ tlev=1                    tlevc=1                   paramchk=1
+ dlc=1.5e-8                cgdl=cglp_hvt             cgsl=cglp_hvt
+ wwc=-4e-2                 dwc=0                     noia=3.0e+19
+ noib=4.0e+3               noic=1.0e-11              em=4.1e+7
+ ef=1.059                  noimod=2                  sa0=0.35e-6
+ sb0=0.35e-6               kvsat=-0.6                wlod=0.3e-6
+ tku0=0.03                 ku0=1.14e-7               llodku0=1
+ wlodku0=1                 lku0=8.4e-8               wku0=3.0e-7
+ pku0=1.4e-14              kvth0=-2.3e-9             stk2=0e-9
+ steta0=0                  lkvth0=1e-8               wkvth0=2.5e-7
+ pkvth0=4e-14              llodvth=1                 wlodvth=1
+ lodk2=1                   lodeta0=1                 minr=1e-3
+ imax=0.01                 imelt=0.01

     6: type=p
+ wmax=1.009e-05-(dxw_hvt+dwmis)     wmin=1.182e-06-(dxw_hvt+dwmis)     xw=1.5e-08+(dxw_hvt+dwmis)
+ lmax=3.48e-07-(dxl_hvt+dlmis)     lmin=1.3e-07              xl=-2e-08 +(dxl_hvt+dlmis)
+ tnom=25                   version=3.24              tox=toxp_hvt
+ toxm=toxp_hvt             xj=2.1e-07                nch=9.52e+17
+ lln=1                     lwn=1                     wln=1
+ wwn=-1                    lint=6.1e-09              ll=0
+ lw=0                      lwl=0                     wint=-1.045e-08
+ wl=0                      ww=0                      wwl=0
+ mobmod=1                  binunit=2                 dwg=0
+ dwb=0                     ldif=8e-08                hdif=hdifp_hvt
+ rsh=rshp_hvt              rd=0                      rs=0
+ rsc=0                     rdc=0                     vth0=-0.426494+dvthp_hvt
+ lvth0=-8.750567e-09+dlvthp_hvt                      wvth0=4.063874e-08+dwvthp_hvt
+ pvth0=-1.903787e-15+dpvthp_hvt                      k1=0.9068309
+ lk1=1.826394e-09          wk1=6.161906e-09          pk1=-4.569105e-15
+ k2=-0.1181389+dk2p_hvt    lk2=0+dlk2p_hvt           k3=0
+ dvt0=0                    dvt1=0                    dvt2=0
+ dvt0w=0                   dvt1w=0                   dvt2w=0
+ nlx=0                     w0=0                      k3b=0
+ vfb=-1.284174             vsat=99106.97             lvsat=0.0002820186+dlvsatp_hvt
+ wvsat=0.009042723         pvsat=-2.855692e-09+dpvsatp_hvt
+ ua=1.201384e-10           lua=2.250761e-18          wua=3.371671e-17
+ pua=-1.903795e-24         ub=1.153786e-18           lub=1.459435e-26
+ wub=-6.028483e-26         pub=1.903795e-32          uc=-4.957441e-11
+ luc=6.258653e-18          rdsw=445                  prwb=0
+ prwg=0                    wr=1                      u0=0.01042711
+ lu0=2.413655e-10          wu0=-1.877888e-09         pu0=-1.903838e-17
+ a0=1.240689               la0=7.815882e-10          wa0=7.223473e-08
+ pa0=-9.518963e-16         keta=0.07580072           lketa=-3.178944e-09
+ wketa=-3.305357e-08       pketa=1.694377e-15        a1=0
+ a2=1                      ags=0.6969037             lags=-2.844338e-08
+ wags=-9.9363e-08          pags=9.518974e-15         b0=0
+ b1=0                      voff=-0.1212909           lvoff=-2.750332e-09
+ nfactor=1.365832          lnfactor=2.374307e-08     wnfactor=-5.358929e-07
+ pnfactor=3.807588e-14     cit=0.0001                cdsc=0
+ cdscb=0                   cdscd=0                   eta0=-0.0002518383
+ leta0=2.374306e-10        weta0=-1.205696e-09       peta0=3.807589e-16
+ etab=-0.000608182         letab=-5.500662e-10       dsub=0
+ pclm=0.8                  pdiblc1=0.0003812707      lpdiblc1=3.749471e-11
+ wpdiblc1=-1.205696e-10    ppdiblc1=3.80759e-17      pdiblc2=0.0003812707
+ lpdiblc2=3.749471e-11     wpdiblc2=-1.205696e-10    ppdiblc2=3.80759e-17
+ pdiblcb=0                 drout=0                   pscbe1=4.24e+08
+ pscbe2=1e-07              pvag=0                    delta=0.01848364
+ ldelta=-1.100132e-09      alpha0=0                  alpha1=0.0105319
+ beta0=11.7442             kt1=-0.2383141            lkt1=-3.690395e-09
+ wkt1=-3.014242e-08        pkt1=9.518974e-15         kt2=0.02484969+dkt2p_hvt
+ lkt2=-4.689534e-09        wkt2=-1.808544e-08        pkt2=5.711383e-15
+ at=10000                  ute=-0.7604008            lute=-1.250542e-08
+ wute=-4.822784e-08        pute=1.523035e-14         ua1=2.576896e-09
+ lua1=-1.78073e-17         wua1=-1.172345e-16        pua1=-2.855692e-23
+ ub1=-3.014182e-18         lub1=5.500661e-26         uc1=-3.377e-10
+ kt1l=0                    prt=0                     cj=cjp_hvt
+ mj=0.4107588              pb=0.8465904              cjsw=cjswp_hvt
+ mjsw=0.1813912            pbsw=0.8465904            cjswg=cjswgp_hvt
+ mjswg=0.1813912           pbswg=0.8465904           tcj=0.0008024992
+ tcjsw=0.0004114948        tcjswg=0.0004114948       tpb=0.001514677
+ tpbsw=0.001514677         tpbswg=0.001514677        cgdo=cgop_hvt
+ cgso=cgop_hvt             cgbo=1e-13                js=1.49e-7
+ jsw=jswp_hvt              capmod=3                  xti=3
+ n=1                       nqsmod=0                  xpart=1
+ cf=0                      tlev=1                    tlevc=1
+ paramchk=1                dlc=1.5e-8                cgdl=cglp_hvt
+ cgsl=cglp_hvt             wwc=-4e-2                 dwc=0
+ noia=3.0e+19              noib=4.0e+3               noic=1.0e-11
+ em=4.1e+7                 ef=1.059                  noimod=2
+ sa0=0.35e-6               sb0=0.35e-6               kvsat=-0.6
+ wlod=0.3e-6               tku0=0.03                 ku0=1.14e-7
+ llodku0=1                 wlodku0=1                 lku0=8.4e-8
+ wku0=3.0e-7               pku0=1.4e-14              kvth0=-2.3e-9
+ stk2=0e-9                 steta0=0                  lkvth0=1e-8
+ wkvth0=2.5e-7             pkvth0=4e-14              llodvth=1
+ wlodvth=1                 lodk2=1                   lodeta0=1
+ minr=1e-3                 imax=0.01                 imelt=0.01

     7: type=p
+ wmax=1.182e-06-(dxw_hvt+dwmis)     wmin=5.81e-07-(dxw_hvt+dwmis)      xw=1.5e-08+(dxw_hvt+dwmis)
+ lmax=2.1e-05              lmin=7.98e-07-(dxl_hvt+dlmis)     xl=-2e-08 +(dxl_hvt+dlmis)
+ tnom=25                   version=3.24              tox=toxp_hvt
+ toxm=toxp_hvt             xj=2.1e-07                nch=9.52e+17
+ lln=1                     lwn=1                     wln=1
+ wwn=-1                    lint=6.1e-09              ll=0
+ lw=0                      lwl=0                     wint=-1.045e-08
+ wl=0                      ww=0                      wwl=0
+ mobmod=1                  binunit=2                 dwg=0
+ dwb=0                     ldif=8e-08                hdif=hdifp_hvt
+ rsh=rshp_hvt              rd=0                      rs=0
+ rsc=0                     rdc=0                     vth0=-0.407913+dvthp_hvt
+ lvth0=-1.124826e-08+dlvthp_hvt                      wvth0=3.224367e-08+dwvthp_hvt
+ pvth0=-6.209743e-15+dpvthp_hvt                      k1=0.8900852
+ lk1=1.702986e-08          wk1=2.081185e-09          pk1=-2.074066e-14
+ k2=-0.1181389+dk2p_hvt    lk2=0+dlk2p_hvt           k3=0
+ dvt0=0                    dvt1=0                    dvt2=0
+ dvt0w=0                   dvt1w=0                   dvt2w=0
+ nlx=0                     w0=0                      k3b=0
+ vfb=-1.382158             vsat=98291.17             lvsat=0.01702982+dlvsatp_hvt
+ wvsat=0.002081182         pvsat=-2.074062e-08+dpvsatp_hvt
+ ua=9.668179e-11           lua=1.724929e-17          wua=7.812902e-17
+ pua=-3.111093e-23         ub=1.447571e-18           lub=-4.213561e-25
+ wub=-2.812418e-25         pub=3.111092e-31          uc=-5.864235e-11
+ luc=-1.637143e-17         wuc=2.6043e-17            puc=-1.037031e-23
+ rdsw=445                  prwb=0                    prwg=0
+ wr=1                      u0=9.0154740e-03          lu0=-7.6274600e-11
+ wu0=-1.0033043e-09        pu0=1.9392506e-16         a0=1.35712
+ la0=-3.541147e-07         wa0=-1.020625e-07         pa0=2.696279e-13
+ keta=0.009032703          lketa=3.953726e-08        wketa=2.601477e-09
+ pketa=-2.592577e-14       a1=0                      a2=1
+ ags=0.4916761             lags=8.295446e-08         b0=0
+ b1=0                      voff=-0.13                nfactor=1.116648
+ lnfactor=-1.659089e-07    cit=-0.0003390272         lcit=3.362071e-10
+ wcit=2.708359e-10         pcit=-2.074062e-16        cdsc=0
+ cdscb=0                   cdscd=0                   eta0=0.001185386
+ leta0=-7.586607e-10       weta0=-4.947747e-10       peta0=5.703671e-16
+ etab=7.327476e-05         letab=-6.746089e-10       wetab=-5.520778e-10
+ petab=5.185155e-16        dsub=0                    pclm=0.8054581
+ lpclm=-8.075976e-08       wpclm=1.35418e-07         ppclm=-1.037031e-13
+ pdiblc1=0.0005280577      lpdiblc1=-2.532526e-10    wpdiblc1=-1.458238e-10
+ ppdiblc1=2.074061e-16     pdiblc2=0.0005449258      lpdiblc2=-4.213562e-10
+ wpdiblc2=-1.562297e-10    ppdiblc2=3.111092e-16     pdiblcb=0
+ drout=0                   pscbe1=4.24e+08           pscbe2=1e-07
+ pvag=0                    delta=0.003841799         ldelta=7.856508e-10
+ wdelta=3.542243e-09       pdelta=2.074062e-15       alpha0=0
+ alpha1=0.0105319          beta0=11.7442             kt1=-0.2625465
+ lkt1=1.746875e-08         wkt1=4.166598e-08         pkt1=-4.148123e-14
+ kt2=0.01+dkt2p_hvt        at=10000                  ute=-0.9378054
+ lute=6.724136e-08         wute=5.416714e-08         pute=-4.14812e-14
+ ua1=2.339248e-09          lua1=-3.384018e-16        wua1=-2.812418e-16
+ pua1=3.111093e-22         ub1=-2.84e-18             uc1=-3.377e-10
+ kt1l=0                    prt=0                     cj=cjp_hvt
+ mj=0.4107588              pb=0.8465904              cjsw=cjswp_hvt
+ mjsw=0.1813912            pbsw=0.8465904            cjswg=cjswgp_hvt
+ mjswg=0.1813912           pbswg=0.8465904           tcj=0.0008024992
+ tcjsw=0.0004114948        tcjswg=0.0004114948       tpb=0.001514677
+ tpbsw=0.001514677         tpbswg=0.001514677        cgdo=cgop_hvt
+ cgso=cgop_hvt             cgbo=1e-13                js=1.49e-7
+ jsw=jswp_hvt              capmod=3                  xti=3
+ n=1                       nqsmod=0                  xpart=1
+ cf=0                      tlev=1                    tlevc=1
+ paramchk=1                dlc=1.5e-8                cgdl=cglp_hvt
+ cgsl=cglp_hvt             wwc=-4e-2                 dwc=0
+ noia=3.0e+19              noib=4.0e+3               noic=1.0e-11
+ em=4.1e+7                 ef=1.059                  noimod=2
+ sa0=0.35e-6               sb0=0.35e-6               kvsat=-0.6
+ wlod=0.3e-6               tku0=0.03                 ku0=1.14e-7
+ llodku0=1                 wlodku0=1                 lku0=8.4e-8
+ wku0=3.0e-7               pku0=1.4e-14              kvth0=-2.3e-9
+ stk2=0e-9                 steta0=0                  lkvth0=1e-8
+ wkvth0=2.5e-7             pkvth0=4e-14              llodvth=1
+ wlodvth=1                 lodk2=1                   lodeta0=1
+ minr=1e-3                 imax=0.01                 imelt=0.01

     8: type=p
+ wmax=1.182e-06-(dxw_hvt+dwmis)     wmin=5.81e-07-(dxw_hvt+dwmis)      xw=1.5e-08+(dxw_hvt+dwmis)
+ lmax=7.98e-07-(dxl_hvt+dlmis)     lmin=3.48e-07-(dxl_hvt+dlmis)     xl=-2e-08 +(dxl_hvt+dlmis)
+ tnom=25                   version=3.24              tox=toxp_hvt
+ toxm=toxp_hvt             xj=2.1e-07                nch=9.52e+17
+ lln=1                     lwn=1                     wln=1
+ wwn=-1                    lint=6.1e-09              ll=0
+ lw=0                      lwl=0                     wint=-1.045e-08
+ wl=0                      ww=0                      wwl=0
+ mobmod=1                  binunit=2                 dwg=0
+ dwb=0                     ldif=8e-08                hdif=hdifp_hvt
+ rsh=rshp_hvt              rd=0                      rs=0
+ rsc=0                     rdc=0                     vth0=-0.405961+dvthp_hvt
+ lvth0=-1.274352e-08+dlvthp_hvt                      wvth0=2.3526e-08+dwvthp_hvt
+ pvth0=4.662426e-16+dpvthp_hvt                       k1=0.9284307
+ lk1=-1.233512e-08         wk1=-5.658552e-08         pk1=2.418631e-14
+ k2=-0.1181389+dk2p_hvt    lk2=0+dlk2p_hvt           k3=0
+ dvt0=0                    dvt1=0                    dvt2=0
+ dvt0w=0                   dvt1w=0                   dvt2w=0
+ nlx=0                     w0=0                      k3b=0
+ vfb=-1.408157             vsat=134936               lvsat=-0.01103279+dlvsatp_hvt
+ wvsat=-0.04254855         pvsat=1.343683e-08+dpvsatp_hvt
+ ua=1.300115e-10           lua=-8.27459e-18          wua=2.434402e-17
+ pua=1.007763e-23          ub=5.40896e-19            lub=2.72976e-25
+ wub=3.882039e-25          pub=-2.015524e-31         uc=-6.810396e-11
+ luc=-9.125739e-18         wuc=-3.619985e-17         puc=3.729527e-23
+ rdsw=445                  prwb=0                    prwg=0
+ wr=1                      u0=7.0022830e-03          lu0=1.4654274e-09
+ wu0=4.6938490e-10         pu0=-9.3386050e-16        a0=0.3941817
+ la0=3.833038e-07          wa0=6.886773e-07          pa0=-3.359207e-13
+ keta=0.04928443           lketa=8.712486e-09        wketa=-2.423456e-08
+ pketa=-5.374733e-15       a1=0                      a2=1
+ ags=0.6711061             lags=-5.445305e-08        wags=-4.386536e-08
+ pags=3.359209e-14         b0=0                      b1=0
+ voff=-0.13                nfactor=0.7956616         lnfactor=7.990237e-08
+ wnfactor=-4.386531e-08    pnfactor=3.359205e-14     cit=-4.406873e-05
+ lcit=1.103279e-10         wcit=1.754614e-10         pcit=-1.343683e-16
+ cdsc=0                    cdscb=0                   cdscd=0
+ eta0=5.24966e-05          leta0=1.089061e-10        weta0=3.377549e-10
+ peta0=-6.718419e-17       etab=0.0002747443         letab=-8.288943e-10
+ wetab=2.127429e-10        petab=-6.71842e-17        dsub=0
+ pclm=0.6298222            lpclm=5.374216e-08        pdiblc1=-1.503546e-05
+ lpdiblc1=1.626482e-10     wpdiblc1=2.127427e-10     ppdiblc1=-6.718415e-17
+ pdiblc2=-0.0003598932     lpdiblc2=2.715543e-10     wpdiblc2=4.254855e-10
+ ppdiblc2=-1.343683e-16    pdiblcb=0                 drout=0
+ pscbe1=4.24e+08           pscbe2=1e-07              pvag=0
+ delta=-0.002242885        ldelta=5.445303e-09       wdelta=1.063714e-08
+ pdelta=-3.359208e-15      alpha0=0                  alpha1=0.0105319
+ beta0=11.7442             kt1=-0.232532             lkt1=-5.516388e-09
+ wkt1=-2.127425e-08        pkt1=6.71841e-15          kt2=0.01+dkt2p_hvt
+ at=10000                  ute=-0.8850889            lute=2.687108e-08
+ ua1=1.327577e-09          lua1=4.363352e-16         wua1=5.198002e-16
+ pua1=-3.023288e-22        ub1=-2.84e-18             uc1=-3.377e-10
+ kt1l=0                    prt=0                     cj=cjp_hvt
+ mj=0.4107588              pb=0.8465904              cjsw=cjswp_hvt
+ mjsw=0.1813912            pbsw=0.8465904            cjswg=cjswgp_hvt
+ mjswg=0.1813912           pbswg=0.8465904           tcj=0.0008024992
+ tcjsw=0.0004114948        tcjswg=0.0004114948       tpb=0.001514677
+ tpbsw=0.001514677         tpbswg=0.001514677        cgdo=cgop_hvt
+ cgso=cgop_hvt             cgbo=1e-13                js=1.49e-7
+ jsw=jswp_hvt              capmod=3                  xti=3
+ n=1                       nqsmod=0                  xpart=1
+ cf=0                      tlev=1                    tlevc=1
+ paramchk=1                dlc=1.5e-8                cgdl=cglp_hvt
+ cgsl=cglp_hvt             wwc=-4e-2                 dwc=0
+ noia=3.0e+19              noib=4.0e+3               noic=1.0e-11
+ em=4.1e+7                 ef=1.059                  noimod=2
+ sa0=0.35e-6               sb0=0.35e-6               kvsat=-0.6
+ wlod=0.3e-6               tku0=0.03                 ku0=1.14e-7
+ llodku0=1                 wlodku0=1                 lku0=8.4e-8
+ wku0=3.0e-7               pku0=1.4e-14              kvth0=-2.3e-9
+ stk2=0e-9                 steta0=0                  lkvth0=1e-8
+ wkvth0=2.5e-7             pkvth0=4e-14              llodvth=1
+ wlodvth=1                 lodk2=1                   lodeta0=1
+ minr=1e-3                 imax=0.01                 imelt=0.01

     9: type=p
+ wmax=1.182e-06-(dxw_hvt+dwmis)     wmin=5.81e-07-(dxw_hvt+dwmis)      xw=1.5e-08+(dxw_hvt+dwmis)
+ lmax=3.48e-07-(dxl_hvt+dlmis)     lmin=1.3e-07              xl=-2e-08 +(dxl_hvt+dlmis)
+ tnom=25                   version=3.24              tox=toxp_hvt
+ toxm=toxp_hvt             xj=2.1e-07                nch=9.52e+17
+ lln=1                     lwn=1                     wln=1
+ wwn=-1                    lint=6.1e-09              ll=0
+ lw=0                      lwl=0                     wint=-1.045e-08
+ wl=0                      ww=0                      wwl=0
+ mobmod=1                  binunit=2                 dwg=0
+ dwb=0                     ldif=8e-08                hdif=hdifp_hvt
+ rsh=rshp_hvt              rd=0                      rs=0
+ rsc=0                     rdc=0                     vth0=-0.41142+dvthp_hvt
+ lvth0=-1.101951e-08+dlvthp_hvt                      wvth0=2.228054e-08+dwvthp_hvt
+ pvth0=8.595607e-16+dpvthp_hvt                       k1=0.9106643
+ lk1=-6.724489e-09         wk1=1.493296e-09          pk1=5.845015e-15
+ k2=-0.1181389+dk2p_hvt    lk2=0+dlk2p_hvt           k3=0
+ dvt0=0                    dvt1=0                    dvt2=0
+ dvt0w=0                   dvt1w=0                   dvt2w=0
+ nlx=0                     w0=0                      k3b=0
+ vfb=-1.35748              vsat=1.1547132e+05        lvsat=-4.8858420e-03+dlvsatp_hvt
+ wvsat=-1.0887419e-02      pvsat=3.4382460e-09+dpvsatp_hvt
+ ua=9.939732e-11           lua=1.393357e-18          wua=5.89773e-17
+ pua=-8.595616e-25         ub=1.121938e-18           lub=8.948288e-26
+ wub=-2.149714e-26         pub=-7.216879e-32         uc=-1.483367e-10
+ luc=1.621175e-17          wuc=1.202826e-16          puc=-1.212188e-23
+ rdsw=445                  prwb=0                    prwg=0
+ wr=1                      u0=1.0122625e-02          lu0=4.8002340e-10
+ wu0=-1.5070576e-09        pu0=-3.0969989e-16        a0=1.563239
+ la0=1.411547e-08          wa0=-3.205991e-07         pa0=-1.719123e-14
+ keta=0.1062237            lketa=-9.268915e-09       wketa=-7.010565e-08
+ pketa=9.111352e-15        a1=0                      a2=1
+ ags=0.6757392             lags=-5.591615e-08        wags=-7.358665e-08
+ pags=4.297807e-14         b0=0                      b1=0
+ voff=-0.1168212           lvoff=-4.16188e-09        wvoff=-5.443715e-09
+ pvoff=1.719124e-15        nfactor=0.8521468         lnfactor=6.206434e-08
+ wnfactor=8.972446e-08     pnfactor=-8.595607e-15    cit=0.0003946862
+ lcit=-2.823094e-11        wcit=-3.588983e-10        pcit=3.438246e-17
+ cdsc=0                    cdscb=0                   cdscd=0
+ eta0=-0.002506599         leta0=9.170683e-10        weta0=1.540376e-09
+ peta0=-4.469719e-16       etab=-0.001055157         letab=-4.089115e-10
+ wetab=5.44371e-10         petab=-1.719123e-16       dsub=0
+ pclm=0.8                  pdiblc1=0.0002822727      lpdiblc1=6.875828e-11
+ pdiblc2=0.0002822727      lpdiblc2=6.875828e-11     pdiblcb=0
+ drout=0                   pscbe1=4.24e+08           pscbe2=1e-07
+ pvag=0                    delta=0.02205943          ldelta=-2.22937e-09
+ wdelta=-4.354966e-09      pdelta=1.375298e-15       alpha0=0
+ alpha1=0.0105319          beta0=11.7442             kt1=-0.2630636
+ lkt1=4.125497e-09         kt2=0.01+dkt2p_hvt        at=10000
+ ute=-0.8                  ua1=2.884594e-09          lua1=-5.537045e-17
+ wua1=-4.919794e-16        pua1=1.719125e-23         ub1=-3.014182e-18
+ lub1=5.500661e-26         uc1=-3.377e-10            kt1l=0
+ prt=0                     cj=cjp_hvt                mj=0.4107588
+ pb=0.8465904              cjsw=cjswp_hvt            mjsw=0.1813912
+ pbsw=0.8465904            cjswg=cjswgp_hvt          mjswg=0.1813912
+ pbswg=0.8465904           tcj=0.0008024992          tcjsw=0.0004114948
+ tcjswg=0.0004114948       tpb=0.001514677           tpbsw=0.001514677
+ tpbswg=0.001514677        cgdo=cgop_hvt             cgso=cgop_hvt
+ cgbo=1e-13                js=1.49e-7                jsw=jswp_hvt
+ capmod=3                  xti=3                     n=1
+ nqsmod=0                  xpart=1                   cf=0
+ tlev=1                    tlevc=1                   paramchk=1
+ dlc=1.5e-8                cgdl=cglp_hvt             cgsl=cglp_hvt
+ wwc=-4e-2                 dwc=0                     noia=3.0e+19
+ noib=4.0e+3               noic=1.0e-11              em=4.1e+7
+ ef=1.059                  noimod=2                  sa0=0.35e-6
+ sb0=0.35e-6               kvsat=-0.6                wlod=0.3e-6
+ tku0=0.03                 ku0=1.14e-7               llodku0=1
+ wlodku0=1                 lku0=8.4e-8               wku0=3.0e-7
+ pku0=1.4e-14              kvth0=-2.3e-9             stk2=0e-9
+ steta0=0                  lkvth0=1e-8               wkvth0=2.5e-7
+ pkvth0=4e-14              llodvth=1                 wlodvth=1
+ lodk2=1                   lodeta0=1                 minr=1e-3
+ imax=0.01                 imelt=0.01

     10: type=p
+ wmax=5.81e-07-(dxw_hvt+dwmis)      wmin=1.5e-07              xw=1.5e-08+(dxw_hvt+dwmis)
+ lmax=2.1e-05              lmin=7.98e-07-(dxl_hvt+dlmis)     xl=-2e-08 +(dxl_hvt+dlmis)
+ tnom=25                   version=3.24              tox=toxp_hvt
+ toxm=toxp_hvt             xj=2.1e-07                nch=9.52e+17
+ lln=1                     lwn=1                     wln=1
+ wwn=-1                    lint=6.1e-09              ll=0
+ lw=0                      lwl=0                     wint=-1.045e-08
+ wl=0                      ww=0                      wwl=0
+ mobmod=1                  binunit=2                 dwg=0
+ dwb=0                     ldif=8e-08                hdif=hdifp_hvt
+ rsh=rshp_hvt              rd=0                      rs=0
+ rsc=0                     rdc=0                     vth0=-0.375248+dvthp_hvt
+ lvth0=-2.392662e-08+dlvthp_hvt                      wvth0=1.209231e-08+dwvthp_hvt
+ pvth0=1.61154e-15+dpvthp_hvt                        k1=0.9347655
+ lk1=-2.499447e-08         wk1=-2.548208e-08         pk1=5.184147e-15
+ k2=-0.1181389+dk2p_hvt    lk2=0+dlk2p_hvt           k3=0
+ dvt0=0                    dvt1=0                    dvt2=0
+ dvt0w=0                   dvt1w=0                   dvt2w=0
+ nlx=0                     w0=0                      k3b=0
+ vfb=-1.365562             vsat=102296               lvsat=-0.02288155+dlvsatp_hvt
+ wvsat=-0.0003894031       pvsat=3.880712e-09+dpvsatp_hvt
+ ua=2.469221e-10           lua=-4.834528e-17         wua=-1.455422e-17
+ pua=9.354366e-24          ub=1.141595e-18           lub=5.525548e-26
+ wub=-9.248508e-26         pub=1.708747e-32          uc=-4.472383e-12
+ luc=-4.233619e-17         wuc=-7.374459e-18         puc=5.647361e-24
+ rdsw=445                  prwb=0                    prwg=0
+ wr=1                      u0=7.2810140e-03          lu0=2.1923206e-10
+ wu0=6.6684360e-11         pu0=1.1626992e-17         a0=1.206865
+ la0=1.14877e-07           wa0=-9.370259e-09         pa0=-1.969305e-14
+ keta=0.01571156           lketa=2.304453e-09        wketa=-1.518709e-09
+ pketa=-2.956856e-15       a1=0                      a2=1
+ ags=0.48852               lags=1.144078e-07         wags=1.947016e-09
+ pags=-1.940356e-14        b0=0                      b1=0
+ voff=-0.1370225           lvoff=-3.333054e-09       wvoff=4.3322e-09
+ pvoff=2.05616e-15         nfactor=1.089425          lnfactor=-2.612076e-07
+ wnfactor=1.679348e-08     pnfactor=5.87897e-14      cit=0.0001796937
+ lcit=-6.102945e-11        wcit=-4.916306e-11        pcit=3.764907e-17
+ cdsc=0                    cdscb=0                   cdscd=0
+ eta0=0.0003036584         leta0=2.269384e-10        weta0=4.916307e-11
+ peta0=-3.764908e-17       etab=-0.000974723         letab=2.250611e-10
+ wetab=9.443209e-11        petab=-3.649103e-17       dsub=0
+ pclm=1.03444              lpclm=-3.432233e-07       wpclm=-5.841052e-09
+ ppclm=5.821068e-14        pdiblc1=0.0001784478      lpdiblc1=1.115919e-10
+ wpdiblc1=6.985056e-11     ppdiblc1=-1.766648e-17    pdiblc2=0.0001784478
+ lpdiblc2=1.115919e-10     wpdiblc2=6.985056e-11     ppdiblc2=-1.766648e-17
+ pdiblcb=0                 drout=0                   pscbe1=4.24e+08
+ pscbe2=1e-07              pvag=0                    delta=0.01077921
+ ldelta=3.23228e-09        wdelta=-7.374458e-10      pdelta=5.64736e-16
+ alpha0=0                  alpha1=0.0105319          beta0=11.7442
+ kt1=-0.1970967            lkt1=-6.559318e-08        wkt1=1.289945e-09
+ pkt1=9.75968e-15          kt2=0.01+dkt2p_hvt        at=10000
+ ute=-0.85                 ua1=1.803658e-09          lua1=2.269384e-16
+ wua1=4.916307e-17         pua1=-3.764907e-23        ub1=-2.84e-18
+ uc1=-3.377e-10            kt1l=0                    prt=0
+ cj=cjp_hvt                mj=0.4107588              pb=0.8465904
+ cjsw=cjswp_hvt            mjsw=0.1813912            pbsw=0.8465904
+ cjswg=cjswgp_hvt          mjswg=0.1813912           pbswg=0.8465904
+ tcj=0.0008024992          tcjsw=0.0004114948        tcjswg=0.0004114948
+ tpb=0.001514677           tpbsw=0.001514677         tpbswg=0.001514677
+ cgdo=cgop_hvt             cgso=cgop_hvt             cgbo=1e-13
+ js=1.49e-7                jsw=jswp_hvt              capmod=3
+ xti=3                     n=1                       nqsmod=0
+ xpart=1                   cf=0                      tlev=1
+ tlevc=1                   paramchk=1                dlc=1.5e-8
+ cgdl=cglp_hvt             cgsl=cglp_hvt             wwc=-4e-2
+ dwc=0                     noia=3.0e+19              noib=4.0e+3
+ noic=1.0e-11              em=4.1e+7                 ef=1.059
+ noimod=2                  sa0=0.35e-6               sb0=0.35e-6
+ kvsat=-0.6                wlod=0.3e-6               tku0=0.03
+ ku0=1.14e-7               llodku0=1                 wlodku0=1
+ lku0=8.4e-8               wku0=3.0e-7               pku0=1.4e-14
+ kvth0=-2.3e-9             stk2=0e-9                 steta0=0
+ lkvth0=1e-8               wkvth0=2.5e-7             pkvth0=4e-14
+ llodvth=1                 wlodvth=1                 lodk2=1
+ lodeta0=1                 minr=1e-3                 imax=0.01
+ imelt=0.01

     11: type=p
+ wmax=5.81e-07-(dxw_hvt+dwmis)      wmin=1.5e-07              xw=1.5e-08+(dxw_hvt+dwmis)
+ lmax=7.98e-07-(dxl_hvt+dlmis)     lmin=3.48e-07-(dxl_hvt+dlmis)     xl=-2e-08 +(dxl_hvt+dlmis)
+ tnom=25                   version=3.24              tox=toxp_hvt
+ toxm=toxp_hvt             xj=2.1e-07                nch=9.52e+17
+ lln=1                     lwn=1                     wln=1
+ wwn=-1                    lint=6.1e-09              ll=0
+ lw=0                      lwl=0                     wint=-1.045e-08
+ wl=0                      ww=0                      wwl=0
+ mobmod=1                  binunit=2                 dwg=0
+ dwb=0                     ldif=8e-08                hdif=hdifp_hvt
+ rsh=rshp_hvt              rd=0                      rs=0
+ rsc=0                     rdc=0                     vth0=-0.388207+dvthp_hvt
+ lvth0=-1.400271e-08+dlvthp_hvt                      wvth0=1.257351e-08+dwvthp_hvt
+ pvth0=1.243038e-15+dpvthp_hvt                       k1=0.8531106
+ lk1=3.753685e-08          wk1=-1.012054e-08         pk1=-6.579718e-15
+ k2=-0.1181389+dk2p_hvt    lk2=0+dlk2p_hvt           k3=0
+ dvt0=0                    dvt1=0                    dvt2=0
+ dvt0w=0                   dvt1w=0                   dvt2w=0
+ nlx=0                     w0=0                      k3b=0
+ vfb=-1.356224             vsat=53059.39             lvsat=0.01482385+dlvsatp_hvt
+ wvsat=0.007961128         pvsat=-2.514124e-09+dpvsatp_hvt
+ ua=1.612531e-10           lua=1.726005e-17          wua=5.071088e-18
+ pua=-5.674693e-24         ub=1.305062e-18           lub=-6.992761e-26
+ wub=-8.321029e-26         pub=9.984832e-33          uc=-1.612159e-10
+ luc=7.769796e-17          wuc=2.12409e-17           puc=-1.626628e-23
+ rdsw=445                  prwb=0                    prwg=0
+ wr=1                      u0=7.5930790e-03          lu0=-1.9746709e-11
+ wu0=1.0492341e-10         pu0=-1.7656481e-17        a0=1.695358
+ la0=-2.592106e-07         wa0=-1.140183e-07         pa0=6.044645e-14
+ keta=0.03657905           lketa=-1.367587e-08       wketa=-1.639662e-08
+ pketa=8.436646e-15        a1=0                      a2=1
+ ags=0.6351797             lags=2.095783e-09         wags=-2.170234e-08
+ pags=-1.29289e-15         b0=0                      b1=0
+ voff=-0.1434885           lvoff=1.618551e-09        wvoff=8.321028e-09
+ pvoff=-9.984839e-16       nfactor=0.5104729         lnfactor=1.821544e-07
+ wnfactor=1.320676e-07     pnfactor=-2.948722e-14    cit=0.0002990468
+ lcit=-1.5243e-10          wcit=-3.620661e-11        pcit=2.772702e-17
+ cdsc=0                    cdscb=0                   cdscd=0
+ eta0=0.0007173825         leta0=-8.989144e-11       weta0=-7.241322e-11
+ peta0=5.545404e-17        etab=-0.0009767285        letab=2.265968e-10
+ wetab=9.847764e-10        petab=-7.183167e-16       dsub=0
+ pclm=0.4362463            lpclm=1.148734e-07        wpclm=1.194169e-07
+ ppclm=-3.771186e-14       pdiblc1=0.0002007716      lpdiblc1=9.449633e-11
+ wpdiblc1=7.961129e-11     ppdiblc1=-2.514124e-17    pdiblc2=0.0002007716
+ lpdiblc2=9.449633e-11     wpdiblc2=7.961129e-11     ppdiblc2=-2.514124e-17
+ pdiblcb=0                 drout=0                   pscbe1=4.24e+08
+ pscbe2=1e-07              pvag=0                    delta=0.015
+ alpha0=0                  alpha1=0.0105319          beta0=11.7442
+ kt1=-0.2969292            lkt1=1.08586e-08          wkt1=1.845239e-08
+ pkt1=-3.383317e-15        kt2=0.01+dkt2p_hvt        at=10000
+ ute=-0.8850889            lute=2.687108e-08         ua1=2.199524e-09
+ lua1=-7.621501e-17        wua1=-1.81033e-17         pua1=1.386351e-23
+ ub1=-2.84e-18             uc1=-3.377e-10            kt1l=0
+ prt=0                     cj=cjp_hvt                mj=0.4107588
+ pb=0.8465904              cjsw=cjswp_hvt            mjsw=0.1813912
+ pbsw=0.8465904            cjswg=cjswgp_hvt          mjswg=0.1813912
+ pbswg=0.8465904           tcj=0.0008024992          tcjsw=0.0004114948
+ tcjswg=0.0004114948       tpb=0.001514677           tpbsw=0.001514677
+ tpbswg=0.001514677        cgdo=cgop_hvt             cgso=cgop_hvt
+ cgbo=1e-13                js=1.49e-7                jsw=jswp_hvt
+ capmod=3                  xti=3                     n=1
+ nqsmod=0                  xpart=1                   cf=0
+ tlev=1                    tlevc=1                   paramchk=1
+ dlc=1.5e-8                cgdl=cglp_hvt             cgsl=cglp_hvt
+ wwc=-4e-2                 dwc=0                     noia=3.0e+19
+ noib=4.0e+3               noic=1.0e-11              em=4.1e+7
+ ef=1.059                  noimod=2                  sa0=0.35e-6
+ sb0=0.35e-6               kvsat=-0.6                wlod=0.3e-6
+ tku0=0.03                 ku0=1.14e-7               llodku0=1
+ wlodku0=1                 lku0=8.4e-8               wku0=3.0e-7
+ pku0=1.4e-14              kvth0=-2.3e-9             stk2=0e-9
+ steta0=0                  lkvth0=1e-8               wkvth0=2.5e-7
+ pkvth0=4e-14              llodvth=1                 wlodvth=1
+ lodk2=1                   lodeta0=1                 minr=1e-3
+ imax=0.01                 imelt=0.01

     12: type=p
+ wmax=5.81e-07-(dxw_hvt+dwmis)      wmin=1.5e-07              xw=1.5e-08+(dxw_hvt+dwmis)
+ lmax=3.48e-07-(dxl_hvt+dlmis)     lmin=1.3e-07              xl=-2e-08 +(dxl_hvt+dlmis)
+ tnom=25                   version=3.24              tox=toxp_hvt
+ toxm=toxp_hvt             xj=2.1e-07                nch=9.52e+17
+ lln=1                     lwn=1                     wln=1
+ wwn=-1                    lint=6.1e-09              ll=0
+ lw=0                      lwl=0                     wint=-1.045e-08
+ wl=0                      ww=0                      wwl=0
+ mobmod=1                  binunit=2                 dwg=0
+ dwb=0                     ldif=8e-08                hdif=hdifp_hvt
+ rsh=rshp_hvt              rd=0                      rs=0
+ rsc=0                     rdc=0                     vth0=-0.400044+dvthp_hvt
+ lvth0=-1.026464e-08+dlvthp_hvt                      wvth0=1.526242e-08+dwvthp_hvt
+ pvth0=3.938814e-16+dpvthp_hvt                       k1=0.9519622
+ lk1=6.319521e-09          wk1=-2.398337e-08         pk1=-2.201835e-15
+ k2=-0.1181389+dk2p_hvt    lk2=0+dlk2p_hvt           k3=0
+ dvt0=0                    dvt1=0                    dvt2=0
+ dvt0w=0                   dvt1w=0                   dvt2w=0
+ nlx=0                     w0=0                      k3b=0
+ vfb=-1.268901             vsat=9.2228180e+04        lvsat=2.4543416e-03+dlvsatp_hvt
+ wvsat=3.4512780e-03       pvsat=-1.0899135e-09+dpvsatp_hvt
+ ua=2.250125e-10           lua=-2.875201e-18         wua=-1.851474e-17
+ pua=1.773712e-24          ub=1.290023e-18           lub=-6.517833e-26
+ wub=-1.25189e-25          pub=2.324172e-32          uc=1.122362e-10
+ luc=-8.658212e-18         wuc=-4.046487e-17         puc=3.220403e-24
+ rdsw=445                  prwb=0                    prwg=0
+ wr=1                      u0=7.6588670e-03          lu0=-4.0522820e-11
+ wu0=1.2834777e-11         pu0=1.1425112e-17         a0=0.9359921
+ la0=-1.940288e-08         wa0=6.634964e-08          pa0=3.486237e-15
+ keta=-0.03142821          lketa=7.800823e-09        wketa=1.481179e-08
+ pketa=-1.41897e-15        a1=0                      a2=1
+ ags=0.5957592             lags=1.454479e-08         wags=-2.424699e-08
+ pags=-4.892897e-16        b0=0                      b1=0
+ voff=-0.1355784           lvoff=-8.794412e-10       wvoff=6.127643e-09
+ pvoff=-3.058129e-16       nfactor=0.8661122         lnfactor=6.98435e-08
+ wnfactor=8.110923e-08     pnfactor=-1.339457e-14    cit=-0.0003485821
+ lcit=5.209121e-11         wcit=9.962397e-11         pcit=-1.516828e-17
+ cdsc=0                    cdscb=0                   cdscd=0
+ eta0=-4.253154e-05        leta0=1.500893e-10        weta0=2.029296e-11
+ peta0=2.617745e-17        etab=0.002828526          letab=-9.751029e-10
+ wetab=-1.851474e-09       petab=1.773712e-16        dsub=0
+ pclm=0.7792795            lpclm=6.543551e-09        wpclm=1.278251e-08
+ ppclm=-4.036717e-15       pdiblc1=0.0002201112      lpdiblc1=8.838893e-11
+ wpdiblc1=3.834752e-11     ppdiblc1=-1.211015e-17    pdiblc2=0.0002201112
+ lpdiblc2=8.838893e-11     wpdiblc2=3.834752e-11     ppdiblc2=-1.211015e-17
+ pdiblcb=0                 drout=0                   pscbe1=4.24e+08
+ pscbe2=1e-07              pvag=0                    delta=0.015
+ alpha0=0                  alpha1=0.0105319          beta0=11.7442
+ kt1=-0.2852153            lkt1=7.159327e-09         wkt1=1.366535e-08
+ pkt1=-1.87157e-15         kt2=0.01+dkt2p_hvt        at=10000
+ ute=-0.8                  ua1=2.068507e-09          lua1=-3.483998e-17
+ wua1=1.146448e-17         pua1=4.526004e-24         ub1=-3.097064e-18
+ lub1=8.118081e-26         wub1=5.113003e-26         pub1=-1.614686e-32
+ uc1=-3.377e-10            kt1l=0                    prt=0
+ cj=cjp_hvt                mj=0.4107588              pb=0.8465904
+ cjsw=cjswp_hvt            mjsw=0.1813912            pbsw=0.8465904
+ cjswg=cjswgp_hvt          mjswg=0.1813912           pbswg=0.8465904
+ tcj=0.0008024992          tcjsw=0.0004114948        tcjswg=0.0004114948
+ tpb=0.001514677           tpbsw=0.001514677         tpbswg=0.001514677
+ cgdo=cgop_hvt             cgso=cgop_hvt             cgbo=1e-13
+ js=1.49e-7                jsw=jswp_hvt              capmod=3
+ xti=3                     n=1                       nqsmod=0
+ xpart=1                   cf=0                      tlev=1
+ tlevc=1                   paramchk=1                dlc=1.5e-8
+ cgdl=cglp_hvt             cgsl=cglp_hvt             wwc=-4e-2
+ dwc=0                     noia=3.0e+19              noib=4.0e+3
+ noic=1.0e-11              em=4.1e+7                 ef=1.059
+ noimod=2                  sa0=0.35e-6               sb0=0.35e-6
+ kvsat=-0.6                wlod=0.3e-6               tku0=0.03
+ ku0=1.14e-7               llodku0=1                 wlodku0=1
+ lku0=8.4e-8               wku0=3.0e-7               pku0=1.4e-14
+ kvth0=-2.3e-9             stk2=0e-9                 steta0=0
+ lkvth0=1e-8               wkvth0=2.5e-7             pkvth0=4e-14
+ llodvth=1                 wlodvth=1                 lodk2=1
+ lodeta0=1                 minr=1e-3                 imax=0.01
+ imelt=0.01
//

     }
ends pch_hvt_mis
//

//
model nch_hvt bsim3v3  {
     1: type=n
+ lmin=8e-07-dxl_hvt        lmax=2.1e-05              wmin=9.985e-06-dxw_hvt
+ wmax=0.0009001            tnom=25                   version=3.24
+ tox=toxn_hvt              toxm=toxn_hvt             xj=1.9e-07
+ nch=1.81e+18              lln=1                     lwn=1
+ wln=1                     wwn=-1                    lint=2.5e-09
+ ll=0                      lw=0                      lwl=0
+ wint=1e-08                wl=0                      ww=0
+ wwl=0                     mobmod=1                  binunit=2
+ xl=-2e-08+dxl_hvt         xw=1.5e-08+dxw_hvt        dwg=0
+ dwb=0                     ldif=8e-08                hdif=hdifn_hvt
+ rsh=rshn_hvt              rd=0                      rs=0
+ rsc=0                     rdc=0                     vth0=0.4194089+dvthn_hvt
+ lvth0=4.579556e-08+dlvthn_hvt                       pvth0=0+dpvthn_hvt
+ k1=0.5080414              lk1=1.953662e-08          k2=-0.01284293+dk2n_hvt
+ lk2=-6.554226e-09+dlk2n_hvt                         k3=0
+ dvt0=0                    dvt1=0                    dvt2=0
+ dvt0w=0                   dvt1w=0                   dvt2w=0
+ nlx=0                     w0=0                      k3b=0
+ vfb=-1.012111             vsat=71084.24             pvsat=0+dpvsatn_hvt
+ lvsat=-0.0008402853+dlvsatn_hvt                     ua=3.206739e-10
+ lua=-6.722274e-18         ub=1.787957e-18           lub=4.033374e-26
+ uc=1.32e-10               rdsw=83.7                 prwb=0
+ prwg=0                    wr=1                      u0=0.0499
+ a0=1.687908               la0=-3.781284e-07         keta=-0.001
+ a1=0                      a2=0.99                   ags=0.480042
+ lags=1.990804e-07         b0=0                      b1=0
+ voff=-0.111               nfactor=0.5025515         lnfactor=1.740483e-07
+ cit=0                     cdsc=0                    cdscb=0
+ cdscd=0                   eta0=-2.214687e-05        leta0=1.218414e-09
+ etab=3.478285e-05         letab=-1.344457e-09       dsub=0
+ pclm=0.4880001            pdiblc1=0                 pdiblc2=0.001
+ pdiblcb=0                 drout=0                   pscbe1=1.458e+08
+ pscbe2=5e-08              pvag=0                    delta=0.01
+ alpha0=0                  alpha1=0.2388             beta0=8.6035
+ kt1=-0.1776848            lkt1=1.680571e-08         kt2=-0.02910761
+ lkt2=7.058397e-09         at=35000                  ute=-1.6
+ ua1=1.808424e-09          lua1=-8.402854e-17        ub1=-2.696663e-18
+ lub1=-3.125862e-25        uc1=-1.251399e-10         luc1=-6.344154e-17
+ kt1l=0                    prt=0                     cj=cjn_hvt
+ mj=0.4774564              pb=0.8578199              cjsw=cjswn_hvt
+ mjsw=0.2551013            pbsw=0.8578199            cjswg=cjswgn_hvt
+ mjswg=0.2551013           pbswg=0.8578199           tcj=0.0007251995
+ tcjsw=0.0003603971        tcjswg=0.0003603971       tpb=0.001168276
+ tpbsw=0.001168276         tpbswg=0.001168276        js=2.50e-6
+ jsw=jswn_hvt              cgdo=cgon_hvt             cgso=cgon_hvt
+ capmod=3                  nqsmod=0                  xpart=1
+ cf=0                      tlev=1                    tlevc=1
+ xti=3                     n=1                       dlc=1.8e-8
+ cgbo=0                    wvth0=0+dwvthn_hvt        cgdl=cgln_hvt
+ cgsl=cgln_hvt             wwc=-4.5e-2               dwc=0
+ noia=5.0e+19              noib=8.0e+4               noic=4.0e-13
+ em=4.1e+7                 ef=1.146                  noimod=2
+ sa0=0.35e-6               sb0=0.35e-6               kvsat=0.4
+ wlod=0.5e-6               tku0=0.03                 ku0=-0.58e-7
+ llodku0=1                 wlodku0=1                 lku0=2.0e-7
+ wku0=0.7e-6               pku0=-0.5e-13             kvth0=5.2e-9
+ stk2=2.5e-9               steta0=-1.1e-10           lkvth0=-1.0e-8
+ wkvth0=2.2e-6             pkvth0=-5e-14             llodvth=1.0
+ wlodvth=1                 lodk2=1                   lodeta0=2
+ minr=1e-3                 imax=0.01                 imelt=0.01

     2: type=n
+ lmin=3.5e-07-dxl_hvt      lmax=8e-07-dxl_hvt        wmin=9.985e-06-dxw_hvt
+ wmax=0.0009001            tnom=25                   version=3.24
+ tox=toxn_hvt              toxm=toxn_hvt             xj=1.9e-07
+ nch=1.81e+18              lln=1                     lwn=1
+ wln=1                     wwn=-1                    lint=2.5e-09
+ ll=0                      lw=0                      lwl=0
+ wint=1e-08                wl=0                      ww=0
+ wwl=0                     mobmod=1                  binunit=2
+ xl=-2e-08+dxl_hvt         xw=1.5e-08+dxw_hvt        dwg=0
+ dwb=0                     ldif=8e-08                hdif=hdifn_hvt
+ rsh=rshn_hvt              rd=0                      rs=0
+ rsc=0                     rdc=0                     vth0=0.4632611+dvthn_hvt
+ lvth0=1.181013e-08+dlvthn_hvt                       pvth0=0+dpvthn_hvt
+ k1=0.4904583              lk1=3.316354e-08          k2=-0.01104444+dk2n_hvt
+ lk2=-7.948056e-09+dlk2n_hvt                         k3=0
+ dvt0=0                    dvt1=0                    dvt2=0
+ dvt0w=0                   dvt1w=0                   dvt2w=0
+ nlx=0                     w0=0                      k3b=0
+ vfb=-1.049257             vsat=70722.22             pvsat=0+dpvsatn_hvt
+ lvsat=-0.0005597223+dlvsatn_hvt                     ua=3.697778e-10
+ lua=-4.477778e-17         ub=1.84e-18               uc=9.733332e-11
+ luc=2.686667e-17          rdsw=83.7                 prwb=0
+ prwg=0                    wr=1                      u0=0.0499
+ a0=1.344445               la0=-1.119445e-07         keta=-0.001
+ a1=0                      a2=0.99                   ags=0.5469177
+ lags=1.472517e-07         b0=0                      b1=0
+ voff=-0.1153333           lvoff=3.358336e-09        nfactor=0.6622239
+ lnfactor=5.030223e-08     cit=0                     cdsc=0
+ cdscb=0                   cdscd=0                   eta0=0.0008494442
+ leta0=5.429307e-10        etab=-0.001801111         letab=7.836113e-11
+ dsub=0                    pclm=0.449                lpclm=3.0225e-08
+ pdiblc1=0                 pdiblc2=0.001             pdiblcb=0
+ drout=0                   pscbe1=1.458e+08          pscbe2=5e-08
+ pvag=0                    delta=0.01                alpha0=0
+ alpha1=0.2388             beta0=8.6035              kt1=-0.1531111
+ lkt1=-2.238885e-09        kt2=-0.0239               lkt2=3.022501e-09
+ at=35000                  ute=-1.6                  ua1=1.858889e-09
+ lua1=-1.231389e-16        ub1=-3.032833e-18         lub1=-5.205424e-26
+ uc1=-1.766666e-10         luc1=-2.350834e-17        kt1l=0
+ prt=0                     cj=cjn_hvt                mj=0.4774564
+ pb=0.8578199              cjsw=cjswn_hvt            mjsw=0.2551013
+ pbsw=0.8578199            cjswg=cjswgn_hvt          mjswg=0.2551013
+ pbswg=0.8578199           tcj=0.0007251995          tcjsw=0.0003603971
+ tcjswg=0.0003603971       tpb=0.001168276           tpbsw=0.001168276
+ tpbswg=0.001168276        js=2.50e-6                jsw=jswn_hvt
+ cgdo=cgon_hvt             cgso=cgon_hvt             capmod=3
+ nqsmod=0                  xpart=1                   cf=0
+ tlev=1                    tlevc=1                   xti=3
+ n=1                       dlc=1.8e-8                cgbo=0
+ wvth0=0+dwvthn_hvt        cgdl=cgln_hvt             cgsl=cgln_hvt
+ wwc=-4.5e-2               dwc=0                     noia=5.0e+19
+ noib=8.0e+4               noic=4.0e-13              em=4.1e+7
+ ef=1.146                  noimod=2                  sa0=0.35e-6
+ sb0=0.35e-6               kvsat=0.4                 wlod=0.5e-6
+ tku0=0.03                 ku0=-0.58e-7              llodku0=1
+ wlodku0=1                 lku0=2.0e-7               wku0=0.7e-6
+ pku0=-0.5e-13             kvth0=5.2e-9              stk2=2.5e-9
+ steta0=-1.1e-10           lkvth0=-1.0e-8            wkvth0=2.2e-6
+ pkvth0=-5e-14             llodvth=1.0               wlodvth=1
+ lodk2=1                   lodeta0=2                 minr=1e-3
+ imax=0.01                 imelt=0.01

     3: type=n
+ lmin=1.3e-07              lmax=3.5e-07-dxl_hvt      wmin=9.985e-06-dxw_hvt
+ wmax=0.0009001            tnom=25                   version=3.24
+ tox=toxn_hvt              toxm=toxn_hvt             xj=1.9e-07
+ nch=1.81e+18              lln=1                     lwn=1
+ wln=1                     wwn=-1                    lint=2.5e-09
+ ll=0                      lw=0                      lwl=0
+ wint=1e-08                wl=0                      ww=0
+ wwl=0                     mobmod=1                  binunit=2
+ xl=-2e-08+dxl_hvt         xw=1.5e-08+dxw_hvt        dwg=0
+ dwb=0                     ldif=8e-08                hdif=hdifn_hvt
+ rsh=rshn_hvt              rd=0                      rs=0
+ rsc=0                     rdc=0                     vth0=0.4850909+dvthn_hvt
+ lvth0=4.715451e-09+dlvthn_hvt                       pvth0=0+dpvthn_hvt
+ k1=0.5119601              lk1=2.617544e-08          k2=-0.008844323+dk2n_hvt
+ lk2=-8.663094e-09+dlk2n_hvt                         k3=0
+ dvt0=0                    dvt1=0                    dvt2=0
+ dvt0w=0                   dvt1w=0                   dvt2w=0
+ nlx=0                     w0=0                      k3b=0
+ vfb=-1.184747             vsat=62318.18             pvsat=0+dpvsatn_hvt
+ lvsat=0.002171591+dlvsatn_hvt                       ua=2.463182e-10
+ lua=-4.653409e-18         ub=2.030623e-18           lub=-6.195237e-26
+ uc=1.440757e-10           luc=1.16754e-17           rdsw=83.7
+ prwb=0                    prwg=0                    wr=1
+ u0=0.04982841             lu0=2.326752e-11          a0=1
+ keta=-0.001               a1=0                      a2=0.99
+ ags=1                     b0=0                      b1=0
+ voff=-0.1064461           lvoff=4.699934e-10        nfactor=0.5864773
+ lnfactor=7.491988e-08     cit=0                     cdsc=0
+ cdscb=0                   cdscd=0                   eta0=-0.0002059428
+ leta0=8.859315e-10        etab=0.000344318          letab=-6.189033e-10
+ dsub=0                    pclm=0.2279546            lpclm=1.020648e-07
+ pdiblc1=0                 pdiblc2=0.0004511364      lpdiblc2=1.783807e-10
+ pdiblcb=0                 drout=0                   pscbe1=1.500955e+08
+ lpscbe1=-1.396023         pscbe2=5e-08              pvag=0
+ delta=0.01                alpha0=0                  alpha1=0.2388
+ beta0=8.6035              kt1=-0.1391909            lkt1=-6.762956e-09
+ kt2=-0.01390795           lkt2=-2.249148e-10        at=35000
+ ute=-1.6                  ua1=1.48e-09              ub1=-3.296568e-18
+ lub1=3.365967e-26         uc1=-2.303864e-10         luc1=-6.049431e-18
+ kt1l=0                    prt=0                     cj=cjn_hvt
+ mj=0.4774564              pb=0.8578199              cjsw=cjswn_hvt
+ mjsw=0.2551013            pbsw=0.8578199            cjswg=cjswgn_hvt
+ mjswg=0.2551013           pbswg=0.8578199           tcj=0.0007251995
+ tcjsw=0.0003603971        tcjswg=0.0003603971       tpb=0.001168276
+ tpbsw=0.001168276         tpbswg=0.001168276        js=2.50e-6
+ jsw=jswn_hvt              cgdo=cgon_hvt             cgso=cgon_hvt
+ capmod=3                  nqsmod=0                  xpart=1
+ cf=0                      tlev=1                    tlevc=1
+ xti=3                     n=1                       dlc=1.8e-8
+ cgbo=0                    wvth0=0+dwvthn_hvt        cgdl=cgln_hvt
+ cgsl=cgln_hvt             wwc=-4.5e-2               dwc=0
+ noia=5.0e+19              noib=8.0e+4               noic=4.0e-13
+ em=4.1e+7                 ef=1.146                  noimod=2
+ sa0=0.35e-6               sb0=0.35e-6               kvsat=0.4
+ wlod=0.5e-6               tku0=0.03                 ku0=-0.58e-7
+ llodku0=1                 wlodku0=1                 lku0=2.0e-7
+ wku0=0.7e-6               pku0=-0.5e-13             kvth0=5.2e-9
+ stk2=2.5e-9               steta0=-1.1e-10           lkvth0=-1.0e-8
+ wkvth0=2.2e-6             pkvth0=-5e-14             llodvth=1.0
+ wlodvth=1                 lodk2=1                   lodeta0=2
+ minr=1e-3                 imax=0.01                 imelt=0.01

     4: type=n
+ lmin=8e-07-dxl_hvt        lmax=2.1e-05              wmin=1.185e-06-dxw_hvt
+ wmax=9.985e-06-dxw_hvt    tnom=25                   version=3.24
+ tox=toxn_hvt              toxm=toxn_hvt             xj=1.9e-07
+ nch=1.81e+18              lln=1                     lwn=1
+ wln=1                     wwn=-1                    lint=2.5e-09
+ ll=0                      lw=0                      lwl=0
+ wint=1e-08                wl=0                      ww=0
+ wwl=0                     mobmod=1                  binunit=2
+ xl=-2e-08+dxl_hvt         xw=1.5e-08+dxw_hvt        dwg=0
+ dwb=0                     ldif=8e-08                hdif=hdifn_hvt
+ rsh=rshn_hvt              rd=0                      rs=0
+ rsc=0                     rdc=0                     vth0=0.4196926+dvthn_hvt
+ lvth0=4.697865e-08+dlvthn_hvt                       wvth0=-2.830991e-09+dwvthn_hvt
+ pvth0=-1.180719e-14+dpvthn_hvt                      k1=0.5080408
+ lk1=1.954225e-08          pk1=-5.616695e-17         k2=-0.01284293+dk2n_hvt
+ lk2=-6.554226e-09+dlk2n_hvt                         k3=0
+ dvt0=0                    dvt1=0                    dvt2=0
+ dvt0w=0                   dvt1w=0                   dvt2w=0
+ nlx=0                     w0=0                      k3b=0
+ vfb=-1.012111             vsat=70559.58             lvsat=-0.0009570163+dlvsatn_hvt
+ wvsat=0.00523612          pvsat=1.164974e-09+dpvsatn_hvt
+ ua=2.777304e-10           lua=8.601493e-18          wua=4.285761e-16
+ pua=-1.529311e-22         ub=1.793262e-18           lub=3.10178e-26
+ wub=-5.294684e-26         pub=9.297308e-32          uc=1.253382e-10
+ luc=-7.60553e-19          wuc=6.648499e-17          puc=7.59033e-24
+ rdsw=83.7                 prwb=0                    prwg=0
+ wr=1                      u0=0.0499                 a0=1.731577
+ la0=-4.365388e-07         wa0=-4.358198e-07         pa0=5.82937e-13
+ keta=-0.001               a1=0                      a2=0.99
+ ags=0.4709562             lags=1.943172e-07         wags=9.067678e-08
+ pags=4.75368e-14          b0=0                      b1=0
+ voff=-0.1074912           lvoff=6.32106e-10         wvoff=-3.501795e-08
+ pvoff=-6.30841e-15        nfactor=0.5025512         lnfactor=1.740517e-07
+ pnfactor=-3.371357e-17    cit=0                     cdsc=0
+ cdscb=0                   cdscd=0                   eta0=-5.016758e-05
+ leta0=1.297286e-09        weta0=2.79646e-10         peta0=-7.871451e-16
+ etab=8.2784e-05           letab=-1.455441e-09       wetab=-4.790526e-10
+ petab=1.107625e-15        dsub=0                    pclm=0.4880001
+ pdiblc1=0                 pdiblc2=0.001             pdiblcb=0
+ drout=0                   pscbe1=1.458e+08          pscbe2=5e-08
+ pvag=0                    delta=0.01                alpha0=0
+ alpha1=0.2388             beta0=8.6035              kt1=-0.1797587
+ lkt1=2.090706e-08         wkt1=2.069743e-08         pkt1=-4.093155e-14
+ kt2=-0.02937345           lkt2=7.784022e-09         wkt2=2.653036e-09
+ pkt2=-7.241734e-15        at=35000                  ute=-1.6
+ ua1=1.777204e-09          lua1=-1.471263e-16        wua1=3.115741e-16
+ pua1=6.29716e-22          ub1=-2.634751e-18         lub1=-2.252633e-25
+ wub1=-6.178793e-25        pub1=-8.714819e-31        uc1=-1.438549e-10
+ luc1=-3.927284e-17        wuc1=1.867754e-16         puc1=-2.412037e-22
+ kt1l=0                    prt=0                     cj=cjn_hvt
+ mj=0.4774564              pb=0.8578199              cjsw=cjswn_hvt
+ mjsw=0.2551013            pbsw=0.8578199            cjswg=cjswgn_hvt
+ mjswg=0.2551013           pbswg=0.8578199           tcj=0.0007251995
+ tcjsw=0.0003603971        tcjswg=0.0003603971       tpb=0.001168276
+ tpbsw=0.001168276         tpbswg=0.001168276        js=2.50e-6
+ jsw=jswn_hvt              cgdo=cgon_hvt             cgso=cgon_hvt
+ capmod=3                  nqsmod=0                  xpart=1
+ cf=0                      tlev=1                    tlevc=1
+ xti=3                     n=1                       dlc=1.8e-8
+ cgbo=0                    cgdl=cgln_hvt             cgsl=cgln_hvt
+ wwc=-4.5e-2               dwc=0                     noia=5.0e+19
+ noib=8.0e+4               noic=4.0e-13              em=4.1e+7
+ ef=1.146                  noimod=2                  sa0=0.35e-6
+ sb0=0.35e-6               kvsat=0.4                 wlod=0.5e-6
+ tku0=0.03                 ku0=-0.58e-7              llodku0=1
+ wlodku0=1                 lku0=2.0e-7               wku0=0.7e-6
+ pku0=-0.5e-13             kvth0=5.2e-9              stk2=2.5e-9
+ steta0=-1.1e-10           lkvth0=-1.0e-8            wkvth0=2.2e-6
+ pkvth0=-5e-14             llodvth=1.0               wlodvth=1
+ lodk2=1                   lodeta0=2                 minr=1e-3
+ imax=0.01                 imelt=0.01

     5: type=n
+ lmin=3.5e-07-dxl_hvt      lmax=8e-07-dxl_hvt        wmin=1.185e-06-dxw_hvt
+ wmax=9.985e-06-dxw_hvt    tnom=25                   version=3.24
+ tox=toxn_hvt              toxm=toxn_hvt             xj=1.9e-07
+ nch=1.81e+18              lln=1                     lwn=1
+ wln=1                     wwn=-1                    lint=2.5e-09
+ ll=0                      lw=0                      lwl=0
+ wint=1e-08                wl=0                      ww=0
+ wwl=0                     mobmod=1                  binunit=2
+ xl=-2e-08+dxl_hvt         xw=1.5e-08+dxw_hvt        dwg=0
+ dwb=0                     ldif=8e-08                hdif=hdifn_hvt
+ rsh=rshn_hvt              rd=0                      rs=0
+ rsc=0                     rdc=0                     vth0=0.4655943+dvthn_hvt
+ lvth0=1.140484e-08+dlvthn_hvt                       wvth0=-2.328516e-08+dwvthn_hvt
+ pvth0=4.044794e-15+dpvthn_hvt                       k1=0.4996458
+ lk1=2.604846e-08          wk1=-9.169081e-08         pk1=7.100858e-14
+ k2=-0.01396853+dk2n_hvt   lk2=-5.681887e-09+dlk2n_hvt
+ wk2=2.918243e-08          pk2=-2.261638e-14         k3=0
+ dvt0=0                    dvt1=0                    dvt2=0
+ dvt0w=0                   dvt1w=0                   dvt2w=0
+ nlx=0                     w0=0                      k3b=0
+ vfb=-1.049257             vsat=71053.34             lvsat=-0.00133968+dlvsatn_hvt
+ wvsat=-0.00330453         pvsat=7.783979e-09+dpvsatn_hvt
+ ua=3.810057e-10           lua=-7.143684e-17         wua=-1.120543e-16
+ pua=2.660575e-22          ub=1.771491e-18           lub=4.789024e-26
+ wub=6.837212e-25          pub=-4.779446e-31         uc=9.143331e-11
+ luc=2.551571e-17          wuc=5.888202e-17          puc=1.348263e-23
+ rdsw=83.7                 prwb=0                    prwg=0
+ wr=1                      u0=0.04952231             lu0=2.927093e-10
+ wu0=3.769341e-09          pu0=-2.921239e-15         a0=1.289852
+ la0=-9.420179e-08         wa0=5.44837e-07           pa0=-1.77072e-13
+ keta=-0.001               a1=0                      a2=0.99
+ ags=0.520685              lags=1.557774e-07         wags=2.618029e-07
+ pags=-8.508595e-14        b0=0                      b1=0
+ voff=-0.1119895           lvoff=4.118255e-09        wvoff=-3.337204e-08
+ pvoff=-7.583989e-15       nfactor=0.6756814         lnfactor=3.987578e-08
+ wnfactor=-1.34306e-07     pnfactor=1.04056e-13      cit=0
+ cdsc=0                    cdscb=0                   cdscd=0
+ eta0=0.0008360352         leta0=6.10479e-10         weta0=1.338228e-10
+ peta0=-6.741321e-16       etab=-0.001957327         letab=1.256449e-10
+ wetab=1.559035e-09        petab=-4.718925e-16       dsub=0
+ pclm=0.449                lpclm=3.0225e-08          pdiblc1=0
+ pdiblc2=0.001             pdiblcb=0                 drout=0
+ pscbe1=1.458e+08          pscbe2=5e-08              pvag=0
+ delta=0.01                alpha0=0                  alpha1=0.2388
+ beta0=8.6035              kt1=-0.1456318            lkt1=-5.541247e-09
+ wkt1=-7.464336e-08        pkt1=3.295757e-14         kt2=-0.02229985
+ lkt2=2.301985e-09         wkt2=-1.596952e-08        pkt2=7.190742e-15
+ at=35000                  ute=-1.6                  ua1=1.682336e-09
+ lua1=-7.36035e-17         wua1=1.761999e-15         pua1=-4.943635e-22
+ ub1=-2.783193e-18         lub1=-1.102209e-25        wub1=-2.491408e-24
+ pub1=5.805028e-31         uc1=-1.7175e-10           luc1=-1.765416e-17
+ wuc1=-4.906832e-17        puc1=-5.842478e-23        kt1l=0
+ prt=0                     cj=cjn_hvt                mj=0.4774564
+ pb=0.8578199              cjsw=cjswn_hvt            mjsw=0.2551013
+ pbsw=0.8578199            cjswg=cjswgn_hvt          mjswg=0.2551013
+ pbswg=0.8578199           tcj=0.0007251995          tcjsw=0.0003603971
+ tcjswg=0.0003603971       tpb=0.001168276           tpbsw=0.001168276
+ tpbswg=0.001168276        js=2.50e-6                jsw=jswn_hvt
+ cgdo=cgon_hvt             cgso=cgon_hvt             capmod=3
+ nqsmod=0                  xpart=1                   cf=0
+ tlev=1                    tlevc=1                   xti=3
+ n=1                       dlc=1.8e-8                cgbo=0
+ cgdl=cgln_hvt             cgsl=cgln_hvt             wwc=-4.5e-2
+ dwc=0                     noia=5.0e+19              noib=8.0e+4
+ noic=4.0e-13              em=4.1e+7                 ef=1.146
+ noimod=2                  sa0=0.35e-6               sb0=0.35e-6
+ kvsat=0.4                 wlod=0.5e-6               tku0=0.03
+ ku0=-0.58e-7              llodku0=1                 wlodku0=1
+ lku0=2.0e-7               wku0=0.7e-6               pku0=-0.5e-13
+ kvth0=5.2e-9              stk2=2.5e-9               steta0=-1.1e-10
+ lkvth0=-1.0e-8            wkvth0=2.2e-6             pkvth0=-5e-14
+ llodvth=1.0               wlodvth=1                 lodk2=1
+ lodeta0=2                 minr=1e-3                 imax=0.01
+ imelt=0.01

     6: type=n
+ lmin=1.3e-07              lmax=3.5e-07-dxl_hvt      wmin=1.185e-06-dxw_hvt
+ wmax=9.985e-06-dxw_hvt    tnom=25                   version=3.24
+ tox=toxn_hvt              toxm=toxn_hvt             xj=1.9e-07
+ nch=1.81e+18              lln=1                     lwn=1
+ wln=1                     wwn=-1                    lint=2.5e-09
+ ll=0                      lw=0                      lwl=0
+ wint=1e-08                wl=0                      ww=0
+ wwl=0                     mobmod=1                  binunit=2
+ xl=-2e-08+dxl_hvt         xw=1.5e-08+dxw_hvt        dwg=0
+ dwb=0                     ldif=8e-08                hdif=hdifn_hvt
+ rsh=rshn_hvt              rd=0                      rs=0
+ rsc=0                     rdc=0                     vth0=0.4871306+dvthn_hvt
+ lvth0=4.405539e-09+dlvthn_hvt                       wvth0=-2.03563e-08+dwvthn_hvt
+ pvth0=3.092914e-15+dpvthn_hvt                       k1=0.4959911
+ lk1=2.723621e-08          wk1=1.593709e-07          pk1=-1.058647e-14
+ k2=-0.004696771+dk2n_hvt  lk2=-8.695208e-09+dlk2n_hvt
+ wk2=-4.139257e-08         pk2=3.204968e-16          k3=0
+ dvt0=0                    dvt1=0                    dvt2=0
+ dvt0w=0                   dvt1w=0                   dvt2w=0
+ nlx=0                     w0=0                      k3b=0
+ vfb=-1.184747             vsat=59262.07             lvsat=0.002492483+dlvsatn_hvt
+ wvsat=0.03050003          pvsat=-3.202503e-09+dpvsatn_hvt
+ ua=1.51327e-10            lua=3.208733e-18          wua=9.480123e-16
+ pua=-7.846421e-23         ub=2.142709e-18           lub=-7.275554e-26
+ wub=-1.118618e-24         pub=1.078156e-31          uc=1.251699e-10
+ luc=1.455133e-17          wuc=1.8868e-16            puc=-2.870171e-23
+ rdsw=83.7                 prwb=0                    prwg=0
+ wr=1                      u0=0.05060095             lu0=-5.784986e-11
+ wu0=-7.710014e-09         pu0=8.095516e-16          a0=1
+ keta=-0.001               a1=0                      a2=0.99
+ ags=1                     b0=0                      b1=0
+ voff=-0.1027899           lvoff=1.128396e-09        wvoff=-3.648937e-08
+ pvoff=-6.570858e-15       nfactor=0.5275993         lnfactor=8.800245e-08
+ wnfactor=5.87602e-07      pnfactor=-1.30564e-13     cit=0
+ cdsc=0                    cdscb=0                   cdscd=0
+ eta0=0.0002239055         leta0=8.094211e-10        weta0=-4.289885e-09
+ peta0=7.635731e-16        etab=0.0003995083         letab=-6.403265e-10
+ wetab=-5.508022e-10       petab=2.138045e-16        dsub=0
+ pclm=0.2328517            lpclm=1.004732e-07        wpclm=-4.887326e-08
+ ppclm=1.588381e-14        pdiblc1=0                 pdiblc2=0.0004511364
+ lpdiblc2=1.783807e-10     pdiblcb=0                 drout=0
+ pscbe1=1.509709e+08       lpscbe1=-1.680557         wpscbe1=-8.737407
+ ppscbe1=2.839658e-06      pscbe2=5e-08              pvag=0
+ delta=0.01                alpha0=0                  alpha1=0.2388
+ beta0=8.6035              kt1=-0.1397224            lkt1=-7.461813e-09
+ wkt1=5.304243e-09         pkt1=6.974598e-15         kt2=-0.01436798
+ lkt2=-2.758731e-10        wkt2=4.591032e-09         pkt2=5.085645e-16
+ at=35000                  ute=-1.6                  ua1=1.420025e-09
+ lua1=1.164762e-17         wua1=5.985526e-16         pua1=-1.162433e-22
+ ub1=-3.237806e-18         lub1=3.752835e-26         wub1=-5.864474e-25
+ pub1=-3.860943e-32        uc1=-2.068809e-10         luc1=-6.236624e-18
+ wuc1=-2.345852e-16        puc1=1.868195e-24         kt1l=0
+ prt=0                     cj=cjn_hvt                mj=0.4774564
+ pb=0.8578199              cjsw=cjswn_hvt            mjsw=0.2551013
+ pbsw=0.8578199            cjswg=cjswgn_hvt          mjswg=0.2551013
+ pbswg=0.8578199           tcj=0.0007251995          tcjsw=0.0003603971
+ tcjswg=0.0003603971       tpb=0.001168276           tpbsw=0.001168276
+ tpbswg=0.001168276        js=2.50e-6                jsw=jswn_hvt
+ cgdo=cgon_hvt             cgso=cgon_hvt             capmod=3
+ nqsmod=0                  xpart=1                   cf=0
+ tlev=1                    tlevc=1                   xti=3
+ n=1                       dlc=1.8e-8                cgbo=0
+ cgdl=cgln_hvt             cgsl=cgln_hvt             wwc=-4.5e-2
+ dwc=0                     noia=5.0e+19              noib=8.0e+4
+ noic=4.0e-13              em=4.1e+7                 ef=1.146
+ noimod=2                  sa0=0.35e-6               sb0=0.35e-6
+ kvsat=0.4                 wlod=0.5e-6               tku0=0.03
+ ku0=-0.58e-7              llodku0=1                 wlodku0=1
+ lku0=2.0e-7               wku0=0.7e-6               pku0=-0.5e-13
+ kvth0=5.2e-9              stk2=2.5e-9               steta0=-1.1e-10
+ lkvth0=-1.0e-8            wkvth0=2.2e-6             pkvth0=-5e-14
+ llodvth=1.0               wlodvth=1                 lodk2=1
+ lodeta0=2                 minr=1e-3                 imax=0.01
+ imelt=0.01

     7: type=n
+ lmin=8e-07-dxl_hvt        lmax=2.1e-05              wmin=5.85e-07-dxw_hvt
+ wmax=1.185e-06-dxw_hvt    tnom=25                   version=3.24
+ tox=toxn_hvt              toxm=toxn_hvt             xj=1.9e-07
+ nch=1.81e+18              lln=1                     lwn=1
+ wln=1                     wwn=-1                    lint=2.5e-09
+ ll=0                      lw=0                      lwl=0
+ wint=1e-08                wl=0                      ww=0
+ wwl=0                     mobmod=1                  binunit=2
+ xl=-2e-08+dxl_hvt         xw=1.5e-08+dxw_hvt        dwg=0
+ dwb=0                     ldif=8e-08                hdif=hdifn_hvt
+ rsh=rshn_hvt              rd=0                      rs=0
+ rsc=0                     rdc=0                     vth0=0.4547555+dvthn_hvt
+ lvth0=3.3561020e-08+dlvthn_hvt                      wvth0=-4.4205170e-08+dwvthn_hvt
+ pvth0=4.0256190e-15+dpvthn_hvt                      k1=0.5080456
+ lk1=1.949465e-08          k2=-0.01284293+dk2n_hvt   lk2=-6.554225e-09+dlk2n_hvt
+ k3=0                      dvt0=0                    dvt1=0
+ dvt2=0                    dvt0w=0                   dvt1w=0
+ dvt2w=0                   nlx=0                     w0=0
+ k3b=0                     vfb=-1.025562             vsat=7.1730010e+04
+ lvsat=4.4620270e-03+dlvsatn_hvt                     wvsat=3.8550080e-03
+ pvsat=-5.2294970e-09+dpvsatn_hvt                    ua=5.995803e-10
+ lua=-2.022287e-16         wua=4.879323e-17          pua=9.584857e-23
+ ub=1.774497e-18           lub=7.114451e-25          wub=-3.080448e-26
+ pub=-7.099311e-31         uc=1.51402e-10            luc=8.834131e-17
+ wuc=3.572962e-17          puc=-9.754987e-23         rdsw=83.7
+ prwb=0                    prwg=0                    wr=1
+ u0=5.4369150e-02          lu0=3.0541589e-09         wu0=-5.2735990e-09
+ pu0=-3.6039070e-15        a0=1.342988               la0=2.494976e-07
+ wa0=2.27154e-08           pa0=-2.26586e-13          keta=-0.001
+ a1=0                      a2=0.99                   ags=0.5159972
+ lags=2.761173e-07         wags=3.752843e-08         pags=-4.898727e-14
+ b0=0                      b1=0                      voff=-0.1318636
+ lvoff=-4.531733e-09       wvoff=-6.258501e-09       pvoff=-2.150806e-16
+ nfactor=0.5052331         lnfactor=1.472993e-07     wnfactor=-3.161303e-09
+ pnfactor=3.153414e-14     cit=0                     cdsc=0
+ cdscb=0                   cdscd=0                   eta0=0.0003123101
+ leta0=-8.86711e-10        weta0=-1.480774e-10       peta0=1.789972e-15
+ etab=-0.0005715185        letab=-6.914148e-10       wetab=2.930242e-10
+ petab=2.060744e-16        dsub=0                    pclm=0.507055
+ lpclm=-1.900727e-07       wpclm=-2.24848e-08        ppclm=2.242857e-13
+ pdiblc1=0                 pdiblc2=0.001             pdiblcb=0
+ drout=0                   pscbe1=1.458e+08          pscbe2=5e-08
+ pvag=0                    delta=0.01                alpha0=0
+ alpha1=0.2388             beta0=8.6035              kt1=-0.1220482
+ lkt1=-6.349197e-08        wkt1=-4.740091e-08        pkt1=5.865932e-14
+ kt2=-0.03401272           lkt2=3.23902e-09          wkt2=8.127375e-09
+ pkt2=-1.878632e-15        at=35000                  ute=-1.6
+ ua1=2.046924e-09          lua1=1.101334e-15         wua1=-6.695142e-18
+ pua1=-8.434673e-22        ub1=-3.214809e-18         lub1=-1.895488e-24
+ wub1=6.658947e-26         pub1=1.099383e-30         uc1=3.305924e-10
+ luc1=-6.010841e-16        wuc1=-3.730724e-16        puc1=4.217336e-22
+ kt1l=0                    prt=0                     cj=cjn_hvt
+ mj=0.4774564              pb=0.8578199              cjsw=cjswn_hvt
+ mjsw=0.2551013            pbsw=0.8578199            cjswg=cjswgn_hvt
+ mjswg=0.2551013           pbswg=0.8578199           tcj=0.0007251995
+ tcjsw=0.0003603971        tcjswg=0.0003603971       tpb=0.001168276
+ tpbsw=0.001168276         tpbswg=0.001168276        js=2.50e-6
+ jsw=jswn_hvt              cgdo=cgon_hvt             cgso=cgon_hvt
+ capmod=3                  nqsmod=0                  xpart=1
+ cf=0                      tlev=1                    tlevc=1
+ xti=3                     n=1                       dlc=1.8e-8
+ cgbo=0                    cgdl=cgln_hvt             cgsl=cgln_hvt
+ wwc=-4.5e-2               dwc=0                     noia=5.0e+19
+ noib=8.0e+4               noic=4.0e-13              em=4.1e+7
+ ef=1.146                  noimod=2                  sa0=0.35e-6
+ sb0=0.35e-6               kvsat=0.4                 wlod=0.5e-6
+ tku0=0.03                 ku0=-0.58e-7              llodku0=1
+ wlodku0=1                 lku0=2.0e-7               wku0=0.7e-6
+ pku0=-0.5e-13             kvth0=5.2e-9              stk2=2.5e-9
+ steta0=-1.1e-10           lkvth0=-1.0e-8            wkvth0=2.2e-6
+ pkvth0=-5e-14             llodvth=1.0               wlodvth=1
+ lodk2=1                   lodeta0=2                 minr=1e-3
+ imax=0.01                 imelt=0.01

     8: type=n
+ lmin=3.5e-07-dxl_hvt      lmax=8e-07-dxl_hvt        wmin=5.85e-07-dxw_hvt
+ wmax=1.185e-06-dxw_hvt    tnom=25                   version=3.24
+ tox=toxn_hvt              toxm=toxn_hvt             xj=1.9e-07
+ nch=1.81e+18              lln=1                     lwn=1
+ wln=1                     wwn=-1                    lint=2.5e-09
+ ll=0                      lw=0                      lwl=0
+ wint=1e-08                wl=0                      ww=0
+ wwl=0                     mobmod=1                  binunit=2
+ xl=-2e-08+dxl_hvt         xw=1.5e-08+dxw_hvt        dwg=0
+ dwb=0                     ldif=8e-08                hdif=hdifn_hvt
+ rsh=rshn_hvt              rd=0                      rs=0
+ rsc=0                     rdc=0                     vth0=0.4886952+dvthn_hvt
+ lvth0=7.2577100e-09+dlvthn_hvt                      wvth0=-5.0544250e-08+dwvthn_hvt
+ pvth0=8.9384100e-15+dpvthn_hvt                      k1=0.355792
+ lk1=1.374912e-07          wk1=7.805652e-08          pk1=-6.049379e-14
+ k2=0.02688538+dk2n_hvt    lk2=-3.734366e-08+dlk2n_hvt
+ wk2=-1.902518e-08         pk2=1.474452e-14          k3=0
+ dvt0=0                    dvt1=0                    dvt2=0
+ dvt0w=0                   dvt1w=0                   dvt2w=0
+ nlx=0                     w0=0                      k3b=0
+ vfb=-1.150501             vsat=6.7079570e+04        lvsat=8.0661210e-03+dlvsatn_hvt
+ wvsat=1.3845166e-03       pvsat=-3.3148660e-09+dpvsatn_hvt
+ ua=-2.526985e-10          lua=4.582872e-16          wua=6.357165e-16
+ pua=-3.590169e-22         ub=4.024672e-18           lub=-1.03244e-24
+ wub=-1.975032e-24         pub=7.968449e-31          uc=2.572987e-10
+ luc=6.271398e-18          wuc=-1.368392e-16         puc=3.619092e-23
+ rdsw=83.7                 prwb=0                    prwg=0
+ wr=1                      u0=6.8247790e-02          lu0=-7.7017780e-09
+ wu0=-1.8326716e-08        pu0=6.5122570e-15         a0=2.14514
+ la0=-3.721706e-07         wa0=-4.644036e-07         pa0=1.509312e-13
+ keta=-0.00123737          lketa=1.83962e-10         wketa=2.80097e-10
+ pketa=-2.170752e-16       a1=0                      a2=0.99
+ ags=0.7800335             lags=7.148913e-08         wags=-4.422832e-08
+ pags=1.43742e-14          b0=0                      b1=0
+ voff=-0.140331            lvoff=2.030486e-09        wvoff=7.097068e-11
+ pvoff=-5.120421e-15       nfactor=0.3440476         lnfactor=2.72218e-07
+ wnfactor=2.570219e-07     pnfactor=-1.701078e-13    cit=0
+ cdsc=0                    cdscb=0                   cdscd=0
+ eta0=-0.001556102         leta0=5.613081e-10        weta0=2.956545e-09
+ peta0=-6.161105e-16       etab=-0.001849815         letab=2.992648e-10
+ wetab=1.43217e-09         petab=-6.767639e-16       dsub=0
+ pclm=0.03011088           lpclm=1.79559e-07         wpclm=4.942892e-07
+ ppclm=-1.762141e-13       pdiblc1=0                 pdiblc2=0.001
+ pdiblcb=0                 drout=0                   pscbe1=1.458e+08
+ pscbe2=5e-08              pvag=0                    delta=0.01
+ alpha0=0                  alpha1=0.2388             beta0=8.6035
+ kt1=-0.2292319            lkt1=1.957536e-08         wkt1=2.40047e-08
+ pkt1=3.319973e-15         kt2=-0.0511389            lkt2=1.651181e-08
+ wkt2=1.806056e-08         pkt2=-9.576849e-15        at=35000
+ ute=-1.6                  ua1=4.536408e-09          lua1=-8.280158e-16
+ wua1=-1.605805e-15        pua1=3.958431e-22         ub1=-6.629293e-18
+ lub1=7.50737e-25          wub1=2.04699e-24          pub1=-4.354275e-31
+ uc1=-3.792778e-10         luc1=-5.093474e-17        wuc1=1.958145e-16
+ puc1=-1.91537e-23         kt1l=0                    prt=0
+ cj=cjn_hvt                mj=0.4774564              pb=0.8578199
+ cjsw=cjswn_hvt            mjsw=0.2551013            pbsw=0.8578199
+ cjswg=cjswgn_hvt          mjswg=0.2551013           pbswg=0.8578199
+ tcj=0.0007251995          tcjsw=0.0003603971        tcjswg=0.0003603971
+ tpb=0.001168276           tpbsw=0.001168276         tpbswg=0.001168276
+ js=2.50e-6                jsw=jswn_hvt              cgdo=cgon_hvt
+ cgso=cgon_hvt             capmod=3                  nqsmod=0
+ xpart=1                   cf=0                      tlev=1
+ tlevc=1                   xti=3                     n=1
+ dlc=1.8e-8                cgbo=0                    cgdl=cgln_hvt
+ cgsl=cgln_hvt             wwc=-4.5e-2               dwc=0
+ noia=5.0e+19              noib=8.0e+4               noic=4.0e-13
+ em=4.1e+7                 ef=1.146                  noimod=2
+ sa0=0.35e-6               sb0=0.35e-6               kvsat=0.4
+ wlod=0.5e-6               tku0=0.03                 ku0=-0.58e-7
+ llodku0=1                 wlodku0=1                 lku0=2.0e-7
+ wku0=0.7e-6               pku0=-0.5e-13             kvth0=5.2e-9
+ stk2=2.5e-9               steta0=-1.1e-10           lkvth0=-1.0e-8
+ wkvth0=2.2e-6             pkvth0=-5e-14             llodvth=1.0
+ wlodvth=1                 lodk2=1                   lodeta0=2
+ minr=1e-3                 imax=0.01                 imelt=0.01

     9: type=n
+ lmin=1.3e-07              lmax=3.5e-07-dxl_hvt      wmin=5.85e-07-dxw_hvt
+ wmax=1.185e-06-dxw_hvt    tnom=25                   version=3.24
+ tox=toxn_hvt              toxm=toxn_hvt             xj=1.9e-07
+ nch=1.81e+18              lln=1                     lwn=1
+ wln=1                     wwn=-1                    lint=2.5e-09
+ ll=0                      lw=0                      lwl=0
+ wint=1e-08                wl=0                      ww=0
+ wwl=0                     mobmod=1                  binunit=2
+ xl=-2e-08+dxl_hvt         xw=1.5e-08+dxw_hvt        dwg=0
+ dwb=0                     ldif=8e-08                hdif=hdifn_hvt
+ rsh=rshn_hvt              rd=0                      rs=0
+ rsc=0                     rdc=0                     vth0=0.4831316+dvthn_hvt
+ lvth0=9.0658830e-09+dlvthn_hvt                      wvth0=-1.5637474e-08+dwvthn_hvt
+ pvth0=-2.4062921e-15+dpvthn_hvt                     k1=0.734523
+ lk1=1.440358e-08          wk1=-1.220968e-07         pk1=4.556031e-15
+ k2=-0.06168143+dk2n_hvt   lk2=-8.559448e-09+dlk2n_hvt
+ wk2=2.584932e-08          pk2=1.603009e-16          k3=0
+ dvt0=0                    dvt1=0                    dvt2=0
+ dvt0w=0                   dvt1w=0                   dvt2w=0
+ nlx=0                     w0=0                      k3b=0
+ vfb=-1.220956             vsat=9.3792410e+04        lvsat=-6.1555290e-04+dlvsatn_hvt
+ wvsat=-1.0245780e-02      pvsat=4.6497980e-10+dpvsatn_hvt
+ ua=1.519674e-09           lua=-1.177337e-16         wua=-6.666368e-16
+ pua=6.42479e-23           ub=5.978106e-19           lub=8.128989e-26
+ wub=7.043617e-25          pub=-7.395798e-32         uc=3.072817e-10
+ luc=-9.973081e-18         wuc=-2.621199e-17         puc=2.370897e-25
+ rdsw=83.7                 prwb=0                    prwg=0
+ wr=1                      u0=4.0831570e-02          lu0=1.2084909e-09
+ wu0=3.8178640e-09         pu0=-6.8473080e-16        a0=1
+ keta=-0.0005144699        lketa=-5.098066e-11       wketa=-5.729256e-10
+ pketa=6.015719e-17        a1=0                      a2=0.99
+ ags=1                     b0=0                      b1=0
+ voff=-0.1175379           lvoff=-5.377271e-09       wvoff=-1.908672e-08
+ pvoff=1.10583e-15         nfactor=1.261301          lnfactor=-2.588921e-08
+ wnfactor=-2.781656e-07    pnfactor=3.828123e-15     cit=0
+ cdsc=0                    cdscb=0                   cdscd=0
+ eta0=-0.005551659         leta0=1.859864e-09        weta0=2.525281e-09
+ peta0=-4.759496e-16       etab=0.00130034           letab=-7.245357e-10
+ wetab=-1.613784e-09       petab=3.131713e-16        dsub=0
+ pclm=0.3692801            lpclm=6.932898e-08        wpclm=-2.098588e-07
+ ppclm=5.2634e-14          pdiblc1=0                 pdiblc2=0.0004511365
+ lpdiblc2=1.783807e-10     pdiblcb=0                 drout=0
+ pscbe1=1.277554e+08       lpscbe1=5.864484          wpscbe1=18.6569
+ ppscbe1=-6.063492e-06     pscbe2=5e-08              pvag=0
+ delta=0.01                alpha0=0                  alpha1=0.2388
+ beta0=8.6035              kt1=-0.1843427            lkt1=4.986384e-09
+ wkt1=5.795624e-08         pkt1=-7.714275e-15        kt2=-0.00127197
+ lkt2=3.050569e-10         wkt2=-1.086226e-08        pkt2=-1.76933e-16
+ at=35000                  ute=-1.6                  ua1=2.643485e-09
+ lua1=-2.128159e-16        wua1=-8.451304e-16        pua1=1.486237e-22
+ ub1=-4.620174e-18         lub1=9.777326e-26         wub1=1.044747e-24
+ pub1=-1.096984e-31        uc1=-5.078409e-10         luc1=-9.151705e-18
+ wuc1=1.205478e-16         puc1=5.307989e-24         kt1l=0
+ prt=0                     cj=cjn_hvt                mj=0.4774564
+ pb=0.8578199              cjsw=cjswn_hvt            mjsw=0.2551013
+ pbsw=0.8578199            cjswg=cjswgn_hvt          mjswg=0.2551013
+ pbswg=0.8578199           tcj=0.0007251995          tcjsw=0.0003603971
+ tcjswg=0.0003603971       tpb=0.001168276           tpbsw=0.001168276
+ tpbswg=0.001168276        js=2.50e-6                jsw=jswn_hvt
+ cgdo=cgon_hvt             cgso=cgon_hvt             capmod=3
+ nqsmod=0                  xpart=1                   cf=0
+ tlev=1                    tlevc=1                   xti=3
+ n=1                       dlc=1.8e-8                cgbo=0
+ cgdl=cgln_hvt             cgsl=cgln_hvt             wwc=-4.5e-2
+ dwc=0                     noia=5.0e+19              noib=8.0e+4
+ noic=4.0e-13              em=4.1e+7                 ef=1.146
+ noimod=2                  sa0=0.35e-6               sb0=0.35e-6
+ kvsat=0.4                 wlod=0.5e-6               tku0=0.03
+ ku0=-0.58e-7              llodku0=1                 wlodku0=1
+ lku0=2.0e-7               wku0=0.7e-6               pku0=-0.5e-13
+ kvth0=5.2e-9              stk2=2.5e-9               steta0=-1.1e-10
+ lkvth0=-1.0e-8            wkvth0=2.2e-6             pkvth0=-5e-14
+ llodvth=1.0               wlodvth=1                 lodk2=1
+ lodeta0=2                 minr=1e-3                 imax=0.01
+ imelt=0.01

     10: type=n
+ lmin=8e-07-dxl_hvt        lmax=2.1e-05              wmin=1.5e-07
+ wmax=5.85e-07-dxw_hvt     tnom=25                   version=3.24
+ tox=toxn_hvt              toxm=toxn_hvt             xj=1.9e-07
+ nch=1.81e+18              lln=1                     lwn=1
+ wln=1                     wwn=-1                    lint=2.5e-09
+ ll=0                      lw=0                      lwl=0
+ wint=1e-08                wl=0                      ww=0
+ wwl=0                     mobmod=1                  binunit=2
+ xl=-2e-08+dxl_hvt         xw=1.5e-08+dxw_hvt        dwg=0
+ dwb=0                     ldif=8e-08                hdif=hdifn_hvt
+ rsh=rshn_hvt              rd=0                      rs=0
+ rsc=0                     rdc=0                     vth0=0.4009124+dvthn_hvt
+ lvth0=4.2103880e-08+dlvthn_hvt                      wvth0=-1.2976179e-08+dwvthn_hvt
+ pvth0=-9.2924260e-16+dpvthn_hvt                     k1=0.4660896
+ lk1=7.059336e-08          wk1=2.433449e-08          pk1=-2.963724e-14
+ k2=0.01107495+dk2n_hvt    lk2=-2.468758e-08+dlk2n_hvt
+ wk2=-1.387237e-08         pk2=1.051735e-14          k3=0
+ dvt0=0                    dvt1=0                    dvt2=0
+ dvt0w=0                   dvt1w=0                   dvt2w=0
+ nlx=0                     w0=0                      k3b=0
+ vfb=-1.060561             vsat=7.6496510e+04        lvsat=-3.3211810e-03+dlvsatn_hvt
+ wvsat=1.0904408e-03       pvsat=-7.1523600e-10+dpvsatn_hvt
+ ua=7.307108e-10           lua=1.333225e-18          wua=-2.726247e-17
+ pua=-2.221737e-23         ub=1.733493e-18           lub=-5.730041e-25
+ wub=-7.022334e-27         pub=3.504938e-32          uc=2.164979e-10
+ luc=-8.299294e-17         wuc=-2.025969e-18         puc=1.823992e-24
+ rdsw=83.7                 prwb=0                    prwg=0
+ wr=1                      u0=4.5677360e-02          lu0=-5.1384870e-09
+ wu0=-2.3235994e-10        pu0=1.1478274e-15         a0=1.386046
+ la0=-1.800078e-07         wa0=-2.258359e-09         pa0=2.252711e-14
+ keta=-0.001               a1=0                      a2=0.99
+ ags=0.589658              lags=1.847151e-07         wags=-5.194869e-09
+ pags=4.026023e-15         b0=0                      b1=0
+ voff=-0.1539544           lvoff=-4.872073e-09       wvoff=6.554135e-09
+ pvoff=-1.768405e-17       nfactor=0.5623719         lnfactor=2.516505e-07
+ wnfactor=-3.630177e-08    pnfactor=-2.898959e-14    cit=0
+ cdsc=0                    cdscb=0                   cdscd=0
+ eta0=-0.001370972         leta0=2.834842e-09        weta0=8.282264e-10
+ peta0=-3.685295e-16       etab=0.0002131643         letab=-5.303135e-10
+ wetab=-1.620918e-10       petab=1.126356e-16        dsub=0
+ pclm=0.4625935            lpclm=2.534301e-07        wpclm=3.302853e-09
+ ppclm=-3.294593e-14       pdiblc1=0                 pdiblc2=0.001
+ pdiblcb=0                 drout=0                   pscbe1=1.458e+08
+ pscbe2=5e-08              pvag=0                    delta=0.01
+ alpha0=0                  alpha1=0.2388             beta0=8.6035
+ kt1=-0.1972071            lkt1=4.706345e-08         wkt1=-3.808792e-09
+ pkt1=-5.462826e-15        kt2=-0.02567298           lkt2=3.277114e-09
+ wkt2=3.290327e-09         pkt2=-1.900726e-15        at=35000
+ ute=-1.6                  ua1=2.13847e-09           lua1=-4.014696e-16
+ wua1=-5.979183e-17        pua1=2.815888e-23         ub1=-2.990002e-18
+ lub1=-2.039093e-25        wub1=-6.379861e-26        pub1=1.182674e-31
+ uc1=-2.92858e-10          luc1=1.362383e-16         wuc1=-1.147118e-17
+ puc1=-5.913372e-24        kt1l=0                    prt=0
+ cj=cjn_hvt                mj=0.4774564              pb=0.8578199
+ cjsw=cjswn_hvt            mjsw=0.2551013            pbsw=0.8578199
+ cjswg=cjswgn_hvt          mjswg=0.2551013           pbswg=0.8578199
+ tcj=0.0007251995          tcjsw=0.0003603971        tcjswg=0.0003603971
+ tpb=0.001168276           tpbsw=0.001168276         tpbswg=0.001168276
+ js=2.50e-6                jsw=jswn_hvt              cgdo=cgon_hvt
+ cgso=cgon_hvt             capmod=3                  nqsmod=0
+ xpart=1                   cf=0                      tlev=1
+ tlevc=1                   xti=3                     n=1
+ dlc=1.8e-8                cgbo=0                    cgdl=cgln_hvt
+ cgsl=cgln_hvt             wwc=-4.5e-2               dwc=0
+ noia=5.0e+19              noib=8.0e+4               noic=4.0e-13
+ em=4.1e+7                 ef=1.146                  noimod=2
+ sa0=0.35e-6               sb0=0.35e-6               kvsat=0.4
+ wlod=0.5e-6               tku0=0.03                 ku0=-0.58e-7
+ llodku0=1                 wlodku0=1                 lku0=2.0e-7
+ wku0=0.7e-6               pku0=-0.5e-13             kvth0=5.2e-9
+ stk2=2.5e-9               steta0=-1.1e-10           lkvth0=-1.0e-8
+ wkvth0=2.2e-6             pkvth0=-5e-14             llodvth=1.0
+ wlodvth=1                 lodk2=1                   lodeta0=2
+ minr=1e-3                 imax=0.01                 imelt=0.01

     11: type=n
+ lmin=3.5e-07-dxl_hvt      lmax=8e-07-dxl_hvt        wmin=1.5e-07
+ wmax=5.85e-07-dxw_hvt     tnom=25                   version=3.24
+ tox=toxn_hvt              toxm=toxn_hvt             xj=1.9e-07
+ nch=1.81e+18              lln=1                     lwn=1
+ wln=1                     wwn=-1                    lint=2.5e-09
+ ll=0                      lw=0                      lwl=0
+ wint=1e-08                wl=0                      ww=0
+ wwl=0                     mobmod=1                  binunit=2
+ xl=-2e-08+dxl_hvt         xw=1.5e-08+dxw_hvt        dwg=0
+ dwb=0                     ldif=8e-08                hdif=hdifn_hvt
+ rsh=rshn_hvt              rd=0                      rs=0
+ rsc=0                     rdc=0                     vth0=0.4186040+dvthn_hvt
+ lvth0=2.8392856e-08+dlvthn_hvt                      wvth0=-9.8913640e-09+dwvthn_hvt
+ pvth0=-3.3199740e-15+dpvthn_hvt                     k1=0.5094053
+ lk1=3.702373e-08          wk1=-1.103913e-08         pk1=-2.222689e-15
+ k2=-0.003018141+dk2n_hvt  lk2=-1.376544e-08+dlk2n_hvt
+ wk2=-1.681141e-09         pk2=1.069144e-15          k3=0
+ dvt0=0                    dvt1=0                    dvt2=0
+ dvt0w=0                   dvt1w=0                   dvt2w=0
+ nlx=0                     w0=0                      k3b=0
+ vfb=-1.079557             vsat=7.1702340e+04        lvsat=3.9429350e-04+dlvsatn_hvt
+ wvsat=-1.2966939e-03      pvsat=1.1347935e-09+dpvsatn_hvt
+ ua=1.057829e-09           lua=-2.52183e-16          wua=-1.243892e-16
+ pua=5.305582e-23          ub=3.91254e-19            lub=4.672314e-25
+ wub=1.323503e-25          pub=-7.296442e-32         uc=-3.44634e-13
+ luc=8.506001e-17          wuc=1.259399e-17          puc=-9.506475e-24
+ rdsw=83.7                 prwb=0                    prwg=0
+ wr=1                      u0=3.3025610e-02          lu0=4.6666220e-09
+ wu0=2.1021476e-09         pu0=-6.6141570e-16        a0=1.26484
+ la0=-8.607289e-08         wa0=4.617086e-08          pa0=-1.500553e-14
+ keta=-0.0006835063        lketa=-2.452827e-10       wketa=-4.11442e-11
+ pketa=3.188675e-17        a1=0                      a2=0.99
+ ags=0.7037777             lags=9.627224e-08         b0=0
+ b1=0                      voff=-0.1459491           lvoff=-1.107618e-08
+ wvoff=3.329452e-09        pvoff=2.481446e-15        nfactor=0.934571
+ lnfactor=-3.680383e-08    wnfactor=-8.548172e-08    pnfactor=9.124866e-15
+ cit=0                     cdsc=0                    cdscb=0
+ cdscd=0                   eta0=0.002577543          leta0=-2.25257e-10
+ weta0=5.590306e-10        peta0=-1.599027e-16       etab=0.000992593
+ letab=-1.134371e-09       wetab=-2.16426e-10        petab=1.547446e-16
+ dsub=0                    pclm=1.007519             lpclm=-1.68887e-07
+ wpclm=-7.260745e-08       ppclm=2.588456e-14        pdiblc1=0
+ pdiblc2=0.001             pdiblcb=0                 drout=0
+ pscbe1=1.458e+08          pscbe2=5e-08              pvag=0
+ delta=0.01                alpha0=0                  alpha1=0.2388
+ beta0=8.6035              kt1=-0.1635328            lkt1=2.096595e-08
+ wkt1=-1.410073e-08        pkt1=2.513426e-15         kt2=-0.02186173
+ lkt2=3.23395e-10          wkt2=1.079803e-09         pkt2=-1.875691e-16
+ at=35000                  ute=-1.6                  ua1=1.80405e-09
+ lua1=-1.422939e-16        wua1=-2.103753e-17        pua1=-1.875692e-24
+ ub1=-3.428371e-18         lub1=1.35826e-25          wub1=1.904549e-25
+ pub1=-7.877907e-32        uc1=1.50519e-11           luc1=-1.023919e-16
+ wuc1=-3.289675e-17        puc1=1.069145e-23         kt1l=0
+ prt=0                     cj=cjn_hvt                mj=0.4774564
+ pb=0.8578199              cjsw=cjswn_hvt            mjsw=0.2551013
+ pbsw=0.8578199            cjswg=cjswgn_hvt          mjswg=0.2551013
+ pbswg=0.8578199           tcj=0.0007251995          tcjsw=0.0003603971
+ tcjswg=0.0003603971       tpb=0.001168276           tpbsw=0.001168276
+ tpbswg=0.001168276        js=2.50e-6                jsw=jswn_hvt
+ cgdo=cgon_hvt             cgso=cgon_hvt             capmod=3
+ nqsmod=0                  xpart=1                   cf=0
+ tlev=1                    tlevc=1                   xti=3
+ n=1                       dlc=1.8e-8                cgbo=0
+ cgdl=cgln_hvt             cgsl=cgln_hvt             wwc=-4.5e-2
+ dwc=0                     noia=5.0e+19              noib=8.0e+4
+ noic=4.0e-13              em=4.1e+7                 ef=1.146
+ noimod=2                  sa0=0.35e-6               sb0=0.35e-6
+ kvsat=0.4                 wlod=0.5e-6               tku0=0.03
+ ku0=-0.58e-7              llodku0=1                 wlodku0=1
+ lku0=2.0e-7               wku0=0.7e-6               pku0=-0.5e-13
+ kvth0=5.2e-9              stk2=2.5e-9               steta0=-1.1e-10
+ lkvth0=-1.0e-8            wkvth0=2.2e-6             pkvth0=-5e-14
+ llodvth=1.0               wlodvth=1                 lodk2=1
+ lodeta0=2                 minr=1e-3                 imax=0.01
+ imelt=0.01

     12: type=n
+ lmin=1.3e-07              lmax=3.5e-07-dxl_hvt      wmin=1.5e-07
+ wmax=5.85e-07-dxw_hvt     tnom=25                   version=3.24
+ tox=toxn_hvt              toxm=toxn_hvt             xj=1.9e-07
+ nch=1.81e+18              lln=1                     lwn=1
+ wln=1                     wwn=-1                    lint=2.5e-09
+ ll=0                      lw=0                      lwl=0
+ wint=1e-08                wl=0                      ww=0
+ wwl=0                     mobmod=1                  binunit=2
+ xl=-2e-08+dxl_hvt         xw=1.5e-08+dxw_hvt        dwg=0
+ dwb=0                     ldif=8e-08                hdif=hdifn_hvt
+ rsh=rshn_hvt              rd=0                      rs=0
+ rsc=0                     rdc=0                     vth0=0.4878460+dvthn_hvt
+ lvth0=5.8892110e-09+dlvthn_hvt                      wvth0=-1.8371834e-08+dwvthn_hvt
+ pvth0=-5.6382190e-16+dpvthn_hvt                     k1=0.5387033
+ lk1=2.750188e-08          wk1=-8.521324e-09         pk1=-3.040978e-15
+ k2=-0.01611192+dk2n_hvt   lk2=-9.509958e-09+dlk2n_hvt
+ wk2=-5.809955e-10         pk2=7.115967e-16          k3=0
+ dvt0=0                    dvt1=0                    dvt2=0
+ dvt0w=0                   dvt1w=0                   dvt2w=0
+ nlx=0                     w0=0                      k3b=0
+ vfb=-1.079557             vsat=7.3378290e+04        lvsat=-1.5038745e-04+dlvsatn_hvt
+ wvsat=1.5944125e-03       pvsat=1.9518381e-10+dpvsatn_hvt
+ ua=2.698758e-10           lua=3.901649e-18          wua=5.824604e-17
+ pua=-6.300626e-24         ub=2.035075e-18           lub=-6.701054e-26
+ wub=-1.292518e-25         pub=1.205628e-32          uc=2.952092e-10
+ luc=-1.099499e-17         wuc=-1.920992e-17         puc=8.297976e-25
+ rdsw=83.7                 prwb=0                    prwg=0
+ wr=1                      u0=4.7351180e-02          lu0=1.0811668e-11
+ wu0=3.6489120e-11         pu0=9.9232600e-18         a0=1
+ keta=-0.001647374         lketa=6.797422e-11        wketa=8.415858e-11
+ pketa=-8.836651e-18       a1=0                      a2=0.99
+ ags=1                     b0=0                      b1=0
+ voff=-0.1683576           lvoff=-3.793393e-09       wvoff=1.038873e-08
+ pvoff=1.871806e-16        nfactor=0.9561155         lnfactor=-4.380577e-08
+ wnfactor=-1.011582e-07    pnfactor=1.421973e-14     cit=0
+ cdsc=0                    cdscb=0                   cdscd=0
+ eta0=-0.001962688         leta0=1.250318e-09        weta0=4.436779e-10
+ peta0=-1.224131e-16       etab=-0.002377304         letab=-3.915411e-11
+ wetab=5.192497e-10        petab=-8.435005e-17       dsub=0
+ pclm=-0.04214924          lpclm=1.722552e-07        wpclm=2.877025e-08
+ ppclm=-7.063204e-15       pdiblc1=0                 pdiblc2=0.0004511365
+ lpdiblc2=1.783807e-10     pdiblcb=0                 drout=0
+ pscbe1=1.608736e+08       lpscbe1=-4.898915         wpscbe1=-0.5516306
+ ppscbe1=1.792798e-07      pscbe2=5e-08              pvag=0
+ delta=0.01                alpha0=0                  alpha1=0.2388
+ beta0=8.6035              kt1=-0.06323737           lkt1=-1.163007e-08
+ wkt1=-1.228487e-08        pkt1=1.923271e-15         kt2=-0.01990152
+ lkt2=-3.136742e-10        wkt2=-5.712102e-11        pkt2=1.81931e-16
+ at=35000                  ute=-1.6                  ua1=1.171919e-09
+ lua1=6.314848e-17         wua1=8.377775e-18         pua1=-1.143567e-23
+ ub1=-2.605378e-18         lub1=-1.316467e-25        wub1=-1.23835e-25
+ pub1=2.336515e-32         uc1=-2.917273e-10         luc1=-2.688636e-18
+ wuc1=-4.798182e-18        puc1=1.559409e-24         kt1l=0
+ prt=0                     cj=cjn_hvt                mj=0.4774564
+ pb=0.8578199              cjsw=cjswn_hvt            mjsw=0.2551013
+ pbsw=0.8578199            cjswg=cjswgn_hvt          mjswg=0.2551013
+ pbswg=0.8578199           tcj=0.0007251995          tcjsw=0.0003603971
+ tcjswg=0.0003603971       tpb=0.001168276           tpbsw=0.001168276
+ tpbswg=0.001168276        js=2.50e-6                jsw=jswn_hvt
+ cgdo=cgon_hvt             cgso=cgon_hvt             capmod=3
+ nqsmod=0                  xpart=1                   cf=0
+ tlev=1                    tlevc=1                   xti=3
+ n=1                       dlc=1.8e-8                cgbo=0
+ cgdl=cgln_hvt             cgsl=cgln_hvt             wwc=-4.5e-2
+ dwc=0                     noia=5.0e+19              noib=8.0e+4
+ noic=4.0e-13              em=4.1e+7                 ef=1.146
+ noimod=2                  sa0=0.35e-6               sb0=0.35e-6
+ kvsat=0.4                 wlod=0.5e-6               tku0=0.03
+ ku0=-0.58e-7              llodku0=1                 wlodku0=1
+ lku0=2.0e-7               wku0=0.7e-6               pku0=-0.5e-13
+ kvth0=5.2e-9              stk2=2.5e-9               steta0=-1.1e-10
+ lkvth0=-1.0e-8            wkvth0=2.2e-6             pkvth0=-5e-14
+ llodvth=1.0               wlodvth=1                 lodk2=1
+ lodeta0=2                 minr=1e-3                 imax=0.01
+ imelt=0.01
//
// **************************************************************
//                                                              *
//               1.2V HIGH Vt PMOS DEVICES MODEL                *
//                                                              *
// **************************************************************
//
     }
model pch_hvt bsim3v3  {
     1: type=p
+ wmax=0.0009001            wmin=1.009e-05-dxw_hvt    xw=1.5e-08+dxw_hvt
+ lmax=2.1e-05              lmin=7.98e-07-dxl_hvt     xl=-2e-08+dxl_hvt
+ tnom=25                   version=3.24              tox=toxp_hvt
+ toxm=toxp_hvt             xj=2.1e-07                nch=9.52e+17
+ lln=1                     lwn=1                     wln=1
+ wwn=-1                    lint=6.1e-09              ll=0
+ lw=0                      lwl=0                     wint=-1.045e-08
+ wl=0                      ww=0                      wwl=0
+ mobmod=1                  binunit=2                 dwg=0
+ dwb=0                     ldif=8e-08                hdif=hdifp_hvt
+ rsh=rshp_hvt              rd=0                      rs=0
+ rsc=0                     rdc=0                     vth0=-0.411869+dvthp_hvt
+ lvth0=-9.124971e-09+dlvthp_hvt                      wvth0=0+dwvthp_hvt
+ pvth0=0+dpvthp_hvt        k1=0.921794               k2=-0.1181389+dk2p_hvt
+ lk2=0+dlk2p_hvt           k3=0                      dvt0=0
+ dvt1=0                    dvt2=0                    dvt0w=0
+ dvt1w=0                   dvt2w=0                   nlx=0
+ w0=0                      k3b=0                     vfb=-1.390157
+ vsat=101664.8             pvsat=0+dpvsatp_hvt       lvsat=-0.01659089+dlvsatp_hvt
+ ua=1.608324e-10           lua=-8.295446e-18         ub=1.2e-18
+ uc=-3.167163e-11          luc=9.124988e-18          rdsw=445
+ prwb=0                    prwg=0                    wr=1
+ u0=0.009108437            lu0=9.12499e-10           a0=1.245838
+ la0=4.147719e-08          keta=0.02383239           lketa=-8.295444e-09
+ a1=0                      a2=1                      ags=0.4916761
+ lags=8.295446e-08         b0=0                      b1=0
+ voff=-0.1308324           lvoff=8.295443e-09        nfactor=1.3
+ cit=0.0001                cdsc=0                    cdscb=0
+ cdscd=0                   eta0=0.0002833522         leta0=1.659089e-10
+ etab=-0.0004025028        letab=-2.488633e-11       dsub=0
+ pclm=1.024972             lpclm=-2.488634e-07       pdiblc1=0.0003
+ pdiblc2=0.0003083239      lpdiblc2=-8.295446e-11    pdiblcb=0
+ drout=0                   pscbe1=4.24e+08           pscbe2=1e-07
+ pvag=0                    delta=0.004167609         ldelta=8.295444e-09
+ alpha0=0                  alpha1=0.0105319          beta0=11.7442
+ kt1=-0.2716648            lkt1=1.65909e-08          kt2=-0.02249717+dkt2p_hvt
+ lkt2=2.488633e-08         at=10000                  ute=-0.9583239
+ lute=8.295442e-08         ua1=2.395838e-09          lua1=4.147723e-17
+ ub1=-2.84e-18             uc1=-3.377e-10            kt1l=0
+ prt=0                     cj=cjp_hvt                mj=0.4107588
+ pb=0.8465904              cjsw=cjswp_hvt            mjsw=0.1813912
+ pbsw=0.8465904            cjswg=cjswgp_hvt          mjswg=0.1813912
+ pbswg=0.8465904           tcj=0.0008024992          tcjsw=0.0004114948
+ tcjswg=0.0004114948       tpb=0.001514677           tpbsw=0.001514677
+ tpbswg=0.001514677        cgdo=cgop_hvt             cgso=cgop_hvt
+ cgbo=1e-13                js=1.49e-7                jsw=jswp_hvt
+ capmod=3                  xti=3                     n=1
+ nqsmod=0                  xpart=1                   cf=0
+ tlev=1                    tlevc=1                   paramchk=1
+ dlc=1.5e-8                cgdl=cglp_hvt             cgsl=cglp_hvt
+ wwc=-4e-2                 dwc=0                     noia=3.0e+19
+ noib=4.0e+3               noic=1.0e-11              em=4.1e+7
+ ef=1.059                  noimod=2                  sa0=0.35e-6
+ sb0=0.35e-6               kvsat=-0.6                wlod=0.3e-6
+ tku0=0.03                 ku0=1.14e-7               llodku0=1
+ wlodku0=1                 lku0=8.4e-8               wku0=3.0e-7
+ pku0=1.4e-14              kvth0=-2.3e-9             stk2=0e-9
+ steta0=0                  lkvth0=1e-8               wkvth0=2.5e-7
+ pkvth0=4e-14              llodvth=1                 wlodvth=1
+ lodk2=1                   lodeta0=1                 minr=1e-3
+ imax=0.01                 imelt=0.01

     2: type=p
+ wmax=0.0009001            wmin=1.009e-05-dxw_hvt    xw=1.5e-08+dxw_hvt
+ lmax=7.98e-07-dxl_hvt     lmin=3.48e-07-dxl_hvt     xl=-2e-08+dxl_hvt
+ tnom=25                   version=3.24              tox=toxp_hvt
+ toxm=toxp_hvt             xj=2.1e-07                nch=9.52e+17
+ lln=1                     lwn=1                     wln=1
+ wwn=-1                    lint=6.1e-09              ll=0
+ lw=0                      lwl=0                     wint=-1.045e-08
+ wl=0                      ww=0                      wwl=0
+ mobmod=1                  binunit=2                 dwg=0
+ dwb=0                     ldif=8e-08                hdif=hdifp_hvt
+ rsh=rshp_hvt              rd=0                      rs=0
+ rsc=0                     rdc=0                     vth0=-0.404837+dvthp_hvt
+ lvth0=-1.451038e-08+dlvthp_hvt                      wvth0=0+dwvthp_hvt
+ pvth0=0+dpvthp_hvt        k1=0.9288118              lk1=-5.374209e-09
+ k2=-0.1181389+dk2p_hvt    lk2=0+dlk2p_hvt           k3=0
+ dvt0=0                    dvt1=0                    dvt2=0
+ dvt0w=0                   dvt1w=0                   dvt2w=0
+ nlx=0                     w0=0                      k3b=0
+ vfb=-1.353496             vsat=65964.45             pvsat=0+dpvsatp_hvt
+ lvsat=0.01074843+dlvsatp_hvt                        ua=1.640356e-10
+ lua=-1.074843e-17         ub=1.2e-18                uc=-1.273823e-11
+ luc=-5.374214e-18         rdsw=445                  prwb=0
+ prwg=0                    wr=1                      u0=0.009808755
+ lu0=3.76195e-10           a0=1.335089               la0=-2.687105e-08
+ keta=-0.02208889          lketa=2.687107e-08        a1=0
+ a2=1                      ags=0.6                   b0=0
+ b1=0                      voff=-0.1129822           lvoff=-5.374213e-09
+ nfactor=1.229822          lnfactor=5.374216e-08     cit=0.0001
+ cdsc=0                    cdscb=0                   cdscd=0
+ eta0=0.0005               etab=0.0009089042         letab=-1.029162e-09
+ dsub=0                    pclm=0.6298222            lpclm=5.374216e-08
+ pdiblc1=0.0001596445      lpdiblc1=1.074843e-10     pdiblc2=-1.053331e-05
+ lpdiblc2=1.612264e-10     pdiblcb=0                 drout=0
+ pscbe1=4.24e+08           pscbe2=1e-07              pvag=0
+ delta=0.015               alpha0=0                  alpha1=0.0105319
+ beta0=11.7442             kt1=-0.25                 kt2=0.01+dkt2p_hvt
+ at=10000                  ute=-0.8850889            lute=2.687108e-08
+ ua1=2.414911e-09          lua1=2.687107e-17         ub1=-2.84e-18
+ uc1=-3.377e-10            kt1l=0                    prt=0
+ cj=cjp_hvt                mj=0.4107588              pb=0.8465904
+ cjsw=cjswp_hvt            mjsw=0.1813912            pbsw=0.8465904
+ cjswg=cjswgp_hvt          mjswg=0.1813912           pbswg=0.8465904
+ tcj=0.0008024992          tcjsw=0.0004114948        tcjswg=0.0004114948
+ tpb=0.001514677           tpbsw=0.001514677         tpbswg=0.001514677
+ cgdo=cgop_hvt             cgso=cgop_hvt             cgbo=1e-13
+ js=1.49e-7                jsw=jswp_hvt              capmod=3
+ xti=3                     n=1                       nqsmod=0
+ xpart=1                   cf=0                      tlev=1
+ tlevc=1                   paramchk=1                dlc=1.5e-8
+ cgdl=cglp_hvt             cgsl=cglp_hvt             wwc=-4e-2
+ dwc=0                     noia=3.0e+19              noib=4.0e+3
+ noic=1.0e-11              em=4.1e+7                 ef=1.059
+ noimod=2                  sa0=0.35e-6               sb0=0.35e-6
+ kvsat=-0.6                wlod=0.3e-6               tku0=0.03
+ ku0=1.14e-7               llodku0=1                 wlodku0=1
+ lku0=8.4e-8               wku0=3.0e-7               pku0=1.4e-14
+ kvth0=-2.3e-9             stk2=0e-9                 steta0=0
+ lkvth0=1e-8               wkvth0=2.5e-7             pkvth0=4e-14
+ llodvth=1                 wlodvth=1                 lodk2=1
+ lodeta0=1                 minr=1e-3                 imax=0.01
+ imelt=0.01

     3: type=p
+ wmax=0.0009001            wmin=1.009e-05-dxw_hvt    xw=1.5e-08+dxw_hvt
+ lmax=3.48e-07-dxl_hvt     lmin=1.3e-07              xl=-2e-08+dxl_hvt
+ tnom=25                   version=3.24              tox=toxp_hvt
+ toxm=toxp_hvt             xj=2.1e-07                nch=9.52e+17
+ lln=1                     lwn=1                     wln=1
+ wwn=-1                    lint=6.1e-09              ll=0
+ lw=0                      lwl=0                     wint=-1.045e-08
+ wl=0                      ww=0                      wwl=0
+ mobmod=1                  binunit=2                 dwg=0
+ dwb=0                     ldif=8e-08                hdif=hdifp_hvt
+ rsh=rshp_hvt              rd=0                      rs=0
+ rsc=0                     rdc=0                     vth0=-0.42248+dvthp_hvt
+ lvth0=-8.938579e-09+dlvthp_hvt                      wvth0=0+dwvthp_hvt
+ pvth0=0+dpvthp_hvt        k1=0.9074395              lk1=1.375164e-09
+ k2=-0.1181389+dk2p_hvt    lk2=0+dlk2p_hvt           k3=0
+ dvt0=0                    dvt1=0                    dvt2=0
+ dvt0w=0                   dvt1w=0                   dvt2w=0
+ nlx=0                     w0=0                      k3b=0
+ vfb=-1.298158             vsat=100000               pvsat=0+dpvsatp_hvt
+ lvsat=0+dlvsatp_hvt       ua=1.234682e-10           lua=2.062748e-18
+ ub=1.147833e-18           lub=1.647447e-26          uc=-4.957441e-11
+ luc=6.258653e-18          rdsw=445                  prwb=0
+ prwg=0                    wr=1                      u0=0.01024166
+ lu0=2.394853e-10          a0=1.247823               la0=6.87582e-10
+ keta=0.07253645           lketa=-3.011613e-09       a1=0
+ a2=1                      ags=0.6870909             lags=-2.750331e-08
+ b0=0                      b1=0                      voff=-0.1212909
+ lvoff=-2.750332e-09       nfactor=1.312909          lnfactor=2.750331e-08
+ cit=0.0001                cdsc=0                    cdscb=0
+ cdscd=0                   eta0=-0.0003709087        leta0=2.750331e-10
+ etab=-0.0006081827        letab=-5.500661e-10       dsub=0
+ pclm=0.8                  pdiblc1=0.0003693637      lpdiblc1=4.125496e-11
+ pdiblc2=0.0003693637      lpdiblc2=4.125496e-11     pdiblcb=0
+ drout=0                   pscbe1=4.24e+08           pscbe2=1e-07
+ pvag=0                    delta=0.01848364          ldelta=-1.100132e-09
+ alpha0=0                  alpha1=0.0105319          beta0=11.7442
+ kt1=-0.2412909            lkt1=-2.750332e-09        kt2=0.02306363+dkt2p_hvt
+ lkt2=-4.125496e-09        at=10000                  ute=-0.7651637
+ lute=-1.100132e-08        ua1=2.565318e-09          lua1=-2.062748e-17
+ ub1=-3.014182e-18         lub1=5.500661e-26         uc1=-3.377e-10
+ kt1l=0                    prt=0                     cj=cjp_hvt
+ mj=0.4107588              pb=0.8465904              cjsw=cjswp_hvt
+ mjsw=0.1813912            pbsw=0.8465904            cjswg=cjswgp_hvt
+ mjswg=0.1813912           pbswg=0.8465904           tcj=0.0008024992
+ tcjsw=0.0004114948        tcjswg=0.0004114948       tpb=0.001514677
+ tpbsw=0.001514677         tpbswg=0.001514677        cgdo=cgop_hvt
+ cgso=cgop_hvt             cgbo=1e-13                js=1.49e-7
+ jsw=jswp_hvt              capmod=3                  xti=3
+ n=1                       nqsmod=0                  xpart=1
+ cf=0                      tlev=1                    tlevc=1
+ paramchk=1                dlc=1.5e-8                cgdl=cglp_hvt
+ cgsl=cglp_hvt             wwc=-4e-2                 dwc=0
+ noia=3.0e+19              noib=4.0e+3               noic=1.0e-11
+ em=4.1e+7                 ef=1.059                  noimod=2
+ sa0=0.35e-6               sb0=0.35e-6               kvsat=-0.6
+ wlod=0.3e-6               tku0=0.03                 ku0=1.14e-7
+ llodku0=1                 wlodku0=1                 lku0=8.4e-8
+ wku0=3.0e-7               pku0=1.4e-14              kvth0=-2.3e-9
+ stk2=0e-9                 steta0=0                  lkvth0=1e-8
+ wkvth0=2.5e-7             pkvth0=4e-14              llodvth=1
+ wlodvth=1                 lodk2=1                   lodeta0=1
+ minr=1e-3                 imax=0.01                 imelt=0.01

     4: type=p
+ wmax=1.009e-05-dxw_hvt    wmin=1.182e-06-dxw_hvt    xw=1.5e-08+dxw_hvt
+ lmax=2.1e-05              lmin=7.98e-07-dxl_hvt     xl=-2e-08+dxl_hvt
+ tnom=25                   version=3.24              tox=toxp_hvt
+ toxm=toxp_hvt             xj=2.1e-07                nch=9.52e+17
+ lln=1                     lwn=1                     wln=1
+ wwn=-1                    lint=6.1e-09              ll=0
+ lw=0                      lwl=0                     wint=-1.045e-08
+ wl=0                      ww=0                      wwl=0
+ mobmod=1                  binunit=2                 dwg=0
+ dwb=0                     ldif=8e-08                hdif=hdifp_hvt
+ rsh=rshp_hvt              rd=0                      rs=0
+ rsc=0                     rdc=0                     vth0=-0.41603+dvthp_hvt
+ lvth0=-8.137578e-09+dlvthp_hvt                      wvth0=4.212857e-08+dwvthp_hvt
+ pvth0=-9.998241e-15+dpvthp_hvt                      k1=0.9258956
+ wk1=-4.15323e-08          k2=-0.1181389+dk2p_hvt    lk2=0+dlk2p_hvt
+ k3=0                      dvt0=0                    dvt1=0
+ dvt2=0                    dvt0w=0                   dvt1w=0
+ dvt2w=0                   nlx=0                     w0=0
+ k3b=0                     vfb=-1.382174             vsat=101892.4
+ lvsat=-0.01885919+dlvsatp_hvt                       wvsat=-0.002304744
+ pvsat=2.296861e-08+dpvsatp_hvt                      ua=1.608324e-10
+ lua=-8.295446e-18         ub=1.197724e-18           lub=2.268304e-26
+ wub=2.304745e-26          pub=-2.296861e-31         uc=-3.090775e-11
+ luc=1.377501e-17          wuc=-7.734977e-18         puc=-4.708565e-23
+ rdsw=445                  prwb=0                    prwg=0
+ wr=1                      u0=0.009233776            lu0=1.025914e-09
+ wu0=-1.269174e-09         pu0=-1.148431e-15         a0=1.242081
+ la0=6.529437e-08          wa0=3.80439e-08           pa0=-2.411703e-13
+ keta=0.02556376           lketa=-1.192473e-08       wketa=-1.75317e-08
+ pketa=3.674978e-14        a1=0                      a2=1
+ ags=0.4916761             lags=8.295447e-08         b0=0
+ b1=0                      voff=-0.1309462           lvoff=9.429596e-09
+ wvoff=1.152371e-09        pvoff=-1.14843e-14        nfactor=1.325068
+ lnfactor=2.268303e-08     wnfactor=-2.538347e-07    pnfactor=-2.296862e-13
+ cit=0.0001296201          lcit=-2.268304e-11        wcit=-2.999297e-10
+ pcit=2.296861e-16         cdsc=0                    cdscb=0
+ cdscd=0                   eta0=0.000215569          leta0=2.282873e-10
+ weta0=6.863655e-10        peta0=-6.316369e-16       etab=-0.0004055756
+ letab=5.735773e-12        wetab=3.111406e-11        petab=-3.100763e-16
+ dsub=0                    pclm=1.039782             lpclm=-2.602049e-07
+ wpclm=-1.499648e-07       ppclm=1.148431e-13        pdiblc1=0.00028519
+ lpdiblc1=1.134151e-11     wpdiblc1=1.499648e-10     ppdiblc1=-1.14843e-16
+ pdiblc2=0.0002935139      lpdiblc2=-7.161296e-11    wpdiblc2=1.499648e-10
+ ppdiblc2=-1.14843e-16     pdiblcb=0                 drout=0
+ pscbe1=4.24e+08           pscbe2=1e-07              pvag=0
+ delta=0.003814505         ldelta=9.089351e-09       wdelta=3.575484e-09
+ pdelta=-8.039015e-15      alpha0=0                  alpha1=0.0105319
+ beta0=11.7442             kt1=-0.2775888            lkt1=2.112751e-08
+ wkt1=5.998594e-08         pkt1=-4.593724e-14        kt2=-0.02694018+dkt2p_hvt
+ lkt2=2.828879e-08         wkt2=4.498945e-08         pkt2=-3.445292e-14
+ at=10000                  ute=-0.9672099            lute=8.975933e-08
+ wute=8.99789e-08          pute=-6.890585e-14        ua1=2.435147e-09
+ lua1=5.848951e-17         wua1=-3.980378e-16        pua1=-1.722646e-22
+ ub1=-2.84e-18             uc1=-3.377e-10            kt1l=0
+ prt=0                     cj=cjp_hvt                mj=0.4107588
+ pb=0.8465904              cjsw=cjswp_hvt            mjsw=0.1813912
+ pbsw=0.8465904            cjswg=cjswgp_hvt          mjswg=0.1813912
+ pbswg=0.8465904           tcj=0.0008024992          tcjsw=0.0004114948
+ tcjswg=0.0004114948       tpb=0.001514677           tpbsw=0.001514677
+ tpbswg=0.001514677        cgdo=cgop_hvt             cgso=cgop_hvt
+ cgbo=1e-13                js=1.49e-7                jsw=jswp_hvt
+ capmod=3                  xti=3                     n=1
+ nqsmod=0                  xpart=1                   cf=0
+ tlev=1                    tlevc=1                   paramchk=1
+ dlc=1.5e-8                cgdl=cglp_hvt             cgsl=cglp_hvt
+ wwc=-4e-2                 dwc=0                     noia=3.0e+19
+ noib=4.0e+3               noic=1.0e-11              em=4.1e+7
+ ef=1.059                  noimod=2                  sa0=0.35e-6
+ sb0=0.35e-6               kvsat=-0.6                wlod=0.3e-6
+ tku0=0.03                 ku0=1.14e-7               llodku0=1
+ wlodku0=1                 lku0=8.4e-8               wku0=3.0e-7
+ pku0=1.4e-14              kvth0=-2.3e-9             stk2=0e-9
+ steta0=0                  lkvth0=1e-8               wkvth0=2.5e-7
+ pkvth0=4e-14              llodvth=1                 wlodvth=1
+ lodk2=1                   lodeta0=1                 minr=1e-3
+ imax=0.01                 imelt=0.01

     5: type=p
+ wmax=1.009e-05-dxw_hvt    wmin=1.182e-06-dxw_hvt    xw=1.5e-08+dxw_hvt
+ lmax=7.98e-07-dxl_hvt     lmin=3.48e-07-dxl_hvt     xl=-2e-08+dxl_hvt
+ tnom=25                   version=3.24              tox=toxp_hvt
+ toxm=toxp_hvt             xj=2.1e-07                nch=9.52e+17
+ lln=1                     lwn=1                     wln=1
+ wwn=-1                    lint=6.1e-09              ll=0
+ lw=0                      lwl=0                     wint=-1.045e-08
+ wl=0                      ww=0                      wwl=0
+ mobmod=1                  binunit=2                 dwg=0
+ dwb=0                     ldif=8e-08                hdif=hdifp_hvt
+ rsh=rshp_hvt              rd=0                      rs=0
+ rsc=0                     rdc=0                     vth0=-0.407324+dvthp_hvt
+ lvth0=-1.480429e-08+dlvthp_hvt                      wvth0=2.518643e-08+dwvthp_hvt
+ pvth0=2.976056e-15+dpvthp_hvt                       k1=0.9352161
+ lk1=-7.137634e-09         wk1=-6.484946e-08         pk1=1.785628e-14
+ k2=-0.1181389+dk2p_hvt    lk2=0+dlk2p_hvt           k3=0
+ dvt0=0                    dvt1=0                    dvt2=0
+ dvt0w=0                   dvt1w=0                   dvt2w=0
+ nlx=0                     w0=0                      k3b=0
+ vfb=-1.3727               vsat=61311.11             lvsat=0.01221795+dlvsatp_hvt
+ wvsat=0.0471192           pvsat=-1.488024e-08+dpvsatp_hvt
+ ua=1.659545e-10           lua=-1.221795e-17         wua=-1.943099e-17
+ pua=1.488025e-23          ub=1.246533e-18           lub=-1.469522e-26
+ wub=-4.711919e-25         pub=1.488024e-31          uc=-1.104899e-12
+ luc=-9.048018e-18         wuc=-1.17798e-16          puc=3.720061e-23
+ rdsw=445                  prwb=0                    prwg=0
+ wr=1                      u0=0.01013976             lu0=3.321093e-10
+ wu0=-3.351752e-09         pu0=4.464078e-16          a0=1.386419
+ la0=-4.524006e-08         wa0=-5.197692e-07         pa0=1.86003e-13
+ keta=-0.02912649          lketa=2.995707e-08        wketa=7.12621e-08
+ pketa=-3.124851e-14       a1=0                      a2=1
+ ags=0.5952027             lags=3.673806e-09         wags=4.857746e-08
+ pags=-3.720062e-14        b0=0                      b1=0
+ voff=-0.1106556           lvoff=-6.108974e-09       wvoff=-2.35596e-08
+ pvoff=7.440121e-15        nfactor=1.294105          lnfactor=4.639456e-08
+ wnfactor=-6.509193e-07    pnfactor=7.440122e-14     cit=0.0001
+ cdsc=0                    cdscb=0                   cdscd=0
+ eta0=0.0005232667         leta0=-7.347612e-12       weta0=-2.355961e-10
+ peta0=7.440124e-17        etab=0.0009717243         letab=-1.049001e-09
+ wetab=-6.361092e-10       petab=2.008833e-16        dsub=0
+ pclm=0.6298222            lpclm=5.374216e-08        pdiblc1=0.0001596445
+ lpdiblc1=1.074843e-10     pdiblc2=-1.053331e-05     lpdiblc2=1.612264e-10
+ pdiblcb=0                 drout=0                   pscbe1=4.24e+08
+ pscbe2=1e-07              pvag=0                    delta=0.01616333
+ ldelta=-3.673805e-10      wdelta=-1.17798e-08       pdelta=3.720061e-15
+ alpha0=0                  alpha1=0.0105319          beta0=11.7442
+ kt1=-0.25                 kt2=0.01+dkt2p_hvt        at=10000
+ ute=-0.8850889            lute=2.687108e-08         ua1=2.505219e-09
+ lua1=4.82825e-18          wua1=-9.144498e-16        pua1=2.232037e-22
+ ub1=-2.84e-18             uc1=-3.377e-10            kt1l=0
+ prt=0                     cj=cjp_hvt                mj=0.4107588
+ pb=0.8465904              cjsw=cjswp_hvt            mjsw=0.1813912
+ pbsw=0.8465904            cjswg=cjswgp_hvt          mjswg=0.1813912
+ pbswg=0.8465904           tcj=0.0008024992          tcjsw=0.0004114948
+ tcjswg=0.0004114948       tpb=0.001514677           tpbsw=0.001514677
+ tpbswg=0.001514677        cgdo=cgop_hvt             cgso=cgop_hvt
+ cgbo=1e-13                js=1.49e-7                jsw=jswp_hvt
+ capmod=3                  xti=3                     n=1
+ nqsmod=0                  xpart=1                   cf=0
+ tlev=1                    tlevc=1                   paramchk=1
+ dlc=1.5e-8                cgdl=cglp_hvt             cgsl=cglp_hvt
+ wwc=-4e-2                 dwc=0                     noia=3.0e+19
+ noib=4.0e+3               noic=1.0e-11              em=4.1e+7
+ ef=1.059                  noimod=2                  sa0=0.35e-6
+ sb0=0.35e-6               kvsat=-0.6                wlod=0.3e-6
+ tku0=0.03                 ku0=1.14e-7               llodku0=1
+ wlodku0=1                 lku0=8.4e-8               wku0=3.0e-7
+ pku0=1.4e-14              kvth0=-2.3e-9             stk2=0e-9
+ steta0=0                  lkvth0=1e-8               wkvth0=2.5e-7
+ pkvth0=4e-14              llodvth=1                 wlodvth=1
+ lodk2=1                   lodeta0=1                 minr=1e-3
+ imax=0.01                 imelt=0.01

     6: type=p
+ wmax=1.009e-05-dxw_hvt    wmin=1.182e-06-dxw_hvt    xw=1.5e-08+dxw_hvt
+ lmax=3.48e-07-dxl_hvt     lmin=1.3e-07              xl=-2e-08+dxl_hvt
+ tnom=25                   version=3.24              tox=toxp_hvt
+ toxm=toxp_hvt             xj=2.1e-07                nch=9.52e+17
+ lln=1                     lwn=1                     wln=1
+ wwn=-1                    lint=6.1e-09              ll=0
+ lw=0                      lwl=0                     wint=-1.045e-08
+ wl=0                      ww=0                      wwl=0
+ mobmod=1                  binunit=2                 dwg=0
+ dwb=0                     ldif=8e-08                hdif=hdifp_hvt
+ rsh=rshp_hvt              rd=0                      rs=0
+ rsc=0                     rdc=0                     vth0=-0.426494+dvthp_hvt
+ lvth0=-8.750567e-09+dlvthp_hvt                      wvth0=4.063874e-08+dwvthp_hvt
+ pvth0=-1.903787e-15+dpvthp_hvt                      k1=0.9068309
+ lk1=1.826394e-09          wk1=6.161906e-09          pk1=-4.569105e-15
+ k2=-0.1181389+dk2p_hvt    lk2=0+dlk2p_hvt           k3=0
+ dvt0=0                    dvt1=0                    dvt2=0
+ dvt0w=0                   dvt1w=0                   dvt2w=0
+ nlx=0                     w0=0                      k3b=0
+ vfb=-1.284174             vsat=99106.97             lvsat=0.0002820186+dlvsatp_hvt
+ wvsat=0.009042723         pvsat=-2.855692e-09+dpvsatp_hvt
+ ua=1.201384e-10           lua=2.250761e-18          wua=3.371671e-17
+ pua=-1.903795e-24         ub=1.153786e-18           lub=1.459435e-26
+ wub=-6.028483e-26         pub=1.903795e-32          uc=-4.957441e-11
+ luc=6.258653e-18          rdsw=445                  prwb=0
+ prwg=0                    wr=1                      u0=0.01042711
+ lu0=2.413655e-10          wu0=-1.877888e-09         pu0=-1.903838e-17
+ a0=1.240689               la0=7.815882e-10          wa0=7.223473e-08
+ pa0=-9.518963e-16         keta=0.07580072           lketa=-3.178944e-09
+ wketa=-3.305357e-08       pketa=1.694377e-15        a1=0
+ a2=1                      ags=0.6969037             lags=-2.844338e-08
+ wags=-9.9363e-08          pags=9.518974e-15         b0=0
+ b1=0                      voff=-0.1212909           lvoff=-2.750332e-09
+ nfactor=1.365832          lnfactor=2.374307e-08     wnfactor=-5.358929e-07
+ pnfactor=3.807588e-14     cit=0.0001                cdsc=0
+ cdscb=0                   cdscd=0                   eta0=-0.0002518383
+ leta0=2.374306e-10        weta0=-1.205696e-09       peta0=3.807589e-16
+ etab=-0.000608182         letab=-5.500662e-10       dsub=0
+ pclm=0.8                  pdiblc1=0.0003812707      lpdiblc1=3.749471e-11
+ wpdiblc1=-1.205696e-10    ppdiblc1=3.80759e-17      pdiblc2=0.0003812707
+ lpdiblc2=3.749471e-11     wpdiblc2=-1.205696e-10    ppdiblc2=3.80759e-17
+ pdiblcb=0                 drout=0                   pscbe1=4.24e+08
+ pscbe2=1e-07              pvag=0                    delta=0.01848364
+ ldelta=-1.100132e-09      alpha0=0                  alpha1=0.0105319
+ beta0=11.7442             kt1=-0.2383141            lkt1=-3.690395e-09
+ wkt1=-3.014242e-08        pkt1=9.518974e-15         kt2=0.02484969+dkt2p_hvt
+ lkt2=-4.689534e-09        wkt2=-1.808544e-08        pkt2=5.711383e-15
+ at=10000                  ute=-0.7604008            lute=-1.250542e-08
+ wute=-4.822784e-08        pute=1.523035e-14         ua1=2.576896e-09
+ lua1=-1.78073e-17         wua1=-1.172345e-16        pua1=-2.855692e-23
+ ub1=-3.014182e-18         lub1=5.500661e-26         uc1=-3.377e-10
+ kt1l=0                    prt=0                     cj=cjp_hvt
+ mj=0.4107588              pb=0.8465904              cjsw=cjswp_hvt
+ mjsw=0.1813912            pbsw=0.8465904            cjswg=cjswgp_hvt
+ mjswg=0.1813912           pbswg=0.8465904           tcj=0.0008024992
+ tcjsw=0.0004114948        tcjswg=0.0004114948       tpb=0.001514677
+ tpbsw=0.001514677         tpbswg=0.001514677        cgdo=cgop_hvt
+ cgso=cgop_hvt             cgbo=1e-13                js=1.49e-7
+ jsw=jswp_hvt              capmod=3                  xti=3
+ n=1                       nqsmod=0                  xpart=1
+ cf=0                      tlev=1                    tlevc=1
+ paramchk=1                dlc=1.5e-8                cgdl=cglp_hvt
+ cgsl=cglp_hvt             wwc=-4e-2                 dwc=0
+ noia=3.0e+19              noib=4.0e+3               noic=1.0e-11
+ em=4.1e+7                 ef=1.059                  noimod=2
+ sa0=0.35e-6               sb0=0.35e-6               kvsat=-0.6
+ wlod=0.3e-6               tku0=0.03                 ku0=1.14e-7
+ llodku0=1                 wlodku0=1                 lku0=8.4e-8
+ wku0=3.0e-7               pku0=1.4e-14              kvth0=-2.3e-9
+ stk2=0e-9                 steta0=0                  lkvth0=1e-8
+ wkvth0=2.5e-7             pkvth0=4e-14              llodvth=1
+ wlodvth=1                 lodk2=1                   lodeta0=1
+ minr=1e-3                 imax=0.01                 imelt=0.01

     7: type=p
+ wmax=1.182e-06-dxw_hvt    wmin=5.81e-07-dxw_hvt     xw=1.5e-08+dxw_hvt
+ lmax=2.1e-05              lmin=7.98e-07-dxl_hvt     xl=-2e-08+dxl_hvt
+ tnom=25                   version=3.24              tox=toxp_hvt
+ toxm=toxp_hvt             xj=2.1e-07                nch=9.52e+17
+ lln=1                     lwn=1                     wln=1
+ wwn=-1                    lint=6.1e-09              ll=0
+ lw=0                      lwl=0                     wint=-1.045e-08
+ wl=0                      ww=0                      wwl=0
+ mobmod=1                  binunit=2                 dwg=0
+ dwb=0                     ldif=8e-08                hdif=hdifp_hvt
+ rsh=rshp_hvt              rd=0                      rs=0
+ rsc=0                     rdc=0                     vth0=-0.407913+dvthp_hvt
+ lvth0=-1.124826e-08+dlvthp_hvt                      wvth0=3.224367e-08+dwvthp_hvt
+ pvth0=-6.209743e-15+dpvthp_hvt                      k1=0.8900852
+ lk1=1.702986e-08          wk1=2.081185e-09          pk1=-2.074066e-14
+ k2=-0.1181389+dk2p_hvt    lk2=0+dlk2p_hvt           k3=0
+ dvt0=0                    dvt1=0                    dvt2=0
+ dvt0w=0                   dvt1w=0                   dvt2w=0
+ nlx=0                     w0=0                      k3b=0
+ vfb=-1.382158             vsat=98291.17             lvsat=0.01702982+dlvsatp_hvt
+ wvsat=0.002081182         pvsat=-2.074062e-08+dpvsatp_hvt
+ ua=9.668179e-11           lua=1.724929e-17          wua=7.812902e-17
+ pua=-3.111093e-23         ub=1.447571e-18           lub=-4.213561e-25
+ wub=-2.812418e-25         pub=3.111092e-31          uc=-5.864235e-11
+ luc=-1.637143e-17         wuc=2.6043e-17            puc=-1.037031e-23
+ rdsw=445                  prwb=0                    prwg=0
+ wr=1                      u0=9.0154740e-03          lu0=-7.6274600e-11
+ wu0=-1.0033043e-09        pu0=1.9392506e-16         a0=1.35712
+ la0=-3.541147e-07         wa0=-1.020625e-07         pa0=2.696279e-13
+ keta=0.009032703          lketa=3.953726e-08        wketa=2.601477e-09
+ pketa=-2.592577e-14       a1=0                      a2=1
+ ags=0.4916761             lags=8.295446e-08         b0=0
+ b1=0                      voff=-0.13                nfactor=1.116648
+ lnfactor=-1.659089e-07    cit=-0.0003390272         lcit=3.362071e-10
+ wcit=2.708359e-10         pcit=-2.074062e-16        cdsc=0
+ cdscb=0                   cdscd=0                   eta0=0.001185386
+ leta0=-7.586607e-10       weta0=-4.947747e-10       peta0=5.703671e-16
+ etab=7.327476e-05         letab=-6.746089e-10       wetab=-5.520778e-10
+ petab=5.185155e-16        dsub=0                    pclm=0.8054581
+ lpclm=-8.075976e-08       wpclm=1.35418e-07         ppclm=-1.037031e-13
+ pdiblc1=0.0005280577      lpdiblc1=-2.532526e-10    wpdiblc1=-1.458238e-10
+ ppdiblc1=2.074061e-16     pdiblc2=0.0005449258      lpdiblc2=-4.213562e-10
+ wpdiblc2=-1.562297e-10    ppdiblc2=3.111092e-16     pdiblcb=0
+ drout=0                   pscbe1=4.24e+08           pscbe2=1e-07
+ pvag=0                    delta=0.003841799         ldelta=7.856508e-10
+ wdelta=3.542243e-09       pdelta=2.074062e-15       alpha0=0
+ alpha1=0.0105319          beta0=11.7442             kt1=-0.2625465
+ lkt1=1.746875e-08         wkt1=4.166598e-08         pkt1=-4.148123e-14
+ kt2=0.01+dkt2p_hvt        at=10000                  ute=-0.9378054
+ lute=6.724136e-08         wute=5.416714e-08         pute=-4.14812e-14
+ ua1=2.339248e-09          lua1=-3.384018e-16        wua1=-2.812418e-16
+ pua1=3.111093e-22         ub1=-2.84e-18             uc1=-3.377e-10
+ kt1l=0                    prt=0                     cj=cjp_hvt
+ mj=0.4107588              pb=0.8465904              cjsw=cjswp_hvt
+ mjsw=0.1813912            pbsw=0.8465904            cjswg=cjswgp_hvt
+ mjswg=0.1813912           pbswg=0.8465904           tcj=0.0008024992
+ tcjsw=0.0004114948        tcjswg=0.0004114948       tpb=0.001514677
+ tpbsw=0.001514677         tpbswg=0.001514677        cgdo=cgop_hvt
+ cgso=cgop_hvt             cgbo=1e-13                js=1.49e-7
+ jsw=jswp_hvt              capmod=3                  xti=3
+ n=1                       nqsmod=0                  xpart=1
+ cf=0                      tlev=1                    tlevc=1
+ paramchk=1                dlc=1.5e-8                cgdl=cglp_hvt
+ cgsl=cglp_hvt             wwc=-4e-2                 dwc=0
+ noia=3.0e+19              noib=4.0e+3               noic=1.0e-11
+ em=4.1e+7                 ef=1.059                  noimod=2
+ sa0=0.35e-6               sb0=0.35e-6               kvsat=-0.6
+ wlod=0.3e-6               tku0=0.03                 ku0=1.14e-7
+ llodku0=1                 wlodku0=1                 lku0=8.4e-8
+ wku0=3.0e-7               pku0=1.4e-14              kvth0=-2.3e-9
+ stk2=0e-9                 steta0=0                  lkvth0=1e-8
+ wkvth0=2.5e-7             pkvth0=4e-14              llodvth=1
+ wlodvth=1                 lodk2=1                   lodeta0=1
+ minr=1e-3                 imax=0.01                 imelt=0.01

     8: type=p
+ wmax=1.182e-06-dxw_hvt    wmin=5.81e-07-dxw_hvt     xw=1.5e-08+dxw_hvt
+ lmax=7.98e-07-dxl_hvt     lmin=3.48e-07-dxl_hvt     xl=-2e-08+dxl_hvt
+ tnom=25                   version=3.24              tox=toxp_hvt
+ toxm=toxp_hvt             xj=2.1e-07                nch=9.52e+17
+ lln=1                     lwn=1                     wln=1
+ wwn=-1                    lint=6.1e-09              ll=0
+ lw=0                      lwl=0                     wint=-1.045e-08
+ wl=0                      ww=0                      wwl=0
+ mobmod=1                  binunit=2                 dwg=0
+ dwb=0                     ldif=8e-08                hdif=hdifp_hvt
+ rsh=rshp_hvt              rd=0                      rs=0
+ rsc=0                     rdc=0                     vth0=-0.405961+dvthp_hvt
+ lvth0=-1.274352e-08+dlvthp_hvt                      wvth0=2.3526e-08+dwvthp_hvt
+ pvth0=4.662426e-16+dpvthp_hvt                       k1=0.9284307
+ lk1=-1.233512e-08         wk1=-5.658552e-08         pk1=2.418631e-14
+ k2=-0.1181389+dk2p_hvt    lk2=0+dlk2p_hvt           k3=0
+ dvt0=0                    dvt1=0                    dvt2=0
+ dvt0w=0                   dvt1w=0                   dvt2w=0
+ nlx=0                     w0=0                      k3b=0
+ vfb=-1.408157             vsat=134936               lvsat=-0.01103279+dlvsatp_hvt
+ wvsat=-0.04254855         pvsat=1.343683e-08+dpvsatp_hvt
+ ua=1.300115e-10           lua=-8.27459e-18          wua=2.434402e-17
+ pua=1.007763e-23          ub=5.40896e-19            lub=2.72976e-25
+ wub=3.882039e-25          pub=-2.015524e-31         uc=-6.810396e-11
+ luc=-9.125739e-18         wuc=-3.619985e-17         puc=3.729527e-23
+ rdsw=445                  prwb=0                    prwg=0
+ wr=1                      u0=7.0022830e-03          lu0=1.4654274e-09
+ wu0=4.6938490e-10         pu0=-9.3386050e-16        a0=0.3941817
+ la0=3.833038e-07          wa0=6.886773e-07          pa0=-3.359207e-13
+ keta=0.04928443           lketa=8.712486e-09        wketa=-2.423456e-08
+ pketa=-5.374733e-15       a1=0                      a2=1
+ ags=0.6711061             lags=-5.445305e-08        wags=-4.386536e-08
+ pags=3.359209e-14         b0=0                      b1=0
+ voff=-0.13                nfactor=0.7956616         lnfactor=7.990237e-08
+ wnfactor=-4.386531e-08    pnfactor=3.359205e-14     cit=-4.406873e-05
+ lcit=1.103279e-10         wcit=1.754614e-10         pcit=-1.343683e-16
+ cdsc=0                    cdscb=0                   cdscd=0
+ eta0=5.24966e-05          leta0=1.089061e-10        weta0=3.377549e-10
+ peta0=-6.718419e-17       etab=0.0002747443         letab=-8.288943e-10
+ wetab=2.127429e-10        petab=-6.71842e-17        dsub=0
+ pclm=0.6298222            lpclm=5.374216e-08        pdiblc1=-1.503546e-05
+ lpdiblc1=1.626482e-10     wpdiblc1=2.127427e-10     ppdiblc1=-6.718415e-17
+ pdiblc2=-0.0003598932     lpdiblc2=2.715543e-10     wpdiblc2=4.254855e-10
+ ppdiblc2=-1.343683e-16    pdiblcb=0                 drout=0
+ pscbe1=4.24e+08           pscbe2=1e-07              pvag=0
+ delta=-0.002242885        ldelta=5.445303e-09       wdelta=1.063714e-08
+ pdelta=-3.359208e-15      alpha0=0                  alpha1=0.0105319
+ beta0=11.7442             kt1=-0.232532             lkt1=-5.516388e-09
+ wkt1=-2.127425e-08        pkt1=6.71841e-15          kt2=0.01+dkt2p_hvt
+ at=10000                  ute=-0.8850889            lute=2.687108e-08
+ ua1=1.327577e-09          lua1=4.363352e-16         wua1=5.198002e-16
+ pua1=-3.023288e-22        ub1=-2.84e-18             uc1=-3.377e-10
+ kt1l=0                    prt=0                     cj=cjp_hvt
+ mj=0.4107588              pb=0.8465904              cjsw=cjswp_hvt
+ mjsw=0.1813912            pbsw=0.8465904            cjswg=cjswgp_hvt
+ mjswg=0.1813912           pbswg=0.8465904           tcj=0.0008024992
+ tcjsw=0.0004114948        tcjswg=0.0004114948       tpb=0.001514677
+ tpbsw=0.001514677         tpbswg=0.001514677        cgdo=cgop_hvt
+ cgso=cgop_hvt             cgbo=1e-13                js=1.49e-7
+ jsw=jswp_hvt              capmod=3                  xti=3
+ n=1                       nqsmod=0                  xpart=1
+ cf=0                      tlev=1                    tlevc=1
+ paramchk=1                dlc=1.5e-8                cgdl=cglp_hvt
+ cgsl=cglp_hvt             wwc=-4e-2                 dwc=0
+ noia=3.0e+19              noib=4.0e+3               noic=1.0e-11
+ em=4.1e+7                 ef=1.059                  noimod=2
+ sa0=0.35e-6               sb0=0.35e-6               kvsat=-0.6
+ wlod=0.3e-6               tku0=0.03                 ku0=1.14e-7
+ llodku0=1                 wlodku0=1                 lku0=8.4e-8
+ wku0=3.0e-7               pku0=1.4e-14              kvth0=-2.3e-9
+ stk2=0e-9                 steta0=0                  lkvth0=1e-8
+ wkvth0=2.5e-7             pkvth0=4e-14              llodvth=1
+ wlodvth=1                 lodk2=1                   lodeta0=1
+ minr=1e-3                 imax=0.01                 imelt=0.01

     9: type=p
+ wmax=1.182e-06-dxw_hvt    wmin=5.81e-07-dxw_hvt     xw=1.5e-08+dxw_hvt
+ lmax=3.48e-07-dxl_hvt     lmin=1.3e-07              xl=-2e-08+dxl_hvt
+ tnom=25                   version=3.24              tox=toxp_hvt
+ toxm=toxp_hvt             xj=2.1e-07                nch=9.52e+17
+ lln=1                     lwn=1                     wln=1
+ wwn=-1                    lint=6.1e-09              ll=0
+ lw=0                      lwl=0                     wint=-1.045e-08
+ wl=0                      ww=0                      wwl=0
+ mobmod=1                  binunit=2                 dwg=0
+ dwb=0                     ldif=8e-08                hdif=hdifp_hvt
+ rsh=rshp_hvt              rd=0                      rs=0
+ rsc=0                     rdc=0                     vth0=-0.41142+dvthp_hvt
+ lvth0=-1.101951e-08+dlvthp_hvt                      wvth0=2.228054e-08+dwvthp_hvt
+ pvth0=8.595607e-16+dpvthp_hvt                       k1=0.9106643
+ lk1=-6.724489e-09         wk1=1.493296e-09          pk1=5.845015e-15
+ k2=-0.1181389+dk2p_hvt    lk2=0+dlk2p_hvt           k3=0
+ dvt0=0                    dvt1=0                    dvt2=0
+ dvt0w=0                   dvt1w=0                   dvt2w=0
+ nlx=0                     w0=0                      k3b=0
+ vfb=-1.35748              vsat=1.1547132e+05        lvsat=-4.8858420e-03+dlvsatp_hvt
+ wvsat=-1.0887419e-02      pvsat=3.4382460e-09+dpvsatp_hvt
+ ua=9.939732e-11           lua=1.393357e-18          wua=5.89773e-17
+ pua=-8.595616e-25         ub=1.121938e-18           lub=8.948288e-26
+ wub=-2.149714e-26         pub=-7.216879e-32         uc=-1.483367e-10
+ luc=1.621175e-17          wuc=1.202826e-16          puc=-1.212188e-23
+ rdsw=445                  prwb=0                    prwg=0
+ wr=1                      u0=1.0122625e-02          lu0=4.8002340e-10
+ wu0=-1.5070576e-09        pu0=-3.0969989e-16        a0=1.563239
+ la0=1.411547e-08          wa0=-3.205991e-07         pa0=-1.719123e-14
+ keta=0.1062237            lketa=-9.268915e-09       wketa=-7.010565e-08
+ pketa=9.111352e-15        a1=0                      a2=1
+ ags=0.6757392             lags=-5.591615e-08        wags=-7.358665e-08
+ pags=4.297807e-14         b0=0                      b1=0
+ voff=-0.1168212           lvoff=-4.16188e-09        wvoff=-5.443715e-09
+ pvoff=1.719124e-15        nfactor=0.8521468         lnfactor=6.206434e-08
+ wnfactor=8.972446e-08     pnfactor=-8.595607e-15    cit=0.0003946862
+ lcit=-2.823094e-11        wcit=-3.588983e-10        pcit=3.438246e-17
+ cdsc=0                    cdscb=0                   cdscd=0
+ eta0=-0.002506599         leta0=9.170683e-10        weta0=1.540376e-09
+ peta0=-4.469719e-16       etab=-0.001055157         letab=-4.089115e-10
+ wetab=5.44371e-10         petab=-1.719123e-16       dsub=0
+ pclm=0.8                  pdiblc1=0.0002822727      lpdiblc1=6.875828e-11
+ pdiblc2=0.0002822727      lpdiblc2=6.875828e-11     pdiblcb=0
+ drout=0                   pscbe1=4.24e+08           pscbe2=1e-07
+ pvag=0                    delta=0.02205943          ldelta=-2.22937e-09
+ wdelta=-4.354966e-09      pdelta=1.375298e-15       alpha0=0
+ alpha1=0.0105319          beta0=11.7442             kt1=-0.2630636
+ lkt1=4.125497e-09         kt2=0.01+dkt2p_hvt        at=10000
+ ute=-0.8                  ua1=2.884594e-09          lua1=-5.537045e-17
+ wua1=-4.919794e-16        pua1=1.719125e-23         ub1=-3.014182e-18
+ lub1=5.500661e-26         uc1=-3.377e-10            kt1l=0
+ prt=0                     cj=cjp_hvt                mj=0.4107588
+ pb=0.8465904              cjsw=cjswp_hvt            mjsw=0.1813912
+ pbsw=0.8465904            cjswg=cjswgp_hvt          mjswg=0.1813912
+ pbswg=0.8465904           tcj=0.0008024992          tcjsw=0.0004114948
+ tcjswg=0.0004114948       tpb=0.001514677           tpbsw=0.001514677
+ tpbswg=0.001514677        cgdo=cgop_hvt             cgso=cgop_hvt
+ cgbo=1e-13                js=1.49e-7                jsw=jswp_hvt
+ capmod=3                  xti=3                     n=1
+ nqsmod=0                  xpart=1                   cf=0
+ tlev=1                    tlevc=1                   paramchk=1
+ dlc=1.5e-8                cgdl=cglp_hvt             cgsl=cglp_hvt
+ wwc=-4e-2                 dwc=0                     noia=3.0e+19
+ noib=4.0e+3               noic=1.0e-11              em=4.1e+7
+ ef=1.059                  noimod=2                  sa0=0.35e-6
+ sb0=0.35e-6               kvsat=-0.6                wlod=0.3e-6
+ tku0=0.03                 ku0=1.14e-7               llodku0=1
+ wlodku0=1                 lku0=8.4e-8               wku0=3.0e-7
+ pku0=1.4e-14              kvth0=-2.3e-9             stk2=0e-9
+ steta0=0                  lkvth0=1e-8               wkvth0=2.5e-7
+ pkvth0=4e-14              llodvth=1                 wlodvth=1
+ lodk2=1                   lodeta0=1                 minr=1e-3
+ imax=0.01                 imelt=0.01

     10: type=p
+ wmax=5.81e-07-dxw_hvt     wmin=1.5e-07              xw=1.5e-08+dxw_hvt
+ lmax=2.1e-05              lmin=7.98e-07-dxl_hvt     xl=-2e-08+dxl_hvt
+ tnom=25                   version=3.24              tox=toxp_hvt
+ toxm=toxp_hvt             xj=2.1e-07                nch=9.52e+17
+ lln=1                     lwn=1                     wln=1
+ wwn=-1                    lint=6.1e-09              ll=0
+ lw=0                      lwl=0                     wint=-1.045e-08
+ wl=0                      ww=0                      wwl=0
+ mobmod=1                  binunit=2                 dwg=0
+ dwb=0                     ldif=8e-08                hdif=hdifp_hvt
+ rsh=rshp_hvt              rd=0                      rs=0
+ rsc=0                     rdc=0                     vth0=-0.375248+dvthp_hvt
+ lvth0=-2.392662e-08+dlvthp_hvt                      wvth0=1.209231e-08+dwvthp_hvt
+ pvth0=1.61154e-15+dpvthp_hvt                        k1=0.9347655
+ lk1=-2.499447e-08         wk1=-2.548208e-08         pk1=5.184147e-15
+ k2=-0.1181389+dk2p_hvt    lk2=0+dlk2p_hvt           k3=0
+ dvt0=0                    dvt1=0                    dvt2=0
+ dvt0w=0                   dvt1w=0                   dvt2w=0
+ nlx=0                     w0=0                      k3b=0
+ vfb=-1.365562             vsat=102296               lvsat=-0.02288155+dlvsatp_hvt
+ wvsat=-0.0003894031       pvsat=3.880712e-09+dpvsatp_hvt
+ ua=2.469221e-10           lua=-4.834528e-17         wua=-1.455422e-17
+ pua=9.354366e-24          ub=1.141595e-18           lub=5.525548e-26
+ wub=-9.248508e-26         pub=1.708747e-32          uc=-4.472383e-12
+ luc=-4.233619e-17         wuc=-7.374459e-18         puc=5.647361e-24
+ rdsw=445                  prwb=0                    prwg=0
+ wr=1                      u0=7.2810140e-03          lu0=2.1923206e-10
+ wu0=6.6684360e-11         pu0=1.1626992e-17         a0=1.206865
+ la0=1.14877e-07           wa0=-9.370259e-09         pa0=-1.969305e-14
+ keta=0.01571156           lketa=2.304453e-09        wketa=-1.518709e-09
+ pketa=-2.956856e-15       a1=0                      a2=1
+ ags=0.48852               lags=1.144078e-07         wags=1.947016e-09
+ pags=-1.940356e-14        b0=0                      b1=0
+ voff=-0.1370225           lvoff=-3.333054e-09       wvoff=4.3322e-09
+ pvoff=2.05616e-15         nfactor=1.089425          lnfactor=-2.612076e-07
+ wnfactor=1.679348e-08     pnfactor=5.87897e-14      cit=0.0001796937
+ lcit=-6.102945e-11        wcit=-4.916306e-11        pcit=3.764907e-17
+ cdsc=0                    cdscb=0                   cdscd=0
+ eta0=0.0003036584         leta0=2.269384e-10        weta0=4.916307e-11
+ peta0=-3.764908e-17       etab=-0.000974723         letab=2.250611e-10
+ wetab=9.443209e-11        petab=-3.649103e-17       dsub=0
+ pclm=1.03444              lpclm=-3.432233e-07       wpclm=-5.841052e-09
+ ppclm=5.821068e-14        pdiblc1=0.0001784478      lpdiblc1=1.115919e-10
+ wpdiblc1=6.985056e-11     ppdiblc1=-1.766648e-17    pdiblc2=0.0001784478
+ lpdiblc2=1.115919e-10     wpdiblc2=6.985056e-11     ppdiblc2=-1.766648e-17
+ pdiblcb=0                 drout=0                   pscbe1=4.24e+08
+ pscbe2=1e-07              pvag=0                    delta=0.01077921
+ ldelta=3.23228e-09        wdelta=-7.374458e-10      pdelta=5.64736e-16
+ alpha0=0                  alpha1=0.0105319          beta0=11.7442
+ kt1=-0.1970967            lkt1=-6.559318e-08        wkt1=1.289945e-09
+ pkt1=9.75968e-15          kt2=0.01+dkt2p_hvt        at=10000
+ ute=-0.85                 ua1=1.803658e-09          lua1=2.269384e-16
+ wua1=4.916307e-17         pua1=-3.764907e-23        ub1=-2.84e-18
+ uc1=-3.377e-10            kt1l=0                    prt=0
+ cj=cjp_hvt                mj=0.4107588              pb=0.8465904
+ cjsw=cjswp_hvt            mjsw=0.1813912            pbsw=0.8465904
+ cjswg=cjswgp_hvt          mjswg=0.1813912           pbswg=0.8465904
+ tcj=0.0008024992          tcjsw=0.0004114948        tcjswg=0.0004114948
+ tpb=0.001514677           tpbsw=0.001514677         tpbswg=0.001514677
+ cgdo=cgop_hvt             cgso=cgop_hvt             cgbo=1e-13
+ js=1.49e-7                jsw=jswp_hvt              capmod=3
+ xti=3                     n=1                       nqsmod=0
+ xpart=1                   cf=0                      tlev=1
+ tlevc=1                   paramchk=1                dlc=1.5e-8
+ cgdl=cglp_hvt             cgsl=cglp_hvt             wwc=-4e-2
+ dwc=0                     noia=3.0e+19              noib=4.0e+3
+ noic=1.0e-11              em=4.1e+7                 ef=1.059
+ noimod=2                  sa0=0.35e-6               sb0=0.35e-6
+ kvsat=-0.6                wlod=0.3e-6               tku0=0.03
+ ku0=1.14e-7               llodku0=1                 wlodku0=1
+ lku0=8.4e-8               wku0=3.0e-7               pku0=1.4e-14
+ kvth0=-2.3e-9             stk2=0e-9                 steta0=0
+ lkvth0=1e-8               wkvth0=2.5e-7             pkvth0=4e-14
+ llodvth=1                 wlodvth=1                 lodk2=1
+ lodeta0=1                 minr=1e-3                 imax=0.01
+ imelt=0.01

     11: type=p
+ wmax=5.81e-07-dxw_hvt     wmin=1.5e-07              xw=1.5e-08+dxw_hvt
+ lmax=7.98e-07-dxl_hvt     lmin=3.48e-07-dxl_hvt     xl=-2e-08+dxl_hvt
+ tnom=25                   version=3.24              tox=toxp_hvt
+ toxm=toxp_hvt             xj=2.1e-07                nch=9.52e+17
+ lln=1                     lwn=1                     wln=1
+ wwn=-1                    lint=6.1e-09              ll=0
+ lw=0                      lwl=0                     wint=-1.045e-08
+ wl=0                      ww=0                      wwl=0
+ mobmod=1                  binunit=2                 dwg=0
+ dwb=0                     ldif=8e-08                hdif=hdifp_hvt
+ rsh=rshp_hvt              rd=0                      rs=0
+ rsc=0                     rdc=0                     vth0=-0.388207+dvthp_hvt
+ lvth0=-1.400271e-08+dlvthp_hvt                      wvth0=1.257351e-08+dwvthp_hvt
+ pvth0=1.243038e-15+dpvthp_hvt                       k1=0.8531106
+ lk1=3.753685e-08          wk1=-1.012054e-08         pk1=-6.579718e-15
+ k2=-0.1181389+dk2p_hvt    lk2=0+dlk2p_hvt           k3=0
+ dvt0=0                    dvt1=0                    dvt2=0
+ dvt0w=0                   dvt1w=0                   dvt2w=0
+ nlx=0                     w0=0                      k3b=0
+ vfb=-1.356224             vsat=53059.39             lvsat=0.01482385+dlvsatp_hvt
+ wvsat=0.007961128         pvsat=-2.514124e-09+dpvsatp_hvt
+ ua=1.612531e-10           lua=1.726005e-17          wua=5.071088e-18
+ pua=-5.674693e-24         ub=1.305062e-18           lub=-6.992761e-26
+ wub=-8.321029e-26         pub=9.984832e-33          uc=-1.612159e-10
+ luc=7.769796e-17          wuc=2.12409e-17           puc=-1.626628e-23
+ rdsw=445                  prwb=0                    prwg=0
+ wr=1                      u0=7.5930790e-03          lu0=-1.9746709e-11
+ wu0=1.0492341e-10         pu0=-1.7656481e-17        a0=1.695358
+ la0=-2.592106e-07         wa0=-1.140183e-07         pa0=6.044645e-14
+ keta=0.03657905           lketa=-1.367587e-08       wketa=-1.639662e-08
+ pketa=8.436646e-15        a1=0                      a2=1
+ ags=0.6351797             lags=2.095783e-09         wags=-2.170234e-08
+ pags=-1.29289e-15         b0=0                      b1=0
+ voff=-0.1434885           lvoff=1.618551e-09        wvoff=8.321028e-09
+ pvoff=-9.984839e-16       nfactor=0.5104729         lnfactor=1.821544e-07
+ wnfactor=1.320676e-07     pnfactor=-2.948722e-14    cit=0.0002990468
+ lcit=-1.5243e-10          wcit=-3.620661e-11        pcit=2.772702e-17
+ cdsc=0                    cdscb=0                   cdscd=0
+ eta0=0.0007173825         leta0=-8.989144e-11       weta0=-7.241322e-11
+ peta0=5.545404e-17        etab=-0.0009767285        letab=2.265968e-10
+ wetab=9.847764e-10        petab=-7.183167e-16       dsub=0
+ pclm=0.4362463            lpclm=1.148734e-07        wpclm=1.194169e-07
+ ppclm=-3.771186e-14       pdiblc1=0.0002007716      lpdiblc1=9.449633e-11
+ wpdiblc1=7.961129e-11     ppdiblc1=-2.514124e-17    pdiblc2=0.0002007716
+ lpdiblc2=9.449633e-11     wpdiblc2=7.961129e-11     ppdiblc2=-2.514124e-17
+ pdiblcb=0                 drout=0                   pscbe1=4.24e+08
+ pscbe2=1e-07              pvag=0                    delta=0.015
+ alpha0=0                  alpha1=0.0105319          beta0=11.7442
+ kt1=-0.2969292            lkt1=1.08586e-08          wkt1=1.845239e-08
+ pkt1=-3.383317e-15        kt2=0.01+dkt2p_hvt        at=10000
+ ute=-0.8850889            lute=2.687108e-08         ua1=2.199524e-09
+ lua1=-7.621501e-17        wua1=-1.81033e-17         pua1=1.386351e-23
+ ub1=-2.84e-18             uc1=-3.377e-10            kt1l=0
+ prt=0                     cj=cjp_hvt                mj=0.4107588
+ pb=0.8465904              cjsw=cjswp_hvt            mjsw=0.1813912
+ pbsw=0.8465904            cjswg=cjswgp_hvt          mjswg=0.1813912
+ pbswg=0.8465904           tcj=0.0008024992          tcjsw=0.0004114948
+ tcjswg=0.0004114948       tpb=0.001514677           tpbsw=0.001514677
+ tpbswg=0.001514677        cgdo=cgop_hvt             cgso=cgop_hvt
+ cgbo=1e-13                js=1.49e-7                jsw=jswp_hvt
+ capmod=3                  xti=3                     n=1
+ nqsmod=0                  xpart=1                   cf=0
+ tlev=1                    tlevc=1                   paramchk=1
+ dlc=1.5e-8                cgdl=cglp_hvt             cgsl=cglp_hvt
+ wwc=-4e-2                 dwc=0                     noia=3.0e+19
+ noib=4.0e+3               noic=1.0e-11              em=4.1e+7
+ ef=1.059                  noimod=2                  sa0=0.35e-6
+ sb0=0.35e-6               kvsat=-0.6                wlod=0.3e-6
+ tku0=0.03                 ku0=1.14e-7               llodku0=1
+ wlodku0=1                 lku0=8.4e-8               wku0=3.0e-7
+ pku0=1.4e-14              kvth0=-2.3e-9             stk2=0e-9
+ steta0=0                  lkvth0=1e-8               wkvth0=2.5e-7
+ pkvth0=4e-14              llodvth=1                 wlodvth=1
+ lodk2=1                   lodeta0=1                 minr=1e-3
+ imax=0.01                 imelt=0.01

     12: type=p
+ wmax=5.81e-07-dxw_hvt     wmin=1.5e-07              xw=1.5e-08+dxw_hvt
+ lmax=3.48e-07-dxl_hvt     lmin=1.3e-07              xl=-2e-08+dxl_hvt
+ tnom=25                   version=3.24              tox=toxp_hvt
+ toxm=toxp_hvt             xj=2.1e-07                nch=9.52e+17
+ lln=1                     lwn=1                     wln=1
+ wwn=-1                    lint=6.1e-09              ll=0
+ lw=0                      lwl=0                     wint=-1.045e-08
+ wl=0                      ww=0                      wwl=0
+ mobmod=1                  binunit=2                 dwg=0
+ dwb=0                     ldif=8e-08                hdif=hdifp_hvt
+ rsh=rshp_hvt              rd=0                      rs=0
+ rsc=0                     rdc=0                     vth0=-0.400044+dvthp_hvt
+ lvth0=-1.026464e-08+dlvthp_hvt                      wvth0=1.526242e-08+dwvthp_hvt
+ pvth0=3.938814e-16+dpvthp_hvt                       k1=0.9519622
+ lk1=6.319521e-09          wk1=-2.398337e-08         pk1=-2.201835e-15
+ k2=-0.1181389+dk2p_hvt    lk2=0+dlk2p_hvt           k3=0
+ dvt0=0                    dvt1=0                    dvt2=0
+ dvt0w=0                   dvt1w=0                   dvt2w=0
+ nlx=0                     w0=0                      k3b=0
+ vfb=-1.268901             vsat=9.2228180e+04        lvsat=2.4543416e-03+dlvsatp_hvt
+ wvsat=3.4512780e-03       pvsat=-1.0899135e-09+dpvsatp_hvt
+ ua=2.250125e-10           lua=-2.875201e-18         wua=-1.851474e-17
+ pua=1.773712e-24          ub=1.290023e-18           lub=-6.517833e-26
+ wub=-1.25189e-25          pub=2.324172e-32          uc=1.122362e-10
+ luc=-8.658212e-18         wuc=-4.046487e-17         puc=3.220403e-24
+ rdsw=445                  prwb=0                    prwg=0
+ wr=1                      u0=7.6588670e-03          lu0=-4.0522820e-11
+ wu0=1.2834777e-11         pu0=1.1425112e-17         a0=0.9359921
+ la0=-1.940288e-08         wa0=6.634964e-08          pa0=3.486237e-15
+ keta=-0.03142821          lketa=7.800823e-09        wketa=1.481179e-08
+ pketa=-1.41897e-15        a1=0                      a2=1
+ ags=0.5957592             lags=1.454479e-08         wags=-2.424699e-08
+ pags=-4.892897e-16        b0=0                      b1=0
+ voff=-0.1355784           lvoff=-8.794412e-10       wvoff=6.127643e-09
+ pvoff=-3.058129e-16       nfactor=0.8661122         lnfactor=6.98435e-08
+ wnfactor=8.110923e-08     pnfactor=-1.339457e-14    cit=-0.0003485821
+ lcit=5.209121e-11         wcit=9.962397e-11         pcit=-1.516828e-17
+ cdsc=0                    cdscb=0                   cdscd=0
+ eta0=-4.253154e-05        leta0=1.500893e-10        weta0=2.029296e-11
+ peta0=2.617745e-17        etab=0.002828526          letab=-9.751029e-10
+ wetab=-1.851474e-09       petab=1.773712e-16        dsub=0
+ pclm=0.7792795            lpclm=6.543551e-09        wpclm=1.278251e-08
+ ppclm=-4.036717e-15       pdiblc1=0.0002201112      lpdiblc1=8.838893e-11
+ wpdiblc1=3.834752e-11     ppdiblc1=-1.211015e-17    pdiblc2=0.0002201112
+ lpdiblc2=8.838893e-11     wpdiblc2=3.834752e-11     ppdiblc2=-1.211015e-17
+ pdiblcb=0                 drout=0                   pscbe1=4.24e+08
+ pscbe2=1e-07              pvag=0                    delta=0.015
+ alpha0=0                  alpha1=0.0105319          beta0=11.7442
+ kt1=-0.2852153            lkt1=7.159327e-09         wkt1=1.366535e-08
+ pkt1=-1.87157e-15         kt2=0.01+dkt2p_hvt        at=10000
+ ute=-0.8                  ua1=2.068507e-09          lua1=-3.483998e-17
+ wua1=1.146448e-17         pua1=4.526004e-24         ub1=-3.097064e-18
+ lub1=8.118081e-26         wub1=5.113003e-26         pub1=-1.614686e-32
+ uc1=-3.377e-10            kt1l=0                    prt=0
+ cj=cjp_hvt                mj=0.4107588              pb=0.8465904
+ cjsw=cjswp_hvt            mjsw=0.1813912            pbsw=0.8465904
+ cjswg=cjswgp_hvt          mjswg=0.1813912           pbswg=0.8465904
+ tcj=0.0008024992          tcjsw=0.0004114948        tcjswg=0.0004114948
+ tpb=0.001514677           tpbsw=0.001514677         tpbswg=0.001514677
+ cgdo=cgop_hvt             cgso=cgop_hvt             cgbo=1e-13
+ js=1.49e-7                jsw=jswp_hvt              capmod=3
+ xti=3                     n=1                       nqsmod=0
+ xpart=1                   cf=0                      tlev=1
+ tlevc=1                   paramchk=1                dlc=1.5e-8
+ cgdl=cglp_hvt             cgsl=cglp_hvt             wwc=-4e-2
+ dwc=0                     noia=3.0e+19              noib=4.0e+3
+ noic=1.0e-11              em=4.1e+7                 ef=1.059
+ noimod=2                  sa0=0.35e-6               sb0=0.35e-6
+ kvsat=-0.6                wlod=0.3e-6               tku0=0.03
+ ku0=1.14e-7               llodku0=1                 wlodku0=1
+ lku0=8.4e-8               wku0=3.0e-7               pku0=1.4e-14
+ kvth0=-2.3e-9             stk2=0e-9                 steta0=0
+ lkvth0=1e-8               wkvth0=2.5e-7             pkvth0=4e-14
+ llodvth=1                 wlodvth=1                 lodk2=1
+ lodeta0=1                 minr=1e-3                 imax=0.01
+ imelt=0.01
//

     }
endsection mos_hvt
//
//
section mos_uhvt
// ******************************************************************************************
//
//                *
//                               1.2V UHI-VT NMOS DEVICE MODELS
//                *
//
//                *
// ******************************************************************************************

model nch_uhvt bsim3v3  {
     1: type=n
+ lmin=1.0000e-05-dxl_uhvt  lmax=21e-6                wmin=1.0000e-05-dxw_uhvt
+ wmax=900.1e-6             version=3.24              mobmod=1
+ nqsmod=0                  binunit=2                 tnom=25
+ xl=-2e-08+dxl_uhvt        xw=1.5e-08+dxw_uhvt       llc=0
+ lwc=0                     lwlc=0                    wlc=0
+ wwlc=0                    tox=toxn_uhvt             toxm=toxn_uhvt
+ wint=0                    lint=0                    dwc=0
+ hdif=hdifn_uhvt           ldif=8e-008               ll=0
+ wl=0                      lln=1                     wln=1
+ lw=0                      ww=0                      lwn=1
+ lwl=0                     wwl=0                     cgbo=0
+ cgso=cgon_uhvt            cgdo=cgon_uhvt            vth0=0.32479+dvthn_uhvt
+ lvth0=0+dlvthn_uhvt       wvth0=0+dwvthn_uhvt       pvth0=0+dpvthn_uhvt
+ k1=0.405                  k2=0.01388+dk2n_uhvt      wk2=0+dwk2n_uhvt
+ k3=-4.426                 k3b=3.154                 nlx=4.655e-007
+ dvt0=0.8812               dvt1=0.1131               dvt2=0.01298
+ dvt0w=0                   dvt1w=0                   dvt2w=-0.032
+ nch=6.148e017             voff=-0.12861             nfactor=1
+ cdsc=0.00024              cdscb=-0.0001318          cdscd=0
+ cit=-0.00132              u0=272.35                 ua=-1.7682e-009
+ ub=2.988e-018             uc=1.4542e-010            ngate=0
+ xj=1.9e-007               w0=4.441e-021             prwg=0
+ prwb=0                    wr=1                      rdsw=50
+ a0=2.3503                 ags=0.84614               a1=0
+ a2=1                      b0=0                      b1=0
+ vsat=120900               keta=-0.039163            dwg=0
+ dwb=0                     alpha0=0                  pclm=0.53106
+ pdiblc1=0                 pdiblc2=0.0040161         pdiblcb=0
+ drout=0.56                pvag=0                    pscbe1=4.24e008
+ pscbe2=1e-005             delta=0.00214             eta0=0.03882
+ etab=-0.01912             dsub=0.2082               clc=1e-007
+ cle=0.6                   cf=0                      ckappa=0.6
+ cgdl=cgln_uhvt            cgsl=cgln_uhvt            kt1=-0.2373
+ kt1l=0                    kt2=-0.015768             ute=-1
+ ua1=2.6187e-009           lua1=0+dlua1n_uhvt        ub1=-1.209e-018
+ uc1=4.334e-011            prt=0                     at=33000
+ noimod=2                  em=4100                   noia=2e020
+ ef=0.98                   noib=5000                 noic=4e-013
+ cj=cjn_uhvt               cjsw=cjswn_uhvt           rd=0
+ rs=0                      xti=3                     n=1
+ cjswg=cjswgn_uhvt         sa0=3.5e-007              sb0=3.5e-007
+ wwn=-1                    rsh=6.6                   alpha1=1.9939
+ beta0=13.572              mj=0.48                   pb=0.8
+ mjsw=0.35                 pbsw=0.74                 mjswg=0.46
+ pbswg=0.8                 js=2.000e-07              jsw=7.500e-13
+ tcj=9.500e-04             tpb=0.0015                tcjsw=4.800e-04
+ tpbsw=0.0009              tcjswg=0.0009             tpbswg=0.0015
+ capmod=3                  xpart=1                   dlc=1.8e-08
+ wwc=-0.045                kvsat=0.4                 wlod=5e-07
+ tku0=0.03                 ku0=-6.2e-08              llodku0=1
+ wlodku0=1                 lku0=2e-07                wku0=7e-07
+ pku0=-5e-14               kvth0=5.2e-09             stk2=2.5e-09
+ steta0=-1.1e-10           lkvth0=-1e-08             wkvth0=2.2e-06
+ pkvth0=-5e-14             llodvth=1                 wlodvth=1
+ lodk2=1                   lodeta0=2                 tlev=1
+ tlevc=1                   minr=1e-3                 imax=0.01
+ imelt=0.01

     2: type=n
+ lmin=8.0000e-07-dxl_uhvt  lmax=1.0000e-05-dxl_uhvt  wmin=1.0000e-05-dxw_uhvt
+ wmax=900.1e-6             version=3.24              mobmod=1
+ nqsmod=0                  binunit=2                 tnom=25
+ xl=-2e-08+dxl_uhvt        xw=1.5e-08+dxw_uhvt       llc=0
+ lwc=0                     lwlc=0                    wlc=0
+ wwlc=0                    tox=toxn_uhvt             toxm=toxn_uhvt
+ wint=0                    lint=0                    dwc=0
+ hdif=hdifn_uhvt           ldif=8e-008               ll=0
+ wl=0                      lln=1                     wln=1
+ lw=0                      ww=0                      lwn=1
+ lwl=0                     wwl=0                     cgbo=0
+ cgso=cgon_uhvt            cgdo=cgon_uhvt            vth0=0.32654076+dvthn_uhvt
+ lvth0=-1.7472594e-008+dlvthn_uhvt                   wvth0=0+dwvthn_uhvt
+ pvth0=0+dpvthn_uhvt       k1=0.405                  k2=0.014009717+dk2n_uhvt
+ lk2=-1.2945796e-009       wk2=0+dwk2n_uhvt          k3=-4.426
+ k3b=3.154                 nlx=4.655e-007            dvt0=0.8812
+ dvt1=0.1131               dvt2=0.01298              dvt0w=0
+ dvt1w=0                   dvt2w=-0.032              nch=6.148e017
+ voff=-0.1290568           lvoff=4.4591074e-009      nfactor=1
+ cdsc=0.00024              cdscb=-0.0001318          cdscd=0
+ cit=-0.0014311238         lcit=1.109016e-009        u0=273.15204
+ lu0=-8.0043939e-006       ua=-1.7886241e-009        lua=2.0383282e-016
+ ub=3.0216248e-018         lub=-3.3557533e-025       uc=1.4474004e-010
+ luc=6.7859661e-018        ngate=0                   xj=1.9e-007
+ w0=4.441e-021             prwg=0                    prwb=0
+ wr=1                      rdsw=50                   a0=2.3575574
+ la0=-7.2428765e-008       ags=0.80949187            lags=3.6574834e-007
+ a1=0                      a2=1                      b0=0
+ b1=0                      vsat=122671.96            lvsat=-0.017684126
+ keta=-0.041888295         lketa=2.719844e-008       dwg=0
+ dwb=0                     alpha0=0                  pclm=0.52521509
+ lpclm=5.8332232e-008      pdiblc1=0                 pdiblc2=0.0024713694
+ lpdiblc2=1.5416412e-008   pdiblcb=0                 drout=0.56
+ pvag=0                    pscbe1=4.24e008           pscbe2=1e-005
+ delta=0.0012455435        ldelta=8.9266761e-009     eta0=0.041584278
+ leta0=-2.7587491e-008     etab=-0.01912             dsub=0.2082
+ clc=1e-007                cle=0.6                   cf=0
+ ckappa=0.6                cgdl=cgln_uhvt            cgsl=cgln_uhvt
+ kt1=-0.23703717           lkt1=-2.6230044e-009      kt1l=0
+ kt2=-0.015395635          lkt2=-3.7162049e-009      ute=-1
+ ua1=2.6389376e-009        lua1=-2.0197134e-016+dlua1n_uhvt
+ ub1=-1.209e-018           uc1=4.334e-011            prt=0
+ at=33000                  noimod=2                  em=4100
+ noia=2e020                ef=0.98                   noib=5000
+ noic=4e-013               cj=cjn_uhvt               cjsw=cjswn_uhvt
+ rd=0                      rs=0                      xti=3
+ n=1                       cjswg=cjswgn_uhvt         sa0=3.5e-007
+ sb0=3.5e-007              wwn=-1                    rsh=6.6
+ alpha1=1.9939             beta0=13.572              mj=0.48
+ pb=0.8                    mjsw=0.35                 pbsw=0.74
+ mjswg=0.46                pbswg=0.8                 js=2.000e-07
+ jsw=7.500e-13             tcj=9.500e-04             tpb=0.0015
+ tcjsw=4.800e-04           tpbsw=0.0009              tcjswg=0.0009
+ tpbswg=0.0015             capmod=3                  xpart=1
+ dlc=1.8e-08               wwc=-0.045                kvsat=0.4
+ wlod=5e-07                tku0=0.03                 ku0=-6.2e-08
+ llodku0=1                 wlodku0=1                 lku0=2e-07
+ wku0=7e-07                pku0=-5e-14               kvth0=5.2e-09
+ stk2=2.5e-09              steta0=-1.1e-10           lkvth0=-1e-08
+ wkvth0=2.2e-06            pkvth0=-5e-14             llodvth=1
+ wlodvth=1                 lodk2=1                   lodeta0=2
+ tlev=1                    tlevc=1                   minr=1e-3
+ imax=0.01                 imelt=0.01

     3: type=n
+ lmin=3.5000e-07-dxl_uhvt  lmax=8.0000e-07-dxl_uhvt  wmin=1.0000e-05-dxw_uhvt
+ wmax=900.1e-6             version=3.24              mobmod=1
+ nqsmod=0                  binunit=2                 tnom=25
+ xl=-2e-08+dxl_uhvt        xw=1.5e-08+dxw_uhvt       llc=0
+ lwc=0                     lwlc=0                    wlc=0
+ wwlc=0                    tox=toxn_uhvt             toxm=toxn_uhvt
+ wint=0                    lint=0                    dwc=0
+ hdif=hdifn_uhvt           ldif=8e-008               ll=0
+ wl=0                      lln=1                     wln=1
+ lw=0                      ww=0                      lwn=1
+ lwl=0                     wwl=0                     cgbo=0
+ cgso=cgon_uhvt            cgdo=cgon_uhvt            vth0=0.31288133+dvthn_uhvt
+ lvth0=-6.81824e-009+dlvthn_uhvt                     wvth0=0+dwvthn_uhvt
+ pvth0=0+dpvthn_uhvt       k1=0.405                  k2=-5.36e-005+dk2n_uhvt
+ lk2=9.674808e-009         wk2=0+dwk2n_uhvt          k3=-4.426
+ k3b=3.154                 nlx=4.655e-007            dvt0=0.8812
+ dvt1=0.1131               dvt2=0.01298              dvt0w=0
+ dvt1w=0                   dvt2w=-0.032              nch=6.148e017
+ voff=-0.12103733          lvoff=-1.79608e-009       nfactor=1
+ cdsc=0.00024              cdscb=-0.0001318          cdscd=0
+ cit=-1.6133797e-005       lcit=5.3237316e-012       u0=238.82933
+ lu0=1.876732e-005         ua=-1.6494733e-009        lua=9.52952e-017
+ ub=2.52672e-018           lub=5.04504e-026          uc=1.06778e-010
+ luc=3.639636e-017         ngate=0                   xj=1.9e-007
+ w0=4.441e-021             prwg=0                    prwb=0
+ wr=1                      rdsw=50                   a0=1.3726
+ la0=6.95838e-007          ags=0.78244667            lags=3.868436e-007
+ a1=0                      a2=1                      b0=0
+ b1=0                      vsat=88127.333            lvsat=0.00926068
+ keta=0.035874533          lketa=-3.3456566e-008     dwg=0
+ dwb=0                     alpha0=0                  pclm=0.67333333
+ lpclm=-5.72e-008          pdiblc1=0                 pdiblc2=0.026768
+ lpdiblc2=-3.53496e-009    pdiblcb=0                 drout=0.56
+ pvag=0                    pscbe1=4.24e008           pscbe2=1e-005
+ delta=0.00023066667       ldelta=9.71828e-009       eta0=0.00345316
+ leta0=2.1547812e-009      etab=-0.028860647         letab=7.5977044e-009
+ dsub=0.2082               clc=1e-007                cle=0.6
+ cf=0                      ckappa=0.6                cgdl=cgln_uhvt
+ cgsl=cgln_uhvt            kt1=-0.24722              lkt1=5.3196e-009
+ kt1l=0                    kt2=-0.010377333          lkt2=-7.63048e-009
+ ute=-1                    ua1=2.5587133e-009        lua1=-1.393964e-016+dlua1n_uhvt
+ ub1=-1.209e-018           uc1=4.334e-011            prt=0
+ at=33000                  noimod=2                  em=4100
+ noia=2e020                ef=0.98                   noib=5000
+ noic=4e-013               cj=cjn_uhvt               cjsw=cjswn_uhvt
+ rd=0                      rs=0                      xti=3
+ n=1                       cjswg=cjswgn_uhvt         sa0=3.5e-007
+ sb0=3.5e-007              wwn=-1                    rsh=6.6
+ alpha1=1.9939             beta0=13.572              mj=0.48
+ pb=0.8                    mjsw=0.35                 pbsw=0.74
+ mjswg=0.46                pbswg=0.8                 js=2.000e-07
+ jsw=7.500e-13             tcj=9.500e-04             tpb=0.0015
+ tcjsw=4.800e-04           tpbsw=0.0009              tcjswg=0.0009
+ tpbswg=0.0015             capmod=3                  xpart=1
+ dlc=1.8e-08               wwc=-0.045                kvsat=0.4
+ wlod=5e-07                tku0=0.03                 ku0=-6.2e-08
+ llodku0=1                 wlodku0=1                 lku0=2e-07
+ wku0=7e-07                pku0=-5e-14               kvth0=5.2e-09
+ stk2=2.5e-09              steta0=-1.1e-10           lkvth0=-1e-08
+ wkvth0=2.2e-06            pkvth0=-5e-14             llodvth=1
+ wlodvth=1                 lodk2=1                   lodeta0=2
+ tlev=1                    tlevc=1                   minr=1e-3
+ imax=0.01                 imelt=0.01

     4: type=n
+ lmin=1.3e-07              lmax=3.5000e-07-dxl_uhvt  wmin=1.0000e-05-dxw_uhvt
+ wmax=900.1e-6             version=3.24              mobmod=1
+ nqsmod=0                  binunit=2                 tnom=25
+ xl=-2e-08+dxl_uhvt        xw=1.5e-08+dxw_uhvt       llc=0
+ lwc=0                     lwlc=0                    wlc=0
+ wwlc=0                    tox=toxn_uhvt             toxm=toxn_uhvt
+ wint=0                    lint=0                    dwc=0
+ hdif=hdifn_uhvt           ldif=8e-008               ll=0
+ wl=0                      lln=1                     wln=1
+ lw=0                      ww=0                      lwn=1
+ lwl=0                     wwl=0                     cgbo=0
+ cgso=cgon_uhvt            cgdo=cgon_uhvt            vth0=0.308465+dvthn_uhvt
+ lvth0=-5.36085e-009+dlvthn_uhvt                     wvth0=0+dwvthn_uhvt
+ pvth0=0+dpvthn_uhvt       k1=0.405                  k2=0.0319115+dk2n_uhvt
+ lk2=-8.73675e-010         wk2=0+dwk2n_uhvt          k3=-4.426
+ k3b=3.154                 nlx=4.655e-007            dvt0=0.8812
+ dvt1=0.1131               dvt2=0.01298              dvt0w=0
+ dvt1w=0                   dvt2w=-0.032              nch=6.148e017
+ voff=-0.117075            lvoff=-3.10365e-009       nfactor=1
+ cdsc=0.00024              cdscb=-0.0001977          lcdscb=2.1747001e-011
+ cdscd=0                   cit=-1.91535e-009         lcit=2.106885e-016
+ u0=343.34                 lu0=-1.57212e-005         ua=-1.00845e-009
+ lua=-1.162425e-016        ub=2.6607e-018            lub=6.237e-027
+ uc=2.15885e-010           luc=3.9105e-019           ngate=0
+ xj=1.9e-007               w0=4.441e-021             prwg=0
+ prwb=0                    wr=1                      rdsw=50
+ a0=2.30405                la0=3.884595e-007         ags=1.4965
+ lags=1.51206e-007         a1=0                      a2=1
+ b0=0                      b1=0                      vsat=125315.5
+ lvsat=-0.003011415        keta=-0.1279795           lketa=2.0615265e-008
+ dwg=0                     dwb=0                     alpha0=0
+ pclm=0.27016              lpclm=7.58472e-008        pdiblc1=0
+ pdiblc2=0.02152175        lpdiblc2=-1.8036975e-009  pdiblcb=0
+ drout=0.56                pvag=0                    pscbe1=4.24e008
+ pscbe2=1e-005             delta=0.02978             ldelta=-3.3e-011
+ eta0=0.0049927            leta0=1.646733e-009       etab=0.00080405
+ letab=-2.1916455e-009     dsub=0.2082               clc=1e-007
+ cle=0.6                   cf=0                      ckappa=0.6
+ cgdl=cgln_uhvt            cgsl=cgln_uhvt            kt1=-0.216395
+ lkt1=-4.85265e-009        kt1l=0                    kt2=-0.02505
+ lkt2=-2.7885e-009         ute=-1                    ua1=2.3749e-009
+ lua1=-7.8738e-017+dlua1n_uhvt                       ub1=-1.209e-018
+ uc1=4.334e-011            prt=0                     at=33000
+ noimod=2                  em=4100                   noia=2e020
+ ef=0.98                   noib=5000                 noic=4e-013
+ cj=cjn_uhvt               cjsw=cjswn_uhvt           rd=0
+ rs=0                      xti=3                     n=1
+ cjswg=cjswgn_uhvt         sa0=3.5e-007              sb0=3.5e-007
+ wwn=-1                    rsh=6.6                   alpha1=1.9939
+ beta0=13.572              mj=0.48                   pb=0.8
+ mjsw=0.35                 pbsw=0.74                 mjswg=0.46
+ pbswg=0.8                 js=2.000e-07              jsw=7.500e-13
+ tcj=9.500e-04             tpb=0.0015                tcjsw=4.800e-04
+ tpbsw=0.0009              tcjswg=0.0009             tpbswg=0.0015
+ capmod=3                  xpart=1                   dlc=1.8e-08
+ wwc=-0.045                kvsat=0.4                 wlod=5e-07
+ tku0=0.03                 ku0=-6.2e-08              llodku0=1
+ wlodku0=1                 lku0=2e-07                wku0=7e-07
+ pku0=-5e-14               kvth0=5.2e-09             stk2=2.5e-09
+ steta0=-1.1e-10           lkvth0=-1e-08             wkvth0=2.2e-06
+ pkvth0=-5e-14             llodvth=1                 wlodvth=1
+ lodk2=1                   lodeta0=2                 tlev=1
+ tlevc=1                   minr=1e-3                 imax=0.01
+ imelt=0.01

     5: type=n
+ lmin=1.0000e-05-dxl_uhvt  lmax=21e-6                wmin=1.2000e-06-dxw_uhvt
+ wmax=1.0000e-05-dxw_uhvt  version=3.24              mobmod=1
+ nqsmod=0                  binunit=2                 tnom=25
+ xl=-2e-08+dxl_uhvt        xw=1.5e-08+dxw_uhvt       llc=0
+ lwc=0                     lwlc=0                    wlc=0
+ wwlc=0                    tox=toxn_uhvt             toxm=toxn_uhvt
+ wint=0                    lint=0                    dwc=0
+ hdif=hdifn_uhvt           ldif=8e-008               ll=0
+ wl=0                      lln=1                     wln=1
+ lw=0                      ww=0                      lwn=1
+ lwl=0                     wwl=0                     cgbo=0
+ cgso=cgon_uhvt            cgdo=cgon_uhvt            vth0=0.32564464+dvthn_uhvt
+ wvth0=-8.5592401e-009+dwvthn_uhvt                   lvth0=0+dlvthn_uhvt
+ pvth0=0+dpvthn_uhvt       k1=0.405                  k2=0.016065233+dk2n_uhvt
+ wk2=-2.1885106e-008+dwk2n_uhvt                      k3=-4.426
+ k3b=3.154                 nlx=4.655e-007            dvt0=0.8812
+ dvt1=0.1131               dvt2=0.01298              dvt0w=0
+ dvt1w=0                   dvt2w=-0.032              nch=6.148e017
+ voff=-0.12784924          wvoff=-7.6189682e-009     nfactor=1
+ cdsc=0.00024              cdscb=-0.0001318          cdscd=0
+ cit=-0.0014896996         wcit=1.6995415e-009       u0=272.1001
+ wu0=2.5027826e-006        ua=-1.8945945e-009        wua=1.2658411e-015
+ ub=3.148739e-018          wub=-1.6098009e-024       uc=1.5837991e-010
+ wuc=-1.2979348e-016       ngate=0                   xj=1.9e-007
+ w0=4.441e-021             prwg=0                    prwb=0
+ wr=1                      rdsw=50                   a0=2.3725566
+ wa0=-2.2289976e-007       ags=0.87201536            wags=-2.5914171e-007
+ a1=0                      a2=1                      b0=0
+ b1=0                      vsat=121067.06            wvsat=-0.0016731309
+ keta=-0.050343899         wketa=1.1197671e-007      dwg=0
+ dwb=0                     alpha0=0                  pclm=0.52956334
+ wpclm=1.4989041e-008      pdiblc1=0                 pdiblc2=0.0038637003
+ wpdiblc2=1.5262826e-009   pdiblcb=0                 drout=0.56
+ pvag=0                    pscbe1=4.24e008           pscbe2=1e-005
+ delta=0.00214             eta0=0.040974002          weta0=-2.1572327e-008
+ etab=-0.01912             dsub=0.2082               clc=1e-007
+ cle=0.6                   cf=0                      ckappa=0.6
+ cgdl=cgln_uhvt            cgsl=cgln_uhvt            kt1=-0.24347165
+ wkt1=6.1809052e-008       kt1l=0                    kt2=-0.015710011
+ wkt2=-5.8075619e-010      ute=-1                    ua1=2.6658779e-009
+ wua1=-4.7248665e-016      lua1=0+dlua1n_uhvt        ub1=-1.209e-018
+ uc1=4.334e-011            prt=0                     at=33000
+ noimod=2                  em=4100                   noia=2e020
+ ef=0.98                   noib=5000                 noic=4e-013
+ cj=cjn_uhvt               cjsw=cjswn_uhvt           rd=0
+ rs=0                      xti=3                     n=1
+ cjswg=cjswgn_uhvt         sa0=3.5e-007              sb0=3.5e-007
+ wwn=-1                    rsh=6.6                   alpha1=1.9939
+ beta0=13.572              mj=0.48                   pb=0.8
+ mjsw=0.35                 pbsw=0.74                 mjswg=0.46
+ pbswg=0.8                 js=2.000e-07              jsw=7.500e-13
+ tcj=9.500e-04             tpb=0.0015                tcjsw=4.800e-04
+ tpbsw=0.0009              tcjswg=0.0009             tpbswg=0.0015
+ capmod=3                  xpart=1                   dlc=1.8e-08
+ wwc=-0.045                kvsat=0.4                 wlod=5e-07
+ tku0=0.03                 ku0=-6.2e-08              llodku0=1
+ wlodku0=1                 lku0=2e-07                wku0=7e-07
+ pku0=-5e-14               kvth0=5.2e-09             stk2=2.5e-09
+ steta0=-1.1e-10           lkvth0=-1e-08             wkvth0=2.2e-06
+ pkvth0=-5e-14             llodvth=1                 wlodvth=1
+ lodk2=1                   lodeta0=2                 tlev=1
+ tlevc=1                   minr=1e-3                 imax=0.01
+ imelt=0.01

     6: type=n
+ lmin=8.0000e-07-dxl_uhvt  lmax=1.0000e-05-dxl_uhvt  wmin=1.2000e-06-dxw_uhvt
+ wmax=1.0000e-05-dxw_uhvt  version=3.24              mobmod=1
+ nqsmod=0                  binunit=2                 tnom=25
+ xl=-2e-08+dxl_uhvt        xw=1.5e-08+dxw_uhvt       llc=0
+ lwc=0                     lwlc=0                    wlc=0
+ wwlc=0                    tox=toxn_uhvt             toxm=toxn_uhvt
+ wint=0                    lint=0                    dwc=0
+ hdif=hdifn_uhvt           ldif=8e-008               ll=0
+ wl=0                      lln=1                     wln=1
+ lw=0                      ww=0                      lwn=1
+ lwl=0                     wwl=0                     cgbo=0
+ cgso=cgon_uhvt            cgdo=cgon_uhvt            vth0=0.3274743+dvthn_uhvt
+ lvth0=-1.8259985e-008+dlvthn_uhvt                   wvth0=-9.3493932e-009+dwvthn_uhvt
+ pvth0=7.8857276e-015+dpvthn_uhvt                    k1=0.405
+ k2=0.016220616+dk2n_uhvt  lk2=-1.5507272e-009       wk2=-2.2142152e-008+dwk2n_uhvt
+ pk2=2.5653185e-015        k3=-4.426                 k3b=3.154
+ nlx=4.655e-007            dvt0=0.8812               dvt1=0.1131
+ dvt2=0.01298              dvt0w=0                   dvt1w=0
+ dvt2w=-0.032              nch=6.148e017             voff=-0.1285448
+ lvoff=6.9416108e-009      wvoff=-5.1277586e-009     pvoff=-2.4862272e-014
+ nfactor=1                 cdsc=0.00024              cdscb=-0.00013142776
+ lcdscb=-3.7149934e-012    wcdscb=-3.7280219e-012    pcdscb=3.7205659e-017
+ cdscd=0                   cit=-0.0016268078         lcit=1.3683402e-009
+ wcit=1.9597752e-009       pcit=-2.5971322e-015      u0=272.90214
+ lu0=-8.0043939e-006       wu0=2.5027826e-006        pu0=-8.9361677e-026
+ ua=-1.9216225e-009        lua=2.6973891e-016        wua=1.3319783e-015
+ pua=-6.6004944e-022       ub=3.1937277e-018         lub=-4.4898777e-025
+ wub=-1.723611e-024        pub=1.1358256e-030        uc=1.5829842e-010
+ luc=8.1323808e-019        wuc=-1.3578715e-016       puc=5.9816871e-023
+ ngate=0                   xj=1.9e-007               w0=4.441e-021
+ prwg=0                    prwb=0                    wr=1
+ rdsw=50                   a0=2.3936877              la0=-2.108882e-007
+ wa0=-3.6184478e-007       pa0=1.3866713e-012        ags=0.83868593
+ lags=3.3262766e-007       wags=-2.9237855e-007      pags=3.3170366e-013
+ a1=0                      a2=1                      b0=0
+ b1=0                      vsat=123029.94            lvsat=-0.019589521
+ wvsat=-0.0035852076       pvsat=1.9082525e-008      keta=-0.053864128
+ lketa=3.5131878e-008      wketa=1.1993797e-007      pketa=-7.9453386e-014
+ dwg=0                     dwb=0                     alpha0=0
+ pclm=0.52200775           lpclm=7.5404846e-008      wpclm=3.2121529e-008
+ ppclm=-1.7098223e-013     pdiblc1=0                 pdiblc2=0.0023318016
+ lpdiblc2=1.528835e-008    wpdiblc2=1.3977713e-009   ppdiblc2=1.2825422e-015
+ pdiblcb=0                 drout=0.56                pvag=0
+ pscbe1=4.24e008           pscbe2=1e-005             delta=0.0013081694
+ ldelta=8.3016693e-009     wdelta=-6.2719865e-010    pdelta=6.2594426e-015
+ eta0=0.044141079          leta0=-3.1607429e-008     weta0=-2.5606363e-008
+ peta0=4.0259682e-014      etab=-0.019238626         letab=1.1838913e-009
+ wetab=1.1880432e-009      petab=-1.1856671e-014     dsub=0.2082
+ clc=1e-007                cle=0.6                   cf=0
+ ckappa=0.6                cgdl=cgln_uhvt            cgsl=cgln_uhvt
+ kt1=-0.24337153           lkt1=-9.9915505e-010      wkt1=6.3438596e-008
+ pkt1=-1.6262851e-014      kt1l=0                    kt2=-0.015353379
+ lkt2=-3.5591938e-009      wkt2=-4.2319451e-010      pkt2=-1.5724656e-015
+ ute=-1                    ua1=2.6874394e-009        lua1=-2.1518409e-016+dlua1n_uhvt
+ wua1=-4.8574574e-016      pua1=1.3232579e-022       ub1=-1.209e-018
+ uc1=4.334e-011            prt=0                     at=33000
+ noimod=2                  em=4100                   noia=2e020
+ ef=0.98                   noib=5000                 noic=4e-013
+ cj=cjn_uhvt               cjsw=cjswn_uhvt           rd=0
+ rs=0                      xti=3                     n=1
+ cjswg=cjswgn_uhvt         sa0=3.5e-007              sb0=3.5e-007
+ wwn=-1                    rsh=6.6                   alpha1=1.9939
+ beta0=13.572              mj=0.48                   pb=0.8
+ mjsw=0.35                 pbsw=0.74                 mjswg=0.46
+ pbswg=0.8                 js=2.000e-07              jsw=7.500e-13
+ tcj=9.500e-04             tpb=0.0015                tcjsw=4.800e-04
+ tpbsw=0.0009              tcjswg=0.0009             tpbswg=0.0015
+ capmod=3                  xpart=1                   dlc=1.8e-08
+ wwc=-0.045                kvsat=0.4                 wlod=5e-07
+ tku0=0.03                 ku0=-6.2e-08              llodku0=1
+ wlodku0=1                 lku0=2e-07                wku0=7e-07
+ pku0=-5e-14               kvth0=5.2e-09             stk2=2.5e-09
+ steta0=-1.1e-10           lkvth0=-1e-08             wkvth0=2.2e-06
+ pkvth0=-5e-14             llodvth=1                 wlodvth=1
+ lodk2=1                   lodeta0=2                 tlev=1
+ tlevc=1                   minr=1e-3                 imax=0.01
+ imelt=0.01

     7: type=n
+ lmin=3.5000e-07-dxl_uhvt  lmax=8.0000e-07-dxl_uhvt  wmin=1.2000e-06-dxw_uhvt
+ wmax=1.0000e-05-dxw_uhvt  version=3.24              mobmod=1
+ nqsmod=0                  binunit=2                 tnom=25
+ xl=-2e-08+dxl_uhvt        xw=1.5e-08+dxw_uhvt       llc=0
+ lwc=0                     lwlc=0                    wlc=0
+ wwlc=0                    tox=toxn_uhvt             toxm=toxn_uhvt
+ wint=0                    lint=0                    dwc=0
+ hdif=hdifn_uhvt           ldif=8e-008               ll=0
+ wl=0                      lln=1                     wln=1
+ lw=0                      ww=0                      lwn=1
+ lwl=0                     wwl=0                     cgbo=0
+ cgso=cgon_uhvt            cgdo=cgon_uhvt            vth0=0.31444868+dvthn_uhvt
+ lvth0=-8.1000043e-009+dlvthn_uhvt                   wvth0=-1.569701e-008+dwvthn_uhvt
+ pvth0=1.2836869e-014+dpvthn_uhvt                    k1=0.405
+ k2=0.00049274868+dk2n_uhvt                          lk2=1.071701e-008
+ wk2=-5.4716821e-009+dwk2n_uhvt                      pk2=-1.0437648e-014
+ k3=-4.426                 k3b=3.154                 nlx=4.655e-007
+ dvt0=0.8812               dvt1=0.1131               dvt2=0.01298
+ dvt0w=0                   dvt1w=0                   dvt2w=-0.032
+ nch=6.148e017             voff=-0.11729808          lvoff=-1.830829e-009
+ wvoff=-3.7448634e-008     pvoff=3.4801124e-016      nfactor=1
+ cdsc=0.00024              cdscb=-0.00013941032      lcdscb=2.511405e-012
+ wcdscb=7.6217337e-011     pcdscb=-2.5151721e-017    cdscd=0
+ cit=0.00018855682         lcit=-4.764423e-011       wcit=-2.0499765e-009
+ pcit=5.3047414e-016       u0=233.84194              lu0=2.246256e-005
+ wu0=4.994872e-005         pu0=-3.7007831e-011       ua=-1.7100153e-009
+ lua=1.0468533e-016        wua=6.063279e-016         pua=-9.4042127e-023
+ ub=2.5193923e-018         lub=7.6993898e-026        wub=7.3387302e-026
+ pub=-2.6583313e-031       uc=1.0279035e-010         luc=4.4109532e-017
+ wuc=3.9936299e-017        puc=-7.7247421e-023       ngate=0
+ xj=1.9e-007               w0=4.441e-021             prwg=0
+ prwb=0                    wr=1                      rdsw=50
+ a0=1.1633098              la0=7.4880653e-007        wa0=2.0960413e-006
+ pa0=-5.3047985e-013       ags=0.79962419            lags=3.6309582e-007
+ wags=-1.7203289e-007      pags=2.3783404e-013       a1=0
+ a2=1                      b0=0                      b1=0
+ vsat=83279.391            lvsat=0.011415908         wvsat=0.04855214
+ pvsat=-2.1584606e-008     keta=0.042027772          lketa=-3.9663804e-008
+ wketa=-6.1624685e-008     pketa=6.2165484e-014      dwg=0
+ dwb=0                     alpha0=0                  pclm=0.77338858
+ lpclm=-1.2067221e-007     wpclm=-1.0020533e-006     ppclm=6.3567416e-013
+ pdiblc1=0                 pdiblc2=0.026112001       lpdiblc2=-3.260206e-009
+ wpdiblc2=6.5698275e-009   ppdiblc2=-2.7516616e-015  pdiblcb=0
+ drout=0.56                pvag=0                    pscbe1=4.24e008
+ pscbe2=1e-005             delta=-0.0030159606       ldelta=1.1674491e-008
+ wdelta=3.2514972e-008     pdelta=-1.9591451e-014    eta0=-0.00022233098
+ leta0=2.9960308e-009      weta0=3.6810042e-008      peta0=-8.4251147e-015
+ etab=-0.02778027          letab=7.846373e-009       wetab=-1.0819977e-008
+ petab=-2.4904159e-015     dsub=0.2082               clc=1e-007
+ cle=0.6                   cf=0                      ckappa=0.6
+ cgdl=cgln_uhvt            cgsl=cgln_uhvt            kt1=-0.24844513
+ lkt1=2.9582475e-009       wkt1=1.2269627e-008       pkt1=2.3648945e-014
+ kt1l=0                    kt2=-0.010135401          lkt2=-7.6292164e-009
+ wkt2=-2.4229517e-009      pkt2=-1.2654954e-017      ute=-1
+ ua1=2.5445411e-009        lua1=-1.0372339e-016+dlua1n_uhvt
+ wua1=1.4193497e-016       pua1=-3.5726517e-022      ub1=-1.209e-018
+ uc1=4.334e-011            prt=0                     at=33000
+ noimod=2                  em=4100                   noia=2e020
+ ef=0.98                   noib=5000                 noic=4e-013
+ cj=cjn_uhvt               cjsw=cjswn_uhvt           rd=0
+ rs=0                      xti=3                     n=1
+ cjswg=cjswgn_uhvt         sa0=3.5e-007              sb0=3.5e-007
+ wwn=-1                    rsh=6.6                   alpha1=1.9939
+ beta0=13.572              mj=0.48                   pb=0.8
+ mjsw=0.35                 pbsw=0.74                 mjswg=0.46
+ pbswg=0.8                 js=2.000e-07              jsw=7.500e-13
+ tcj=9.500e-04             tpb=0.0015                tcjsw=4.800e-04
+ tpbsw=0.0009              tcjswg=0.0009             tpbswg=0.0015
+ capmod=3                  xpart=1                   dlc=1.8e-08
+ wwc=-0.045                kvsat=0.4                 wlod=5e-07
+ tku0=0.03                 ku0=-6.2e-08              llodku0=1
+ wlodku0=1                 lku0=2e-07                wku0=7e-07
+ pku0=-5e-14               kvth0=5.2e-09             stk2=2.5e-09
+ steta0=-1.1e-10           lkvth0=-1e-08             wkvth0=2.2e-06
+ pkvth0=-5e-14             llodvth=1                 wlodvth=1
+ lodk2=1                   lodeta0=2                 tlev=1
+ tlevc=1                   minr=1e-3                 imax=0.01
+ imelt=0.01

     8: type=n
+ lmin=1.3e-07              lmax=3.5000e-07-dxl_uhvt  wmin=1.2000e-06-dxw_uhvt
+ wmax=1.0000e-05-dxw_uhvt  version=3.24              mobmod=1
+ nqsmod=0                  binunit=2                 tnom=25
+ xl=-2e-08+dxl_uhvt        xw=1.5e-08+dxw_uhvt       llc=0
+ lwc=0                     lwlc=0                    wlc=0
+ wwlc=0                    tox=toxn_uhvt             toxm=toxn_uhvt
+ wint=0                    lint=0                    dwc=0
+ hdif=hdifn_uhvt           ldif=8e-008               ll=0
+ wl=0                      lln=1                     wln=1
+ lw=0                      ww=0                      lwn=1
+ lwl=0                     wwl=0                     cgbo=0
+ cgso=cgon_uhvt            cgdo=cgon_uhvt            vth0=0.30514377+dvthn_uhvt
+ lvth0=-5.0293828e-009+dlvthn_uhvt                   wvth0=3.326212e-008+dwvthn_uhvt
+ pvth0=-3.3196439e-015+dpvthn_uhvt                   k1=0.405
+ k2=0.036420869+dk2n_uhvt  lk2=-1.1392702e-009       wk2=-4.516133e-008+dwk2n_uhvt
+ pk2=2.659936e-015         k3=-4.426                 k3b=3.154
+ nlx=4.655e-007            dvt0=0.8812               dvt1=0.1131
+ dvt2=0.01298              dvt0w=0                   dvt1w=0
+ dvt2w=-0.032              nch=6.148e017             voff=-0.11403957
+ lvoff=-2.9061366e-009     wvoff=-3.0399821e-008     pvoff=-1.9780971e-015
+ nfactor=1                 cdsc=0.00024              cdscb=-0.0002067987
+ lcdscb=2.474957e-011      wcdscb=9.1123416e-011     pcdscb=-3.0070727e-017
+ cdscd=0                   cit=6.6270547e-005        lcit=-7.2897602e-012
+ wcit=-6.6371872e-010      pcit=7.3009059e-017       u0=352.91986
+ lu0=-1.6833153e-005       wu0=-9.5942306e-005       pu0=1.1136207e-011
+ ua=-1.0079253e-009        lua=-1.2700436e-016       wua=-5.2544608e-018
+ pua=1.0778005e-022        ub=2.7046195e-018         lub=1.5868913e-026
+ wub=-4.3985368e-025       pub=-9.6463604e-032       uc=2.3601555e-010
+ luc=1.4521753e-019        wuc=-2.0160744e-016       puc=2.4620122e-024
+ ngate=0                   xj=1.9e-007               w0=4.441e-021
+ prwg=0                    prwb=0                    wr=1
+ rdsw=50                   a0=2.1458446              la0=4.2457006e-007
+ wa0=1.5844273e-006        pa0=-3.6164725e-013       ags=1.4744574
+ lags=1.4040085e-007       wags=2.2075649e-007       pags=1.0821355e-013
+ a1=0                      a2=1                      b0=0
+ b1=0                      vsat=126905.42            lvsat=-0.0029806831
+ wvsat=-0.01592309         pvsat=-3.0778004e-010     keta=-0.1476324
+ lketa=2.2924054e-008      wketa=1.9682381e-007      pketa=-2.3122518e-014
+ dwg=0                     dwb=0                     alpha0=0
+ pclm=0.13125098           lpclm=9.1233201e-008      wpclm=1.3911738e-006
+ ppclm=-1.540908e-013      pdiblc1=0                 pdiblc2=0.021501903
+ lpdiblc2=-1.7388735e-009  wpdiblc2=1.9877072e-010   ppdiblc2=-6.4921283e-016
+ pdiblcb=0                 drout=0.56                pvag=0
+ pscbe1=4.24e008           pscbe2=1e-005             delta=0.033801926
+ ldelta=-4.7541188e-010    wdelta=-4.027959e-008     pdelta=4.4307549e-015
+ eta0=0.0033678032         leta0=1.8112865e-009      weta0=1.6273342e-008
+ peta0=-1.6480036e-015     etab=0.0035549274         letab=-2.494242e-009
+ wetab=-2.7550037e-008     petab=3.030504e-015       dsub=0.2082
+ clc=1e-007                cle=0.6                   cf=0
+ ckappa=0.6                cgdl=cgln_uhvt            cgsl=cgln_uhvt
+ kt1=-0.22700968           lkt1=-4.1154488e-009      wkt1=1.0630604e-007
+ pkt1=-7.3830705e-015      kt1l=0                    kt2=-0.02415946
+ lkt2=-3.0012769e-009      wkt2=-8.9187558e-009      pkt2=2.1309604e-015
+ ute=-1                    ua1=2.4907806e-009        lua1=-8.5982438e-017+dlua1n_uhvt
+ wua1=-1.1605445e-015      pua1=7.2553042e-023       ub1=-1.209e-018
+ uc1=4.334e-011            prt=0                     at=33000
+ noimod=2                  em=4100                   noia=2e020
+ ef=0.98                   noib=5000                 noic=4e-013
+ cj=cjn_uhvt               cjsw=cjswn_uhvt           rd=0
+ rs=0                      xti=3                     n=1
+ cjswg=cjswgn_uhvt         sa0=3.5e-007              sb0=3.5e-007
+ wwn=-1                    rsh=6.6                   alpha1=1.9939
+ beta0=13.572              mj=0.48                   pb=0.8
+ mjsw=0.35                 pbsw=0.74                 mjswg=0.46
+ pbswg=0.8                 js=2.000e-07              jsw=7.500e-13
+ tcj=9.500e-04             tpb=0.0015                tcjsw=4.800e-04
+ tpbsw=0.0009              tcjswg=0.0009             tpbswg=0.0015
+ capmod=3                  xpart=1                   dlc=1.8e-08
+ wwc=-0.045                kvsat=0.4                 wlod=5e-07
+ tku0=0.03                 ku0=-6.2e-08              llodku0=1
+ wlodku0=1                 lku0=2e-07                wku0=7e-07
+ pku0=-5e-14               kvth0=5.2e-09             stk2=2.5e-09
+ steta0=-1.1e-10           lkvth0=-1e-08             wkvth0=2.2e-06
+ pkvth0=-5e-14             llodvth=1                 wlodvth=1
+ lodk2=1                   lodeta0=2                 tlev=1
+ tlevc=1                   minr=1e-3                 imax=0.01
+ imelt=0.01

     9: type=n
+ lmin=1.0000e-05-dxl_uhvt  lmax=21e-6                wmin=6.0000e-07-dxw_uhvt
+ wmax=1.2000e-06-dxw_uhvt  version=3.24              mobmod=1
+ nqsmod=0                  binunit=2                 tnom=25
+ xl=-2e-08+dxl_uhvt        xw=1.5e-08+dxw_uhvt       llc=0
+ lwc=0                     lwlc=0                    wlc=0
+ wwlc=0                    tox=toxn_uhvt             toxm=toxn_uhvt
+ wint=0                    lint=0                    dwc=0
+ hdif=hdifn_uhvt           ldif=8e-008               ll=0
+ wl=0                      lln=1                     wln=1
+ lw=0                      ww=0                      lwn=1
+ lwl=0                     wwl=0                     cgbo=0
+ cgso=cgon_uhvt            cgdo=cgon_uhvt            vth0=0.32769175+dvthn_uhvt
+ wvth0=-1.1046476e-008+dwvthn_uhvt                   lvth0=0+dlvthn_uhvt
+ pvth0=0+dpvthn_uhvt       k1=0.405                  k2=0.004376845+dk2n_uhvt
+ wk2=-7.6837147e-009+dwk2n_uhvt                      k3=-4.426
+ k3b=3.154                 nlx=4.655e-007            dvt0=0.8812
+ dvt1=0.1131               dvt2=0.01298              dvt0w=0
+ dvt1w=0                   dvt2w=-0.032              nch=6.148e017
+ voff=-0.12429025          wvoff=-1.1943146e-008     nfactor=1
+ cdsc=0.00024              cdscb=0.0007379125        wcdscb=-1.0567007e-009
+ cdscd=0                   cit=0.001575955           wcit=-2.0252288e-009
+ u0=274.324                wu0=-1.9926e-007          ua=-1.0521945e-009
+ wua=2.4232507e-016        ub=1.813345e-018          wub=1.2702825e-026
+ uc=9.236335e-011          wuc=-4.958336e-017        ngate=0
+ xj=1.9e-007               w0=4.441e-021             prwg=0
+ prwb=0                    wr=1                      rdsw=50
+ a0=1.039255               wa0=1.3970617e-006        ags=0.49631875
+ wags=1.9732967e-007       a1=0                      a2=1
+ b0=0                      b1=0                      vsat=150839.75
+ wvsat=-0.037846946        keta=0.06345165           wketa=-2.6284885e-008
+ dwg=0                     dwb=0                     alpha0=0
+ pclm=0.4823475            wpclm=7.2356288e-008      pdiblc1=0
+ pdiblc2=-0.032021078      wpdiblc2=4.5126288e-008   pdiblcb=0
+ drout=0.56                pvag=0                    pscbe1=4.24e008
+ pscbe2=1e-005             delta=-0.0083355          wdelta=1.2727733e-008
+ eta0=0.011690825          weta0=1.4006733e-008      etab=-0.01912
+ dsub=0.2082               clc=1e-007                cle=0.6
+ cf=0                      ckappa=0.6                cgdl=cgln_uhvt
+ cgsl=cgln_uhvt            kt1=-0.2006975            wkt1=9.8384625e-009
+ kt1l=0                    kt2=-0.00999905           wkt2=-7.5195743e-009
+ ute=-1                    ua1=2.292375e-009         wua1=-1.8680625e-017
+ lua1=0+dlua1n_uhvt        ub1=-1.209e-018           uc1=4.334e-011
+ prt=0                     at=33000                  noimod=2
+ em=4100                   noia=2e020                ef=0.98
+ noib=5000                 noic=4e-013               cj=cjn_uhvt
+ cjsw=cjswn_uhvt           rd=0                      rs=0
+ xti=3                     n=1                       cjswg=cjswgn_uhvt
+ sa0=3.5e-007              sb0=3.5e-007              wwn=-1
+ rsh=6.6                   alpha1=1.9939             beta0=13.572
+ mj=0.48                   pb=0.8                    mjsw=0.35
+ pbsw=0.74                 mjswg=0.46                pbswg=0.8
+ js=2.000e-07              jsw=7.500e-13             tcj=9.500e-04
+ tpb=0.0015                tcjsw=4.800e-04           tpbsw=0.0009
+ tcjswg=0.0009             tpbswg=0.0015             capmod=3
+ xpart=1                   dlc=1.8e-08               wwc=-0.045
+ kvsat=0.4                 wlod=5e-07                tku0=0.03
+ ku0=-6.2e-08              llodku0=1                 wlodku0=1
+ lku0=2e-07                wku0=7e-07                pku0=-5e-14
+ kvth0=5.2e-09             stk2=2.5e-09              steta0=-1.1e-10
+ lkvth0=-1e-08             wkvth0=2.2e-06            pkvth0=-5e-14
+ llodvth=1                 wlodvth=1                 lodk2=1
+ lodeta0=2                 tlev=1                    tlevc=1
+ minr=1e-3                 imax=0.01                 imelt=0.01

     10: type=n
+ lmin=8.0000e-07-dxl_uhvt  lmax=1.0000e-05-dxl_uhvt  wmin=6.0000e-07-dxw_uhvt
+ wmax=1.2000e-06-dxw_uhvt  version=3.24              mobmod=1
+ nqsmod=0                  binunit=2                 tnom=25
+ xl=-2e-08+dxl_uhvt        xw=1.5e-08+dxw_uhvt       llc=0
+ lwc=0                     lwlc=0                    wlc=0
+ wwlc=0                    tox=toxn_uhvt             toxm=toxn_uhvt
+ wint=0                    lint=0                    dwc=0
+ hdif=hdifn_uhvt           ldif=8e-008               ll=0
+ wl=0                      lln=1                     wln=1
+ lw=0                      ww=0                      lwn=1
+ lwl=0                     wwl=0                     cgbo=0
+ cgso=cgon_uhvt            cgdo=cgon_uhvt            vth0=0.3278717+dvthn_uhvt
+ lvth0=-1.7959119e-009+dlvthn_uhvt                   wvth0=-9.8322356e-009+dwvthn_uhvt
+ pvth0=-1.2118121e-014+dpvthn_uhvt                   k1=0.405
+ k2=0.0040727709+dk2n_uhvt lk2=3.0346595e-009        wk2=-7.3825197e-009+dwk2n_uhvt
+ pk2=-3.0059264e-015       k3=-4.426                 k3b=3.154
+ nlx=4.655e-007            dvt0=0.8812               dvt1=0.1131
+ dvt2=0.01298              dvt0w=0                   dvt1w=0
+ dvt2w=-0.032              nch=6.148e017             voff=-0.12161712
+ lvoff=-2.6677858e-008     wvoff=-1.3544888e-008     pvoff=1.5985383e-014
+ nfactor=1                 cdsc=0.00024              cdscb=0.00073245292
+ lcdscb=5.4486569e-011     wcdscb=-1.0533431e-009    pcdscb=-3.350924e-017
+ cdscd=0                   cit=0.0018368159          lcit=-2.6033921e-009
+ wcit=-2.2485277e-009      pcit=2.2285225e-015       u0=275.31462
+ lu0=-9.8863995e-006       wu0=-4.2838193e-007       pu0=2.2866368e-012
+ ua=-1.04739e-009          lua=-4.794852e-017        wua=2.6978591e-016
+ pua=-2.7405922e-022       ub=1.7756646e-018         lub=3.7604998e-025
+ wub=-6.6438049e-028       pub=1.3340471e-031        uc=8.6578758e-011
+ luc=5.7730232e-017        wuc=-4.8647762e-017       puc=-9.337276e-024
+ ngate=0                   xj=1.9e-007               w0=4.441e-021
+ prwg=0                    prwb=0                    wr=1
+ rdsw=50                   a0=0.97906825             la0=6.0066377e-007
+ wa0=1.3569178e-006        pa0=4.0063563e-013        ags=0.42988532
+ lags=6.630056e-007        wags=2.0431419e-007       pags=-6.9705542e-014
+ a1=0                      a2=1                      b0=0
+ b1=0                      vsat=150904.76            lvsat=-0.00064877051
+ wvsat=-0.03745311         pvsat=-3.9304863e-009     keta=0.067697141
+ lketa=-4.2370003e-008     wketa=-2.7758973e-008     pketa=1.4711399e-014
+ dwg=0                     dwb=0                     alpha0=0
+ pclm=0.49560157           lpclm=-1.3227557e-007     wpclm=6.4205037e-008
+ ppclm=8.1349476e-014      pdiblc1=0                 pdiblc2=-0.037478541
+ lpdiblc2=5.4465482e-008   wpdiblc2=4.9767337e-008   ppdiblc2=-4.6317673e-014
+ pdiblcb=0                 drout=0.56                pvag=0
+ pscbe1=4.24e008           pscbe2=1e-005             delta=-0.0095775228
+ ldelta=1.2395388e-008     wdelta=1.2598917e-008     pdelta=1.2855746e-015
+ eta0=0.011128572          leta0=5.6112832e-009      weta0=1.4503832e-008
+ peta0=-4.9610535e-015     etab=-0.017430028         letab=-1.6865918e-008
+ wetab=-1.0094035e-009     petab=1.0073847e-014      dsub=0.2082
+ clc=1e-007                cle=0.6                   cf=0
+ ckappa=0.6                cgdl=cgln_uhvt            cgsl=cgln_uhvt
+ kt1=-0.1993431            lkt1=-1.3516934e-008      wkt1=9.9440486e-009
+ pkt1=-1.0537497e-015      kt1l=0                    kt2=-0.008774503
+ lkt2=-1.2220979e-008      wkt2=-8.4165285e-009      pkt2=8.9516036e-015
+ ute=-1                    ua1=2.3129219e-009        lua1=-2.050576e-016+dlua1n_uhvt
+ wua1=-3.0706887e-017      pua1=1.2002209e-022       ub1=-1.209e-018
+ uc1=4.334e-011            prt=0                     at=33000
+ noimod=2                  em=4100                   noia=2e020
+ ef=0.98                   noib=5000                 noic=4e-013
+ cj=cjn_uhvt               cjsw=cjswn_uhvt           rd=0
+ rs=0                      xti=3                     n=1
+ cjswg=cjswgn_uhvt         sa0=3.5e-007              sb0=3.5e-007
+ wwn=-1                    rsh=6.6                   alpha1=1.9939
+ beta0=13.572              mj=0.48                   pb=0.8
+ mjsw=0.35                 pbsw=0.74                 mjswg=0.46
+ pbswg=0.8                 js=2.000e-07              jsw=7.500e-13
+ tcj=9.500e-04             tpb=0.0015                tcjsw=4.800e-04
+ tpbsw=0.0009              tcjswg=0.0009             tpbswg=0.0015
+ capmod=3                  xpart=1                   dlc=1.8e-08
+ wwc=-0.045                kvsat=0.4                 wlod=5e-07
+ tku0=0.03                 ku0=-6.2e-08              llodku0=1
+ wlodku0=1                 lku0=2e-07                wku0=7e-07
+ pku0=-5e-14               kvth0=5.2e-09             stk2=2.5e-09
+ steta0=-1.1e-10           lkvth0=-1e-08             wkvth0=2.2e-06
+ pkvth0=-5e-14             llodvth=1                 wlodvth=1
+ lodk2=1                   lodeta0=2                 tlev=1
+ tlevc=1                   minr=1e-3                 imax=0.01
+ imelt=0.01

     11: type=n
+ lmin=3.5000e-07-dxl_uhvt  lmax=8.0000e-07-dxl_uhvt  wmin=6.0000e-07-dxw_uhvt
+ wmax=1.2000e-06-dxw_uhvt  version=3.24              mobmod=1
+ nqsmod=0                  binunit=2                 tnom=25
+ xl=-2e-08+dxl_uhvt        xw=1.5e-08+dxw_uhvt       llc=0
+ lwc=0                     lwlc=0                    wlc=0
+ wwlc=0                    tox=toxn_uhvt             toxm=toxn_uhvt
+ wint=0                    lint=0                    dwc=0
+ hdif=hdifn_uhvt           ldif=8e-008               ll=0
+ wl=0                      lln=1                     wln=1
+ lw=0                      ww=0                      lwn=1
+ lwl=0                     wwl=0                     cgbo=0
+ cgso=cgon_uhvt            cgdo=cgon_uhvt            vth0=0.31362912+dvthn_uhvt
+ lvth0=9.313304e-009+dlvthn_uhvt                     wvth0=-1.4701237e-008+dwvthn_uhvt
+ pvth0=-8.3203006e-015+dpvthn_uhvt                   k1=0.405
+ k2=0.013173063+dk2n_uhvt  lk2=-4.0635681e-009       wk2=-2.0878264e-008+dwk2n_uhvt
+ pk2=7.5207539e-015        k3=-4.426                 k3b=3.154
+ nlx=4.655e-007            dvt0=0.8812               dvt1=0.1131
+ dvt2=0.01298              dvt0w=0                   dvt1w=0
+ dvt2w=-0.032              nch=6.148e017             voff=-0.16456578
+ lvoff=6.822101e-009       wvoff=1.9981627e-008      pvoff=-1.0165299e-014
+ nfactor=1                 cdsc=0.00024              cdscb=0.0008495305
+ lcdscb=-3.683394e-011     wcdscb=-1.1253458e-009    pcdscb=2.2652873e-017
+ cdscd=0                   cit=-0.0033462565         lcit=1.4394044e-009
+ wcit=2.2448217e-009       pcit=-1.2762899e-015      u0=269.10335
+ lu0=-5.041608e-006        wu0=7.1061098e-006        pu0=-3.5902667e-012
+ ua=-1.021847e-009         lua=-6.787209e-017        wua=-2.297966e-016
+ pua=1.1561514e-022        ub=2.1863368e-018         lub=5.572567e-026
+ wub=4.7804965e-025        pub=-2.3999223e-031       uc=1.9809918e-010
+ luc=-2.9255698e-017       wuc=-7.5863928e-017       puc=1.1891334e-023
+ ngate=0                   xj=1.9e-007               w0=4.441e-021
+ prwg=0                    prwb=0                    wr=1
+ rdsw=50                   a0=1.4683365              la0=2.1903453e-007
+ wa0=1.7254339e-006        pa0=1.1319313e-013        ags=0.39249683
+ lags=6.9216862e-007       wags=3.2262685e-007       pags=-1.6198941e-013
+ a1=0                      a2=1                      b0=0
+ b1=0                      vsat=194683.87            lvsat=-0.034796476
+ wvsat=-0.086804298        pvsat=3.456344e-008       keta=-0.018006199
+ lketa=2.4478603e-008      wketa=1.131659e-008       pketa=-1.5767539e-014
+ dwg=0                     dwb=0                     alpha0=0
+ pclm=-0.76731668          lpclm=8.5280066e-007      wpclm=8.6990357e-007
+ ppclm=-5.4709538e-013     pdiblc1=0                 pdiblc2=0.052687157
+ lpdiblc2=-1.5863762e-008  wpdiblc2=-2.5718986e-008  ppdiblc2=1.2561659e-014
+ pdiblcb=0                 drout=0.56                pvag=0
+ pscbe1=4.24e008           pscbe2=1e-005             delta=0.00584815
+ ldelta=3.63363e-010       wdelta=2.1745078e-008     pdelta=-5.8484305e-015
+ eta0=0.010888822          leta0=5.7982882e-009      weta0=2.3309991e-008
+ peta0=-1.1829858e-014     etab=-0.053670533         letab=1.1401676e-008
+ wetab=2.0636694e-008      petab=-6.810109e-015      dsub=0.2082
+ clc=1e-007                cle=0.6                   cf=0
+ ckappa=0.6                cgdl=cgln_uhvt            cgsl=cgln_uhvt
+ kt1=-0.2613545            lkt1=3.485196e-008        wkt1=2.7954518e-008
+ pkt1=-1.5101915e-014      kt1l=0                    kt2=-0.00721329
+ lkt2=-1.3438725e-008      wkt2=-5.9733167e-009      pkt2=7.0458984e-015
+ ute=-1                    ua1=2.6654463e-009        lua1=-4.8002669e-016+dlua1n_uhvt
+ wua1=-4.964895e-018       pua1=9.9943336e-023       ub1=-1.209e-018
+ uc1=4.334e-011            prt=0                     at=33000
+ noimod=2                  em=4100                   noia=2e020
+ ef=0.98                   noib=5000                 noic=4e-013
+ cj=cjn_uhvt               cjsw=cjswn_uhvt           rd=0
+ rs=0                      xti=3                     n=1
+ cjswg=cjswgn_uhvt         sa0=3.5e-007              sb0=3.5e-007
+ wwn=-1                    rsh=6.6                   alpha1=1.9939
+ beta0=13.572              mj=0.48                   pb=0.8
+ mjsw=0.35                 pbsw=0.74                 mjswg=0.46
+ pbswg=0.8                 js=2.000e-07              jsw=7.500e-13
+ tcj=9.500e-04             tpb=0.0015                tcjsw=4.800e-04
+ tpbsw=0.0009              tcjswg=0.0009             tpbswg=0.0015
+ capmod=3                  xpart=1                   dlc=1.8e-08
+ wwc=-0.045                kvsat=0.4                 wlod=5e-07
+ tku0=0.03                 ku0=-6.2e-08              llodku0=1
+ wlodku0=1                 lku0=2e-07                wku0=7e-07
+ pku0=-5e-14               kvth0=5.2e-09             stk2=2.5e-09
+ steta0=-1.1e-10           lkvth0=-1e-08             wkvth0=2.2e-06
+ pkvth0=-5e-14             llodvth=1                 wlodvth=1
+ lodk2=1                   lodeta0=2                 tlev=1
+ tlevc=1                   minr=1e-3                 imax=0.01
+ imelt=0.01

     12: type=n
+ lmin=1.3e-07              lmax=3.5000e-07-dxl_uhvt  wmin=6.0000e-07-dxw_uhvt
+ wmax=1.2000e-06-dxw_uhvt  version=3.24              mobmod=1
+ nqsmod=0                  binunit=2                 tnom=25
+ xl=-2e-08+dxl_uhvt        xw=1.5e-08+dxw_uhvt       llc=0
+ lwc=0                     lwlc=0                    wlc=0
+ wwlc=0                    tox=toxn_uhvt             toxm=toxn_uhvt
+ wint=0                    lint=0                    dwc=0
+ hdif=hdifn_uhvt           ldif=8e-008               ll=0
+ wl=0                      lln=1                     wln=1
+ lw=0                      ww=0                      lwn=1
+ lwl=0                     wwl=0                     cgbo=0
+ cgso=cgon_uhvt            cgdo=cgon_uhvt            vth0=0.36657563+dvthn_uhvt
+ lvth0=-8.1590438e-009+dlvthn_uhvt                   wvth0=-4.1377584e-008+dwvthn_uhvt
+ pvth0=4.8289416e-016+dpvthn_uhvt                    k1=0.405
+ k2=-0.0019445613+dk2n_uhvt                          lk2=9.2524781e-010
+ wk2=1.4526677e-009+dwk2n_uhvt                       pk2=1.5154657e-016
+ k3=-4.426                 k3b=3.154                 nlx=4.655e-007
+ dvt0=0.8812               dvt1=0.1131               dvt2=0.01298
+ dvt0w=0                   dvt1w=0                   dvt2w=-0.032
+ nch=6.148e017             voff=-0.112123            lvoff=-1.0484018e-008
+ wvoff=-3.2728455e-008     pvoff=7.2290283e-015      nfactor=1
+ cdsc=0.00024              cdscb=0.0007379125        wcdscb=-1.0567007e-009
+ cdscd=0                   cit=0.0016239509          lcit=-2.0076404e-010
+ wcit=-2.5563003e-009      pcit=3.0808031e-016       u0=258.24175
+ lu0=-1.45728e-006         wu0=1.9091599e-005        pu0=-7.5454781e-012
+ ua=-1.12705e-009          lua=-3.31551e-017         wua=1.39482e-016
+ pua=-6.246801e-024        ub=2.5407838e-018         lub=-6.1241813e-026
+ wub=-2.4079326e-025       pub=-2.7740728e-033       uc=1.2111159e-010
+ luc=-3.8497924e-018       wuc=-6.1999126e-017       puc=7.3159492e-024
+ ngate=0                   xj=1.9e-007               w0=4.441e-021
+ prwg=0                    prwb=0                    wr=1
+ rdsw=50                   a0=3.6287113              la0=-4.9388914e-007
+ wa0=-2.1725567e-007       pa0=7.5428067e-013        ags=3.306195
+ lags=-2.6935178e-007      wags=-2.0048047e-006      pags=6.0606299e-013
+ a1=0                      a2=1                      b0=0
+ b1=0                      vsat=100787.63            lvsat=-0.0038107163
+ wvsat=0.015810036         pvsat=7.0071024e-010      keta=-0.00369431
+ lketa=1.9755679e-008      wketa=2.1939024e-008      pketa=-1.9272943e-014
+ dwg=0                     dwb=0                     alpha0=0
+ pclm=2.1985245            lpclm=-1.2592693e-007     wpclm=-1.1205635e-006
+ ppclm=1.0975876e-013      pdiblc1=0                 pdiblc2=0.018536175
+ lpdiblc2=-4.5939383e-009  wpdiblc2=3.8021299e-009   ppdiblc2=2.8196909e-015
+ pdiblcb=0                 drout=0.56                pvag=0
+ pscbe1=4.24e008           pscbe2=1e-005             delta=-0.0135975
+ ldelta=6.7804275e-009     wdelta=1.7310713e-008     pdelta=-4.3850899e-015
+ eta0=0.030446326          leta0=-6.5568814e-010     weta0=-1.6627064e-008
+ peta0=1.3493707e-015      etab=-0.010606094         letab=-2.8095891e-009
+ wetab=-1.0344396e-008     petab=3.4136507e-015      dsub=0.2039975
+ ldsub=1.386825e-009       wdsub=5.1060375e-009      pdsub=-1.6849924e-015
+ clc=1e-007                cle=0.6                   cf=0
+ ckappa=0.6                cgdl=cgln_uhvt            cgsl=cgln_uhvt
+ kt1=-0.1046035            lkt1=-1.687587e-008       wkt1=-4.2417473e-008
+ pkt1=8.1208413e-015       kt1l=0                    kt2=-0.054385175
+ lkt2=2.1279968e-009       wkt2=2.7805488e-008       pkt2=-4.1011071e-015
+ ute=-1                    ua1=1.0687125e-009        lua1=4.6895475e-017+dlua1n_uhvt
+ wua1=5.6726831e-016       pua1=-8.8893622e-023      ub1=-1.209e-018
+ uc1=4.334e-011            prt=0                     at=33000
+ noimod=2                  em=4100                   noia=2e020
+ ef=0.98                   noib=5000                 noic=4e-013
+ cj=cjn_uhvt               cjsw=cjswn_uhvt           rd=0
+ rs=0                      xti=3                     n=1
+ cjswg=cjswgn_uhvt         sa0=3.5e-007              sb0=3.5e-007
+ wwn=-1                    rsh=6.6                   alpha1=1.9939
+ beta0=13.572              mj=0.48                   pb=0.8
+ mjsw=0.35                 pbsw=0.74                 mjswg=0.46
+ pbswg=0.8                 js=2.000e-07              jsw=7.500e-13
+ tcj=9.500e-04             tpb=0.0015                tcjsw=4.800e-04
+ tpbsw=0.0009              tcjswg=0.0009             tpbswg=0.0015
+ capmod=3                  xpart=1                   dlc=1.8e-08
+ wwc=-0.045                kvsat=0.4                 wlod=5e-07
+ tku0=0.03                 ku0=-6.2e-08              llodku0=1
+ wlodku0=1                 lku0=2e-07                wku0=7e-07
+ pku0=-5e-14               kvth0=5.2e-09             stk2=2.5e-09
+ steta0=-1.1e-10           lkvth0=-1e-08             wkvth0=2.2e-06
+ pkvth0=-5e-14             llodvth=1                 wlodvth=1
+ lodk2=1                   lodeta0=2                 tlev=1
+ tlevc=1                   minr=1e-3                 imax=0.01
+ imelt=0.01

     13: type=n
+ lmin=1.0000e-05-dxl_uhvt  lmax=21e-6                wmin=1.5e-07
+ wmax=6.0000e-07-dxw_uhvt  version=3.24              mobmod=1
+ nqsmod=0                  binunit=2                 tnom=25
+ xl=-2e-08+dxl_uhvt        xw=1.5e-08+dxw_uhvt       llc=0
+ lwc=0                     lwlc=0                    wlc=0
+ wwlc=0                    tox=toxn_uhvt             toxm=toxn_uhvt
+ wint=0                    lint=0                    dwc=0
+ hdif=hdifn_uhvt           ldif=8e-008               ll=0
+ wl=0                      lln=1                     wln=1
+ lw=0                      ww=0                      lwn=1
+ lwl=0                     wwl=0                     cgbo=0
+ cgso=cgon_uhvt            cgdo=cgon_uhvt            vth0=0.31864367+dvthn_uhvt
+ wvth0=-5.481905e-009+dwvthn_uhvt                    lvth0=0+dlvthn_uhvt
+ pvth0=0+dpvthn_uhvt       k1=0.405                  k2=-0.011439862+dk2n_uhvt
+ wk2=2.0435599e-009+dwk2n_uhvt                       k3=-4.426
+ k3b=3.154                 nlx=4.655e-007            dvt0=0.8812
+ dvt1=0.1131               dvt2=0.01298              dvt0w=0
+ dvt1w=0                   dvt2w=-0.032              nch=6.148e017
+ voff=-0.14740967          wvoff=2.275295e-009       nfactor=1
+ cdsc=0.00024              cdscb=-0.0013397434       wcdscb=2.2105766e-010
+ cdscd=0                   cit=-0.00098842333        wcit=-4.4813615e-010
+ u0=276.51533              wu0=-1.54693e-006         ua=-7.9892233e-010
+ wua=8.6562685e-017        ub=1.8296e-018            wub=2.706e-027
+ uc=-6.5790333e-012        wuc=1.1266206e-017        ngate=0
+ xj=1.9e-007               w0=4.441e-021             prwg=0
+ prwb=0                    wr=1                      rdsw=50
+ a0=3.2559733              wa0=3.37799e-008          ags=0.803397
+ wags=8.476545e-009        a1=0                      a2=1
+ b0=0                      b1=0                      vsat=89776.667
+ wvsat=-0.00029315         keta=0.03136616           wketa=-6.5523084e-009
+ dwg=0                     dwb=0                     alpha0=0
+ pclm=0.61855333           wpclm=-1.14103e-008       pdiblc1=0
+ pdiblc2=0.039871467       wpdiblc2=9.12373e-010     pdiblcb=0
+ drout=0.56                pvag=0                    pscbe1=4.24e008
+ pscbe2=1e-005             delta=0.013771667         wdelta=-8.68175e-010
+ eta0=0.033800867          weta0=4.09057e-010        etab=-0.01912
+ dsub=0.2082               clc=1e-007                cle=0.6
+ cf=0                      ckappa=0.6                cgdl=cgln_uhvt
+ cgsl=cgln_uhvt            kt1=-0.18554333           wkt1=5.1865e-010
+ kt1l=0                    kt2=-0.024662133          wkt2=1.498222e-009
+ ute=-1                    ua1=2.2499733e-009        wua1=7.3964e-018
+ lua1=0+dlua1n_uhvt        ub1=-1.209e-018           uc1=4.334e-011
+ prt=0                     at=33000                  noimod=2
+ em=4100                   noia=2e020                ef=0.98
+ noib=5000                 noic=4e-013               cj=cjn_uhvt
+ cjsw=cjswn_uhvt           rd=0                      rs=0
+ xti=3                     n=1                       cjswg=cjswgn_uhvt
+ sa0=3.5e-007              sb0=3.5e-007              wwn=-1
+ rsh=6.6                   alpha1=1.9939             beta0=13.572
+ mj=0.48                   pb=0.8                    mjsw=0.35
+ pbsw=0.74                 mjswg=0.46                pbswg=0.8
+ js=2.000e-07              jsw=7.500e-13             tcj=9.500e-04
+ tpb=0.0015                tcjsw=4.800e-04           tpbsw=0.0009
+ tcjswg=0.0009             tpbswg=0.0015             capmod=3
+ xpart=1                   dlc=1.8e-08               wwc=-0.045
+ kvsat=0.4                 wlod=5e-07                tku0=0.03
+ ku0=-6.2e-08              llodku0=1                 wlodku0=1
+ lku0=2e-07                wku0=7e-07                pku0=-5e-14
+ kvth0=5.2e-09             stk2=2.5e-09              steta0=-1.1e-10
+ lkvth0=-1e-08             wkvth0=2.2e-06            pkvth0=-5e-14
+ llodvth=1                 wlodvth=1                 lodk2=1
+ lodeta0=2                 tlev=1                    tlevc=1
+ minr=1e-3                 imax=0.01                 imelt=0.01

     14: type=n
+ lmin=8.0000e-07-dxl_uhvt  lmax=1.0000e-05-dxl_uhvt  wmin=1.5e-07
+ wmax=6.0000e-07-dxw_uhvt  version=3.24              mobmod=1
+ nqsmod=0                  binunit=2                 tnom=25
+ xl=-2e-08+dxl_uhvt        xw=1.5e-08+dxw_uhvt       llc=0
+ lwc=0                     lwlc=0                    wlc=0
+ wwlc=0                    tox=toxn_uhvt             toxm=toxn_uhvt
+ wint=0                    lint=0                    dwc=0
+ hdif=hdifn_uhvt           ldif=8e-008               ll=0
+ wl=0                      lln=1                     wln=1
+ lw=0                      ww=0                      lwn=1
+ lwl=0                     wwl=0                     cgbo=0
+ cgso=cgon_uhvt            cgdo=cgon_uhvt            vth0=0.32096524+dvthn_uhvt
+ lvth0=-2.3169308e-008+dlvthn_uhvt                   wvth0=-5.5847624e-009+dwvthn_uhvt
+ pvth0=1.026517e-015+dpvthn_uhvt                     k1=0.405
+ k2=-0.010931982+dk2n_uhvt lk2=-5.0686358e-009       wk2=1.8454036e-009+dwk2n_uhvt
+ pk2=1.9776002e-015        k3=-4.426                 k3b=3.154
+ nlx=4.655e-007            dvt0=0.8812               dvt1=0.1131
+ dvt2=0.01298              dvt0w=0                   dvt1w=0
+ dvt2w=-0.032              nch=6.148e017             voff=-0.14710287
+ lvoff=-3.061864e-009      wvoff=2.1288475e-009      pvoff=1.4615465e-015
+ nfactor=1                 cdsc=0.00024              cdscb=-0.0013397434
+ wcdscb=2.2105766e-010     cdscd=0                   cit=-0.0010247919
+ lcit=3.6295865e-010       wcit=-4.8863884e-010      pcit=4.0421682e-016
+ u0=277.69141              lu0=-1.1737239e-005       wu0=-1.8901067e-006
+ pu0=3.4249033e-012        ua=-7.5642553e-010        lua=-4.2411809e-016
+ wua=9.0842739e-017        pua=-4.2714936e-023       ub=1.7638582e-018
+ lub=6.5610364e-025        wub=6.5966103e-027        pub=-3.8828291e-032
+ uc=-1.221435e-011         luc=5.6240457e-017        wuc=1.211e-017
+ puc=-8.4210645e-024       ngate=0                   xj=1.9e-007
+ w0=4.441e-021             prwg=0                    prwb=0
+ wr=1                      rdsw=50                   a0=3.0703184
+ la0=1.8528367e-006        wa0=7.079901e-008         pa0=-3.6945071e-013
+ ags=0.74504427            lags=5.8236027e-007       wags=1.0491441e-008
+ pags=-2.0108666e-014      a1=0                      a2=1
+ b0=0                      b1=0                      vsat=90760.908
+ lvsat=-0.0098227282       wvsat=-0.00046464275      pvsat=1.7114977e-009
+ keta=0.033316781          lketa=-1.9467199e-008     wketa=-6.6150514e-009
+ pketa=6.2617536e-016      dwg=0                     dwb=0
+ alpha0=0                  pclm=0.61701764           lpclm=1.5326243e-008
+ wpclm=-1.0465847e-008     ppclm=-9.4256392e-015     pdiblc1=0
+ pdiblc2=0.041927971       lpdiblc2=-2.0523909e-008  wpdiblc2=9.3233269e-010
+ ppdiblc2=-1.9919772e-016  pdiblcb=0                 drout=0.56
+ pvag=0                    pscbe1=4.24e008           pscbe2=1e-005
+ delta=0.012313971         ldelta=1.4547803e-008     wdelta=-8.643513e-010
+ pdelta=-3.8160483e-017    eta0=0.033348724          leta0=4.5123854e-009
+ weta0=8.384389e-010       peta0=-4.2852314e-015     etab=-0.01941183
+ letab=2.9124656e-009      wetab=2.0940469e-010      petab=-2.0898588e-015
+ dsub=0.2082               clc=1e-007                cle=0.6
+ cf=0                      ckappa=0.6                cgdl=cgln_uhvt
+ cgsl=cgln_uhvt            kt1=-0.18393953           lkt1=-1.6005967e-008
+ wkt1=4.708538e-010        pkt1=4.7700603e-016       kt1l=0
+ kt2=-0.024885666          lkt2=2.2308511e-009       wkt2=1.4918364e-009
+ pkt2=6.3728006e-017       ute=-1                    ua1=2.2468121e-009
+ lua1=3.1549384e-017+dlua1n_uhvt                     wua1=9.9506287e-018
+ pua1=-2.5491202e-023      ub1=-1.209e-018           uc1=4.334e-011
+ prt=0                     at=33000                  noimod=2
+ em=4100                   noia=2e020                ef=0.98
+ noib=5000                 noic=4e-013               cj=cjn_uhvt
+ cjsw=cjswn_uhvt           rd=0                      rs=0
+ xti=3                     n=1                       cjswg=cjswgn_uhvt
+ sa0=3.5e-007              sb0=3.5e-007              wwn=-1
+ rsh=6.6                   alpha1=1.9939             beta0=13.572
+ mj=0.48                   pb=0.8                    mjsw=0.35
+ pbsw=0.74                 mjswg=0.46                pbswg=0.8
+ js=2.000e-07              jsw=7.500e-13             tcj=9.500e-04
+ tpb=0.0015                tcjsw=4.800e-04           tpbsw=0.0009
+ tcjswg=0.0009             tpbswg=0.0015             capmod=3
+ xpart=1                   dlc=1.8e-08               wwc=-0.045
+ kvsat=0.4                 wlod=5e-07                tku0=0.03
+ ku0=-6.2e-08              llodku0=1                 wlodku0=1
+ lku0=2e-07                wku0=7e-07                pku0=-5e-14
+ kvth0=5.2e-09             stk2=2.5e-09              steta0=-1.1e-10
+ lkvth0=-1e-08             wkvth0=2.2e-06            pkvth0=-5e-14
+ llodvth=1                 wlodvth=1                 lodk2=1
+ lodeta0=2                 tlev=1                    tlevc=1
+ minr=1e-3                 imax=0.01                 imelt=0.01

     15: type=n
+ lmin=3.5000e-07-dxl_uhvt  lmax=8.0000e-07-dxl_uhvt  wmin=1.5e-07
+ wmax=6.0000e-07-dxw_uhvt  version=3.24              mobmod=1
+ nqsmod=0                  binunit=2                 tnom=25
+ xl=-2e-08+dxl_uhvt        xw=1.5e-08+dxw_uhvt       llc=0
+ lwc=0                     lwlc=0                    wlc=0
+ wwlc=0                    tox=toxn_uhvt             toxm=toxn_uhvt
+ wint=0                    lint=0                    dwc=0
+ hdif=hdifn_uhvt           ldif=8e-008               ll=0
+ wl=0                      lln=1                     wln=1
+ lw=0                      ww=0                      lwn=1
+ lwl=0                     wwl=0                     cgbo=0
+ cgso=cgon_uhvt            cgdo=cgon_uhvt            vth0=0.30101091+dvthn_uhvt
+ lvth0=-7.6049307e-009+dlvthn_uhvt                   wvth0=-6.9410403e-009+dwvthn_uhvt
+ pvth0=2.0844138e-015+dpvthn_uhvt                    k1=0.405
+ k2=-0.03061784+dk2n_uhvt  lk2=1.0286333e-008        wk2=6.0531416e-009+dwk2n_uhvt
+ pk2=-1.3044354e-015       k3=-4.426                 k3b=3.154
+ nlx=4.655e-007            dvt0=0.8812               dvt1=0.1131
+ dvt2=0.01298              dvt0w=0                   dvt1w=0
+ dvt2w=-0.032              nch=6.148e017             voff=-0.1382852
+ lvoff=-9.939644e-009      wvoff=3.819068e-009       pvoff=1.4317446e-016
+ nfactor=1                 cdsc=0.00024              cdscb=-0.0013397434
+ wcdscb=2.2105766e-010     cdscd=0                   cit=0.00062907769
+ lcit=-9.2705966e-010      wcit=-2.0000888e-010      pcit=1.7908545e-016
+ u0=281.49082              lu0=-1.4700781e-005       wu0=-5.1218567e-007
+ pu0=2.3501249e-012        ua=-1.6127573e-009        lua=2.4382072e-016
+ wua=1.3361326e-016        pua=-7.6075943e-023       ub=3.2667816e-018
+ lub=-5.1617661e-025       wub=-1.8642386e-025       pub=1.1172767e-031
+ uc=8.2494313e-011         luc=-1.76323e-017         wuc=-4.7669347e-018
+ puc=4.7429442e-024        ngate=0                   xj=1.9e-007
+ w0=4.441e-021             prwg=0                    prwb=0
+ wr=1                      rdsw=50                   a0=4.5398878
+ la0=7.0657253e-007        wa0=-1.6357018e-007       pa0=-1.8664274e-013
+ ags=1.0504231             lags=3.4416477e-007       wags=-8.1997813e-008
+ pags=5.2032952e-014       a1=0                      a2=1
+ b0=0                      b1=0                      vsat=41862.142
+ lvsat=0.028318309         wvsat=0.0071810625        pvsat=-4.2521525e-009
+ keta=0.024095199          lketa=-1.2274365e-008     wketa=-1.457577e-008
+ pketa=6.8355357e-015      dwg=0                     dwb=0
+ alpha0=0                  pclm=0.85239647           lpclm=-1.6826924e-007
+ wpclm=-1.2622002e-007     ppclm=8.0862613e-014      pdiblc1=0
+ pdiblc2=0.0064351311      lpdiblc2=7.1605057e-009   wpdiblc2=2.7260094e-009
+ ppdiblc2=-1.5982655e-015  pdiblcb=0                 drout=0.56
+ pvag=0                    pscbe1=4.24e008           pscbe2=1e-005
+ delta=0.043067444         ldelta=-9.4399067e-009    wdelta=-1.1447883e-009
+ pdelta=1.805804e-016      eta0=0.064497577          leta0=-1.978372e-008
+ weta0=-9.6593932e-009     peta0=3.9030777e-015      etab=-0.019440584
+ letab=2.9348939e-009      wetab=-4.1472457e-010     petab=-1.603038e-015
+ dsub=0.2082               clc=1e-007                cle=0.6
+ cf=0                      ckappa=0.6                cgdl=cgln_uhvt
+ cgsl=cgln_uhvt            kt1=-0.22734269           lkt1=1.7848497e-008
+ wkt1=7.0372537e-009       pkt1=-4.6447859e-015      kt1l=0
+ kt2=-0.020915089          lkt2=-8.6619867e-010      wkt2=2.4532897e-009
+ pkt2=-6.8620552e-016      ute=-1                    ua1=2.7408511e-009
+ lua1=-3.5380107e-016+dlua1n_uhvt                    wua1=-5.1338833e-017
+ pua1=2.2314578e-023       ub1=-1.209e-018           uc1=4.3456429e-011
+ luc1=-9.0814533e-020      wuc1=-7.1603767e-020      puc1=5.5850938e-026
+ prt=0                     at=33000                  noimod=2
+ em=4100                   noia=2e020                ef=0.98
+ noib=5000                 noic=4e-013               cj=cjn_uhvt
+ cjsw=cjswn_uhvt           rd=0                      rs=0
+ xti=3                     n=1                       cjswg=cjswgn_uhvt
+ sa0=3.5e-007              sb0=3.5e-007              wwn=-1
+ rsh=6.6                   alpha1=1.9939             beta0=13.572
+ mj=0.48                   pb=0.8                    mjsw=0.35
+ pbsw=0.74                 mjswg=0.46                pbswg=0.8
+ js=2.000e-07              jsw=7.500e-13             tcj=9.500e-04
+ tpb=0.0015                tcjsw=4.800e-04           tpbsw=0.0009
+ tcjswg=0.0009             tpbswg=0.0015             capmod=3
+ xpart=1                   dlc=1.8e-08               wwc=-0.045
+ kvsat=0.4                 wlod=5e-07                tku0=0.03
+ ku0=-6.2e-08              llodku0=1                 wlodku0=1
+ lku0=2e-07                wku0=7e-07                pku0=-5e-14
+ kvth0=5.2e-09             stk2=2.5e-09              steta0=-1.1e-10
+ lkvth0=-1e-08             wkvth0=2.2e-06            pkvth0=-5e-14
+ llodvth=1                 wlodvth=1                 lodk2=1
+ lodeta0=2                 tlev=1                    tlevc=1
+ minr=1e-3                 imax=0.01                 imelt=0.01

     16: type=n
+ lmin=1.3e-07              lmax=3.5000e-07-dxl_uhvt  wmin=1.5e-07
+ wmax=6.0000e-07-dxw_uhvt  version=3.24              mobmod=1
+ nqsmod=0                  binunit=2                 tnom=25
+ xl=-2e-08+dxl_uhvt        xw=1.5e-08+dxw_uhvt       llc=0
+ lwc=0                     lwlc=0                    wlc=0
+ wwlc=0                    tox=toxn_uhvt             toxm=toxn_uhvt
+ wint=0                    lint=0                    dwc=0
+ hdif=hdifn_uhvt           ldif=8e-008               ll=0
+ wl=0                      lln=1                     wln=1
+ lw=0                      ww=0                      lwn=1
+ lwl=0                     wwl=0                     cgbo=0
+ cgso=cgon_uhvt            cgdo=cgon_uhvt            vth0=0.29712983+dvthn_uhvt
+ lvth0=-6.324175e-009+dlvthn_uhvt                    wvth0=1.3315775e-009+dwvthn_uhvt
+ pvth0=-6.4555013e-016+dpvthn_uhvt                   k1=0.405
+ k2=-0.0032343167+dk2n_uhvt                          lk2=1.2497705e-009
+ wk2=2.2458673e-009+dwk2n_uhvt                       pk2=-4.8034883e-017
+ k3=-4.426                 k3b=3.154                 nlx=4.655e-007
+ dvt0=0.8812               dvt1=0.1131               dvt2=0.01298
+ dvt0w=0                   dvt1w=0                   dvt2w=-0.032
+ nch=6.148e017             voff=-0.17567633          lvoff=2.39943e-009
+ wvoff=6.356845e-009       pvoff=-6.9429195e-016     nfactor=1
+ cdsc=0.00024              cdscb=-0.0013397434       wcdscb=2.2105766e-010
+ cdscd=0                   cit=-0.0034114901         lcit=4.0632771e-010
+ wcit=5.4049588e-010       pcit=-6.5281117e-017      u0=281.69133
+ lu0=-1.476695e-005        wu0=4.670105e-006         pu0=6.39969e-013
+ ua=-7.4507667e-010        lua=-4.25139e-017         wua=-9.54316e-017
+ pua=-4.91139e-025         ub=1.93156e-018           lub=-7.55535e-026
+ wub=1.3387935e-025        pub=6.027615e-033         uc=-5.3938e-012
+ luc=1.1370777e-017        wuc=1.5801687e-017        puc=-2.044701e-024
+ ngate=0                   xj=1.9e-007               w0=4.441e-021
+ prwg=0                    prwb=0                    wr=1
+ rdsw=50                   a0=4.121295               la0=8.4470815e-007
+ wa0=-5.2019468e-007       pa0=-6.895666e-014        ags=-0.92304333
+ lags=9.954087e-007        wags=5.961769e-007        pags=-1.717647e-013
+ a1=0                      a2=1                      b0=0
+ b1=0                      vsat=144659.3             lvsat=-0.005604753
+ wvsat=-0.011171045        pvsat=1.8040428e-009      keta=0.05365583
+ lketa=-2.2029373e-008     wketa=-1.3331312e-008     pketa=6.4248646e-015
+ dwg=0                     dwb=0                     alpha0=0
+ pclm=0.072694             lpclm=8.903257e-008       wpclm=1.8682224e-007
+ ppclm=-2.2441332e-014     pdiblc1=0                 pdiblc2=0.025384917
+ lpdiblc2=9.070765e-010    wpdiblc2=-4.0984625e-010  ppdiblc2=-5.6343317e-016
+ pdiblcb=0                 drout=0.56                pvag=0
+ pscbe1=4.24e008           pscbe2=1e-005             delta=0.015756333
+ ldelta=-4.2724e-010       wdelta=-7.41895e-010      pdelta=4.76256e-017
+ eta0=1.4365e-005          leta0=1.4957399e-009      weta0=2.0885923e-009
+ peta0=2.624245e-017       etab=-0.017191758         letab=2.1927813e-009
+ wetab=-6.2942124e-009     petab=3.3719297e-016      dsub=0.21380333
+ ldsub=-1.8491e-009        wdsub=-9.2455e-010        pdsub=3.051015e-016
+ clc=1e-007                cle=0.6                   cf=0
+ ckappa=0.6                cgdl=cgln_uhvt            cgsl=cgln_uhvt
+ kt1=-0.1589285            lkt1=-4.728185e-009       wkt1=-9.0075975e-009
+ pkt1=6.5001503e-016       kt1l=0                    kt2=-0.0080429333
+ lkt2=-5.11401e-009        wkt2=-6.94991e-010        pkt2=3.527271e-016
+ ute=-1                    ua1=1.992145e-009         lua1=-1.0672805e-016+dlua1n_uhvt
+ wua1=-6.42675e-019        pua1=5.5848458e-024       ub1=-1.209e-018
+ uc1=4.310185e-011         luc1=2.61965e-020         wuc1=1.4646225e-019
+ puc1=-1.6110848e-026      prt=0                     at=33000
+ noimod=2                  em=4100                   noia=2e020
+ ef=0.98                   noib=5000                 noic=4e-013
+ cj=cjn_uhvt               cjsw=cjswn_uhvt           rd=0
+ rs=0                      xti=3                     n=1
+ cjswg=cjswgn_uhvt         sa0=3.5e-007              sb0=3.5e-007
+ wwn=-1                    rsh=6.6                   alpha1=1.9939
+ beta0=13.572              mj=0.48                   pb=0.8
+ mjsw=0.35                 pbsw=0.74                 mjswg=0.46
+ pbswg=0.8                 js=2.000e-07              jsw=7.500e-13
+ tcj=9.500e-04             tpb=0.0015                tcjsw=4.800e-04
+ tpbsw=0.0009              tcjswg=0.0009             tpbswg=0.0015
+ capmod=3                  xpart=1                   dlc=1.8e-08
+ wwc=-0.045                kvsat=0.4                 wlod=5e-07
+ tku0=0.03                 ku0=-6.2e-08              llodku0=1
+ wlodku0=1                 lku0=2e-07                wku0=7e-07
+ pku0=-5e-14               kvth0=5.2e-09             stk2=2.5e-09
+ steta0=-1.1e-10           lkvth0=-1e-08             wkvth0=2.2e-06
+ pkvth0=-5e-14             llodvth=1                 wlodvth=1
+ lodk2=1                   lodeta0=2                 tlev=1
+ tlevc=1                   minr=1e-3                 imax=0.01
+ imelt=0.01
//
// ******************************************************************************************
//
//                *
//                               1.2V UHI-VT PMOS DEVICE MODELS
//                *
//
//                *
// ******************************************************************************************

     }
model pch_uhvt bsim3v3  {
     1: type=p
+ lmin=1.0000e-05-dxl_uhvt  lmax=2.1e-05              wmin=1.0000e-05-dxw_uhvt
+ wmax=0.0009001            version=3.24              mobmod=1
+ nqsmod=0                  binunit=2                 tnom=25
+ xl=-2e-08+dxl_uhvt        xw=1.5e-08+dxw_uhvt       llc=0
+ lwc=0                     lwlc=0                    wlc=0
+ wwlc=0                    tox=toxp_uhvt             toxm=toxp_uhvt
+ wint=-6.5e-009            lint=4e-009               dwc=0
+ hdif=hdifp_uhvt           ldif=8e-008               ll=0
+ wl=0                      lln=1                     wln=1
+ lw=0                      ww=0                      lwn=1
+ lwl=0                     wwl=0                     cgbo=0
+ cgso=cgop_uhvt            cgdo=cgop_uhvt            vth0=-0.28292+dvthp_uhvt
+ lvth0=0+dlvthp_uhvt       wvth0=0+dwvthp_uhvt       pvth0=0+dpvthp_uhvt
+ k1=0.4403                 k2=0.017128+dk2p_uhvt     wk2=0+dwk2p_uhvt
+ k3=-3.269                 k3b=4.16                  nlx=1.451e-007
+ dvt0=0.1                  dvt1=0.06171              dvt2=-0.032
+ dvt0w=0                   dvt1w=0                   dvt2w=0
+ nch=7.3e017               voff=-0.10292             nfactor=1
+ cdsc=0                    cdscb=0                   cdscd=0
+ cit=0                     u0=145.23                 ua=1.9988e-009
+ ub=4.3996e-019            uc=3.8488e-011            ngate=0
+ xj=2.1e-007               w0=9.011e-008             prwg=0
+ prwb=0                    wr=1                      rdsw=445
+ a0=3.482                  ags=0.73568               a1=0
+ a2=0.99                   b0=0                      b1=0
+ vsat=111430+dvsatp_uhvt   keta=-0.0064543           dwg=0
+ dwb=0                     alpha0=0                  pclm=0.6409
+ pdiblc1=0                 pdiblc2=0.022877          pdiblcb=0
+ drout=0                   pvag=0                    pscbe1=4.24e008
+ pscbe2=1e-007             delta=0.01569             eta0=0.04788
+ etab=-2e-005              dsub=0.56                 clc=1e-007
+ cle=0.6                   cf=0                      ckappa=0.6
+ cgdl=cglp_uhvt            cgsl=cglp_uhvt            kt1=-0.264
+ kt1l=0                    kt2=-0.01835              lkt2=0+dlkt2p_uhvt
+ ute=-1                    ua1=3.2681e-009           ub1=-3.35e-018
+ uc1=7.181e-011            prt=0                     at=50000
+ noimod=2                  em=4100                   noia=1e020
+ ef=1.18                   noib=400000               noic=1e-011
+ cj=cjp_uhvt               cjsw=cjswp_uhvt           rd=0
+ rs=0                      xti=3                     n=1
+ cjswg=cjswgp_uhvt         sa0=3.5e-007              sb0=3.5e-007
+ wwn=-1                    rsh=7.2                   alpha1=0.0016892
+ beta0=10.862              mj=0.41                   pb=0.8
+ mjsw=0.049                pbsw=0.74                 mjswg=0.48
+ pbswg=0.8                 js=1.300e-07              jsw=4.500e-13
+ tcj=8.466e-04             tpb=0.0015                tcjsw=1.509e-04
+ tpbsw=2.300e-03           tcjswg=0.0012             tpbswg=0.0019
+ capmod=3                  xpart=1                   dlc=1.5e-08
+ wwc=-0.04                 kvsat=-0.6                wlod=3e-07
+ tku0=0.5                  ku0=1.14e-07              llodku0=1
+ wlodku0=1                 lku0=6e-08                wku0=3e-07
+ pku0=1e-14                kvth0=-2.3e-09            stk2=0
+ steta0=0                  lkvth0=1e-08              wkvth0=2.5e-07
+ pkvth0=4e-14              llodvth=1                 wlodvth=1
+ lodk2=1                   lodeta0=1                 tlev=1
+ tlevc=1                   minr=1e-3                 imax=0.01
+ imelt=0.01

     2: type=p
+ lmin=8.0000e-07-dxl_uhvt  lmax=1.0000e-05-dxl_uhvt  wmin=1.0000e-05-dxw_uhvt
+ wmax=0.0009001            version=3.24              mobmod=1
+ nqsmod=0                  binunit=2                 tnom=25
+ xl=-2e-08+dxl_uhvt        xw=1.5e-08+dxw_uhvt       llc=0
+ lwc=0                     lwlc=0                    wlc=0
+ wwlc=0                    tox=toxp_uhvt             toxm=toxp_uhvt
+ wint=-6.5e-009            lint=4e-009               dwc=0
+ hdif=hdifp_uhvt           ldif=8e-008               ll=0
+ wl=0                      lln=1                     wln=1
+ lw=0                      ww=0                      lwn=1
+ lwl=0                     wwl=0                     cgbo=0
+ cgso=cgop_uhvt            cgdo=cgop_uhvt            vth0=-0.28024905+dvthp_uhvt
+ lvth0=-2.6634735e-008+dlvthp_uhvt                   wvth0=0+dwvthp_uhvt
+ pvth0=0+dpvthp_uhvt       k1=0.4403                 k2=0.016118946+dk2p_uhvt
+ lk2=1.006229e-008         wk2=0+dwk2p_uhvt          k3=-3.269
+ k3b=4.16                  nlx=1.451e-007            dvt0=0.1
+ dvt1=0.06171              dvt2=-0.032               dvt0w=0
+ dvt1w=0                   dvt2w=0                   nch=7.3e017
+ voff=-0.10151194          lvoff=-1.4041183e-008     nfactor=1
+ cdsc=0                    cdscb=0                   cdscd=0
+ cit=0                     u0=145.36007              lu0=-1.2970104e-006
+ ua=2.1176964e-009         lua=-1.1856348e-015       ub=3.3108786e-019
+ lub=1.085673e-024         uc=2.8325963e-011         luc=1.0133584e-016
+ ngate=0                   xj=2.1e-007               w0=9.011e-008
+ prwg=0                    prwb=0                    wr=1
+ rdsw=445                  a0=3.4887382              la0=-6.7193504e-008
+ ags=0.70613254            lags=2.9464728e-007       a1=0
+ a2=0.99                   b0=0                      b1=0
+ vsat=111299.94+dvsatp_uhvt                          lvsat=0.0012970104
+ keta=-0.0040768169        lketa=-2.3708261e-008     dwg=0
+ dwb=0                     alpha0=0                  pclm=0.63499756
+ lpclm=5.8859166e-008      pdiblc1=0                 pdiblc2=0.020552777
+ lpdiblc2=2.3177157e-008   pdiblcb=0                 drout=0
+ pvag=0                    pscbe1=4.24e008           pscbe2=1e-007
+ delta=0.014475778         ldelta=1.2108219e-008     eta0=0.04788
+ etab=-2e-005              dsub=0.56                 clc=1e-007
+ cle=0.6                   cf=0                      ckappa=0.6
+ cgdl=cglp_uhvt            cgsl=cglp_uhvt            kt1=-0.2639077
+ lkt1=-9.2045896e-010      kt1l=0                    kt2=-0.017401783
+ lkt2=-9.4556238e-009+dlkt2p_uhvt                    ute=-1
+ ua1=3.2639967e-009        lua1=4.0918585e-017       ub1=-3.35e-018
+ uc1=7.181e-011            prt=0                     at=50000
+ noimod=2                  em=4100                   noia=1e020
+ ef=1.18                   noib=400000               noic=1e-011
+ cj=cjp_uhvt               cjsw=cjswp_uhvt           rd=0
+ rs=0                      xti=3                     n=1
+ cjswg=cjswgp_uhvt         sa0=3.5e-007              sb0=3.5e-007
+ wwn=-1                    rsh=7.2                   alpha1=0.0016892
+ beta0=10.862              mj=0.41                   pb=0.8
+ mjsw=0.049                pbsw=0.74                 mjswg=0.48
+ pbswg=0.8                 js=1.300e-07              jsw=4.500e-13
+ tcj=8.466e-04             tpb=0.0015                tcjsw=1.509e-04
+ tpbsw=2.300e-03           tcjswg=0.0012             tpbswg=0.0019
+ capmod=3                  xpart=1                   dlc=1.5e-08
+ wwc=-0.04                 kvsat=-0.6                wlod=3e-07
+ tku0=0.5                  ku0=1.14e-07              llodku0=1
+ wlodku0=1                 lku0=6e-08                wku0=3e-07
+ pku0=1e-14                kvth0=-2.3e-09            stk2=0
+ steta0=0                  lkvth0=1e-08              wkvth0=2.5e-07
+ pkvth0=4e-14              llodvth=1                 wlodvth=1
+ lodk2=1                   lodeta0=1                 tlev=1
+ tlevc=1                   minr=1e-3                 imax=0.01
+ imelt=0.01

     3: type=p
+ lmin=3.5000e-07-dxl_uhvt  lmax=8.0000e-07-dxl_uhvt  wmin=1.0000e-05-dxw_uhvt
+ wmax=0.0009001            version=3.24              mobmod=1
+ nqsmod=0                  binunit=2                 tnom=25
+ xl=-2e-08+dxl_uhvt        xw=1.5e-08+dxw_uhvt       llc=0
+ lwc=0                     lwlc=0                    wlc=0
+ wwlc=0                    tox=toxp_uhvt             toxm=toxp_uhvt
+ wint=-6.5e-009            lint=4e-009               dwc=0
+ hdif=hdifp_uhvt           ldif=8e-008               ll=0
+ wl=0                      lln=1                     wln=1
+ lw=0                      ww=0                      lwn=1
+ lwl=0                     wwl=0                     cgbo=0
+ cgso=cgop_uhvt            cgdo=cgop_uhvt            vth0=-0.30353724+dvthp_uhvt
+ lvth0=-8.6562473e-009+dlvthp_uhvt                   wvth0=0+dwvthp_uhvt
+ pvth0=0+dpvthp_uhvt       k1=0.4403                 k2=0.029444231+dk2p_uhvt
+ lk2=-2.2483042e-010       wk2=0+dwk2p_uhvt          k3=-3.269
+ k3b=4.16                  nlx=1.451e-007            dvt0=0.1
+ dvt1=0.06171              dvt2=-0.032               dvt0w=0
+ dvt1w=0                   dvt2w=0                   nch=7.3e017
+ voff=-0.099879111         lvoff=-1.5301726e-008     nfactor=1
+ cdsc=0                    cdscb=0                   cdscd=0
+ cit=0.00014168            lcit=-1.0937696e-010      u0=145.3544
+ lu0=-1.2926368e-006       ua=6.6065404e-010         lua=-6.0798122e-017
+ ub=1.9323889e-018         lub=-1.5053142e-025       uc=2.0223854e-010
+ luc=-3.2924675e-017       ngate=0                   xj=2.1e-007
+ w0=9.011e-008             prwg=0                    prwb=0
+ wr=1                      rdsw=445                  a0=3.785524
+ la0=-2.9631213e-007       ags=0.80229333            lags=2.2041115e-007
+ a1=0                      a2=0.99                   b0=0
+ b1=0                      vsat=107856.62+dvsatp_uhvt
+ lvsat=0.0039552476        keta=-0.021292338         lketa=-1.0417879e-008
+ dwg=0                     dwb=0                     alpha0=0
+ pclm=0.66655356           lpclm=3.4497935e-008      pdiblc1=0
+ pdiblc2=0.059815684       lpdiblc2=-7.1338084e-009  pdiblcb=0
+ drout=0                   pvag=0                    pscbe1=4.24e008
+ pscbe2=1e-007             delta=0.034567822         ldelta=-3.4028388e-009
+ eta0=0.04788              etab=-2e-005              dsub=0.56
+ clc=1e-007                cle=0.6                   cf=0
+ ckappa=0.6                cgdl=cglp_uhvt            cgsl=cglp_uhvt
+ kt1=-0.28449156           lkt1=1.4970281e-008       kt1l=0
+ kt2=-0.018236889          lkt2=-8.8109218e-009+dlkt2p_uhvt
+ ute=-1                    ua1=3.752988e-009         lua1=-3.3658274e-016
+ ub1=-3.35e-018            uc1=7.181e-011            prt=0
+ at=50000                  noimod=2                  em=4100
+ noia=1e020                ef=1.18                   noib=400000
+ noic=1e-011               cj=cjp_uhvt               cjsw=cjswp_uhvt
+ rd=0                      rs=0                      xti=3
+ n=1                       cjswg=cjswgp_uhvt         sa0=3.5e-007
+ sb0=3.5e-007              wwn=-1                    rsh=7.2
+ alpha1=0.0016892          beta0=10.862              mj=0.41
+ pb=0.8                    mjsw=0.049                pbsw=0.74
+ mjswg=0.48                pbswg=0.8                 js=1.300e-07
+ jsw=4.500e-13             tcj=8.466e-04             tpb=0.0015
+ tcjsw=1.509e-04           tpbsw=2.300e-03           tcjswg=0.0012
+ tpbswg=0.0019             capmod=3                  xpart=1
+ dlc=1.5e-08               wwc=-0.04                 kvsat=-0.6
+ wlod=3e-07                tku0=0.5                  ku0=1.14e-07
+ llodku0=1                 wlodku0=1                 lku0=6e-08
+ wku0=3e-07                pku0=1e-14                kvth0=-2.3e-09
+ stk2=0                    steta0=0                  lkvth0=1e-08
+ wkvth0=2.5e-07            pkvth0=4e-14              llodvth=1
+ wlodvth=1                 lodk2=1                   lodeta0=1
+ tlev=1                    tlevc=1                   minr=1e-3
+ imax=0.01                 imelt=0.01

     4: type=p
+ lmin=1.3e-07              lmax=3.5000e-07-dxl_uhvt  wmin=1.0000e-05-dxw_uhvt
+ wmax=0.0009001            version=3.24              mobmod=1
+ nqsmod=0                  binunit=2                 tnom=25
+ xl=-2e-08+dxl_uhvt        xw=1.5e-08+dxw_uhvt       llc=0
+ lwc=0                     lwlc=0                    wlc=0
+ wwlc=0                    tox=toxp_uhvt             toxm=toxp_uhvt
+ wint=-6.5e-009            lint=4e-009               dwc=0
+ hdif=hdifp_uhvt           ldif=8e-008               ll=0
+ wl=0                      lln=1                     wln=1
+ lw=0                      ww=0                      lwn=1
+ lwl=0                     wwl=0                     cgbo=0
+ cgso=cgop_uhvt            cgdo=cgop_uhvt            vth0=-0.34268318+dvthp_uhvt
+ lvth0=3.9487446e-009+dlvthp_uhvt                    wvth0=0+dwvthp_uhvt
+ pvth0=0+dpvthp_uhvt       k1=0.4403                 k2=0.020228073+dk2p_uhvt
+ lk2=2.7427726e-009        wk2=0+dwk2p_uhvt          k3=-3.269
+ k3b=4.16                  nlx=1.451e-007            dvt0=0.1
+ dvt1=0.06171              dvt2=-0.032               dvt0w=0
+ dvt1w=0                   dvt2w=0                   nch=7.3e017
+ voff=-0.14341273          lvoff=-1.2839018e-009     nfactor=1
+ cdsc=0                    cdscb=0                   cdscd=0
+ cit=-0.00075343636        lcit=1.7885051e-010       u0=145.35973
+ lu0=-1.2943522e-006       ua=3.5941282e-010         lua=3.6201553e-017
+ ub=1.7969378e-018         lub=-1.0691618e-025       uc=8.1752255e-011
+ luc=5.87191e-018          ngate=0                   xj=2.1e-007
+ w0=9.011e-008             prwg=0                    prwb=0
+ wr=1                      rdsw=445                  a0=2.1396627
+ la0=2.336552e-007         ags=0.78763636            lags=2.2513069e-007
+ a1=0                      a2=0.99                   b0=0
+ b1=0                      vsat=120204.91+dvsatp_uhvt
+ lvsat=-2.0900727e-005     keta=-0.020837236         lketa=-1.0564422e-008
+ dwg=0                     dwb=0                     alpha0=0
+ pclm=0.62736173           lpclm=4.7117704e-008      pdiblc1=0
+ pdiblc2=0.0537311         lpdiblc2=-5.1745722e-009  pdiblcb=0
+ drout=0                   pvag=0                    pscbe1=4.24e008
+ pscbe2=1e-007             delta=0.023536364         ldelta=1.4929091e-010
+ eta0=0.04788              etab=-2e-005              dsub=0.56
+ clc=1e-007                cle=0.6                   cf=0
+ ckappa=0.6                cgdl=cglp_uhvt            cgsl=cglp_uhvt
+ kt1=-0.21389091           lkt1=-7.7631273e-009      kt1l=0
+ kt2=-0.018384546          lkt2=-8.7633764e-009+dlkt2p_uhvt
+ ute=-1                    ua1=2.8757218e-009        lua1=-5.4103026e-017
+ ub1=-3.35e-018            uc1=7.181e-011            prt=0
+ at=50000                  noimod=2                  em=4100
+ noia=1e020                ef=1.18                   noib=400000
+ noic=1e-011               cj=cjp_uhvt               cjsw=cjswp_uhvt
+ rd=0                      rs=0                      xti=3
+ n=1                       cjswg=cjswgp_uhvt         sa0=3.5e-007
+ sb0=3.5e-007              wwn=-1                    rsh=7.2
+ alpha1=0.0016892          beta0=10.862              mj=0.41
+ pb=0.8                    mjsw=0.049                pbsw=0.74
+ mjswg=0.48                pbswg=0.8                 js=1.300e-07
+ jsw=4.500e-13             tcj=8.466e-04             tpb=0.0015
+ tcjsw=1.509e-04           tpbsw=2.300e-03           tcjswg=0.0012
+ tpbswg=0.0019             capmod=3                  xpart=1
+ dlc=1.5e-08               wwc=-0.04                 kvsat=-0.6
+ wlod=3e-07                tku0=0.5                  ku0=1.14e-07
+ llodku0=1                 wlodku0=1                 lku0=6e-08
+ wku0=3e-07                pku0=1e-14                kvth0=-2.3e-09
+ stk2=0                    steta0=0                  lkvth0=1e-08
+ wkvth0=2.5e-07            pkvth0=4e-14              llodvth=1
+ wlodvth=1                 lodk2=1                   lodeta0=1
+ tlev=1                    tlevc=1                   minr=1e-3
+ imax=0.01                 imelt=0.01

     5: type=p
+ lmin=1.0000e-05-dxl_uhvt  lmax=2.1e-05              wmin=1.2000e-06-dxw_uhvt
+ wmax=1.0000e-05-dxw_uhvt  version=3.24              mobmod=1
+ nqsmod=0                  binunit=2                 tnom=25
+ xl=-2e-08+dxl_uhvt        xw=1.5e-08+dxw_uhvt       llc=0
+ lwc=0                     lwlc=0                    wlc=0
+ wwlc=0                    tox=toxp_uhvt             toxm=toxp_uhvt
+ wint=-6.5e-009            lint=4e-009               dwc=0
+ hdif=hdifp_uhvt           ldif=8e-008               ll=0
+ wl=0                      lln=1                     wln=1
+ lw=0                      ww=0                      lwn=1
+ lwl=0                     wwl=0                     cgbo=0
+ cgso=cgop_uhvt            cgdo=cgop_uhvt            vth0=-0.28358284+dvthp_uhvt
+ wvth0=6.6469686e-009+dwvthp_uhvt                    lvth0=0+dlvthp_uhvt
+ pvth0=0+dpvthp_uhvt       k1=0.4403                 k2=0.017756234+dk2p_uhvt
+ wk2=-6.2999269e-009+dwk2p_uhvt                      k3=-3.269
+ k3b=4.16                  nlx=1.451e-007            dvt0=0.1
+ dvt1=0.06171              dvt2=-0.032               dvt0w=0
+ dvt1w=0                   dvt2w=0                   nch=7.3e017
+ voff=-0.10318514          wvoff=2.6587875e-009      nfactor=1
+ cdsc=0                    cdscb=0                   cdscd=0
+ cit=0                     u0=145.95145              wu0=-7.2347006e-006
+ ua=1.9424376e-009         wua=5.6520224e-016        ub=4.2720834e-019
+ wub=1.2787368e-025        uc=4.9492973e-011         wuc=-1.1035787e-016
+ ngate=0                   xj=2.1e-007               w0=9.011e-008
+ prwg=0                    prwb=0                    wr=1
+ rdsw=445                  a0=3.4030452              wa0=7.9175892e-007
+ ags=0.7329491             wags=2.7385511e-008       a1=0
+ a2=0.99                   b0=0                      b1=0
+ vsat=110234.1+dvsatp_uhvt wvsat=0.011992531         keta=-0.0072184104
+ wketa=7.6624995e-009      dwg=0                     dwb=0
+ alpha0=0                  pclm=0.6409               pdiblc1=0
+ pdiblc2=0.022971472       wpdiblc2=-9.4736795e-010  pdiblcb=0
+ drout=0                   pvag=0                    pscbe1=4.24e008
+ pscbe2=1e-007             delta=0.014273614         wdelta=1.4203523e-008
+ eta0=0.04788              etab=-2e-005              dsub=0.56
+ clc=1e-007                cle=0.6                   cf=0
+ ckappa=0.6                cgdl=cglp_uhvt            cgsl=cglp_uhvt
+ kt1=-0.26606527           wkt1=2.0710555e-008       kt1l=0
+ kt2=-0.019250068          wkt2=9.0258837e-009       lkt2=0+dlkt2p_uhvt
+ ute=-1                    ua1=3.3001955e-009        wua1=-3.2185322e-016
+ ub1=-3.35e-018            uc1=7.181e-011            prt=0
+ at=50000                  noimod=2                  em=4100
+ noia=1e020                ef=1.18                   noib=400000
+ noic=1e-011               cj=cjp_uhvt               cjsw=cjswp_uhvt
+ rd=0                      rs=0                      xti=3
+ n=1                       cjswg=cjswgp_uhvt         sa0=3.5e-007
+ sb0=3.5e-007              wwn=-1                    rsh=7.2
+ alpha1=0.0016892          beta0=10.862              mj=0.41
+ pb=0.8                    mjsw=0.049                pbsw=0.74
+ mjswg=0.48                pbswg=0.8                 js=1.300e-07
+ jsw=4.500e-13             tcj=8.466e-04             tpb=0.0015
+ tcjsw=1.509e-04           tpbsw=2.300e-03           tcjswg=0.0012
+ tpbswg=0.0019             capmod=3                  xpart=1
+ dlc=1.5e-08               wwc=-0.04                 kvsat=-0.6
+ wlod=3e-07                tku0=0.5                  ku0=1.14e-07
+ llodku0=1                 wlodku0=1                 lku0=6e-08
+ wku0=3e-07                pku0=1e-14                kvth0=-2.3e-09
+ stk2=0                    steta0=0                  lkvth0=1e-08
+ wkvth0=2.5e-07            pkvth0=4e-14              llodvth=1
+ wlodvth=1                 lodk2=1                   lodeta0=1
+ tlev=1                    tlevc=1                   minr=1e-3
+ imax=0.01                 imelt=0.01

     6: type=p
+ lmin=8.0000e-07-dxl_uhvt  lmax=1.0000e-05-dxl_uhvt  wmin=1.2000e-06-dxw_uhvt
+ wmax=1.0000e-05-dxw_uhvt  version=3.24              mobmod=1
+ nqsmod=0                  binunit=2                 tnom=25
+ xl=-2e-08+dxl_uhvt        xw=1.5e-08+dxw_uhvt       llc=0
+ lwc=0                     lwlc=0                    wlc=0
+ wwlc=0                    tox=toxp_uhvt             toxm=toxp_uhvt
+ wint=-6.5e-009            lint=4e-009               dwc=0
+ hdif=hdifp_uhvt           ldif=8e-008               ll=0
+ wl=0                      lln=1                     wln=1
+ lw=0                      ww=0                      lwn=1
+ lwl=0                     wwl=0                     cgbo=0
+ cgso=cgop_uhvt            cgdo=cgop_uhvt            vth0=-0.28079889+dvthp_uhvt
+ lvth0=-2.7761556e-008+dlvthp_uhvt                   wvth0=5.5138202e-009+dwvthp_uhvt
+ pvth0=1.1299756e-014+dpvthp_uhvt                    k1=0.4403
+ k2=0.016697249+dk2p_uhvt  lk2=1.0560193e-008        wk2=-5.799228e-009+dwk2p_uhvt
+ pk2=-4.99297e-015         k3=-3.269                 k3b=4.16
+ nlx=1.451e-007            dvt0=0.1                  dvt1=0.06171
+ dvt2=-0.032               dvt0w=0                   dvt1w=0
+ dvt2w=0                   nch=7.3e017               voff=-0.1016834
+ lvoff=-1.4975335e-008     wvoff=1.7193898e-009      pvoff=9.3676736e-015
+ nfactor=1                 cdsc=0                    cdscb=0
+ cdscd=0                   cit=9.3928058e-006        lcit=-9.3665059e-011
+ wcit=-9.4191056e-011      pcit=9.3927321e-016       u0=146.16454
+ lu0=-2.1249023e-006       wu0=-8.0672418e-006       pu0=8.3021007e-012
+ ua=2.0715308e-009         lua=-1.2873172e-015       wua=4.629488e-016
+ pua=1.0196713e-021        ub=3.0539103e-019         lub=1.2147622e-024
+ wub=2.5768787e-025        pub=-1.2945071e-030       uc=3.8282457e-011
+ luc=1.1179127e-016        wuc=-9.9843721e-017       puc=-1.048471e-022
+ ngate=0                   xj=2.1e-007               w0=9.011e-008
+ prwg=0                    prwb=0                    wr=1
+ rdsw=445                  a0=3.4111733              la0=-8.105398e-008
+ wa0=7.778206e-007         pa0=1.3899286e-013        ags=0.70342306
+ lags=2.9443359e-007       wags=2.7170624e-008       pags=2.1428553e-015
+ a1=0                      a2=0.99                   b0=0
+ b1=0                      vsat=110003.68+dvsatp_uhvt
+ lvsat=0.0022977204        wvsat=0.012998861         pvsat=-1.003512e-008
+ keta=-0.0048468725        lketa=-2.3648977e-008     wketa=7.7221172e-009
+ pketa=-5.945077e-016      dwg=0                     dwb=0
+ alpha0=0                  pclm=0.63580857           lpclm=5.0771748e-008
+ wpclm=-8.1328354e-009     ppclm=8.1100634e-014      pdiblc1=0
+ pdiblc2=0.020735961       lpdiblc2=2.2292515e-008   wpdiblc2=-1.8369776e-009
+ ppdiblc2=8.8711869e-015   pdiblcb=0                 drout=0
+ pvag=0                    pscbe1=4.24e008           pscbe2=1e-007
+ delta=0.01301993          ldelta=1.2501731e-008     wdelta=1.4599244e-008
+ pdelta=-3.9461325e-015    eta0=0.04788              etab=-2e-005
+ dsub=0.56                 clc=1e-007                cle=0.6
+ cf=0                      ckappa=0.6                cgdl=cglp_uhvt
+ cgsl=cglp_uhvt            kt1=-0.26616852           lkt1=1.0295828e-009
+ wkt1=2.2671548e-008       pkt1=-1.9555019e-014      kt1l=0
+ kt2=-0.018305656          lkt2=-9.4176739e-009+dlkt2p_uhvt
+ wkt2=9.0640468e-009       pkt2=-3.8056174e-016      ute=-1
+ ua1=3.2967162e-009        lua1=3.4694799e-017       wua1=-3.2811196e-016
+ pua1=6.2412125e-023       ub1=-3.35e-018            uc1=7.181e-011
+ prt=0                     at=50000                  noimod=2
+ em=4100                   noia=1e020                ef=1.18
+ noib=400000               noic=1e-011               cj=cjp_uhvt
+ cjsw=cjswp_uhvt           rd=0                      rs=0
+ xti=3                     n=1                       cjswg=cjswgp_uhvt
+ sa0=3.5e-007              sb0=3.5e-007              wwn=-1
+ rsh=7.2                   alpha1=0.0016892          beta0=10.862
+ mj=0.41                   pb=0.8                    mjsw=0.049
+ pbsw=0.74                 mjswg=0.48                pbswg=0.8
+ js=1.300e-07              jsw=4.500e-13             tcj=8.466e-04
+ tpb=0.0015                tcjsw=1.509e-04           tpbsw=2.300e-03
+ tcjswg=0.0012             tpbswg=0.0019             capmod=3
+ xpart=1                   dlc=1.5e-08               wwc=-0.04
+ kvsat=-0.6                wlod=3e-07                tku0=0.5
+ ku0=1.14e-07              llodku0=1                 wlodku0=1
+ lku0=6e-08                wku0=3e-07                pku0=1e-14
+ kvth0=-2.3e-09            stk2=0                    steta0=0
+ lkvth0=1e-08              wkvth0=2.5e-07            pkvth0=4e-14
+ llodvth=1                 wlodvth=1                 lodk2=1
+ lodeta0=1                 tlev=1                    tlevc=1
+ minr=1e-3                 imax=0.01                 imelt=0.01

     7: type=p
+ lmin=3.5000e-07-dxl_uhvt  lmax=8.0000e-07-dxl_uhvt  wmin=1.2000e-06-dxw_uhvt
+ wmax=1.0000e-05-dxw_uhvt  version=3.24              mobmod=1
+ nqsmod=0                  binunit=2                 tnom=25
+ xl=-2e-08+dxl_uhvt        xw=1.5e-08+dxw_uhvt       llc=0
+ lwc=0                     lwlc=0                    wlc=0
+ wwlc=0                    tox=toxp_uhvt             toxm=toxp_uhvt
+ wint=-6.5e-009            lint=4e-009               dwc=0
+ hdif=hdifp_uhvt           ldif=8e-008               ll=0
+ wl=0                      lln=1                     wln=1
+ lw=0                      ww=0                      lwn=1
+ lwl=0                     wwl=0                     cgbo=0
+ cgso=cgop_uhvt            cgdo=cgop_uhvt            vth0=-0.30450524+dvthp_uhvt
+ lvth0=-9.4602558e-009+dlvthp_uhvt                   wvth0=9.7070309e-009+dwvthp_uhvt
+ pvth0=8.0625976e-015+dpvthp_uhvt                    k1=0.4403
+ k2=0.030874181+dk2p_uhvt  lk2=-3.8439875e-010       wk2=-1.433954e-008+dwk2p_uhvt
+ pk2=1.6001512e-015        k3=-3.269                 k3b=4.16
+ nlx=1.451e-007            dvt0=0.1                  dvt1=0.06171
+ dvt2=-0.032               dvt0w=0                   dvt1w=0
+ dvt2w=0                   nch=7.3e017               voff=-0.10031201
+ lvoff=-1.6034045e-008     wvoff=4.3411313e-009      pvoff=7.3436891e-015
+ nfactor=1                 cdsc=0                    cdscb=0
+ cdscd=0                   cit=3.9876046e-005        lcit=-1.1719812e-010
+ wcit=1.0208901e-009       pcit=7.84306e-017         u0=145.66562
+ lu0=-1.7397365e-006       wu0=-3.1208878e-006       pu0=4.4835155e-012
+ ua=4.2868135e-010         lua=-1.9037472e-017       wua=2.3262222e-015
+ pua=-4.187758e-022        ub=2.2035377e-018         lub=-2.5060697e-025
+ wub=-2.7190799e-024       pub=1.0035576e-030        uc=2.4051327e-010
+ luc=-4.4330919e-017       wuc=-3.8381901e-016       puc=1.1438182e-022
+ ngate=0                   xj=2.1e-007               w0=9.011e-008
+ prwg=0                    prwb=0                    wr=1
+ rdsw=445                  a0=3.7515642              la0=-3.4383574e-007
+ wa0=3.4054869e-007        pa0=4.7656677e-013        ags=0.83748068
+ lags=1.9094111e-007       wags=-3.5285872e-007      pags=2.9552551e-013
+ a1=0                      a2=0.99                   b0=0
+ b1=0                      vsat=107856.62+dvsatp_uhvt
+ lvsat=0.0039552476        keta=-0.021553837         lketa=-1.07512e-008
+ wketa=2.622317e-009       pketa=3.3425381e-015      dwg=0
+ dwb=0                     alpha0=0                  pclm=0.64455186
+ lpclm=4.4021929e-008      wpclm=2.2063302e-007      ppclm=-9.550661e-014
+ pdiblc1=0                 pdiblc2=0.057218375       lpdiblc2=-5.8719081e-009
+ wpdiblc2=2.6045824e-008   ppdiblc2=-1.2654336e-014  pdiblcb=0
+ drout=0                   pvag=0                    pscbe1=4.24e008
+ pscbe2=1e-007             delta=0.033876328         ldelta=-3.5994084e-009
+ wdelta=6.9343043e-009     pdelta=1.9712008e-015     eta0=0.04788
+ etab=-2e-005              dsub=0.56                 clc=1e-007
+ cle=0.6                   cf=0                      ckappa=0.6
+ cgdl=cglp_uhvt            cgsl=cglp_uhvt            kt1=-0.28149046
+ lkt1=1.285812e-008        wkt1=-3.0094986e-008      pkt1=2.1180746e-014
+ kt1l=0                    kt2=-0.017396608          lkt2=-1.0119459e-008+dlkt2p_uhvt
+ wkt2=-8.4263349e-009      pkt2=1.3122013e-014       ute=-1
+ ua1=3.7655336e-009        lua1=-3.2723219e-016      wua1=-1.2580698e-016
+ pua1=-9.3767315e-023      ub1=-3.35e-018            uc1=7.181e-011
+ prt=0                     at=50000                  noimod=2
+ em=4100                   noia=1e020                ef=1.18
+ noib=400000               noic=1e-011               cj=cjp_uhvt
+ cjsw=cjswp_uhvt           rd=0                      rs=0
+ xti=3                     n=1                       cjswg=cjswgp_uhvt
+ sa0=3.5e-007              sb0=3.5e-007              wwn=-1
+ rsh=7.2                   alpha1=0.0016892          beta0=10.862
+ mj=0.41                   pb=0.8                    mjsw=0.049
+ pbsw=0.74                 mjswg=0.48                pbswg=0.8
+ js=1.300e-07              jsw=4.500e-13             tcj=8.466e-04
+ tpb=0.0015                tcjsw=1.509e-04           tpbsw=2.300e-03
+ tcjswg=0.0012             tpbswg=0.0019             capmod=3
+ xpart=1                   dlc=1.5e-08               wwc=-0.04
+ kvsat=-0.6                wlod=3e-07                tku0=0.5
+ ku0=1.14e-07              llodku0=1                 wlodku0=1
+ lku0=6e-08                wku0=3e-07                pku0=1e-14
+ kvth0=-2.3e-09            stk2=0                    steta0=0
+ lkvth0=1e-08              wkvth0=2.5e-07            pkvth0=4e-14
+ llodvth=1                 wlodvth=1                 lodk2=1
+ lodeta0=1                 tlev=1                    tlevc=1
+ minr=1e-3                 imax=0.01                 imelt=0.01

     8: type=p
+ lmin=1.3e-07              lmax=3.5000e-07-dxl_uhvt  wmin=1.2000e-06-dxw_uhvt
+ wmax=1.0000e-05-dxw_uhvt  version=3.24              mobmod=1
+ nqsmod=0                  binunit=2                 tnom=25
+ xl=-2e-08+dxl_uhvt        xw=1.5e-08+dxw_uhvt       llc=0
+ lwc=0                     lwlc=0                    wlc=0
+ wwlc=0                    tox=toxp_uhvt             toxm=toxp_uhvt
+ wint=-6.5e-009            lint=4e-009               dwc=0
+ hdif=hdifp_uhvt           ldif=8e-008               ll=0
+ wl=0                      lln=1                     wln=1
+ lw=0                      ww=0                      lwn=1
+ lwl=0                     wwl=0                     cgbo=0
+ cgso=cgop_uhvt            cgdo=cgop_uhvt            vth0=-0.34599411+dvthp_uhvt
+ lvth0=3.8991623e-009+dlvthp_uhvt                    wvth0=3.3202022e-008+dwvthp_uhvt
+ pvth0=4.9721056e-016+dpvthp_uhvt                    k1=0.4403
+ k2=0.020121602+dk2p_uhvt  lk2=3.0779318e-009        wk2=1.0676876e-009+dwk2p_uhvt
+ pk2=-3.3609762e-015       k3=-3.269                 k3b=4.16
+ nlx=1.451e-007            dvt0=0.1                  dvt1=0.06171
+ dvt2=-0.032               dvt0w=0                   dvt1w=0
+ dvt2w=0                   nch=7.3e017               voff=-0.14712079
+ lvoff=-9.6161735e-010     wvoff=3.7184478e-008      pvoff=-3.2318686e-015
+ nfactor=1                 cdsc=0                    cdscb=0
+ cdscd=0                   cit=-0.00095408801        lcit=2.0285831e-010
+ wcit=2.0121347e-009       pcit=-2.4075019e-016      u0=144.10516
+ lu0=-1.2372701e-006       wu0=1.2580772e-005        pu0=-5.7241887e-013
+ ua=2.7419318e-010         lua=3.0707717e-017        wua=8.545825e-016
+ pua=5.5092183e-023        ub=1.7228133e-018         lub=-9.5813717e-026
+ wub=7.4332103e-025        pub=-1.1133547e-031       uc=7.0054178e-011
+ luc=1.055691e-017         wuc=1.1730831e-016        puc=-4.6981175e-023
+ ngate=0                   xj=2.1e-007               w0=9.011e-008
+ prwg=0                    prwb=0                    wr=1
+ rdsw=445                  a0=2.0418079              la0=2.067058e-007
+ wa0=9.8128848e-007        pa0=2.7024856e-013        ags=0.85574913
+ lags=1.8505867e-007       wags=-6.8303486e-007      pags=4.0184223e-013
+ a1=0                      a2=0.99                   b0=0
+ b1=0                      vsat=122183.39+dvsatp_uhvt
+ lvsat=-0.00065796982      wvsat=-0.019840152        pvsat=6.3885289e-009
+ keta=-0.018696405         lketa=-1.1671293e-008     wketa=-2.1468258e-008
+ pketa=1.1099703e-014      dwg=0                     dwb=0
+ alpha0=0                  pclm=0.61862073           lpclm=5.2371753e-008
+ wpclm=8.7654752e-008      ppclm=-5.2687606e-014     pdiblc1=0
+ pdiblc2=0.055665493       lpdiblc2=-5.3718803e-009  wpdiblc2=-1.9398094e-008
+ ppdiblc2=1.9786055e-015   pdiblcb=0                 drout=0
+ pvag=0                    pscbe1=4.24e008           pscbe2=1e-007
+ delta=0.022757814         ldelta=-1.9246991e-011    wdelta=7.807294e-009
+ pdelta=1.6900981e-015     eta0=0.04788              etab=-2e-005
+ dsub=0.56                 clc=1e-007                cle=0.6
+ cf=0                      ckappa=0.6                cgdl=cglp_uhvt
+ cgsl=cglp_uhvt            kt1=-0.2158448            lkt1=-8.2797824e-009
+ wkt1=1.959361e-008        pkt1=5.1810176e-015       kt1l=0
+ kt2=-0.020957698          lkt2=-8.9727884e-009+dlkt2p_uhvt
+ wkt2=2.580357e-008        pkt2=2.0999834e-015       ute=-1
+ ua1=2.9132304e-009        lua1=-5.2790555e-017      wua1=-3.7613574e-016
+ pua1=-1.3161456e-023      ub1=-3.35e-018            uc1=7.181e-011
+ prt=0                     at=50000                  noimod=2
+ em=4100                   noia=1e020                ef=1.18
+ noib=400000               noic=1e-011               cj=cjp_uhvt
+ cjsw=cjswp_uhvt           rd=0                      rs=0
+ xti=3                     n=1                       cjswg=cjswgp_uhvt
+ sa0=3.5e-007              sb0=3.5e-007              wwn=-1
+ rsh=7.2                   alpha1=0.0016892          beta0=10.862
+ mj=0.41                   pb=0.8                    mjsw=0.049
+ pbsw=0.74                 mjswg=0.48                pbswg=0.8
+ js=1.300e-07              jsw=4.500e-13             tcj=8.466e-04
+ tpb=0.0015                tcjsw=1.509e-04           tpbsw=2.300e-03
+ tcjswg=0.0012             tpbswg=0.0019             capmod=3
+ xpart=1                   dlc=1.5e-08               wwc=-0.04
+ kvsat=-0.6                wlod=3e-07                tku0=0.5
+ ku0=1.14e-07              llodku0=1                 wlodku0=1
+ lku0=6e-08                wku0=3e-07                pku0=1e-14
+ kvth0=-2.3e-09            stk2=0                    steta0=0
+ lkvth0=1e-08              wkvth0=2.5e-07            pkvth0=4e-14
+ llodvth=1                 wlodvth=1                 lodk2=1
+ lodeta0=1                 tlev=1                    tlevc=1
+ minr=1e-3                 imax=0.01                 imelt=0.01

     9: type=p
+ lmin=1.0000e-05-dxl_uhvt  lmax=2.1e-05              wmin=6.0000e-07-dxw_uhvt
+ wmax=1.2000e-06-dxw_uhvt  version=3.24              mobmod=1
+ nqsmod=0                  binunit=2                 tnom=25
+ xl=-2e-08+dxl_uhvt        xw=1.5e-08+dxw_uhvt       llc=0
+ lwc=0                     lwlc=0                    wlc=0
+ wwlc=0                    tox=toxp_uhvt             toxm=toxp_uhvt
+ wint=-6.5e-009            lint=4e-009               dwc=0
+ hdif=hdifp_uhvt           ldif=8e-008               ll=0
+ wl=0                      lln=1                     wln=1
+ lw=0                      ww=0                      lwn=1
+ lwl=0                     wwl=0                     cgbo=0
+ cgso=cgop_uhvt            cgdo=cgop_uhvt            vth0=-0.28835407+dvthp_uhvt
+ wvth0=1.2506034e-008+dwvthp_uhvt                    lvth0=0+dlvthp_uhvt
+ pvth0=0+dpvthp_uhvt       k1=0.4403                 k2=0.017535076+dk2p_uhvt
+ wk2=-6.0283453e-009+dwk2p_uhvt                      k3=-3.269
+ k3b=4.16                  nlx=1.451e-007            dvt0=0.1
+ dvt1=0.06171              dvt2=-0.032               dvt0w=0
+ dvt1w=0                   dvt2w=0                   nch=7.3e017
+ voff=-0.10160613          wvoff=7.1977173e-010      nfactor=1
+ cdsc=0                    cdscb=0                   cdscd=0
+ cit=0.00053924267         wcit=-6.6219e-010         u0=130.5772
+ wu0=1.1644878e-005        ua=7.8109933e-010         wua=1.9913256e-015
+ ub=2.0554018e-018         wub=-1.8715479e-024       uc=1.280703e-010
+ wuc=-2.0685083e-016       ngate=0                   xj=2.1e-007
+ w0=9.011e-008             prwg=0                    prwb=0
+ wr=1                      rdsw=445                  a0=4.2516907
+ wa0=-2.5037774e-007       ags=0.75554307            wags=-3.5988587e-010
+ a1=0                      a2=0.99                   b0=0
+ b1=0                      vsat=140933.33+dvsatp_uhvt
+ wvsat=-0.025706133        keta=-0.015012914         wketa=1.723415e-008
+ dwg=0                     dwb=0                     alpha0=0
+ pclm=0.34574              wpclm=3.6245648e-007      pdiblc1=0
+ pdiblc2=0.021771913       wpdiblc2=5.2569043e-010   pdiblcb=0
+ drout=0                   pvag=0                    pscbe1=4.24e008
+ pscbe2=1e-007             delta=0.032905            wdelta=-8.67582e-009
+ eta0=0.04788              etab=-2e-005              dsub=0.56
+ clc=1e-007                cle=0.6                   cf=0
+ ckappa=0.6                cgdl=cglp_uhvt            cgsl=cglp_uhvt
+ kt1=-0.25028853           wkt1=1.3367189e-009       kt1l=0
+ kt2=-0.020194833          wkt2=1.0186055e-008       lkt2=0+dlkt2p_uhvt
+ ute=-1                    ua1=2.8061587e-009        wua1=2.8482396e-016
+ ub1=-3.35e-018            uc1=7.181e-011            prt=0
+ at=50000                  noimod=2                  em=4100
+ noia=1e020                ef=1.18                   noib=400000
+ noic=1e-011               cj=cjp_uhvt               cjsw=cjswp_uhvt
+ rd=0                      rs=0                      xti=3
+ n=1                       cjswg=cjswgp_uhvt         sa0=3.5e-007
+ sb0=3.5e-007              wwn=-1                    rsh=7.2
+ alpha1=0.0016892          beta0=10.862              mj=0.41
+ pb=0.8                    mjsw=0.049                pbsw=0.74
+ mjswg=0.48                pbswg=0.8                 js=1.300e-07
+ jsw=4.500e-13             tcj=8.466e-04             tpb=0.0015
+ tcjsw=1.509e-04           tpbsw=2.300e-03           tcjswg=0.0012
+ tpbswg=0.0019             capmod=3                  xpart=1
+ dlc=1.5e-08               wwc=-0.04                 kvsat=-0.6
+ wlod=3e-07                tku0=0.5                  ku0=1.14e-07
+ llodku0=1                 wlodku0=1                 lku0=6e-08
+ wku0=3e-07                pku0=1e-14                kvth0=-2.3e-09
+ stk2=0                    steta0=0                  lkvth0=1e-08
+ wkvth0=2.5e-07            pkvth0=4e-14              llodvth=1
+ wlodvth=1                 lodk2=1                   lodeta0=1
+ tlev=1                    tlevc=1                   minr=1e-3
+ imax=0.01                 imelt=0.01

     10: type=p
+ lmin=8.0000e-07-dxl_uhvt  lmax=1.0000e-05-dxl_uhvt  wmin=6.0000e-07-dxw_uhvt
+ wmax=1.2000e-06-dxw_uhvt  version=3.24              mobmod=1
+ nqsmod=0                  binunit=2                 tnom=25
+ xl=-2e-08+dxl_uhvt        xw=1.5e-08+dxw_uhvt       llc=0
+ lwc=0                     lwlc=0                    wlc=0
+ wwlc=0                    tox=toxp_uhvt             toxm=toxp_uhvt
+ wint=-6.5e-009            lint=4e-009               dwc=0
+ hdif=hdifp_uhvt           ldif=8e-008               ll=0
+ wl=0                      lln=1                     wln=1
+ lw=0                      ww=0                      lwn=1
+ lwl=0                     wwl=0                     cgbo=0
+ cgso=cgop_uhvt            cgdo=cgop_uhvt            vth0=-0.28731671+dvthp_uhvt
+ lvth0=-1.0344508e-008+dlvthp_uhvt                   wvth0=1.3517704e-008+dwvthp_uhvt
+ pvth0=-1.0088378e-014+dpvthp_uhvt                   k1=0.4403
+ k2=0.016135454+dk2p_uhvt  lk2=1.3957034e-008        wk2=-5.109343e-009+dwk2p_uhvt
+ pk2=-9.1642911e-015       k3=-3.269                 k3b=4.16
+ nlx=1.451e-007            dvt0=0.1                  dvt1=0.06171
+ dvt2=-0.032               dvt0w=0                   dvt1w=0
+ dvt2w=0                   nch=7.3e017               voff=-0.10292897
+ lvoff=1.3191293e-008      wvoff=3.2489479e-009      pvoff=-2.5220945e-014
+ nfactor=1                 cdsc=0                    cdscb=0
+ cdscd=0                   cit=0.00039243162         lcit=1.4639998e-009
+ wcit=-5.6456272e-010      pcit=-9.7353922e-016      u0=130.14745
+ lu0=4.2854338e-006        wu0=1.1601737e-005        pu0=4.3020801e-013
+ ua=7.23207e-010           lua=5.7730237e-016        wua=2.1186904e-015
+ pua=-1.2700816e-021       ub=2.2769827e-018         lub=-2.2096046e-024
+ wub=-2.1634267e-024       pub=2.9106153e-030        uc=1.3187384e-010
+ luc=-3.7928937e-017       wuc=-2.1477395e-016       puc=7.9009315e-023
+ ngate=0                   xj=2.1e-007               w0=9.011e-008
+ prwg=0                    prwb=0                    wr=1
+ rdsw=445                  a0=4.3199349              la0=-6.8053101e-007
+ wa0=-3.3813853e-007       pa0=8.7515065e-013        ags=0.73236598
+ lags=2.3112189e-007       wags=-8.3712806e-009      pags=7.9889628e-014
+ a1=0                      a2=0.99                   b0=0
+ b1=0                      vsat=142138.96+dvsatp_uhvt
+ lvsat=-0.012022533        wvsat=-0.026463268        pvsat=7.5501506e-009
+ keta=-0.013053367         lketa=-1.9540607e-008     wketa=1.7799692e-008
+ pketa=-5.6395861e-015     dwg=0                     dwb=0
+ alpha0=0                  pclm=0.30218773           lpclm=4.3430322e-007
+ wpclm=4.0155355e-007      ppclm=-3.8987601e-013     pdiblc1=0
+ pdiblc2=0.021112908       lpdiblc2=6.5715972e-009   wpdiblc2=-2.2998685e-009
+ ppdiblc2=2.8176474e-014   pdiblcb=0                 drout=0
+ pvag=0                    pscbe1=4.24e008           pscbe2=1e-007
+ delta=0.033047714         ldelta=-1.4231411e-009    wdelta=-9.9948744e-009
+ pdelta=1.315361e-014      eta0=0.04788              etab=-2e-005
+ dsub=0.56                 clc=1e-007                cle=0.6
+ cf=0                      ckappa=0.6                cgdl=cglp_uhvt
+ cgsl=cglp_uhvt            kt1=-0.24666239           lkt1=-3.6159868e-008
+ wkt1=-1.2819761e-009      pkt1=2.6113626e-014       kt1l=0
+ kt2=-0.01835862           lkt2=-1.8310718e-008+dlkt2p_uhvt
+ wkt2=9.1290862e-009       pkt2=1.0540096e-014       ute=-1
+ ua1=2.7690471e-009        lua1=3.7007638e-016       wua1=3.1986572e-016
+ pua1=-3.4943646e-022      ub1=-3.35e-018            uc1=7.181e-011
+ prt=0                     at=50000                  noimod=2
+ em=4100                   noia=1e020                ef=1.18
+ noib=400000               noic=1e-011               cj=cjp_uhvt
+ cjsw=cjswp_uhvt           rd=0                      rs=0
+ xti=3                     n=1                       cjswg=cjswgp_uhvt
+ sa0=3.5e-007              sb0=3.5e-007              wwn=-1
+ rsh=7.2                   alpha1=0.0016892          beta0=10.862
+ mj=0.41                   pb=0.8                    mjsw=0.049
+ pbsw=0.74                 mjswg=0.48                pbswg=0.8
+ js=1.300e-07              jsw=4.500e-13             tcj=8.466e-04
+ tpb=0.0015                tcjsw=1.509e-04           tpbsw=2.300e-03
+ tcjswg=0.0012             tpbswg=0.0019             capmod=3
+ xpart=1                   dlc=1.5e-08               wwc=-0.04
+ kvsat=-0.6                wlod=3e-07                tku0=0.5
+ ku0=1.14e-07              llodku0=1                 wlodku0=1
+ lku0=6e-08                wku0=3e-07                pku0=1e-14
+ kvth0=-2.3e-09            stk2=0                    steta0=0
+ lkvth0=1e-08              wkvth0=2.5e-07            pkvth0=4e-14
+ llodvth=1                 wlodvth=1                 lodk2=1
+ lodeta0=1                 tlev=1                    tlevc=1
+ minr=1e-3                 imax=0.01                 imelt=0.01

     11: type=p
+ lmin=3.5000e-07-dxl_uhvt  lmax=8.0000e-07-dxl_uhvt  wmin=6.0000e-07-dxw_uhvt
+ wmax=1.2000e-06-dxw_uhvt  version=3.24              mobmod=1
+ nqsmod=0                  binunit=2                 tnom=25
+ xl=-2e-08+dxl_uhvt        xw=1.5e-08+dxw_uhvt       llc=0
+ lwc=0                     lwlc=0                    wlc=0
+ wwlc=0                    tox=toxp_uhvt             toxm=toxp_uhvt
+ wint=-6.5e-009            lint=4e-009               dwc=0
+ hdif=hdifp_uhvt           ldif=8e-008               ll=0
+ wl=0                      lln=1                     wln=1
+ lw=0                      ww=0                      lwn=1
+ lwl=0                     wwl=0                     cgbo=0
+ cgso=cgop_uhvt            cgdo=cgop_uhvt            vth0=-0.28899801+dvthp_uhvt
+ lvth0=-9.0465426e-009+dlvthp_uhvt                   wvth0=-9.3358393e-009+dwvthp_uhvt
+ pvth0=7.5545578e-015+dpvthp_uhvt                    k1=0.4403
+ k2=0.037638814+dk2p_uhvt  lk2=-2.6435601e-009       wk2=-2.2646509e-008+dwk2p_uhvt
+ pk2=4.3744014e-015        k3=-3.269                 k3b=4.16
+ nlx=1.451e-007            dvt0=0.1                  dvt1=0.06171
+ dvt2=-0.032               dvt0w=0                   dvt1w=0
+ dvt2w=0                   nch=7.3e017               voff=-0.057952068
+ lvoff=-2.1530873e-008     wvoff=-4.767688e-008      pvoff=1.4093794e-014
+ nfactor=1                 cdsc=0                    cdscb=0
+ cdscd=0                   cit=0.0022668345          lcit=1.6960757e-011
+ wcit=-1.7138149e-009      pcit=-8.6316503e-017      u0=123.47141
+ lu0=9.4393421e-006        wu0=2.4133604e-005        pu0=-9.2443931e-012
+ ua=2.3113569e-009         lua=-6.4874937e-016       wua=1.4296609e-017
+ pua=3.545104e-022         ub=-2.4855256e-018        lub=1.4670518e-024
+ wub=3.0390898e-024        pub=-1.1057274e-030       uc=-6.8563256e-011
+ luc=1.168085e-016         wuc=-4.2730334e-018       puc=-8.3497389e-023
+ ngate=0                   xj=2.1e-007               w0=9.011e-008
+ prwg=0                    prwb=0                    wr=1
+ rdsw=445                  a0=4.6919859              la0=-9.6775445e-007
+ wa0=-8.1428919e-007       pa0=1.242739e-012         ags=0.6360287
+ lags=3.0549427e-007       wags=-1.0547569e-007      pags=1.5485423e-013
+ a1=0                      a2=0.99                   b0=0
+ b1=0                      vsat=116079.89+dvsatp_uhvt
+ lvsat=0.0080950735        wvsat=-0.010098169        pvsat=-5.0837062e-009
+ keta=-0.045392457         lketa=5.4251709e-009      wketa=3.1896142e-008
+ pketa=-1.6522045e-014     dwg=0                     dwb=0
+ alpha0=0                  pclm=1.1211784            lpclm=-1.9795757e-007
+ wpclm=-3.6466435e-007     ppclm=2.0164421e-013      pdiblc1=0
+ pdiblc2=0.033196582       lpdiblc2=-2.7569991e-009  wpdiblc2=5.5544585e-008
+ ppdiblc2=-1.6479444e-014  pdiblcb=0                 drout=0
+ pvag=0                    pscbe1=4.24e008           pscbe2=1e-007
+ delta=0.042370368         ldelta=-8.6202302e-009    wdelta=-3.4963769e-009
+ pdelta=8.1367699e-015     eta0=0.04788              etab=-2e-005
+ dsub=0.56                 clc=1e-007                cle=0.6
+ cf=0                      ckappa=0.6                cgdl=cglp_uhvt
+ cgsl=cglp_uhvt            kt1=-0.36512356           lkt1=5.5292152e-008
+ wkt1=7.260646e-008        pkt1=-3.0928246e-014      kt1l=0
+ kt2=-0.047591147          lkt2=4.2567929e-009+dlkt2p_uhvt
+ wkt2=2.8652559e-008       pkt2=-4.5320246e-015      ute=-1
+ ua1=3.8010886e-009        lua1=-4.2665963e-016      wua1=-1.6946854e-016
+ pua1=2.8329592e-023       ub1=-3.35e-018            uc1=7.181e-011
+ prt=0                     at=50000                  noimod=2
+ em=4100                   noia=1e020                ef=1.18
+ noib=400000               noic=1e-011               cj=cjp_uhvt
+ cjsw=cjswp_uhvt           rd=0                      rs=0
+ xti=3                     n=1                       cjswg=cjswgp_uhvt
+ sa0=3.5e-007              sb0=3.5e-007              wwn=-1
+ rsh=7.2                   alpha1=0.0016892          beta0=10.862
+ mj=0.41                   pb=0.8                    mjsw=0.049
+ pbsw=0.74                 mjswg=0.48                pbswg=0.8
+ js=1.300e-07              jsw=4.500e-13             tcj=8.466e-04
+ tpb=0.0015                tcjsw=1.509e-04           tpbsw=2.300e-03
+ tcjswg=0.0012             tpbswg=0.0019             capmod=3
+ xpart=1                   dlc=1.5e-08               wwc=-0.04
+ kvsat=-0.6                wlod=3e-07                tku0=0.5
+ ku0=1.14e-07              llodku0=1                 wlodku0=1
+ lku0=6e-08                wku0=3e-07                pku0=1e-14
+ kvth0=-2.3e-09            stk2=0                    steta0=0
+ lkvth0=1e-08              wkvth0=2.5e-07            pkvth0=4e-14
+ llodvth=1                 wlodvth=1                 lodk2=1
+ lodeta0=1                 tlev=1                    tlevc=1
+ minr=1e-3                 imax=0.01                 imelt=0.01

     12: type=p
+ lmin=1.3e-07              lmax=3.5000e-07-dxl_uhvt  wmin=6.0000e-07-dxw_uhvt
+ wmax=1.2000e-06-dxw_uhvt  version=3.24              mobmod=1
+ nqsmod=0                  binunit=2                 tnom=25
+ xl=-2e-08+dxl_uhvt        xw=1.5e-08+dxw_uhvt       llc=0
+ lwc=0                     lwlc=0                    wlc=0
+ wwlc=0                    tox=toxp_uhvt             toxm=toxp_uhvt
+ wint=-6.5e-009            lint=4e-009               dwc=0
+ hdif=hdifp_uhvt           ldif=8e-008               ll=0
+ wl=0                      lln=1                     wln=1
+ lw=0                      ww=0                      lwn=1
+ lwl=0                     wwl=0                     cgbo=0
+ cgso=cgop_uhvt            cgdo=cgop_uhvt            vth0=-0.33275484+dvthp_uhvt
+ lvth0=5.0431564e-009+dlvthp_uhvt                    wvth0=1.6944198e-008+dwvthp_uhvt
+ pvth0=-9.0761416e-016+dpvthp_uhvt                   k1=0.4403
+ k2=0.030035511+dk2p_uhvt  lk2=-1.952964e-010        wk2=-1.1106592e-008+dwk2p_uhvt
+ pk2=6.5854795e-016        k3=-3.269                 k3b=4.16
+ nlx=1.451e-007            dvt0=0.1                  dvt1=0.06171
+ dvt2=-0.032               dvt0w=0                   dvt1w=0
+ dvt2w=0                   nch=7.3e017               voff=-0.1211219
+ lvoff=-1.1901869e-009     wvoff=5.257839e-009       pvoff=-2.9511852e-015
+ nfactor=1                 cdsc=0                    cdscb=0
+ cdscd=0                   cit=0.003167368           lcit=-2.7301102e-010
+ wcit=-3.0490132e-009      pcit=3.4361735e-016       u0=152.35971
+ lu0=1.3730783e-007        wu0=2.4441859e-006        pu0=-2.2604006e-012
+ ua=2.7169079e-011         lua=8.6759118e-017        wua=1.1579281e-015
+ pua=-1.3738937e-023       ub=2.5148052e-018         lub=-1.4305467e-025
+ wub=-2.2924503e-025       pub=-5.3323579e-032       uc=4.4720884e-010
+ luc=-4.9270112e-017       wuc=-3.4583762e-016       puc=2.6486407e-023
+ ngate=0                   xj=2.1e-007               w0=9.011e-008
+ prwg=0                    prwb=0                    wr=1
+ rdsw=445                  a0=-1.8916901             la0=1.1521892e-006
+ wa0=5.8116239e-006        pa0=-8.9080507e-013       ags=0.85889618
+ lags=2.3373094e-007       wags=-6.8689943e-007      pags=3.4207268e-013
+ a1=0                      a2=0.99                   b0=0
+ b1=0                      vsat=112335.07+dvsatp_uhvt
+ lvsat=0.0093009033        wvsat=-0.0077464264       pvsat=-5.8409673e-009
+ keta=-0.020660449         lketa=-2.5385357e-009     wketa=-1.9056412e-008
+ pketa=-1.1532265e-016     dwg=0                     dwb=0
+ alpha0=0                  pclm=0.31010916           lpclm=6.3206725e-008
+ wpclm=4.6650696e-007      ppclm=-6.5992952e-014     pdiblc1=0
+ pdiblc2=0.034665002       lpdiblc2=-3.2298302e-009  wpdiblc2=6.3905097e-009
+ ppdiblc2=-6.5183199e-016  pdiblcb=0                 drout=0
+ pvag=0                    pscbe1=4.24e008           pscbe2=1e-007
+ delta=-0.0052889588       ldelta=6.726073e-009      wdelta=4.2248731e-008
+ pdelta=-6.5931549e-015    eta0=0.04788              etab=-2e-005
+ dsub=0.56                 clc=1e-007                cle=0.6
+ cf=0                      ckappa=0.6                cgdl=cglp_uhvt
+ cgsl=cglp_uhvt            kt1=-0.16161021           lkt1=-1.0239147e-008
+ wkt1=-4.7006469e-008      pkt1=7.5871171e-015       kt1l=0
+ kt2=-0.0033851832         lkt2=-9.9775275e-009+dlkt2p_uhvt
+ wkt2=4.2245226e-009       pkt2=3.3338031e-015       ute=-1
+ ua1=2.5925402e-009        lua1=-3.7507052e-017      wua1=1.7671798e-017
+ pua1=-3.1929598e-023      ub1=-3.35e-018            uc1=7.181e-011
+ prt=0                     at=50000                  noimod=2
+ em=4100                   noia=1e020                ef=1.18
+ noib=400000               noic=1e-011               cj=cjp_uhvt
+ cjsw=cjswp_uhvt           rd=0                      rs=0
+ xti=3                     n=1                       cjswg=cjswgp_uhvt
+ sa0=3.5e-007              sb0=3.5e-007              wwn=-1
+ rsh=7.2                   alpha1=0.0016892          beta0=10.862
+ mj=0.41                   pb=0.8                    mjsw=0.049
+ pbsw=0.74                 mjswg=0.48                pbswg=0.8
+ js=1.300e-07              jsw=4.500e-13             tcj=8.466e-04
+ tpb=0.0015                tcjsw=1.509e-04           tpbsw=2.300e-03
+ tcjswg=0.0012             tpbswg=0.0019             capmod=3
+ xpart=1                   dlc=1.5e-08               wwc=-0.04
+ kvsat=-0.6                wlod=3e-07                tku0=0.5
+ ku0=1.14e-07              llodku0=1                 wlodku0=1
+ lku0=6e-08                wku0=3e-07                pku0=1e-14
+ kvth0=-2.3e-09            stk2=0                    steta0=0
+ lkvth0=1e-08              wkvth0=2.5e-07            pkvth0=4e-14
+ llodvth=1                 wlodvth=1                 lodk2=1
+ lodeta0=1                 tlev=1                    tlevc=1
+ minr=1e-3                 imax=0.01                 imelt=0.01

     13: type=p
+ lmin=1.0000e-05-dxl_uhvt  lmax=2.1e-05              wmin=1.5e-07
+ wmax=6.0000e-07-dxw_uhvt  version=3.24              mobmod=1
+ nqsmod=0                  binunit=2                 tnom=25
+ xl=-2e-08+dxl_uhvt        xw=1.5e-08+dxw_uhvt       llc=0
+ lwc=0                     lwlc=0                    wlc=0
+ wwlc=0                    tox=toxp_uhvt             toxm=toxp_uhvt
+ wint=-6.5e-009            lint=4e-009               dwc=0
+ hdif=hdifp_uhvt           ldif=8e-008               ll=0
+ wl=0                      lln=1                     wln=1
+ lw=0                      ww=0                      lwn=1
+ lwl=0                     wwl=0                     cgbo=0
+ cgso=cgop_uhvt            cgdo=cgop_uhvt            vth0=-0.26707533+dvthp_uhvt
+ wvth0=-8.5701067e-010+dwvthp_uhvt                   lvth0=0+dlvthp_uhvt
+ pvth0=0+dpvthp_uhvt       k1=0.4403                 k2=0.013656048+dk2p_uhvt
+ wk2=-3.5923155e-009+dwk2p_uhvt                      k3=-3.269
+ k3b=4.16                  nlx=1.451e-007            dvt0=0.1
+ dvt1=0.06171              dvt2=-0.032               dvt0w=0
+ dvt1w=0                   dvt2w=0                   nch=7.3e017
+ voff=-0.098086667         wvoff=-1.4904533e-009     nfactor=1
+ cdsc=0                    cdscb=0                   cdscd=0
+ cit=-0.00038494356        wcit=-8.1801047e-011      u0=144.97062
+ wu0=2.6058092e-006        ua=3.3696236e-009         wua=3.6573241e-016
+ ub=3.9770276e-019         wub=-8.3051289e-025       uc=-1.3450067e-010
+ wuc=-4.1956261e-017       ngate=0                   xj=2.1e-007
+ w0=9.011e-008             prwg=0                    prwb=0
+ wr=1                      rdsw=445                  a0=4.2141027
+ wa0=-2.2677248e-007       ags=0.78390489            wags=-1.817111e-008
+ a1=0                      a2=0.99                   b0=0
+ b1=0                      vsat=100000+dvsatp_uhvt   keta=0.00704728
+ wketa=3.3803482e-009      dwg=0                     dwb=0
+ alpha0=0                  pclm=0.99168711           wpclm=-4.3198306e-008
+ pdiblc1=0                 pdiblc2=0.019685449       wpdiblc2=1.8359901e-009
+ pdiblcb=0                 drout=0                   pvag=0
+ pscbe1=4.24e008           pscbe2=1e-007             delta=0.020806711
+ wdelta=-1.0780946e-009    eta0=0.04788              etab=-2e-005
+ dsub=0.56                 clc=1e-007                cle=0.6
+ cf=0                      ckappa=0.6                cgdl=cglp_uhvt
+ cgsl=cglp_uhvt            kt1=-0.27195662           wkt1=1.4944279e-008
+ kt1l=0                    kt2=-0.0015023822         wkt2=-1.552804e-009
+ lkt2=0+dlkt2p_uhvt        ute=-1                    ua1=3.5089e-009
+ wua1=-1.564976e-016       ub1=-3.35e-018            uc1=7.181e-011
+ prt=0                     at=50000                  noimod=2
+ em=4100                   noia=1e020                ef=1.18
+ noib=400000               noic=1e-011               cj=cjp_uhvt
+ cjsw=cjswp_uhvt           rd=0                      rs=0
+ xti=3                     n=1                       cjswg=cjswgp_uhvt
+ sa0=3.5e-007              sb0=3.5e-007              wwn=-1
+ rsh=7.2                   alpha1=0.0016892          beta0=10.862
+ mj=0.41                   pb=0.8                    mjsw=0.049
+ pbsw=0.74                 mjswg=0.48                pbswg=0.8
+ js=1.300e-07              jsw=4.500e-13             tcj=8.466e-04
+ tpb=0.0015                tcjsw=1.509e-04           tpbsw=2.300e-03
+ tcjswg=0.0012             tpbswg=0.0019             capmod=3
+ xpart=1                   dlc=1.5e-08               wwc=-0.04
+ kvsat=-0.6                wlod=3e-07                tku0=0.5
+ ku0=1.14e-07              llodku0=1                 wlodku0=1
+ lku0=6e-08                wku0=3e-07                pku0=1e-14
+ kvth0=-2.3e-09            stk2=0                    steta0=0
+ lkvth0=1e-08              wkvth0=2.5e-07            pkvth0=4e-14
+ llodvth=1                 wlodvth=1                 lodk2=1
+ lodeta0=1                 tlev=1                    tlevc=1
+ minr=1e-3                 imax=0.01                 imelt=0.01

     14: type=p
+ lmin=8.0000e-07-dxl_uhvt  lmax=1.0000e-05-dxl_uhvt  wmin=1.5e-07
+ wmax=6.0000e-07-dxw_uhvt  version=3.24              mobmod=1
+ nqsmod=0                  binunit=2                 tnom=25
+ xl=-2e-08+dxl_uhvt        xw=1.5e-08+dxw_uhvt       llc=0
+ lwc=0                     lwlc=0                    wlc=0
+ wwlc=0                    tox=toxp_uhvt             toxm=toxp_uhvt
+ wint=-6.5e-009            lint=4e-009               dwc=0
+ hdif=hdifp_uhvt           ldif=8e-008               ll=0
+ wl=0                      lln=1                     wln=1
+ lw=0                      ww=0                      lwn=1
+ lwl=0                     wwl=0                     cgbo=0
+ cgso=cgop_uhvt            cgdo=cgop_uhvt            vth0=-0.26343061+dvthp_uhvt
+ lvth0=-3.6345224e-008+dlvthp_uhvt                   wvth0=-1.4827699e-009+dwvthp_uhvt
+ pvth0=6.2400715e-015+dpvthp_uhvt                    k1=0.4403
+ k2=0.014117322+dk2p_uhvt  lk2=-4.5998283e-009       wk2=-3.8419563e-009+dwk2p_uhvt
+ pk2=2.4894185e-015        k3=-3.269                 k3b=4.16
+ nlx=1.451e-007            dvt0=0.1                  dvt1=0.06171
+ dvt2=-0.032               dvt0w=0                   dvt1w=0
+ dvt2w=0                   nch=7.3e017               voff=-0.094532759
+ lvoff=-3.5439567e-008     wvoff=-2.0238704e-009     pvoff=5.3192348e-015
+ nfactor=1                 cdsc=0                    cdscb=0
+ cdscd=0                   cit=-0.00035812306        lcit=-2.6745398e-010
+ wcit=-9.3214379e-011      pcit=1.1381375e-016       u0=144.23685
+ lu0=7.317221e-006         wu0=2.7535985e-006        pu0=-1.4737544e-012
+ ua=3.5265304e-009         lua=-1.5646754e-015       wua=3.5820329e-016
+ pua=7.5080407e-023        ub=1.379731e-019          lub=2.5900242e-024
+ wub=-8.2012866e-025       pub=-1.0355151e-031       uc=-1.4281547e-010
+ luc=8.2915188e-017        wuc=-4.2269058e-017       puc=3.1192043e-024
+ ngate=0                   xj=2.1e-007               w0=9.011e-008
+ prwg=0                    prwb=0                    wr=1
+ rdsw=445                  a0=4.1435928              la0=7.0312428e-007
+ wa0=-2.2739573e-007       pa0=6.2151278e-015        ags=0.74670784
+ lags=3.7092897e-007       wags=-1.7377968e-008      pags=-7.9092178e-015
+ a1=0                      a2=0.99                   b0=0
+ b1=0                      vsat=100000+dvsatp_uhvt   keta=0.010214713
+ lketa=-3.1585639e-008     wketa=3.1873383e-009      pketa=1.9246941e-015
+ dwg=0                     dwb=0                     alpha0=0
+ pclm=1.0245047            lpclm=-3.2725682e-007     wpclm=-5.2061492e-008
+ ppclm=8.838369e-014       pdiblc1=0                 pdiblc2=0.0123105
+ lpdiblc2=7.354299e-008    wpdiblc2=3.2280439e-009   ppdiblc2=-1.3881561e-014
+ pdiblcb=0                 drout=0                   pvag=0
+ pscbe1=4.24e008           pscbe2=1e-007             delta=0.018810517
+ ldelta=1.990605e-008      wdelta=-1.0539147e-009    pdelta=-2.4112202e-016
+ eta0=0.04788              etab=-2e-005              dsub=0.56
+ clc=1e-007                cle=0.6                   cf=0
+ ckappa=0.6                cgdl=cglp_uhvt            cgsl=cglp_uhvt
+ kt1=-0.27412448           lkt1=2.1617843e-008       wkt1=1.5964212e-008
+ pkt1=-1.0170776e-014      kt1l=0                    kt2=-0.0015184883
+ lkt2=1.6060986e-010+dlkt2p_uhvt                     wkt2=-1.4465166e-009
+ pkt2=-1.0598976e-015      ute=-1                    ua1=3.5517647e-009
+ lua1=-4.2744664e-016      wua1=-1.7168091e-016      pua1=1.51408e-022
+ ub1=-3.35e-018            uc1=7.181e-011            prt=0
+ at=50000                  noimod=2                  em=4100
+ noia=1e020                ef=1.18                   noib=400000
+ noic=1e-011               cj=cjp_uhvt               cjsw=cjswp_uhvt
+ rd=0                      rs=0                      xti=3
+ n=1                       cjswg=cjswgp_uhvt         sa0=3.5e-007
+ sb0=3.5e-007              wwn=-1                    rsh=7.2
+ alpha1=0.0016892          beta0=10.862              mj=0.41
+ pb=0.8                    mjsw=0.049                pbsw=0.74
+ mjswg=0.48                pbswg=0.8                 js=1.300e-07
+ jsw=4.500e-13             tcj=8.466e-04             tpb=0.0015
+ tcjsw=1.509e-04           tpbsw=2.300e-03           tcjswg=0.0012
+ tpbswg=0.0019             capmod=3                  xpart=1
+ dlc=1.5e-08               wwc=-0.04                 kvsat=-0.6
+ wlod=3e-07                tku0=0.5                  ku0=1.14e-07
+ llodku0=1                 wlodku0=1                 lku0=6e-08
+ wku0=3e-07                pku0=1e-14                kvth0=-2.3e-09
+ stk2=0                    steta0=0                  lkvth0=1e-08
+ wkvth0=2.5e-07            pkvth0=4e-14              llodvth=1
+ wlodvth=1                 lodk2=1                   lodeta0=1
+ tlev=1                    tlevc=1                   minr=1e-3
+ imax=0.01                 imelt=0.01

     15: type=p
+ lmin=3.5000e-07-dxl_uhvt  lmax=8.0000e-07-dxl_uhvt  wmin=1.5e-07
+ wmax=6.0000e-07-dxw_uhvt  version=3.24              mobmod=1
+ nqsmod=0                  binunit=2                 tnom=25
+ xl=-2e-08+dxl_uhvt        xw=1.5e-08+dxw_uhvt       llc=0
+ lwc=0                     lwlc=0                    wlc=0
+ wwlc=0                    tox=toxp_uhvt             toxm=toxp_uhvt
+ wint=-6.5e-009            lint=4e-009               dwc=0
+ hdif=hdifp_uhvt           ldif=8e-008               ll=0
+ wl=0                      lln=1                     wln=1
+ lw=0                      ww=0                      lwn=1
+ lwl=0                     wwl=0                     cgbo=0
+ cgso=cgop_uhvt            cgdo=cgop_uhvt            vth0=-0.3148664+dvthp_uhvt
+ lvth0=3.3632126e-009+dlvthp_uhvt                    wvth0=6.9095098e-009+dwvthp_uhvt
+ pvth0=-2.387685e-016+dpvthp_uhvt                    k1=0.4403
+ k2=-0.0013958723+dk2p_uhvt                          lk2=7.3763576e-009
+ wk2=1.8672736e-009+dwk2p_uhvt                       pk2=-1.918107e-015
+ k3=-3.269                 k3b=4.16                  nlx=1.451e-007
+ dvt0=0.1                  dvt1=0.06171              dvt2=-0.032
+ dvt0w=0                   dvt1w=0                   dvt2w=0
+ nch=7.3e017               voff=-0.14329521          lvoff=2.2050444e-009
+ wvoff=5.9186123e-009      pvoff=-8.1236181e-016     nfactor=1
+ cdsc=0                    cdscb=0                   cdscd=0
+ cit=-0.00040184934        lcit=-2.3369729e-010      wcit=-3.7881483e-011
+ pcit=7.1096753e-017       u0=162.76921              lu0=-6.9897647e-006
+ wu0=-5.454176e-007        pu0=1.073086e-012         ua=1.686085e-009
+ lua=-1.4385145e-016       wua=4.069674e-016         pua=3.743451e-023
+ ub=3.9234427e-018         lub=-3.323584e-025        wub=-9.8574234e-025
+ pub=2.4302243e-032        uc=-4.0552365e-011        luc=3.9680734e-018
+ wuc=-2.1863873e-017       puc=-1.2633598e-023       ngate=0
+ xj=2.1e-007               w0=9.011e-008             prwg=0
+ prwb=0                    wr=1                      rdsw=445
+ a0=3.0425087              la0=1.5531612e-006        wa0=2.215825e-007
+ pa0=-3.4039606e-013       ags=0.44891289            lags=6.0082667e-007
+ wags=1.2033037e-008       pags=-3.0614513e-014      a1=0
+ a2=0.99                   b0=0                      b1=0
+ vsat=100000+dvsatp_uhvt   keta=0.0033979013         lketa=-2.632306e-008
+ wketa=1.2557968e-009      pketa=3.4158442e-015      dwg=0
+ dwb=0                     alpha0=0                  pclm=0.32075011
+ lpclm=2.1604172e-007      wpclm=1.3800461e-007      ppclm=-5.8347338e-014
+ pdiblc1=0                 pdiblc2=0.16287122        lpdiblc2=-4.2689889e-008
+ wpdiblc2=-2.589109e-008   ppdiblc2=8.5984106e-015   pdiblcb=0
+ drout=0                   pvag=0                    pscbe1=4.24e008
+ pscbe2=1e-007             delta=0.033382705         ldelta=8.6563209e-009
+ wdelta=2.1478757e-009     pdelta=-2.7129042e-015    eta0=0.04788
+ etab=-2e-005              dsub=0.56                 clc=1e-007
+ cle=0.6                   cf=0                      ckappa=0.6
+ cgdl=cglp_uhvt            cgsl=cglp_uhvt            kt1=-0.25962526
+ lkt1=1.0424447e-008       wkt1=6.3535266e-009       pkt1=-2.7513267e-015
+ kt1l=0                    kt2=-4.7084998e-005       lkt2=-9.7531349e-010+dlkt2p_uhvt
+ wkt2=-1.2051121e-009      pkt2=-1.2462618e-015      ute=-1
+ ua1=3.5304373e-009        lua1=-4.109819e-016       wua1=5.0046111e-019
+ pua1=1.8483976e-023       ub1=-3.35e-018            uc1=7.181e-011
+ prt=0                     at=50000                  noimod=2
+ em=4100                   noia=1e020                ef=1.18
+ noib=400000               noic=1e-011               cj=cjp_uhvt
+ cjsw=cjswp_uhvt           rd=0                      rs=0
+ xti=3                     n=1                       cjswg=cjswgp_uhvt
+ sa0=3.5e-007              sb0=3.5e-007              wwn=-1
+ rsh=7.2                   alpha1=0.0016892          beta0=10.862
+ mj=0.41                   pb=0.8                    mjsw=0.049
+ pbsw=0.74                 mjswg=0.48                pbswg=0.8
+ js=1.300e-07              jsw=4.500e-13             tcj=8.466e-04
+ tpb=0.0015                tcjsw=1.509e-04           tpbsw=2.300e-03
+ tcjswg=0.0012             tpbswg=0.0019             capmod=3
+ xpart=1                   dlc=1.5e-08               wwc=-0.04
+ kvsat=-0.6                wlod=3e-07                tku0=0.5
+ ku0=1.14e-07              llodku0=1                 wlodku0=1
+ lku0=6e-08                wku0=3e-07                pku0=1e-14
+ kvth0=-2.3e-09            stk2=0                    steta0=0
+ lkvth0=1e-08              wkvth0=2.5e-07            pkvth0=4e-14
+ llodvth=1                 wlodvth=1                 lodk2=1
+ lodeta0=1                 tlev=1                    tlevc=1
+ minr=1e-3                 imax=0.01                 imelt=0.01

     16: type=p
+ lmin=1.3e-07              lmax=3.5000e-07-dxl_uhvt  wmin=1.5e-07
+ wmax=6.0000e-07-dxw_uhvt  version=3.24              mobmod=1
+ nqsmod=0                  binunit=2                 tnom=25
+ xl=-2e-08+dxl_uhvt        xw=1.5e-08+dxw_uhvt       llc=0
+ lwc=0                     lwlc=0                    wlc=0
+ wwlc=0                    tox=toxp_uhvt             toxm=toxp_uhvt
+ wint=-6.5e-009            lint=4e-009               dwc=0
+ hdif=hdifp_uhvt           ldif=8e-008               ll=0
+ wl=0                      lln=1                     wln=1
+ lw=0                      ww=0                      lwn=1
+ lwl=0                     wwl=0                     cgbo=0
+ cgso=cgop_uhvt            cgdo=cgop_uhvt            vth0=-0.31178436+dvthp_uhvt
+ lvth0=2.3707927e-009+dlvthp_uhvt                    wvth0=3.7747312e-009+dwvthp_uhvt
+ pvth0=7.7063022e-016+dpvthp_uhvt                    k1=0.4403
+ k2=0.019347002+dk2p_uhvt  lk2=6.9715205e-010        wk2=-4.3942087e-009+dwk2p_uhvt
+ pk2=9.8090325e-017        k3=-3.269                 k3b=4.16
+ nlx=1.451e-007            dvt0=0.1                  dvt1=0.06171
+ dvt2=-0.032               dvt0w=0                   dvt1w=0
+ dvt2w=0                   nch=7.3e017               voff=-0.11560761
+ lvoff=-6.710361e-009      wvoff=1.7948671e-009      pvoff=5.1548413e-016
+ nfactor=1                 cdsc=0                    cdscb=0
+ cdscd=0                   cit=-0.0021397333         lcit=3.2590133e-010
+ wcit=2.8384634e-010       pcit=-3.2499605e-017      u0=154.88361
+ lu0=-4.4506009e-006       wu0=8.591786e-007         pu0=6.2080606e-013
+ ua=7.5860936e-010         lua=1.547957e-016         wua=6.9858361e-016
+ pua=-5.6465909e-023       ub=4.112697e-018          lub=-3.9329828e-025
+ wub=-1.2327211e-024       pub=1.0382941e-031        uc=1.9015843e-011
+ luc=-1.521289e-017        wuc=-7.6932414e-017       puc=5.0984718e-024
+ ngate=0                   xj=2.1e-007               w0=9.011e-008
+ prwg=0                    prwb=0                    wr=1
+ rdsw=445                  a0=9.2797294              la0=-4.5522388e-007
+ wa0=-1.2040275e-006       pa0=1.1865035e-013        ags=-0.27090411
+ lags=8.3260774e-007       wags=2.2615145e-008       pags=-3.4021952e-014
+ a1=0                      a2=0.99                   b0=0
+ b1=0                      vsat=100000+dvsatp_uhvt   keta=-0.070071562
+ lketa=-2.6658931e-009     wketa=1.1973767e-008      pketa=-3.5342185e-017
+ dwg=0                     dwb=0                     alpha0=0
+ pclm=1.1472537            lpclm=-5.0092435e-008     wpclm=-5.9219798e-008
+ ppclm=5.1589206e-015      pdiblc1=0                 pdiblc2=0.042948387
+ lpdiblc2=-4.0747355e-009  wpdiblc2=1.1885439e-009   ppdiblc2=-1.2123148e-016
+ pdiblcb=0                 drout=0                   pvag=0
+ pscbe1=4.24e008           pscbe2=1e-007             delta=0.07761014
+ ldelta=-5.5849132e-009    wdelta=-9.8119027e-009    pdelta=1.1381445e-015
+ eta0=0.04788              etab=-2e-005              dsub=0.56
+ clc=1e-007                cle=0.6                   cf=0
+ ckappa=0.6                cgdl=cglp_uhvt            cgsl=cglp_uhvt
+ kt1=-0.23100099           lkt1=1.2074317e-009       wkt1=-3.4290589e-009
+ pkt1=3.9866578e-016       kt1l=0                    kt2=0.016160637
+ lkt2=-6.1941999e-009+dlkt2p_uhvt                    wkt2=-8.0502524e-009
+ pkt2=9.5787334e-016       ute=-1                    ua1=2.3815408e-009
+ lua1=-4.1037218e-017      wua1=1.5017943e-016       pua1=-2.9712653e-023
+ ub1=-3.35e-018            uc1=7.181e-011            prt=0
+ at=50000                  noimod=2                  em=4100
+ noia=1e020                ef=1.18                   noib=400000
+ noic=1e-011               cj=cjp_uhvt               cjsw=cjswp_uhvt
+ rd=0                      rs=0                      xti=3
+ n=1                       cjswg=cjswgp_uhvt         sa0=3.5e-007
+ sb0=3.5e-007              wwn=-1                    rsh=7.2
+ alpha1=0.0016892          beta0=10.862              mj=0.41
+ pb=0.8                    mjsw=0.049                pbsw=0.74
+ mjswg=0.48                pbswg=0.8                 js=1.300e-07
+ jsw=4.500e-13             tcj=8.466e-04             tpb=0.0015
+ tcjsw=1.509e-04           tpbsw=2.300e-03           tcjswg=0.0012
+ tpbswg=0.0019             capmod=3                  xpart=1
+ dlc=1.5e-08               wwc=-0.04                 kvsat=-0.6
+ wlod=3e-07                tku0=0.5                  ku0=1.14e-07
+ llodku0=1                 wlodku0=1                 lku0=6e-08
+ wku0=3e-07                pku0=1e-14                kvth0=-2.3e-09
+ stk2=0                    steta0=0                  lkvth0=1e-08
+ wkvth0=2.5e-07            pkvth0=4e-14              llodvth=1
+ wlodvth=1                 lodk2=1                   lodeta0=1
+ tlev=1                    tlevc=1                   minr=1e-3
+ imax=0.01                 imelt=0.01

     }
endsection mos_uhvt

//  *************************************************************
//                                                              *
//             2.5V NATIVE NMOS DEVICES MODEL                   *
//                                                              *
//  *************************************************************
//
section mos_na25
//
model nch_na25 bsim3v3  {
     1: type=n
+ lmin=1.2e-06              lmax=2.1e-05              wmin=1.5e-07
+ wmax=1.01e-04             tnom=25                   version=3.2
+ tox=toxn_na25             toxm=toxn_na25            xj=3.7e-07
+ nch=2.37e+15              lln=-1                    lwn=1
+ wln=1                     wwn=1                     lint=1.25e-08
+ wint=5e-09                mobmod=1                  binunit=2
+ xl=-4e-08+dxln_na25       xw=1e-8+dxwn_na25         dwg=0
+ dwb=0                     ldif=8e-08                hdif=hdifn_na25
+ rsh=6.5                   rd=0                      rs=0
+ vth0=-0.1065937+dvthn_na25                          lvth0=-5.207797e-08
+ wvth0=4.708472e-09        pvth0=-1.646218e-15       k1=0.08286425
+ lk1=-9.925581e-09         wk1=2.965507e-09          pk1=1.131457e-14
+ k2=-0.007094954           lk2=1.095182e-08          wk2=6.850397e-09
+ pk2=-4.413141e-15         k3=0                      dvt0=0
+ dvt1=0                    dvt2=0                    dvt0w=0
+ dvt1w=0                   dvt2w=0                   nlx=0
+ w0=0                      k3b=0                     vfb=-0.8430378
+ vsat=211974.7             lvsat=-0.1190887          wvsat=-4.285109e-05
+ pvsat=4.261459e-10        ua=3.954674e-10           lua=-3.270499e-17
+ wua=3.845095e-17          pua=-6.037654e-23         ub=8.608167e-19
+ lub=1.04893e-24           wub=-8.855563e-26         pub=-2.513631e-32
+ uc=1.69724e-12            luc=-2.251118e-18         wuc=-6.921135e-18
+ puc=-3.107315e-25         rdsw=175                  prwb=0
+ prwg=0                    wr=1                      u0=0.0478359
+ lu0=1.030029e-10          wu0=-9.60484e-10          pu0=1.311071e-15
+ a0=-0.2862996             la0=1.852749e-06          wa0=2.083282e-08
+ pa0=-2.071822e-13         keta=-0.004811431         lketa=-1.082215e-09
+ wketa=-1.02589e-09        pketa=6.365623e-17        a1=0
+ a2=0.99                   ags=-0.02                 b0=0
+ b1=0                      voff=-0.1084754           lvoff=-4.089606e-09
+ wvoff=-1.989904e-09       pvoff=2.440228e-15        nfactor=1
+ cit=-0.0006991099         lcit=9.288329e-10         wcit=1.276861e-10
+ pcit=-9.476181e-17        cdsc=0                    cdscb=0
+ cdscd=0                   eta0=0.0002397729         leta0=2.58796e-09
+ etab=-5e-05               dsub=0                    pclm=0.6
+ pdiblc1=1e-06             pdiblc2=0.004349432       lpdiblc2=6.4699e-09
+ pdiblcb=0.01              drout=0                   pscbe1=4e+08
+ pscbe2=1e-06              pvag=0                    delta=0.01
+ alpha0=0                  alpha1=2.45               beta0=23
+ kt1=-0.255                kt2=-0.01882562           at=-50000
+ ute=-1.554099             lute=1.64837e-09          wute=4.097882e-08
+ pute=-1.64372e-14         ua1=1.75e-09              ub1=-2.78467e-18
+ uc1=-1.242718e-11         kt1l=0                    prt=0
+ cj=cjn_na25               mj=0.4621645              pb=0.6660649
+ cjsw=cjswn_na25           mjsw=1e-4                 pbsw=0.6660649
+ cjswg=cjswgn_na25         mjswg=1e-4                pbswg=0.6660649
+ tcj=3.965237e-3           tcjsw=1.592614e-3         tpb=2.520767e-3
+ tpbsw=2.520767e-3         tlev=1                    tlevc=1
+ js=7.0e-7                 jsw=7.96e-12              n=1
+ xti=3                     cgdo=cgon_na25            cgso=cgon_na25
+ cgbo=0                    capmod=3                  nqsmod=0
+ xpart=1                   cf=0                      llc=-0.0215
+ vfbcv=-1                  acde=1                    moin=15
+ noff=1                    voffcv=0                  dlc=1.277e-8
+ noia=1.0e+18              noib=2e+3                 noic=1.0e-14
+ em=1e+6                   ef=0.8                    noimod=2
+ minr=1e-3                 imax=0.01                 imelt=0.01
//
     }
endsection mos_na25
//
//
//  *************************************************************
//                                                              *
//   Vertical BIPOLAR MODELS for 1.2V device process            *
//                                                              *
//  *************************************************************
//  *************************************************************
//                                                              *
//                PNP Bipolar MODEL                             *
//                                                              *
//  *************************************************************

section tt_bip
parameters isa=1
parameters bfa=1
parameters nfa=1
parameters rba=1
parameters rea=1
parameters rca=1
parameters rbma=1
parameters cjea=1
parameters cjca=1
include "cr013g_2d5_v1d4.scs" section=bip
endsection tt_bip

section ss_bip
parameters isa=0.7
parameters bfa=0.85
parameters nfa=0.9975
parameters rba=1.2
parameters rea=1.2
parameters rca=1.2
parameters rbma=1.2
parameters cjea=1.05
parameters cjca=1.05
include "cr013g_2d5_v1d4.scs" section=bip
endsection ss_bip

section ff_bip
parameters isa=1.3
parameters bfa=1.15
parameters nfa=1.0025
parameters rba=0.8
parameters rea=0.8
parameters rca=0.8
parameters rbma=0.8
parameters cjea=0.95
parameters cjca=0.95
include "cr013g_2d5_v1d4.scs" section=bip
endsection ff_bip

section bip

model pnp10 bjt type=pnp
+ bf=2.2659*bfa             nf=1.005*nfa              is=1.08e-17*isa
+ ise=1.08e-17*isa          isc=1.08e-17*isa          ne=1.2902
+ rb=116*rba                irb=1.806e-4              rbm=0.1*rbma
+ re=15*rea                 ikf=0.0033265             nkf=0.55979
+ vaf=210                   br=7.3928e-3              nr=1
+ nc=1.161                  rc=25*rca                 ikr=1e-4
+ var=30                    xti=3                     eg=1.18
+ xtb=0                     trb1=-0.005051            tirb1=1.052e-4
+ trm1=0                    tre1=5.6225e-3            trc1=0.0049247
+ tikf1=-2.1594e-3          tbf1=4.5418e-3            tnf1=7e-5
+ tne1=8.1e-4               tvaf1=-6.95e-5            tbr1=-2.8114e-4
+ tnr1=-1.501e-4            cje=1.4063e-13*cjea       vje=0.8975311
+ mje=0.42                  fc=0                      cjc=6.302478e-14*cjca
+ vjc=0.55                  mjc=0.31                  tlevc=1
+ cte=8.83914e-4            ctc=2.748026e-3           tvje=1.572025e-3
+ tvjc=2.748026e-3          tnom=25                   rbmod=spice
+ minr=1e-3

model pnp5 bjt type=pnp
+ bf=2.3324*bfa             nf=1.005*nfa              is=2.99e-18*isa
+ ise=2.99e-18*isa          isc=2.99e-18*isa          ne=1.2502
+ rb=217.53*rba             irb=7.806e-005            rbm=0.1*rbma
+ re=17.955*rea             ikf=0.0010975             nkf=0.46412
+ vaf=200.8                 br=0.0029185              nr=1
+ nc=1.15                   rc=25*rca                 ikr=1e-4
+ var=26.4                  xti=3                     eg=1.18
+ xtb=0                     trb1=2.764e-3             tirb1=1.052e-3
+ trm1=9.44e-6              tre1=4.8696e-4            tikf1=-3.504e-3
+ tikr1=-3.925e-3           trc1=0.0024               tbf1=4.7016e-3
+ tnf1=6.7e-5               tne1=4.9324e-4            tvaf1=-5.95e-5
+ tbr1=-2.944e-4            tnc1=3.017e-4             tnr1=-1.501e-4
+ cje=3.61615e-14*cjea      vje=0.8975311             mje=0.42
+ fc=0                      cjc=3.691436e-14*cjca     vjc=0.55
+ mjc=0.31                  tlevc=1                   cte=8.83914e-4
+ ctc=2.748026e-3           tvje=1.572025e-3          tvjc=2.688919e-3
+ tnom=25                   tbf2=3.788e-6             rbmod=spice
+ minr=1e-3

model pnp2 bjt type=pnp
+ bf=2.521*bfa              nf=1.005*nfa              is=6.0501e-19*isa
+ ise=6.0501e-19*isa        isc=6.0501e-19*isa        ne=1.2631
+ rb=456.23*rba             irb=7.806e-5              rbm=0.1*rbma
+ re=15.974*rea             ikf=3.0914e-4             nkf=0.3981
+ vaf=100.4                 br=7.788e-4               nr=1
+ nc=1.1                    rc=20*rca                 ikr=1e-4
+ var=23.29                 xti=3                     eg=1.18
+ xtb=0                     trb1=1.0337e-3            tirb1=1.052e-3
+ trm1=9.44e-6              tre1=-1.226e-3            tikf1=-3.5374e-3
+ tikr1=-3.925e-3           trc1=1.44e-3              tbf1=5.5854e-3
+ tnf1=5.844e-5             tne1=1e-4                 tvaf1=-7.95e-4
+ tbr1=-2.5254e-4           tnc1=1.0173e-4            tnr1=-1.303883e-4
+ cje=6.26776e-15*cjea      vje=0.8975311             mje=0.42
+ fc=0                      cjc=2.404746e-14*cjca     vjc=0.55
+ mjc=0.31                  tlevc=1                   cte=8.83914e-4
+ ctc=2.748026e-3           tvje=1.572025e-3          tvjc=2.688919e-3
+ tnom=25                   tbf2=2.9999e-6            rbmod=spice
+ minr=1e-3

endsection bip
//
//
//  *************************************************************
//                                                              *
//                NPN Bipolar MODEL                             *
//                                                              *
//  *************************************************************

section tt_bip_npn
parameters isb=1
parameters bfb=1
parameters nfb=1
parameters rbb=1
parameters reb=1
parameters rcb=1
parameters rbmb=1
parameters cjeb=1
parameters cjcb=1
include "cr013g_2d5_v1d4.scs" section=bip_npn
endsection tt_bip_npn

section ss_bip_npn
parameters isb=0.70
parameters bfb=0.85
parameters nfb=0.9975
parameters rbb=1.2
parameters reb=1.2
parameters rcb=1.2
parameters rbmb=1.2
parameters cjeb=1.05
parameters cjcb=1.05
include "cr013g_2d5_v1d4.scs" section=bip_npn
endsection ss_bip_npn

section ff_bip_npn
parameters isb=1.30
parameters bfb=1.15
parameters nfb=1.0025
parameters rbb=0.8
parameters reb=0.8
parameters rcb=0.8
parameters rbmb=0.8
parameters cjeb=0.95
parameters cjcb=0.95
include "cr013g_2d5_v1d4.scs" section=bip_npn
endsection ff_bip_npn

section bip_npn

model npn10 bjt type=npn
+ bf=7.67*bfb               nf=1.005*nfb              ise=1.99e-17*isb
+ ne=1.1902                 is=1.99e-17*isb           rb=467.48*rbb
+ irb=0.0005                rbm=0.05*rbmb             re=35*reb
+ ikf=0.05                  nkf=0.2625                vaf=88.56
+ br=0.825                  nr=1                      tlev=0
+ isc=1.99e-17*isb          nc=1.1615                 rc=120*rcb
+ ikr=0.0001104             var=38.16                 xti=3
+ eg=1.17                   xtb=0                     tbf1=0.0047088
+ tbf2=1.99e-06             trb1=0.0064135            trc1=0.008
+ tikf1=-0.0075             tikr1=0.0014              tbr1=0.000198
+ tbr2=2e-07                tne1=0.00045              tnf1=-3e-5
+ cje=1.323e-13*cjeb        vje=0.7908                mje=0.4522
+ cte=0.0008988             tvje=0.001265             cjc=2.187e-13*cjcb
+ vjc=0.625                 mjc=0.3411                ctc=0.001009
+ tvjc=0.001837             tlevc=1                   fc=0
+ tnom=25                   rbmod=spice               minr=1e-3
//
model npn5 bjt type=npn
+ bf=8.05*bfb               nf=1.005*nfb              ise=5.34e-18*isb
+ ne=1.19                   is=5.34e-18*isb           rb=501.8*rbb
+ irb=0.09                  rbm=0.1*rbmb              re=35*reb
+ ikf=0.037959              nkf=0.62748               vaf=72
+ br=0.53934                nr=1                      tlev=0
+ isc=5.34e-18*isb          nc=1.0829                 rc=125*rcb
+ ikr=0.00013498            var=71.4                  xti=3
+ eg=1.17                   xtb=0                     tbf1=0.0046922
+ tbf2=1.4e-06              trb1=0.003                trc1=0.008
+ tikf1=-0.0052             tikr1=0.004               tbr1=6.72e-005
+ tbr2=1e-06                tne1=0.0005               tnf1=-2.2e-5
+ cje=3.449e-14*cjeb        vje=0.7908                mje=0.4522
+ cte=0.0008988             tvje=0.001265             cjc=1.081e-13*cjcb
+ vjc=0.625                 mjc=0.3411                ctc=0.001009
+ tvjc=0.001837             tlevc=1                   fc=0
+ tnom=25                   rbmod=spice               minr=1e-3
//
model npn2 bjt type=npn
+ bf=10.97*bfb              nf=1.005*nfb              ise=1.065e-18*isb
+ ne=1.1595                 is=1.065e-18*isb          rb=750*rbb
+ irb=0.001                 rbm=1*rbmb                re=70*reb
+ ikf=0.00042146            nkf=0.15484               vaf=108
+ br=0.18988                nr=1                      tlev=0
+ isc=1.065e-18*isb         nc=1.4175                 rc=125*rcb
+ ikr=1                     var=50.21                 xti=3
+ eg=1.17                   xtb=0                     tbf1=0.0039346
+ tbf2=1.3375e-05           trb1=0.0057475            trc1=0.008
+ tikf1=-0.0062922          tikr1=0.005               tbr1=0.0003175
+ tbr2=-1e-06               tne1=0.0005               tnf1=-2e-05
+ cje=6.194e-15*cjeb        vje=0.7908                mje=0.4522
+ cte=0.0008988             tvje=0.001265             cjc=5.724e-14*cjcb
+ vjc=0.625                 mjc=0.3411                ctc=0.001009
+ tvjc=0.001837             tlevc=1                   fc=0
+ tnom=25                   rbmod=spice               minr=1e-3

endsection bip_npn

//
//
//  *************************************************************
//                                                              *
//               1.2V Junction DIODE Corner MODELS              *
//                                                              *
//  *************************************************************
//  ****************** CORNER_LIB OF TYPICAL MODEL *************************

section tt_dio
parameters is_d=1
parameters jsw_d=1
parameters n_d=1
parameters rs_d=1
parameters cj_d=1
parameters cjsw_d=1
include "cr013g_2d5_v1d4.scs" section=dio
endsection tt_dio
//  ****************** CORNER_LIB OF SLOW MODEL ****************************
section ss_dio
parameters is_d=0.7
parameters jsw_d=0.5
parameters n_d=1.0025
parameters rs_d=1.2
parameters cj_d=1.05
parameters cjsw_d=1.1
include "cr013g_2d5_v1d4.scs" section=dio
endsection ss_dio
//  ****************** CORNER_LIB OF FAST MODEL ****************************
section ff_dio
parameters is_d=1.3
parameters jsw_d=2
parameters n_d=0.9975
parameters rs_d=0.8
parameters cj_d=0.95
parameters cjsw_d=0.9
include "cr013g_2d5_v1d4.scs" section=dio
endsection ff_dio
//
//  *************************************************************
//                                                              *
//        Junction DIODE MODELS  for 1.2V device process        *
//                                                              *
//  *************************************************************
//
section dio
//
//  *************************************************************
//                       MODEL OF N+/PW DIODE                   *
//                                                              *
//  *************************************************************
//
//
model ndio diode
+ level=1                   is=8.00e-7*is_d           rs=1.00e-10*rs_d
+ n=1.02*n_d                bv=10.6                   ibv=0.05
+ isw=1.55e-13*jsw_d        cj=0.001376*cj_d          vj=0.7956
+ mj=0.4528                 cjsw=2.06e-10*cjsw_d      vjsw=0.7956
+ mjsw=0.2323               tlev=1                    eg=1.17
+ xti=3                     tbv1=-1*-0.000888         trs=0.00277
+ tlevc=1                   cta=0.0009067             ctp=0.0002781
+ pta=0.001427              ptp=0.001427              tnom=25
+ fc=0                      fcs=0                     area=3.92e-08
+ pj=0.00084                ns=1.02*n_d               nz=1.02*n_d
+ imax=1e40                 minr=1e-10                allow_scaling=1
//
//
//  *************************************************************
//                       MODEL OF P+/NW DIODE                   *
//                                                              *
//  *************************************************************
//
//
model pdio diode
+ level=1                   is=1.80e-7*is_d           rs=1.00e-10*rs_d
+ n=1.02*n_d                bv=8.4                    ibv=0.02
+ isw=6.60e-14*jsw_d        cj=0.001369*cj_d          vj=0.9
+ mj=0.4234                 cjsw=9.8e-11*cjsw_d       vjsw=0.9
+ mjsw=0.1716               tlev=1                    eg=1.17
+ xti=3                     tbv1=-1*-0.000845         trs=0.00289
+ tlevc=1                   cta=0.000887              ctp=0.000298
+ pta=0.001643              ptp=0.001643              tnom=25
+ fc=0                      fcs=0                     area=3.92e-08
+ pj=0.00084                ns=1.02*n_d               nz=1.02*n_d
+ imax=1e40                 minr=1e-10                allow_scaling=1
//
//  *************************************************************
//                       MODEL OF NW/PSUB DIODE                 *
//                                                              *
//  *************************************************************
//
model nwdio diode
+ level=1                   is=6.20e-7*is_d           rs=1.00e-10*rs_d
+ n=1.02*n_d                bv=13.6                   ibv=0.01
+ isw=3.17e-12*jsw_d        cj=0.0001291*cj_d         vj=0.8122
+ mj=0.4897                 cjsw=5.35e-10*cjsw_d      vjsw=0.8122
+ mjsw=0.2822               tlev=1                    eg=1.17
+ xti=3                     tbv1=-1*-1.29e-3          trs=0.00204
+ tlevc=1                   cta=0.002483              ctp=0.001238
+ pta=0.003184              ptp=0.003184              tnom=25
+ fc=0                      fcs=0                     area=3.92e-08
+ pj=0.00084                ns=1.02*n_d               nz=1.02*n_d
+ imax=1e40                 minr=1e-10                allow_scaling=1
//
endsection dio
//
//
//  *************************************************************
//                                                              *
//                DNW Junction DIODE Corner MODELS              *
//                                                              *
//  *************************************************************
//  ****************** CORNER_LIB OF TYPICAL MODEL *************************
section tt_dio_dnw
parameters is_d_dnw=1
parameters jsw_d_dnw=1
parameters n_d_dnw=1
parameters rs_d_dnw=1
parameters cj_d_dnw=1
parameters cjsw_d_dnw=1
include "cr013g_2d5_v1d4.scs" section=dio_dnw
endsection tt_dio_dnw
//  ****************** CORNER_LIB OF SLOW MODEL ****************************
section ss_dio_dnw
parameters is_d_dnw=0.7
parameters jsw_d_dnw=0.5
parameters n_d_dnw=1.0025
parameters rs_d_dnw=1.2
parameters cj_d_dnw=1.05
parameters cjsw_d_dnw=1.1
include "cr013g_2d5_v1d4.scs" section=dio_dnw
endsection ss_dio_dnw
//  ****************** CORNER_LIB OF FAST MODEL ****************************
section ff_dio_dnw
parameters is_d_dnw=1.3
parameters jsw_d_dnw=2
parameters n_d_dnw=0.9975
parameters rs_d_dnw=0.8
parameters cj_d_dnw=0.95
parameters cjsw_d_dnw=0.9
include "cr013g_2d5_v1d4.scs" section=dio_dnw
endsection ff_dio_dnw
//

section dio_dnw
//
//  *************************************************************
//                    MODEL OF DNW_PSUB DIODE                   *
//                                                              *
//  *************************************************************
//
//
model dnwpsub diode
+ level=1                   is=9.76e-7*is_d_dnw       rs=1.00e-10*rs_d_dnw
+ n=1.02*n_d_dnw            bv=13.8                   ibv=0.03
+ isw=4.13e-12*jsw_d_dnw    area=3.92e-8              pj=8.4e-4
+ cj=1.322062e-4*cj_d_dnw   vj=0.6012182              mj=0.3431207
+ cjsw=1.136579e-9*cjsw_d_dnw                         vjsw=0.6012182
+ mjsw=0.3037134            tlev=1                    eg=1.17
+ xti=3                     tbv1=-1*-7.1e-4           trs=2.65e-3
+ tlevc=1                   cta=2.572685e-3           ctp=2.05458e-3
+ pta=3.145801e-3           ptp=3.145801e-3           tnom=25
+ fc=0                      fcs=0                     ns=1.02*n_d_dnw
+ nz=1.02*n_d_dnw           imax=1e40                 minr=1e-10
+ allow_scaling=1
//
//  *************************************************************
//                     MODEL OF PW_DNW DIODE                    *
//                                                              *
//  *************************************************************
//
//
model pwdnw diode
+ level=1                   is=2.55e-6*is_d_dnw       rs=1.00e-10*rs_d_dnw
+ n=1.02*n_d_dnw            bv=13.7                   ibv=0.03
+ isw=5.44e-12*jsw_d_dnw    area=3.92e-8              pj=8.4e-4
+ cj=6.476416e-4*cj_d_dnw   vj=0.6258547              mj=0.3352525
+ cjsw=2.148838e-9*cjsw_d_dnw                         vjsw=0.6258547
+ mjsw=0.3516833            tlev=1                    eg=1.17
+ xti=3                     tbv1=-1*-7.1e-4           trs=2.65e-3
+ tlevc=1                   cta=9.800653e-4           ctp=1.067032e-3
+ pta=1.857987e-3           ptp=1.857987e-3           tnom=25
+ fc=0                      fcs=0                     ns=1.02*n_d_dnw
+ nz=1.02*n_d_dnw           imax=1e40                 minr=1e-10
+ allow_scaling=1
//
endsection dio_dnw
//
//
//  *************************************************************
//                                                              *
//           1.2V High Vt Junction DIODE Corner MODELS          *
//                                                              *
//  *************************************************************
//  ****************** LIBRARY OF TYPICAL CASE ********************
section tt_dio_hvt
parameters is_d_hvt=1
parameters jsw_d_hvt=1
parameters n_d_hvt=1
parameters rs_d_hvt=1
parameters cj_d_hvt=1
parameters cjsw_d_hvt=1
include "cr013g_2d5_v1d4.scs" section=dio_hvt
endsection tt_dio_hvt
//  ****************** LIBRARY OF SLOW CASE ***********************
section ss_dio_hvt
parameters is_d_hvt=0.7
parameters jsw_d_hvt=0.5
parameters n_d_hvt=1.0025
parameters rs_d_hvt=1.2
parameters cj_d_hvt=1.05
parameters cjsw_d_hvt=1.1
include "cr013g_2d5_v1d4.scs" section=dio_hvt
endsection ss_dio_hvt
//  ****************** LIBRARY OF FAST CASE ***********************
section ff_dio_hvt
parameters is_d_hvt=1.3
parameters jsw_d_hvt=2
parameters n_d_hvt=0.9975
parameters rs_d_hvt=0.8
parameters cj_d_hvt=0.95
parameters cjsw_d_hvt=0.9
include "cr013g_2d5_v1d4.scs" section=dio_hvt
endsection ff_dio_hvt
//
//  *************************************************************
//                                                              *
//    Junction DIODE MODELS for 1.2V High Vt device process     *
//                                                              *
//  *************************************************************
//
section dio_hvt
//
//  *************************************************************
//                       MODEL OF N+/PW DIODE                   *
//                                                              *
//  *************************************************************
//
model ndio_hvt diode
+ level=1                   is=2.50e-6*is_d_hvt       rs=1.00e-10*rs_d_hvt
+ n=1.02*n_d_hvt            bv=8.9                    ibv=0.03
+ isw=2.55e-12*jsw_d_hvt    area=3.92e-8              pj=8.4e-4
+ cj=1.590799e-3*cj_d_hvt   vj=0.8578199              mj=0.4774564
+ cjsw=2.023103e-10*cjsw_d_hvt                        vjsw=0.8578199
+ mjsw=0.2551013            tlev=1                    eg=1.17
+ xti=3                     tbv1=-1*-8.88e-4          trs=2.77e-3
+ tlevc=1                   cta=7.251995e-4           ctp=3.603971e-4
+ pta=1.168276e-3           ptp=1.168276e-3           tnom=25
+ fc=0                      fcs=0                     ns=1.02*n_d_hvt
+ nz=1.02*n_d_hvt           imax=1e40                 minr=1e-10
+ allow_scaling=1
//
//  *************************************************************
//                       MODEL OF P+/NW DIODE                   *
//                                                              *
//  *************************************************************
//
model pdio_hvt diode
+ level=1                   is=1.49e-7*is_d_hvt       rs=1.00e-10*rs_d_hvt
+ n=1.02*n_d_hvt            bv=8.2                    ibv=0.03
+ isw=2.00e-13*jsw_d_hvt    area=3.92e-8              pj=8.4e-4
+ cj=1.469162e-3*cj_d_hvt   vj=0.8465904              mj=0.4107588
+ cjsw=9.358381e-11*cjsw_d_hvt                        vjsw=0.8465904
+ mjsw=0.1813912            tlev=1                    eg=1.17
+ xti=3                     tbv1=-1*-8.45e-4          trs=2.89e-3
+ tlevc=1                   cta=8.024992e-4           ctp=4.114948e-4
+ pta=1.514677e-3           ptp=1.514677e-3           tnom=25
+ fc=0                      fcs=0                     ns=1.02*n_d_hvt
+ nz=1.02*n_d_hvt           imax=1e40                 minr=1e-10
+ allow_scaling=1
//
endsection dio_hvt
//
//
// **************************************************************
//                                                              *
//       1.2V Ultra High Vt Junction DIODE Corner MODELS        *
//                                                              *
// **************************************************************
// ******************* CORNER_LIB OF TYPICAL MODEL *************************

section tt_dio_uhvt
parameters is_d_uhvt=1
parameters jsw_d_uhvt=1
parameters n_d_uhvt=1
parameters rs_d_uhvt=1
parameters cj_d_uhvt=1
parameters cjsw_d_uhvt=1
include "cr013g_2d5_v1d4.scs" section=dio_uhvt
endsection tt_dio_uhvt
// ******************* CORNER_LIB OF SLOW MODEL ****************************

section ss_dio_uhvt
parameters is_d_uhvt=0.7
parameters jsw_d_uhvt=0.5
parameters n_d_uhvt=1.0025
parameters rs_d_uhvt=1.2
parameters cj_d_uhvt=1.05
parameters cjsw_d_uhvt=1.1
include "cr013g_2d5_v1d4.scs" section=dio_uhvt
endsection ss_dio_uhvt
// ******************* CORNER_LIB OF FAST MODEL ****************************

section ff_dio_uhvt
parameters is_d_uhvt=1.3
parameters jsw_d_uhvt=2
parameters n_d_uhvt=0.9975
parameters rs_d_uhvt=0.8
parameters cj_d_uhvt=0.95
parameters cjsw_d_uhvt=0.9
include "cr013g_2d5_v1d4.scs" section=dio_uhvt
endsection ff_dio_uhvt
//
// **************************************************************
//                                                              *
//  Junction DIODE MODELS for 1.2V Ultra High Vt device process *
//                                                              *
// **************************************************************
//

section dio_uhvt
//
// **************************************************************
//                       MODEL OF N+/PW DIODE                   *
// **************************************************************
model ndio_uhvt diode
+ level=1                   n=1.01*n_d_uhvt           is=2.000e-07*is_d_uhvt
+ isw=7.500e-13*jsw_d_uhvt  rs=1.000e-10*rs_d_uhvt    bv=10.5
+ ibv=0.03                  fc=0                      cj=1.323e-03*cj_d_uhvt
+ vj=0.8                    mj=0.48                   cjsw=1.439e-10*cjsw_d_uhvt
+ vjsw=0.74                 mjsw=0.35                 cta=9.500e-04
+ ctp=4.800e-04             pta=1.500e-03             ptp=9.000e-04
+ tlev=1                    eg=1.170                  xti=3
+ tlevc=1                   trs=2.500e-03             tbv1=-1*-0.00085
+ tnom=25                   ns=1.01*n_d_uhvt          nz=1.01*n_d_uhvt
+ imax=1e40                 minr=1e-10                allow_scaling=1

// **************************************************************
//                       MODEL OF P+/NW DIODE                   *
// **************************************************************
model pdio_uhvt diode
+ level=1                   n=1.01*n_d_uhvt           is=1.300e-07*is_d_uhvt
+ isw=4.500e-13*jsw_d_uhvt  rs=1.000e-10*rs_d_uhvt    bv=8.4
+ ibv=0.03                  fc=0                      cj=1.458e-03*cj_d_uhvt
+ vj=0.8                    mj=0.41                   cjsw=7.533e-11*cjsw_d_uhvt
+ vjsw=0.74                 mjsw=0.049                cta=8.466e-04
+ ctp=1.509e-04             pta=1.500e-03             ptp=2.300e-03
+ tlev=1                    eg=1.170                  xti=3
+ tlevc=1                   trs=2.500e-03             tbv1=-1*-0.0009
+ tnom=25                   ns=1.01*n_d_uhvt          nz=1.01*n_d_uhvt
+ imax=1e40                 minr=1e-10                allow_scaling=1

endsection dio_uhvt
//
//  *************************************************************
//            1.2V Native Junction DIODE Corner MODELS          *
//  *************************************************************
//  ****************** LIBRARY OF TYPICAL CASE ********************
section tt_dio_na
parameters is_d_na=1.0
parameters jsw_d_na=1.0
parameters n_d_na=1.0
parameters rs_d_na=1.0
parameters cj_d_na=1.0
parameters cjsw_d_na=1.0
include "cr013g_2d5_v1d4.scs" section=dio_na
endsection tt_dio_na
//  ****************** LIBRARY OF SLOW CASE ***********************
section ss_dio_na
parameters is_d_na=0.7
parameters jsw_d_na=0.5
parameters n_d_na=1.0025
parameters rs_d_na=1.2
parameters cj_d_na=1.05
parameters cjsw_d_na=1.1
include "cr013g_2d5_v1d4.scs" section=dio_na
endsection ss_dio_na
//  ****************** LIBRARY OF FAST CASE ***********************
section ff_dio_na
parameters is_d_na=1.3
parameters jsw_d_na=2.0
parameters n_d_na=0.9975
parameters rs_d_na=0.8
parameters cj_d_na=0.95
parameters cjsw_d_na=0.9
include "cr013g_2d5_v1d4.scs" section=dio_na
endsection ff_dio_na
//
//
//  *************************************************************
//                                                              *
//     Junction DIODE MODELS for 1.2V Native device process     *
//                                                              *
//  *************************************************************
//
section dio_na
//
//  *************************************************************
//                       MODEL OF N+/PW DIODE                   *
//                                                              *
//  *************************************************************
//
model ndio_na diode
+ level=1                   is=9.00e-7*is_d_na        rs=1.00e-10*rs_d_na
+ n=1.02*n_d_na             bv=13.8                   ibv=0.03
+ isw=2.03e-12*jsw_d_na     area=3.92e-8              pj=8.4e-4
+ cj=1.238858e-4*cj_d_na    vj=0.6660649              mj=0.4596073
+ cjsw=1.726958e-10*cjsw_d_na                         vjsw=0.6660649
+ mjsw=1e-4                 tlev=1                    eg=1.17
+ xti=3                     tbv1=-1*-1.4e-3           trs=2.65e-3
+ tlevc=1                   cta=3.449993e-3           ctp=1.348721e-3
+ pta=2.69401e-3            ptp=2.69401e-3            tnom=25
+ fc=0                      fcs=0                     ns=1.02*n_d_na
+ nz=1.02*n_d_na            imax=1e40                 minr=1e-10
+ allow_scaling=1
//
endsection dio_na
//
//
//  *************************************************************
//                                                              *
//               2.5V Junction DIODE Corner MODELS              *
//                                                              *
//  *************************************************************
//  ****************** LIBRARY OF TYPICAL CASE ********************

section tt_dio_25
parameters is_d_25=1
parameters jsw_d_25=1
parameters n_d_25=1
parameters rs_d_25=1
parameters cj_d_25=1
parameters cjsw_d_25=1
parameters cj_d_esd25=1
include "cr013g_2d5_v1d4.scs" section=dio_25
endsection tt_dio_25
//  ****************** LIBRARY OF SLOW CASE ***********************
section ss_dio_25
parameters is_d_25=0.7
parameters jsw_d_25=0.5
parameters n_d_25=1.0025
parameters rs_d_25=1.2
parameters cj_d_25=1.05
parameters cjsw_d_25=1.1
parameters cj_d_esd25=1.05
include "cr013g_2d5_v1d4.scs" section=dio_25
endsection ss_dio_25
//  ****************** LIBRARY OF FAST CASE ***********************
section ff_dio_25
parameters is_d_25=1.3
parameters jsw_d_25=2
parameters n_d_25=0.9975
parameters rs_d_25=0.8
parameters cj_d_25=0.95
parameters cjsw_d_25=0.9
parameters cj_d_esd25=0.95
include "cr013g_2d5_v1d4.scs" section=dio_25
endsection ff_dio_25
//
//  *************************************************************
//                                                              *
//         Junction DIODE MODELS for 2.5 device process         *
//                                                              *
//  *************************************************************
//
section dio_25
//
//  *************************************************************
//                       MODEL OF N+/PW DIODE                   *
//                                                              *
//  *************************************************************
//
model ndio_25 diode
+ level=1                   is=4.03e-7*is_d_25        rs=1.00e-10*rs_d_25
+ n=1.02*n_d_25             bv=13.1                   ibv=0.03
+ isw=2.10e-12*jsw_d_25     cj=9.68e-4*cj_d_25        pj=8.4e-4
+ mj=0.3193271              fc=0                      cjsw=9.5e-11*cjsw_d_25
+ area=3.92e-8              mjsw=0.01                 tlevc=1
+ tlev=1                    xti=3                     eg=1.17
+ vjsw=0.7249372            vj=0.7249372              pta=1.816363e-3
+ tnom=25                   ptp=1.816363e-3           tbv1=-1*-9.0e-4
+ trs=2.77e-3               cta=1.010853e-3           ctp=9.297595e-5
+ ns=1.02*n_d_25            nz=1.02*n_d_25            imax=1e40
+ minr=1e-3                 allow_scaling=1
//
//  *************************************************************
//                       MODEL OF P+/NW DIODE                   *
//                                                              *
//  *************************************************************
//
model pdio_25 diode
+ level=1                   is=2.00e-7*is_d_25        rs=1.00e-10*rs_d_25
+ n=1.05*n_d_25             bv=9.8                    ibv=0.03
+ isw=6.50e-13*jsw_d_25     cj=1.247e-3*cj_d_25       pj=8.4e-4
+ mj=0.3952264              fc=0                      cjsw=7.7e-11*cjsw_d_25
+ area=3.92e-8              mjsw=0.0450429            tlevc=1
+ tlev=1                    xti=3                     eg=1.17
+ vjsw=0.854899             vj=0.854899               pta=1.603538e-3
+ tnom=25                   ptp=1.603538e-3           tbv1=-1*-8.1e-4
+ trs=2.89e-3               cta=9.016089e-4           ctp=1.793034e-4
+ ns=1.05*n_d_25            nz=1.05*n_d_25            imax=1e40
+ minr=1e-3                 allow_scaling=1
//
//  *************************************************************
//                    MODEL OF 2.5V ESD DIODE                   *
//                                                              *
//  *************************************************************
//
model dio_esd25 diode
+ level=1                   cj=0.002315*cj_d_esd25    vj=0.8519
+ mj=0.3629                 tlevc=1                   cta=0.0006826
+ pta=0.001323              tnom=25                   fc=0
+ ns=1                      nz=1                      imax=1e40
+ minr=1e-3                 allow_scaling=1
//
endsection dio_25
//
//
//  *************************************************************
//            1.2V Low-Vt Junction DIODE Corner MODELS          *
//  *************************************************************
//  ****************** LIBRARY OF TYPICAL CASE ********************
section tt_dio_lvt
parameters is_d_lvt=1
parameters jsw_d_lvt=1
parameters n_d_lvt=1
parameters rs_d_lvt=1
parameters cj_d_lvt=1
parameters cjsw_d_lvt=1
include "cr013g_2d5_v1d4.scs" section=dio_lvt
endsection tt_dio_lvt
//  ****************** LIBRARY OF SLOW CASE ***********************
section ss_dio_lvt
parameters is_d_lvt=0.7
parameters jsw_d_lvt=0.5
parameters n_d_lvt=1.0025
parameters rs_d_lvt=1.2
parameters cj_d_lvt=1.05
parameters cjsw_d_lvt=1.1
include "cr013g_2d5_v1d4.scs" section=dio_lvt
endsection ss_dio_lvt
//  ****************** LIBRARY OF FAST CASE ***********************
section ff_dio_lvt
parameters is_d_lvt=1.3
parameters jsw_d_lvt=2
parameters n_d_lvt=0.9975
parameters rs_d_lvt=0.8
parameters cj_d_lvt=0.95
parameters cjsw_d_lvt=0.9
include "cr013g_2d5_v1d4.scs" section=dio_lvt
endsection ff_dio_lvt
//
//  ********************************************************************
//                                                                     *
//        Junction DIODE MODELS  for 1.2V Low-Vt device process        *
//                                                                     *
//  ********************************************************************
//
section dio_lvt
//
//  *************************************************************
//                       MODEL OF N+/PW Lvt Junction  diode     *
//                                                              *
//  *************************************************************
//
model ndio_lvt diode
+ level=1                   is=6.00e-07*is_d_lvt      rs=1.00e-10*rs_d_lvt
+ n=1.02*n_d_lvt            bv=10.9                   ibv=0.03
+ isw=1.65e-12*jsw_d_lvt    tlev=1                    tlevc=1
+ eg=1.17                   xti=3                     tbv1=-1*-8.00e-04
+ trs=-2.65e-04             cj=0.001013*cj_d_lvt      cjsw=1.13925e-10*cjsw_d_lvt
+ mj=0.3473                 mjsw=0.1679               vj=0.6209
+ pta=2.69e-03              vjsw=0.6209               ptp=0.001367
+ tnom=25                   cta=0.000976              ctp=0.000255
+ fc=0                      fcs=0                     area=3.92e-08
+ pj=0.00084                ns=1.02*n_d_lvt           nz=1.02*n_d_lvt
+ imax=1e40                 minr=1e-10                allow_scaling=1
//
//  *************************************************************
//                       MODEL OF P+/NW LVt Junction Diode      *
//                                                              *
//  *************************************************************
//
model pdio_lvt diode
+ level=1                   is=2.00e-07*is_d_lvt      rs=1.00e-10*rs_d_lvt
+ n=1.02*n_d_lvt            bv=9.00                   ibv=0.03
+ isw=3.81e-13*jsw_d_lvt    tlev=1                    tlevc=1
+ eg=1.17                   xti=3                     tbv1=-1*-8.00e-04
+ trs=3.65e-04              cj=0.00129033*cj_d_lvt    cjsw=8.93333e-11*cjsw_d_lvt
+ mj=0.385643               mjsw=0.158                vj=0.826557
+ pta=0.00165968            vjsw=0.826557             ptp=2.69e-03
+ tnom=25                   cta=0.00090284            ctp=0.00029887
+ fc=0                      fcs=0                     area=3.92e-08
+ pj=0.00084                ns=1.02*n_d_lvt           nz=1.02*n_d_lvt
+ imax=1e40                 minr=1e-10                allow_scaling=1
//
endsection dio_lvt
//
//
//  *************************************************************
//                                                              *
//            2.5V Low-Vt Junction DIODE Corner MODELS          *
//                                                              *
//  *************************************************************
//  ****************** LIBRARY OF TYPICAL CASE ********************
section tt_dio_lvt25
parameters is_d_lvt25=1
parameters jsw_d_lvt25=1
parameters n_d_lvt25=1
parameters rs_d_lvt25=1
parameters cj_d_lvt25=1
parameters cjsw_d_lvt25=1
include "cr013g_2d5_v1d4.scs" section=dio_lvt25
endsection tt_dio_lvt25
//  ****************** LIBRARY OF SLOW CASE ***********************
section ss_dio_lvt25
parameters is_d_lvt25=0.7
parameters jsw_d_lvt25=0.5
parameters n_d_lvt25=1.0025
parameters rs_d_lvt25=1.2
parameters cj_d_lvt25=1.05
parameters cjsw_d_lvt25=1.1
include "cr013g_2d5_v1d4.scs" section=dio_lvt25
endsection ss_dio_lvt25
//  ****************** LIBRARY OF FAST CASE ***********************
section ff_dio_lvt25
parameters is_d_lvt25=1.3
parameters jsw_d_lvt25=2
parameters n_d_lvt25=0.9975
parameters rs_d_lvt25=0.8
parameters cj_d_lvt25=0.95
parameters cjsw_d_lvt25=0.9
include "cr013g_2d5_v1d4.scs" section=dio_lvt25
endsection ff_dio_lvt25
//
//  ********************************************************************
//                                                                     *
//        Junction DIODE MODELS for 2.5V Low-Vt device process         *
//                                                                     *
//  ********************************************************************
//
section dio_lvt25
//
//  *************************************************************
//                       MODEL OF N+/PW Lvt Junction  diode     *
//                                                              *
//  *************************************************************
//
model ndio_lvt25 diode
+ level=1                   is=3.03e-7*is_d_lvt25     rs=1.0e-10*rs_d_lvt25
+ n=1.02*n_d_lvt25          bv=11.0                   ibv=0.03
+ isw=1.10e-12*jsw_d_lvt25  area=3.92e-8              pj=8.40e-4
+ cj=9.9226e-04*cj_d_lvt25  vj=0.6842167              mj=0.2904575
+ cjsw=2.3321e-10*cjsw_d_lvt25                        vjsw=0.6842167
+ mjsw=0.2                  tlev=1.0                  eg=1.17
+ xti=3.0                   tbv1=-1*-9.00e-04         trs=9.00e-04
+ tlevc=1.0                 cta=1.04239e-3            ctp=7.570649e-04
+ pta=0.001367              ptp=0.001367              tnom=25.0
+ fc=0                      ns=1.02*n_d_lvt25         nz=1.02*n_d_lvt25
+ imax=1e40                 minr=1e-3                 allow_scaling=1
//
//  *************************************************************
//                       MODEL OF P+/NW LVt Junction Diode      *
//                                                              *
//  *************************************************************
//
model pdio_lvt25 diode
+ level=1                   is=2.03e-7*is_d_lvt25     rs=1.00e-10*rs_d_lvt25
+ n=1.02*n_d_lvt25          bv=10.6                   ibv=0.03
+ isw=4.50e-13*jsw_d_lvt25  area=3.92e-8              pj=8.40e-4
+ cj=9.14e-04*cj_d_lvt25    vj=0.8564895              mj=0.3576069
+ cjsw=7.6093e-11*cjsw_d_lvt25                        vjsw=0.6842167
+ mjsw=0.2                  tlev=1.0                  eg=1.17
+ xti=3.0                   tbv1=-1*-8.00e-04         trs=4.00e-03
+ tlevc=1.0                 cta=1.04239e-3            ctp=7.570649e-04
+ pta=0.001367              ptp=0.001367              tnom=25.0
+ fc=0                      ns=1.02*n_d_lvt25         nz=1.02*n_d_lvt25
+ imax=1e40                 minr=1e-3                 allow_scaling=1
//
endsection dio_lvt25
//
//
//  *************************************************************
//                                                              *
//            2.5V Native Junction DIODE Corner MODELS          *
//                                                              *
//  *************************************************************
//  ****************** LIBRARY OF TYPICAL CASE ********************
section tt_dio_na25
parameters is_d_na25=1
parameters jsw_d_na25=1
parameters n_d_na25=1
parameters rs_d_na25=1
parameters cj_d_na25=1
parameters cjsw_d_na25=1
include "cr013g_2d5_v1d4.scs" section=dio_na25
endsection tt_dio_na25
//  ****************** LIBRARY OF SLOW CASE ***********************
section ss_dio_na25
parameters is_d_na25=0.7
parameters jsw_d_na25=0.5
parameters n_d_na25=1.0025
parameters rs_d_na25=1.2
parameters cj_d_na25=1.05
parameters cjsw_d_na25=1.1
include "cr013g_2d5_v1d4.scs" section=dio_na25
endsection ss_dio_na25
//  ****************** LIBRARY OF FAST CASE ***********************
section ff_dio_na25
parameters is_d_na25=1.3
parameters jsw_d_na25=2
parameters n_d_na25=0.9975
parameters rs_d_na25=0.8
parameters cj_d_na25=0.95
parameters cjsw_d_na25=0.9
include "cr013g_2d5_v1d4.scs" section=dio_na25
endsection ff_dio_na25
//
//  *************************************************************
//                                                              *
//     Junction DIODE MODELS for 2.5V Native device process     *
//                                                              *
//  *************************************************************
//
section dio_na25
//
//  *************************************************************
//                       MODEL OF N+/PW DIODE                   *
//                                                              *
//  *************************************************************
//
model ndio_na25 diode
+ level=1                   is=7.00e-7*is_d_na25      rs=1.00e-10*rs_d_na25
+ n=1.02*n_d_na25           bv=15.2                   ibv=0.03
+ isw=2.23e-12*jsw_d_na25   area=3.92e-8              pj=8.4e-4
+ cj=1.238858e-4*cj_d_na25  vj=0.6660649              mj=0.4596073
+ cjsw=1.726958e-10*cjsw_d_na25                       vjsw=0.6660649
+ mjsw=1e-4                 tlev=1                    eg=1.17
+ xti=3                     tbv1=-1*-9.0e-4           trs=2.65e-3
+ tlevc=1                   cta=3.449993e-3           ctp=1.348721e-3
+ pta=2.69401e-3            ptp=2.69401e-3            tnom=25
+ fc=0                      ns=1.02*is_d_na25         nz=1.02*is_d_na25
+ imax=1e40                 minr=1e-3                 allow_scaling=1
//
endsection dio_na25
//
//
//  ************************************************************************
//
//    0.13um CM013G process resistor model
//
//  ************************************************************************

section tt_res
parameters par_res=0
parameters r_rppolyl=7.67
parameters r_rppolys=7.67
parameters r_rnpolyl=7.31
parameters r_rnpolys=7.31
parameters r_rnodl=6.65
parameters r_rnods=6.65
parameters r_rnodwo=72.75
parameters r_rpodl=7.25
parameters r_rpods=7.25
parameters r_rpodwo=145.87
parameters r_rnwod=409
parameters r_rnwsti=1090
parameters r_rm1l=0.064
parameters r_rm1s=0.090
parameters r_rm1w=0.102
parameters r_rm2_7l=0.042
parameters r_rm2_7s=0.057
parameters r_rm2_7w=0.062
parameters r_rm8l=0.021
parameters r_rm8s=0.0225
parameters r_rm8w=0.0238
parameters r_rmu=0.00540
parameters r_rnpolywo=260.09
parameters r_rppolywo=319.55
parameters r_rppolyhri=950
include "cr013g_2d5_v1d4.scs" section=res
endsection tt_res

section ss_res
parameters par_res=0
parameters r_rppolyl=7.67 + 1.92
parameters r_rppolys=7.67 + 2.32
parameters r_rnpolyl=7.31 + 1.90
parameters r_rnpolys=7.31 + 2.36
parameters r_rnodl=6.65 + 1.60
parameters r_rnods=6.65 + 1.70
parameters r_rnodwo=72.75 + 13.33
parameters r_rpodl=7.25 + 1.88
parameters r_rpods=7.25 + 2.59
parameters r_rpodwo=145.87 + 29.17
parameters r_rnwod=409 + 75
parameters r_rnwsti=1090 + 243.83
parameters r_rm1l=0.064 + 0.019
parameters r_rm1s=0.090 + 0.027
parameters r_rm1w=0.102 + 0.031
parameters r_rm2_7l=0.042 + 0.013
parameters r_rm2_7s=0.057 + 0.017
parameters r_rm2_7w=0.062 + 0.019
parameters r_rm8l=0.021 + 0.0063
parameters r_rm8s=0.0225 + 0.0068
parameters r_rm8w=0.0238 + 0.0071
parameters r_rmu=0.00540 + 0.0016
parameters r_rnpolywo=260.09 + 43.52
parameters r_rppolywo=319.55 + 63.91
parameters r_rppolyhri=950 + 190
include "cr013g_2d5_v1d4.scs" section=res
endsection ss_res

section ff_res
parameters par_res=0
parameters r_rppolyl=7.67 - 1.92
parameters r_rppolys=7.67 - 2.32
parameters r_rnpolyl=7.31 - 1.90
parameters r_rnpolys=7.31 - 2.36
parameters r_rnodl=6.65 - 1.60
parameters r_rnods=6.65 - 1.70
parameters r_rnodwo=72.75 - 13.33
parameters r_rpodl=7.25 - 1.88
parameters r_rpods=7.25 - 2.59
parameters r_rpodwo=145.87 - 29.17
parameters r_rnwod=409 - 75
parameters r_rnwsti=1090 - 243.83
parameters r_rm1l=0.064 - 0.019
parameters r_rm1s=0.090 - 0.027
parameters r_rm1w=0.102 - 0.031
parameters r_rm2_7l=0.042 - 0.013
parameters r_rm2_7s=0.057 - 0.017
parameters r_rm2_7w=0.062 - 0.019
parameters r_rm8l=0.021 - 0.0063
parameters r_rm8s=0.0225 - 0.0068
parameters r_rm8w=0.0238 - 0.0071
parameters r_rmu=0.00540 - 0.0016
parameters r_rnpolywo=260.09 - 43.52
parameters r_rppolywo=319.55 - 63.91
parameters r_rppolyhri=950 - 190
include "cr013g_2d5_v1d4.scs" section=res
endsection ff_res

section res

subckt rppolyl ( n1 n2 )
parameters l=1u w=1u mf=1 rsh=r_rppolyl dw=-0.035u ptc1=2.64e-03 ptc2=1.92e-06
+ pvc1=3.14e-03 pvc2=6.18e-03 pt=temp tfac=1.0 + ptc1 * (pt - 25.0) + ptc2 * (pt
+ - 25.0) * (pt - 25.0)
r1 ( n1 n2 ) bsource r=rsh / mf * l / (w - dw) * (1 + pvc1 * abs(v(n2,n1)) + pvc2
+ * v(n2,n1) * v(n2,n1)) * tfac
ends rppolyl

subckt rppolys ( n1 n2 )
parameters l=1u w=1u mf=1 rsh=r_rppolys dw=-0.035u ptc1=2.88e-03 ptc2=4.47e-07
+ pvc1=1.93e-04 pvc2=1.99e-03 pt=temp tfac=1.0 + ptc1 * (pt - 25.0) + ptc2 * (pt
+ - 25.0) * (pt - 25.0)
r1 ( n1 n2 ) bsource r=rsh / mf * l / (w - dw) * (1 + pvc1 * abs(v(n2,n1)) + pvc2
+ * v(n2,n1) * v(n2,n1)) * tfac
ends rppolys

subckt rnpolyl ( n1 n2 )
parameters l=1u w=1u mf=1 rsh=r_rnpolyl dw=-0.055u ptc1=2.77e-03 ptc2=1.51e-06
+ pvc1=3.37e-03 pvc2=6.34e-03 pt=temp tfac=1.0 + ptc1 * (pt - 25.0) + ptc2 * (pt
+ - 25.0) * (pt - 25.0)
r1 ( n1 n2 ) bsource r=rsh / mf * l / (w - dw) * (1 + pvc1 * abs(v(n2,n1)) + pvc2
+ * v(n2,n1) * v(n2,n1)) * tfac
ends rnpolyl

subckt rnpolys ( n1 n2 )
parameters l=1u w=1u mf=1 rsh=r_rnpolys dw=-0.055u ptc1=3.29e-03 ptc2=1.67e-07
+ pvc1=3.56e-04 pvc2=2.66e-03 pt=temp tfac=1.0 + ptc1 * (pt - 25.0) + ptc2 * (pt
+ - 25.0) * (pt - 25.0)
r1 ( n1 n2 ) bsource r=rsh / mf * l / (w - dw) * (1 + pvc1 * abs(v(n2,n1)) + pvc2
+ * v(n2,n1) * v(n2,n1)) * tfac
ends rnpolys

subckt rnodl ( n1 n2 )
parameters l=1u w=1u mf=1 rsh=r_rnodl dw=-0.057u ptc1=2.97e-03 ptc2=2.89e-07
+ pvc1=-9.44e-05 pvc2=1.42e-03 pt=temp tfac=1.0 + ptc1 * (pt - 25.0) + ptc2 *
+ (pt - 25.0) * (pt - 25.0)
r1 ( n1 n2 ) bsource r=rsh / mf * l / (w - dw) * (1 + pvc1 * abs(v(n2,n1)) + pvc2
+ * v(n2,n1) * v(n2,n1)) * tfac
ends rnodl

subckt rnods ( n1 n2 )
parameters l=1u w=1u mf=1 rsh=r_rnods dw=-0.057u ptc1=3.34e-03 ptc2=3.79e-07
+ pvc1=-1.67e-04 pvc2=6.88e-04 pt=temp tfac=1.0 + ptc1 * (pt - 25.0) + ptc2 *
+ (pt - 25.0) * (pt - 25.0)
r1 ( n1 n2 ) bsource r=rsh / mf * l / (w - dw) * (1 + pvc1 * abs(v(n2,n1)) + pvc2
+ * v(n2,n1) * v(n2,n1)) * tfac
ends rnods

subckt rnodwo ( n1 n2 )
parameters l=1u w=1u mf=1 rsh=r_rnodwo dw=0.011u ptc1=1.32e-03 ptc2=5.53e-07
+ pvc1=2.99e-04 pvc2=5.56e-05 pt=temp tfac=1.0 + ptc1 * (pt - 25.0) + ptc2 * (pt
+ - 25.0) * (pt - 25.0)
r1 ( n1 n2 ) bsource r=rsh / mf * l / (w - dw) * (1 + pvc1 * abs(v(n2,n1)) + pvc2
+ * v(n2,n1) * v(n2,n1)) * tfac
ends rnodwo

subckt rpodl ( n1 n2 )
parameters l=1u w=1u mf=1 rsh=r_rpodl dw=-0.070u ptc1=2.89e-03 ptc2=1.03e-06
+ pvc1=-1.94e-04 pvc2=1.20e-03 pt=temp tfac=1.0 + ptc1 * (pt - 25.0) + ptc2 *
+ (pt - 25.0) * (pt - 25.0)
r1 ( n1 n2 ) bsource r=rsh / mf * l / (w - dw) * (1 + pvc1 * abs(v(n2,n1)) + pvc2
+ * v(n2,n1) * v(n2,n1)) * tfac
ends rpodl

subckt rpods ( n1 n2 )
parameters l=1u w=1u mf=1 rsh=r_rpods dw=-0.070u ptc1=3.45e-03 ptc2=4.16e-07
+ pvc1=-1.57e-04 pvc2=5.77e-04 pt=temp tfac=1.0 + ptc1 * (pt - 25.0) + ptc2 *
+ (pt - 25.0) * (pt - 25.0)
r1 ( n1 n2 ) bsource r=rsh / mf * l / (w - dw) * (1 + pvc1 * abs(v(n2,n1)) + pvc2
+ * v(n2,n1) * v(n2,n1)) * tfac
ends rpods

subckt rpodwo ( n1 n2 )
parameters l=1u w=1u mf=1 rsh=r_rpodwo dw=0.068u ptc1=1.28e-03 ptc2=9.43e-07
+ pvc1=3.68e-05 pvc2=2.45e-04 pt=temp tfac=1.0 + ptc1 * (pt - 25.0) + ptc2 * (pt
+ - 25.0) * (pt - 25.0)
r1 ( n1 n2 ) bsource r=rsh / mf * l / (w - dw) * (1 + pvc1 * abs(v(n2,n1)) + pvc2
+ * v(n2,n1) * v(n2,n1)) * tfac
ends rpodwo

subckt rnwod ( n1 n2 )
parameters l=1u w=1u mf=1 rsh=r_rnwod dw=0.224u ptc1=2.33e-03 ptc2=8.76e-06
+ pvc1=1.45e-02 pvc2=-6.27e-04 pt=temp tfac=1.0 + ptc1 * (pt - 25.0) + ptc2 *
+ (pt - 25.0) * (pt - 25.0)
r1 ( n1 n2 ) bsource r=rsh / mf * l / (w - dw) * (1 + pvc1 * abs(v(n2,n1)) + pvc2
+ * v(n2,n1) * v(n2,n1)) * tfac
ends rnwod

subckt rnwsti ( n1 n2 )
parameters l=1u w=1u mf=1 rsh=r_rnwsti dw=0.451u ptc1=2.62e-03 ptc2=9.25e-06
+ pvc1=2.06e-02 pvc2=-8.27e-04 pt=temp tfac=1.0 + ptc1 * (pt - 25.0) + ptc2 *
+ (pt - 25.0) * (pt - 25.0)
r1 ( n1 n2 ) bsource r=rsh / mf * l / (w - dw) * (1 + pvc1 * abs(v(n2,n1)) + pvc2
+ * v(n2,n1) * v(n2,n1)) * tfac
ends rnwsti

subckt rm1l ( n1 n2 )
parameters l=1u w=1u mf=1 rsh=r_rm1l dw=0 ptc1=3.21e-03 ptc2=2.34e-07 pvc1=0
+ pvc2=0 pt=temp tfac=1.0 + ptc1 * (pt - 25.0) + ptc2 * (pt - 25.0) * (pt - 25.0)
r1 ( n1 n2 ) bsource r=rsh / mf * l / (w - dw) * (1 + pvc1 * abs(v(n2,n1)) + pvc2
+ * v(n2,n1) * v(n2,n1)) * tfac
ends rm1l

subckt rm1s ( n1 n2 )
parameters l=1u w=1u mf=1 rsh=r_rm1s dw=0 ptc1=3.21e-03 ptc2=2.34e-07 pvc1=0
+ pvc2=0 pt=temp tfac=1.0 + ptc1 * (pt - 25.0) + ptc2 * (pt - 25.0) * (pt - 25.0)
r1 ( n1 n2 ) bsource r=rsh / mf * l / (w - dw) * (1 + pvc1 * abs(v(n2,n1)) + pvc2
+ * v(n2,n1) * v(n2,n1)) * tfac
ends rm1s

subckt rm1w ( n1 n2 )
parameters l=1u w=1u mf=1 rsh=r_rm1w dw=0 ptc1=3.21e-03 ptc2=2.34e-07 pvc1=0
+ pvc2=0 pt=temp tfac=1.0 + ptc1 * (pt - 25.0) + ptc2 * (pt - 25.0) * (pt - 25.0)
r1 ( n1 n2 ) bsource r=rsh / mf * l / (w - dw) * (1 + pvc1 * abs(v(n2,n1)) + pvc2
+ * v(n2,n1) * v(n2,n1)) * tfac
ends rm1w

subckt rm2_7l ( n1 n2 )
parameters l=1u w=1u mf=1 rsh=r_rm2_7l dw=0 ptc1=3.19e-03 ptc2=2.40e-07 pvc1=0
+ pvc2=0 pt=temp tfac=1.0 + ptc1 * (pt - 25.0) + ptc2 * (pt - 25.0) * (pt - 25.0)
r1 ( n1 n2 ) bsource r=rsh / mf * l / (w - dw) * (1 + pvc1 * abs(v(n2,n1)) + pvc2
+ * v(n2,n1) * v(n2,n1)) * tfac
ends rm2_7l

subckt rm2_7s ( n1 n2 )
parameters l=1u w=1u mf=1 rsh=r_rm2_7s dw=0 ptc1=3.19e-03 ptc2=2.40e-07 pvc1=0
+ pvc2=0 pt=temp tfac=1.0 + ptc1 * (pt - 25.0) + ptc2 * (pt - 25.0) * (pt - 25.0)
r1 ( n1 n2 ) bsource r=rsh / mf * l / (w - dw) * (1 + pvc1 * abs(v(n2,n1)) + pvc2
+ * v(n2,n1) * v(n2,n1)) * tfac
ends rm2_7s

subckt rm2_7w ( n1 n2 )
parameters l=1u w=1u mf=1 rsh=r_rm2_7w dw=0 ptc1=3.19e-03 ptc2=2.40e-07 pvc1=0
+ pvc2=0 pt=temp tfac=1.0 + ptc1 * (pt - 25.0) + ptc2 * (pt - 25.0) * (pt - 25.0)
r1 ( n1 n2 ) bsource r=rsh / mf * l / (w - dw) * (1 + pvc1 * abs(v(n2,n1)) + pvc2
+ * v(n2,n1) * v(n2,n1)) * tfac
ends rm2_7w

subckt rm8l ( n1 n2 )
parameters l=1u w=1u mf=1 rsh=r_rm8l dw=0 ptc1=3.23e-03 ptc2=2.24e-07 pvc1=0
+ pvc2=0 pt=temp tfac=1.0 + ptc1 * (pt - 25.0) + ptc2 * (pt - 25.0) * (pt - 25.0)
r1 ( n1 n2 ) bsource r=rsh / mf * l / (w - dw) * (1 + pvc1 * abs(v(n2,n1)) + pvc2
+ * v(n2,n1) * v(n2,n1)) * tfac
ends rm8l

subckt rm8s ( n1 n2 )
parameters l=1u w=1u mf=1 rsh=r_rm8s dw=0 ptc1=3.23e-03 ptc2=2.24e-07 pvc1=0
+ pvc2=0 pt=temp tfac=1.0 + ptc1 * (pt - 25.0) + ptc2 * (pt - 25.0) * (pt - 25.0)
r1 ( n1 n2 ) bsource r=rsh / mf * l / (w - dw) * (1 + pvc1 * abs(v(n2,n1)) + pvc2
+ * v(n2,n1) * v(n2,n1)) * tfac
ends rm8s

subckt rm8w ( n1 n2 )
parameters l=1u w=1u mf=1 rsh=r_rm8w dw=0 ptc1=3.23e-03 ptc2=2.24e-07 pvc1=0
+ pvc2=0 pt=temp tfac=1.0 + ptc1 * (pt - 25.0) + ptc2 * (pt - 25.0) * (pt - 25.0)
r1 ( n1 n2 ) bsource r=rsh / mf * l / (w - dw) * (1 + pvc1 * abs(v(n2,n1)) + pvc2
+ * v(n2,n1) * v(n2,n1)) * tfac
ends rm8w

subckt rmu ( n1 n2 )
parameters l=1u w=1u mf=1 rsh=r_rmu dw=0 ptc1=3.41E-03 ptc2=4.08E-06 pvc1=0
+ pvc2=0 pt=temp tfac=1.0 + ptc1 * (pt - 25.0) + ptc2 * (pt - 25.0) * (pt - 25.0)
r1 ( n1 n2 ) bsource r=rsh / mf * l / (w - dw) * (1 + pvc1 * abs(v(n2,n1)) + pvc2
+ * v(n2,n1) * v(n2,n1)) * tfac
ends rmu

subckt rnpolywo ( n1 n2 )
parameters l=1u w=1u mf=1 rend0=3.91e-05 rsh=r_rnpolywo dl=0.02051u dw=0.07157u
+ pt=temp pvce1=9.19e-01 pvce2=1.86e+01 pvce3=-1.64e+00 ptce1=2.75e-04 ptce2=-4.10e-06
+ pvcp1=-2.73e-02 pvcp2=1.23e-05 pvcp3=-1.70e+00 ptcp1=-1.11e-03 ptcp2=1.51e-06
+ tface=1.0 + ptce1 * (pt - 25.0) + ptce2 * (pt - 25.0) * (pt - 25.0) tfacp=1.0
+ + ptcp1 * (pt - 25.0) + ptcp2 * (pt - 25.0) * (pt - 25.0)
rend1 ( n1 3 ) bsource r=rend0 / mf / (w - dw) * tface * (1 + pvce1 * (tanh(pvce2
+ * abs(v(n1,3)) + pvce3) - tanh(pvce3)))
rpure ( 3 4 ) bsource r=rsh / mf * (l - dl) / (w - dw) * tfacp * (1 + pvcp1 * (tanh(pvcp2
+ * abs(v(3,4) / (l - dl)) + pvcp3) - tanh(pvcp3))) l=l-dl w=mf*(w-dw) kf=2.15E-22 af=2 fexp=1.02 wdexp=1 ldexp=1
rend2 ( 4 n2 ) bsource r=rend0 / mf / (w - dw) * tface * (1 + pvce1 * (tanh(pvce2
+ * abs(v(4,n2)) + pvce3) - tanh(pvce3)))
ends rnpolywo

subckt rppolywo ( n1 n2 )
parameters l=1u w=1u mf=1 rend0=1.01e-04 rsh=r_rppolywo dl=0.04698u dw=0.07953u
+ pt=temp pvce1=-9.40e-02 pvce2=6.39e+01 pvce3=-2.71e+00 ptce1=-1.71e-03 ptce2=1.06e-06
+ pvcp1=-1.99e-01 pvcp2=6.05e-06 pvcp3=-3.23e+00 ptcp1=-1.19e-04 ptcp2=6.54e-07
+ tface=1.0 + ptce1 * (pt - 25.0) + ptce2 * (pt - 25.0) * (pt - 25.0) tfacp=1.0
+ + ptcp1 * (pt - 25.0) + ptcp2 * (pt - 25.0) * (pt - 25.0)
rend1 ( n1 3 ) bsource r=rend0 / mf / (w - dw) * tface * (1 + pvce1 * (tanh(pvce2
+ * abs(v(n1,3)) + pvce3) - tanh(pvce3)))
rpure ( 3 4 ) bsource r=rsh / mf * (l - dl) / (w - dw) * tfacp * (1 + pvcp1 * (tanh(pvcp2
+ * abs(v(3,4) / (l - dl)) + pvcp3) - tanh(pvcp3))) l=l-dl w=mf*(w-dw) kf=1.25E-22 af=2 fexp=1.08 wdexp=1 ldexp=1
rend2 ( 4 n2 ) bsource r=rend0 / mf / (w - dw) * tface * (1 + pvce1 * (tanh(pvce2
+ * abs(v(4,n2)) + pvce3) - tanh(pvce3)))
ends rppolywo

subckt rppolyhri ( n1 n2 )
parameters l=1u w=1u mf=1 rend0=5.320e-05 rsh=r_rppolyhri dl=0u dw=0.093u
+ pt=temp pvce1=0.5 pvce2=1.25 pvce3=-1.25 ptce1=-6.5e-04 ptce2=3.5e-08
+ pvcp1=-0.095 pvcp2=1.205e-06 pvcp3=-0.873 ptcp1=-7.67e-04 ptcp2=7.594e-07
+ tface=1.0 + ptce1 * (pt - 25.0) + ptce2 * (pt - 25.0) * (pt - 25.0) tfacp=1.0
+ + ptcp1 * (pt - 25.0) + ptcp2 * (pt - 25.0) * (pt - 25.0)
rend1 ( n1 3 ) bsource r=rend0 / mf / (w - dw) * tface * (1 + pvce1 * (tanh(pvce2
+ * abs(v(n1,3)) + pvce3) - tanh(pvce3)))
rpure ( 3 4 ) bsource r=rsh / mf * (l - dl) / (w - dw) * tfacp * (1 + pvcp1 * (tanh(pvcp2
+ * abs(v(3,4) / (l - dl)) + pvcp3) - tanh(pvcp3))) l=l-dl w=mf*(w-dw) kf=1.65E-22 af=2 fexp=0.95 wdexp=1 ldexp=1
rend2 ( 4 n2 ) bsource r=rend0 / mf / (w - dw) * tface * (1 + pvce1 * (tanh(pvce2
+ * abs(v(4,n2)) + pvce3) - tanh(pvce3)))
ends rppolyhri

//  ********************************
//        Mismatch   model         *
//  ********************************
subckt rppolyl_mis ( n1 n2 )
parameters l=1u w=1u mf=1 geo_fac=1 / sqrt(mf * l * w * 1e12) factmis=0.00871085
+ * geo_fac * par_res  rsh=r_rppolyl * (1 + factmis) dw=-0.035u ptc1=2.64e-03 ptc2=1.92e-06
+ pvc1=3.14e-03 pvc2=6.18e-03 pt=temp tfac=1.0 + ptc1 * (pt - 25.0) + ptc2 * (pt
+ - 25.0) * (pt - 25.0)
r1 ( n1 n2 ) bsource r=rsh / mf * l / (w - dw) * (1 + pvc1 * abs(v(n2,n1)) + pvc2
+ * v(n2,n1) * v(n2,n1)) * tfac
ends rppolyl_mis

subckt rppolys_mis  ( n1 n2 )
parameters l=1u w=1u mf=1 geo_fac=1 / sqrt(mf * l * w * 1e12) factmis=0.00871085
+ * geo_fac * par_res rsh=r_rppolys * (1 + factmis) dw=-0.035u ptc1=2.88e-03 ptc2=4.47e-07
+ pvc1=1.93e-04 pvc2=1.99e-03 pt=temp tfac=1.0 + ptc1 * (pt - 25.0) + ptc2 * (pt
+ - 25.0) * (pt - 25.0)
r1 ( n1 n2 ) bsource r=rsh / mf * l / (w - dw) * (1 + pvc1 * abs(v(n2,n1)) + pvc2
+ * v(n2,n1) * v(n2,n1)) * tfac
ends rppolys_mis

subckt rnpolyl_mis  ( n1 n2 )
parameters l=1u w=1u mf=1 geo_fac=1 / sqrt(mf * l * w * 1e12) factmis=0.00919451 *
+ geo_fac * par_res rsh=r_rnpolyl * (1 + factmis)  dw=-0.055u ptc1=2.77e-03 ptc2=1.51e-06
+ pvc1=3.37e-03 pvc2=6.34e-03 pt=temp tfac=1.0 + ptc1 * (pt - 25.0) + ptc2 * (pt
+ - 25.0) * (pt - 25.0)
r1 ( n1 n2 ) bsource r=rsh / mf * l / (w - dw) * (1 + pvc1 * abs(v(n2,n1)) + pvc2
+ * v(n2,n1) * v(n2,n1)) * tfac
ends rnpolyl_mis

subckt rnpolys_mis  ( n1 n2 )
parameters l=1u w=1u mf=1 geo_fac=1 / sqrt(mf * l * w * 1e12) factmis=0.00919451 *
+ geo_fac * par_res rsh=r_rnpolys * (1 + factmis)  dw=-0.055u ptc1=3.29e-03 ptc2=1.67e-07
+ pvc1=3.56e-04 pvc2=2.66e-03 pt=temp tfac=1.0 + ptc1 * (pt - 25.0) + ptc2 * (pt
+ - 25.0) * (pt - 25.0)
r1 ( n1 n2 ) bsource r=rsh / mf * l / (w - dw) * (1 + pvc1 * abs(v(n2,n1)) + pvc2
+ * v(n2,n1) * v(n2,n1)) * tfac
ends rnpolys_mis

subckt rnpolywo_mis ( n1 n2 )
parameters l=1u w=1u mf=1 geo_fac=1 / sqrt(mf * l * w * 1e12) factmis=0.02897 * geo_fac * par_res
+ rend0=3.91e-05 * (1 + factmis) rsh=r_rnpolywo * (1 + factmis) dl=0.02051u dw=0.07157u
+ pt=temp pvce1=9.19e-01 pvce2=1.86e+01 pvce3=-1.64e+00 ptce1=2.75e-04 ptce2=-4.10e-06
+ pvcp1=-2.73e-02 pvcp2=1.23e-05 pvcp3=-1.70e+00 ptcp1=-1.11e-03 ptcp2=1.51e-06
+ tface=1.0 + ptce1 * (pt - 25.0) + ptce2 * (pt - 25.0) * (pt - 25.0) tfacp=1.0
+ + ptcp1 * (pt - 25.0) + ptcp2 * (pt - 25.0) * (pt - 25.0)
rend1 ( n1 3 ) bsource r=rend0 / mf / (w - dw) * tface * (1 + pvce1 * (tanh(pvce2
+ * abs(v(n1,3)) + pvce3) - tanh(pvce3)))
rpure ( 3 4 ) bsource r=rsh / mf * (l - dl) / (w - dw) * tfacp * (1 + pvcp1 * (tanh(pvcp2
+ * abs(v(3,4) / (l - dl)) + pvcp3) - tanh(pvcp3))) l=l-dl w=mf*(w-dw) kf=2.15E-22 af=2 fexp=1.02 wdexp=1 ldexp=1
rend2 ( 4 n2 ) bsource r=rend0 / mf / (w - dw) * tface * (1 + pvce1 * (tanh(pvce2
+ * abs(v(4,n2)) + pvce3) - tanh(pvce3)))
ends rnpolywo_mis

subckt rppolywo_mis ( n1 n2 )
parameters l=1u w=1u mf=1 geo_fac = 1 / sqrt(mf * l * w * 1e12) factmis=0.01456 * geo_fac * par_res
+ rend0=1.01e-04 * (1 + factmis) rsh=r_rppolywo * (1 + factmis) dl=0.04698u dw=0.07953u
+ pt=temp pvce1=-9.40e-02 pvce2=6.39e+01 pvce3=-2.71e+00 ptce1=-1.71e-03 ptce2=1.06e-06
+ pvcp1=-1.99e-01 pvcp2=6.05e-06 pvcp3=-3.23e+00 ptcp1=-1.19e-04 ptcp2=6.54e-07
+ tface=1.0 + ptce1 * (pt - 25.0) + ptce2 * (pt - 25.0) * (pt - 25.0) tfacp=1.0
+ + ptcp1 * (pt - 25.0) + ptcp2 * (pt - 25.0) * (pt - 25.0)
rend1 ( n1 3 ) bsource r=rend0 / mf / (w - dw) * tface * (1 + pvce1 * (tanh(pvce2
+ * abs(v(n1,3)) + pvce3) - tanh(pvce3)))
rpure ( 3 4 ) bsource r=rsh / mf * (l - dl) / (w - dw) * tfacp * (1 + pvcp1 * (tanh(pvcp2
+ * abs(v(3,4) / (l - dl)) + pvcp3) - tanh(pvcp3))) l=l-dl w=mf*(w-dw) kf=1.25E-22 af=2 fexp=1.08 wdexp=1 ldexp=1
rend2 ( 4 n2 ) bsource r=rend0 / mf / (w - dw) * tface * (1 + pvce1 * (tanh(pvce2
+ * abs(v(4,n2)) + pvce3) - tanh(pvce3)))
ends rppolywo_mis

subckt rppolyhri_mis ( n1 n2 )
parameters l=1u w=1u mf=1 geo_fac =1 / sqrt(mf * l * w * 1e12) factmis=0.011823 * geo_fac * par_res
+ rend0=5.320e-05 * (1 + factmis) rsh=r_rppolyhri * (1 + factmis) dl=0u dw=0.093u
+ pt=temp pvce1=0.5 pvce2=1.25 pvce3=-1.25 ptce1=-6.5e-04 ptce2=3.5e-08
+ pvcp1=-0.095 pvcp2=1.205e-06 pvcp3=-0.873 ptcp1=-7.67e-04 ptcp2=7.594e-07
+ tface=1.0 + ptce1 * (pt - 25.0) + ptce2 * (pt - 25.0) * (pt - 25.0) tfacp=1.0
+ + ptcp1 * (pt - 25.0) + ptcp2 * (pt - 25.0) * (pt - 25.0)
rend1 ( n1 3 ) bsource r=rend0 / mf / (w - dw) * tface * (1 + pvce1 * (tanh(pvce2
+ * abs(v(n1,3)) + pvce3) - tanh(pvce3)))
rpure ( 3 4 ) bsource r=rsh / mf * (l - dl) / (w - dw) * tfacp * (1 + pvcp1 * (tanh(pvcp2
+ * abs(v(3,4) / (l - dl)) + pvcp3) - tanh(pvcp3))) l=l-dl w=mf*(w-dw) kf=1.65E-22 af=2 fexp=0.95 wdexp=1 ldexp=1
rend2 ( 4 n2 ) bsource r=rend0 / mf / (w - dw) * tface * (1 + pvce1 * (tanh(pvce2
+ * abs(v(4,n2)) + pvce3) - tanh(pvce3)))
ends rppolyhri_mis

endsection res
//
//
//  ****************************************************************************
//                                                                             *
//       23.LIB TT_MOS_CAP                                                     *
//              SS_MOS_CAP                                                     *
//              FF_MOS_CAP                                                     *
//                                                                             *
//         ( 1.2V Core NMOS in N-Well varactor )                               *
//                                                                             *
//  ****************************************************************************
//  ******************************************************************************
//                                                                               *
//                   1.2V NMOS in N-Well varactor MODEL                          *
//                                                                               *
//  ******************************************************************************
//  *************** CORNER_LIB OF TYPICAL MODEL ****************************
section tt_mos_cap
parameters xl_var=0.032e-6
parameters xw_var=0
parameters cmin_a=2.1e-3
parameters cmin_l=2.5e-10
parameters cmin_w=4.1e-10
parameters dcga=5e-3
parameters dcgw=0
parameters fac_var=1
include "cr013g_2d5_v1d4.scs" section=mos_cap
endsection tt_mos_cap
//  ***************** CORNER_LIB OF SLOW MODEL *****************************
section ss_mos_cap
parameters xl_var=0.027e-6
parameters xw_var=0.0075E-6
parameters cmin_a=1.932e-3
parameters cmin_l=2.3e-10
parameters cmin_w=3.772e-10
parameters dcga=4.813e-3
parameters dcgw=0
parameters fac_var=0.4082
include "cr013g_2d5_v1d4.scs" section=mos_cap
endsection ss_mos_cap
//  ***************** CORNER_LIB OF FAST MODEL *****************************
section ff_mos_cap
parameters xl_var=0.037e-6
parameters xw_var=-0.0075E-6
parameters cmin_a=2.268e-3
parameters cmin_l=2.7e-10
parameters cmin_w=4.428e-10
parameters dcga=5.187e-3
parameters dcgw=0
parameters fac_var=2.45
include "cr013g_2d5_v1d4.scs" section=mos_cap
endsection ff_mos_cap
//  ************************************************************************
section mos_cap

subckt nmoscap ( ng nds )
parameters lr=10e-6 wr=10e-6
+ l_eff=(lr - 2 * xl_var)
+ w_eff=(wr - 2 * xw_var) a_eff=(l_eff * w_eff) dvgs= - 0.05
+ * (1 + 3.6e-03 * (temp - 25)) vgnorm=0.35 * (1 + 2.03e-03 * (temp - 25)) forward_eff=a_eff
+ * 6e2 gtmp=50e-12 varbf=2.2 rev_eff=a_eff * 1.5e1 varbr=0

cg ( ng nds ) bsource q=((cmin_a * a_eff + 2 * cmin_l * l_eff + 2 * cmin_w * w_eff
+ + (dcga * a_eff + 2 * dcgw * w_eff)) * v(ng,nds) + vgnorm * (dcga * a_eff + 2 * dcgw * w_eff)
+ * log(cosh((v(ng,nds) - dvgs) / vgnorm)))

gdf1 ( ng nds ) bsource i =fac_var * (forward_eff * pow((abs(v(ng,nds)) + v(ng,nds)) / 2,varbf
+ + 2) + gtmp * (abs(v(ng,nds)) + v(ng,nds)) - rev_eff * pow((abs(v(ng,nds)) - v(ng,nds)) / 2,varbr
+ + 2))

ends nmoscap
endsection mos_cap
//
//
//  ****************************************************************************
//                                                                             *
//       24.LIB TT_MOS_CAP_25                                                  *
//              SS_MOS_CAP_25                                                  *
//              FF_MOS_CAP_25                                                  *
//                                                                             *
//         ( 2.5V Core NMOS in N-Well varactor )                               *
//                                                                             *
//  ****************************************************************************
//  ******************************************************************************
//                                                                               *
//                   2.5V NMOS in N-Well varactor MODEL                          *
//                                                                               *
//  ******************************************************************************
//  *************** CORNER_LIB OF TYPICAL MODEL ****************************
section tt_mos_cap_25
parameters xl_var25=0.06E-6
parameters xw_var25=0.02E-6
parameters cmin_a_25=1.25E-3
parameters cmin_l_25=2.5e-10
parameters cmin_w_25=4.0E-10
parameters dcga_25=2.25E-3
parameters dcgw_25=4.0E-11
include "cr013g_2d5_v1d4.scs" section=mos_cap_25
endsection tt_mos_cap_25
//  ***************** CORNER_LIB OF SLOW MODEL *****************************
section ss_mos_cap_25
parameters xl_var25=0.0534E-6
parameters xw_var25=0.0275E-6
parameters cmin_a_25=1.15E-3
parameters cmin_l_25=2.3E-10
parameters cmin_w_25=3.68E-10
parameters dcga_25=2.1458E-3
parameters dcgw_25=3.81E-11
include "cr013g_2d5_v1d4.scs" section=mos_cap_25
endsection ss_mos_cap_25
//  ***************** CORNER_LIB OF FAST MODEL *****************************
section ff_mos_cap_25
parameters xl_var25=0.0666E-6
parameters xw_var25=0.0125E-6
parameters cmin_a_25=1.35E-3
parameters cmin_l_25=2.7E-10
parameters cmin_w_25=4.32E-10
parameters dcga_25=2.3542E-3
parameters dcgw_25=4.19E-11

include "cr013g_2d5_v1d4.scs" section=mos_cap_25
endsection ff_mos_cap_25
//  ************************************************************************
section mos_cap_25

subckt nmoscap_25 ( ng nds )
parameters gr=1 br=1 lr=10e-6 wr=10e-6
+ l_eff_25=(lr - 2 * xl_var25) * (gr * br)
+ w_eff_25=(wr - 2 * xw_var25) * (gr * br) a_eff_25=(l_eff_25 * w_eff_25) / (gr * br) dvgs_25= - 0.15
+ * (1 + 3.5e-03 * (temp - 25)) vgnorm_25=0.5 * (1 + 2.3e-03 * (temp - 25))

cg ( ng nds ) bsource q=((cmin_a_25 * a_eff_25 + 2 * cmin_l_25 * l_eff_25 + 2 * cmin_w_25 * w_eff_25
+ + (dcga_25 * a_eff_25 + 2 * dcgw_25 * w_eff_25)) * v(ng,nds) + vgnorm_25 * (dcga_25 * a_eff_25 + 2 * dcgw_25 * w_eff_25)
+ * log(cosh((v(ng,nds) - dvgs_25) / vgnorm_25)))

ends nmoscap_25
endsection mos_cap_25

section tt_mim
parameters par_mim=0
parameters cmimbb_mimfac=1.0
include "cr013g_2d5_v1d4.scs" section=mim
endsection tt_mim

section ff_mim
parameters par_mim=0
parameters cmimbb_mimfac=0.9
include "cr013g_2d5_v1d4.scs" section=mim
endsection ff_mim

section ss_mim
parameters par_mim=0
parameters cmimbb_mimfac=1.1
include "cr013g_2d5_v1d4.scs" section=mim
endsection ss_mim

section mim
//*************************************************************************************************
//  MIM CAPACITOR MODEL :
//
//
//     ## library files:
//
//     1. The base band 1.0fF MIM capacitors with sub-circuit 'mimcap_1p0_sin'
//     2. The base band 1.5fF MIM capacitors with sub-circuit 'mimcap_1p5_sin'
//
//
//            Model name         lt(um)        wt(um)
//                           low    high    low    high
//     --------------------------------------------------
//     mimcap_1p0_sin         2     100      2     100
//     mimcap_1p5_sin         2     100      2     100
//     --------------------------------------------------
//     End Model
//            **lt: length dimension of top metal
//            **wt: width dimension of top metal
//
//
//*************************************************************************************************
//
//
subckt mimcap_1p0_sin ( top bottom )
parameters lt=10u wt=10u cmim_para=(((wt - 0.108e-6) * (lt - 0.108e-6) * 1e12 * 1.0274) + 2 * ((wt - 0.108e-6)
+ + (lt - 0.108e-6)) * 1e6 * 0.1686 ) * 1e-15 * (1 + (temp - 25) *  - 4.13e-5 + (temp
+ - 25) * (temp - 25) *  - 8e-8)
//
cmim ( top bottom ) bsource q=cmim_para * (v(top,bottom) + 0.5*v(top,bottom)**(2) * 2.96e-5 + 1/3*v(top,bottom)
+ ** 3 *  - 2.44e-5) * cmimbb_mimfac
//
ends mimcap_1p0_sin
//
//
subckt mimcap_1p5_sin ( top bottom )
parameters lt=10u wt=10u cmim_para=(((wt - 0.092e-6) * (lt - 0.092e-6) * 1e12 *
+ 1.547) + 2 * ((wt - 0.092e-6) + (lt - 0.092e-6)) * 1e6 * 0.164) * 1e-15 * (1 +
+ (temp - 25) *  - 5.016e-5 + (temp - 25) * (temp - 25) * 6.5e-9)
//
cmim ( top bottom ) bsource q=cmim_para * (v(top,bottom) + 0.5*v(top,bottom)**(2) * - 3.043e-5 + 1/3*v(top,bottom)
+ ** 3 *  - 4.6125e-5) * cmimbb_mimfac
//
ends mimcap_1p5_sin
//
//
//
//  ********************************
//        Mismatch   model         *
//  ********************************
subckt mimcap_1p0_sin_mis ( top bottom )
parameters lt=10u wt=10u mf=1
+ geo_fac=1 / sqrt(mf * lt * wt * 1e12)
+ factmis=0.004458 * geo_fac * par_mim
+ cmim_para=(1+factmis) * mf * (((wt - 0.108e-6) * (lt - 0.108e-6) * 1e12 * 1.0274) + 2 * ((wt - 0.108e-6)
+ + (lt - 0.108e-6)) * 1e6 * 0.1686 ) * 1e-15 * (1 + (temp - 25) *  - 4.13e-5 + (temp
+ - 25) * (temp - 25) *  - 8e-8)
//
cmim ( top bottom ) bsource q=cmim_para * (v(top,bottom) + 0.5*v(top,bottom)**(2) * 2.96e-5 + 1/3*v(top,bottom)
+ ** 3 *  - 2.44e-5) * cmimbb_mimfac
//
ends mimcap_1p0_sin_mis

subckt mimcap_1p5_sin_mis ( top bottom )
parameters lt=10u wt=10u mf=1
+ geo_fac=1 / sqrt(mf * lt * wt * 1e12)
+ factmis=0.006042 * geo_fac * par_mim
+ cmim_para=(1+factmis) * mf * (((wt - 0.092e-6) * (lt - 0.092e-6) * 1e12 *
+ 1.547) + 2 * ((wt - 0.092e-6) + (lt - 0.092e-6)) * 1e6 * 0.164) * 1e-15 * (1 +
+ (temp - 25) *  - 5.016e-5 + (temp - 25) * (temp - 25) * 6.5e-9)
//
cmim ( top bottom ) bsource q=cmim_para * (v(top,bottom) + 0.5*v(top,bottom)**(2) * - 3.043e-5 + 1/3*v(top,bottom)
+ ** 3 *  - 4.6125e-5) * cmimbb_mimfac
//
ends mimcap_1p5_sin_mis

endsection mim

//
//  *********************************************************************
//              	              RTMOM                                   *
//  *********************************************************************
//  *********** Library of typical corner *******************************
section tt_rtmom
parameters rtmom_fac=1
include "cr013g_2d5_v1d4.scs" section=rtmom
endsection tt_rtmom

//  *********** Library of slow corner **********************************

section ss_rtmom
parameters rtmom_fac=1.25
include "cr013g_2d5_v1d4.scs" section=rtmom
endsection ss_rtmom

//  *********** Library of fast corner **********************************

section ff_rtmom
parameters rtmom_fac=0.75
include "cr013g_2d5_v1d4.scs" section=rtmom
endsection ff_rtmom

//  **********************************************************************

section rtmom

//  **************************************************************************************
//
//          *                                                         *
//                         RTMOM with  Width = 0.2um
//          *
//
//          *
//                         parameter range: nv : 8~288, nh : 8~288
//          *
//                                          nv and nh should be even fingers
//          *
//                                          s(spacing):0.21u ~0.4u
//          *
//                                          lay(MOM layer number): 3~6
//          *
//
//          *
//
//          *                                                      *
//  **************************************************************************************
subckt crtmom ( a b p )
parameters nv=32 nh=32 s=0.21u lay=6 edg=((int((lay - 1) / 2) + 2600 / 3700) * (nv
+ - 1) * (nh * (0.2u + s) - s) + int(lay / 2) * (nh - 1) * (nv * (0.2u + s) - s))
+ area=(nv * nh / 2 * 0.2u * 0.2u * (lay - 1)) fri2=((int((lay + 1) / 2) * nv *
+ 0.2u + int(lay / 2) * nh * 0.2u) + 0.21u * 2 * lay + int(lay / 2) * (nv * (0.2u
+ + s) - s + 0.5u) * 2 + int((lay + 1) / 2) * (nh * (0.2u + s) - s ) * 2)
+ fri1=((nh * nv / 2 * 0.2u * 4) * (lay - 1)) abm=(((nv * (0.2u + s) - s + 0.71u
+ * 2) + (nh * (0.2u + s) - s + 0.5u)) * 0.21u) afm=(nv * 0.2u * (nh * (0.2u + s)
+ - s + 0.5u) / 2) pf=((nh * (0.2u + s) - s + 0.5u) * (nv) + 2 * ((nv * (0.2u +
+ s) - s + 1.42u) + (nh * (0.2u + s) - s + 0.71u)))
+ cc1=0.42 * s ** 2 * 1e12 - 0.4714 * s * 1e6 + 0.1865 cc2=0.0532 cf= - 0.001 * s
+ * s * 1e12 + 0.0277 * s * 1e6 + 0.004 ca=( - 0.0333 * s * s * 1e12 + 0.0373 *
+ s * 1e6 + 0.0106) / 0.2 ca_p=( - 0.0931 * s * s * 1e12 + 0.0767 * s * 1e6 + 0.0152)
+ / 0.2 cf_p=0.014 * s * s * 1e12 + 0.0298 * s * 1e6 + 0.0063
//
cab ( a b ) bsource q=(cc1 * edg * 1e-9 + cf * 1e-9 * fri1 + ca * 1e-3 * area
+ + cc2 * 1e-9 * fri2) * (1 + (temp - 25) * 30.36 * 1e-6 + (temp - 25) * (temp
+ - 25) * 1e-8) * (v(a,b) - 2.65 * 1e-6 /2 * v(a,b) **2 - 0.1 * 1e-6 /3 * v(a,b) **3) *
+ rtmom_fac
cpa ( a p ) bsource q=(ca_p * (abm + afm) * 1e-3 + cf_p * pf * 1e-9)  * (1 +
+ (temp - 25) * 30.36 * 1e-6 + (temp - 25) * (temp - 25) * 1e-8) * (v(a,p) - 2.65
+ * 1e-6 /2 * v(a,p) **2 - 0.1 * 1e-6 /3 * v(a,p) **3 ) * rtmom_fac
cpb ( b p ) bsource q=(ca_p * (abm + afm) * 1e-3 + cf_p * pf * 1e-9)  * (1 +
+ (temp - 25) * 30.36 * 1e-6 + (temp - 25) * (temp - 25) * 1e-8) * (v(b,p) - 2.65
+ * 1e-6 /2 * v(b,p) **2 - 0.1 * 1e-6 /3 * v(b,p) **3 ) * rtmom_fac

ends crtmom

endsection rtmom

endlibrary tsmclib
