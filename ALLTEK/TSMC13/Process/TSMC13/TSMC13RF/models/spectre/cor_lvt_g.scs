library lvt_g_cor

section ff_lvt_g
include "cr013g_2d5_v1d4.scs" section = ff_lvt_g
endsection ff_lvt_g

section fs_lvt_g
include "cr013g_2d5_v1d4.scs" section = fs_lvt_g
endsection fs_lvt_g

section sf_lvt_g
include "cr013g_2d5_v1d4.scs" section = sf_lvt_g
endsection sf_lvt_g

section ss_lvt_g
include "cr013g_2d5_v1d4.scs" section = ss_lvt_g
endsection ss_lvt_g

section tt_lvt_g
include "cr013g_2d5_v1d4.scs" section = tt_lvt_g
endsection tt_lvt_g

endlibrary lvt_g_cor
