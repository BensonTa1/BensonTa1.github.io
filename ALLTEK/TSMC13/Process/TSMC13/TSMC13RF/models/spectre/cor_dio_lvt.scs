library dio_lvt_cor

section ff_dio_lvt
include "cr013g_2d5_v1d4.scs" section = ff_dio_lvt
endsection ff_dio_lvt

section ss_dio_lvt
include "cr013g_2d5_v1d4.scs" section = ss_dio_lvt
endsection ss_dio_lvt

section tt_dio_lvt
include "cr013g_2d5_v1d4.scs" section = tt_dio_lvt
endsection tt_dio_lvt

endlibrary dio_lvt_cor
