ADE simulation setup
Run mode: Single Run, Sweeps and Corners
Tests:
  TEST_UMC18_ALLTEK_PLL:CP_TRAN:1: TEST_UMC18_ALLTEK_PLL/CP_TRAN/config, simulator spectre
Global variables:
  CP_FB_CTRL = 1.8
  CP_I_CTRL = 0
  D0 = 0.
  D1 = 0
  D2 = 0
  D3 = 1.8
  VOUT = {Exclusion List}0.9{Exclusion List}{From/To}Auto:0:9:1.8{From/To}
  VS = 1.8
Corners:
  model folders: /home/IC/Desktop/virtuoso/Process/UMC18/Models/Spectre
  C0: mm180_reg18_v124.lib.scs[tt ff ss snfp fnsp], rnnpo_rf_v2d4.lib.scs[typ min max], mm180_res_v141.lib.scs[res_max res_typ res_min]
