ADE simulation setup
Run mode: Single Run, Sweeps and Corners
Tests:
  TEST_UMC18_ALLTEK_PLL:DIVIDER_TSPC_D2_D3:1: TEST_UMC18_ALLTEK_PLL/DIVIDER_TSPC_D2_D3/schematic, simulator spectre
Global variables:
  MC = 1.8
  FS = 4.5G
  VS = {Exclusion List}1.8{Exclusion List}{Center/Span%}Auto:1.8:3:20{Center/Span%}
  temperature = {Exclusion List}30{Exclusion List}{From/To}Auto:-25:5:125{From/To}
Corners (nominal off):
  model folders: /home/IC/Desktop/virtuoso/Process/UMC18/Models/Spectre
  C0: mm180_reg18_v124.lib.scs[tt ff ss snfp fnsp]
