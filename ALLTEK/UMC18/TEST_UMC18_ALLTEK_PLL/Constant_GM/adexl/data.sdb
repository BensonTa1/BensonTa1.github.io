ADE simulation setup
Run mode: Single Run, Sweeps and Corners
Tests:
  TEST_UMC18_ALLTEK_PLL:DIVIDER_2_3:1: TEST_UMC18_ALLTEK_PLL/Constant_GM/config, simulator spectre
Global variables:
  VS = {Exclusion List}1.8{Exclusion List}{Center/Span%}Auto:1.8:3:20{Center/Span%}
  temperature = {Exclusion List}30{Exclusion List}{From/To}Auto:-25:5:125{From/To}
Corners (nominal off):
  model folders: /home/IC/Desktop/virtuoso/Process/UMC18/Models/Spectre
  C0: mm180_reg18_v124.lib.scs[tt ff ss snfp fnsp], rnnpo_rf_v2d4.lib.scs[typ min max]
