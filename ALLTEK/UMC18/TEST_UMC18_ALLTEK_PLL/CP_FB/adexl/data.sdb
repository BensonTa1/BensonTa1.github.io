ADE simulation setup
Run mode: Single Run, Sweeps and Corners
Tests:
  TEST_UMC18_ALLTEK_PLL:CP_FB:1: TEST_UMC18_ALLTEK_PLL/CP_FB/schematic, simulator spectre
Global variables:
  D3 = 0
  D2 = 0
  D1 = 1.8
  D0 = 0
  CP_FB_CTRL = 0
  CP_I_CTRL = 0
  VS = 1.8
  temperature = {Exclusion List}30{Exclusion List}{From/To}Auto:-25:5:100{From/To}
  VOUT = {Exclusion List}0.9{Exclusion List}{From/To}Auto:0:6:1.8{From/To}
Corners (nominal off):
  model folders: /home/IC/Desktop/virtuoso/Process/UMC18/Models/Spectre
  C0: mm180_reg18_v124.lib.scs[tt ff ss snfp fnsp], rnnpo_rf_v2d4.lib.scs[typ min max], mm180_res_v141.lib.scs[res_max res_typ res_min]
Specs:
  TEST_UMC18_ALLTEK_PLL:CP_FB:1 / Phase Margin: > 75
