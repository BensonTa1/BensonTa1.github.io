ADE simulation setup
Run mode: Single Run, Sweeps and Corners
Tests:
  TEST_UMC18_ALLTEK_PLL:PLL:1: TEST_UMC18_ALLTEK_PLL/PLL/config, simulator spectre
Global variables:
  CP_D0 = 0
  CP_D1 = 0
  CP_D2 = 1.8
  CP_D3 = 0
  MMD_D0 = 1.8
  MMD_D1 = 1.8
  MMD_D2 = 1.8
  MMD_D3 = 1.8
  MMD_D4 = 1.8
  CP_FB_SEL = 0
  FS = 19.2M
  VDD = {Exclusion List}1.8{Exclusion List}{Center/Span%}Auto:1.8:3:20{Center/Span%}
  temperature = {Inclusion List}30{Inclusion List}{From/To}Auto:-25:5:100{From/To}
