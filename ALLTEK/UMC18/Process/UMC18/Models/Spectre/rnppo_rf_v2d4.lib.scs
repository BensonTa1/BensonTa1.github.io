//
simulator lang=spectre insensitive=yes
library mylib
section typ
parameters ddw_rnppo_rf=0
parameters drsh_rnppo_rf=0
parameters dcox_rnppo_rf=0
//
include "./rnppo_rf_v2d4.mdl.scs"
//
endsection typ
//
section min
parameters ddw_rnppo_rf=-0.1
parameters drsh_rnppo_rf=-0.25
parameters dcox_rnppo_rf=-0.12
include "./rnppo_rf_v2d4.mdl.scs"
//
endsection min
//
section max
parameters ddw_rnppo_rf=0.1
parameters drsh_rnppo_rf=0.25
parameters dcox_rnppo_rf=0.12
include "./rnppo_rf_v2d4.mdl.scs"
//
endsection max
endlibrary mylib
