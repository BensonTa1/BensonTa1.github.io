//  ****************************************************************************************
//       0.18um MIXED MODE Vertical PNP Model(Emitter area: 25 um2)                        *
//  ****************************************************************************************
simulator lang=spectre insensitive=yes
//
// DEVICE 1
inline subckt pnp_v50x50_mm ( c b e )
parameters mis_flag=1 mismatch=0
//
//
+ abf_50x50=4.3500e-3 ais_50x50=9.3000e-4
+ p_bf_50x50=abf_50x50 * mc_bf_pnp_50x50 * mis_flag
+ p_is_50x50=ais_50x50 * mc_is_pnp_50x50 * mis_flag
//
//
pnp_v50x50_mm ( c b e ) pnp_v50x50_mm_main

model pnp_v50x50_mm_main bjt type=pnp
+  is=5.6e-18*(1+dis_pnp_v50x50_mm)*(1+p_is_50x50)
+  bf = 1.38*(1+dbf_pnp_v50x50_mm)*(1+p_bf_50x50)
+  nf=1.034*(1+dnf_pnp_v50x50_mm)                          vaf=785
+  ikf=0.0021                ise=1e-20                 ne=1.049
+  br=0.00013                nr=1.02                   var=55
+  ikr=0.0021                isc=1.05e-12              nc=1.44
+  rb=266.4                  irb=2.3e-05               rbm=59.48
+  re=0.001*(1+dre_pnp_v50x50_mm)
+  rc=0.12*(1+drc_pnp_v50x50_mm)                           tlevc=1
+  xtb=1.48                  eg=1.17                   xti=2.38
+  trb1=0.0035               cje=2.85e-14*(1+dcje_pnp_v50x50_mm)
+  vje=0.762                 mje=0.395
+  cjc=2.81e-14*(1+dcjc_pnp_v50x50_mm)                     vjc=0.458
+  mjc=0.75                  fc=0.5                    trm1=0.0035
+  trm2=0                    compatible=hspice         struct=vertical
//
//  ****************************************************************************************
//       0.18um MIXED MODE Vertical PNP Model(Emitter area: 100 um2)                       *
//  ****************************************************************************************
//
ends pnp_v100x100_mm

// DEVICE 2
inline subckt pnp_v100x100_mm ( c b e )
parameters mis_flag=1 mismatch=0
//
//
+ abf_100x100=1.5900e-3 ais_100x100=4.0000e-4
+ p_bf_100x100=abf_100x100 * mc_bf_pnp_100x100 * mis_flag
+ p_is_100x100=ais_100x100 * mc_is_pnp_100x100 * mis_flag
//
//
pnp_v100x100_mm ( c b e ) pnp_v100x100_mm_main

model pnp_v100x100_mm_main bjt type=pnp
+  is=2.8e-17*(1+dis_pnp_v100x100_mm)*(1+p_is_100x100)
+  bf = 1.36*(1+dbf_pnp_v100x100_mm)*(1+p_bf_100x100)
+  nf=1.054*(1+dnf_pnp_v100x100_mm)                        vaf=785
+  ikf=0.005                 ise=1.1e-18               ne=1.049
+  br=0.00063                nr=1.06                   var=55
+  ikr=0.027                 isc=1.95e-12              nc=1.44
+  rb=66.4                   irb=1e-06                 rbm=59.48
+  re=0.001*(1+dre_pnp_v100x100_mm)
+  rc=0.12*(1+drc_pnp_v100x100_mm)                         tlevc=1
+  xtb=1.298                 eg=1.17                   xti=1.98
+  trb1=0.004                tre1=0.001
+  cje=1.14e-13*(1+dcje_pnp_v100x100_mm)                   vje=0.762
+  mje=0.395                 cjc=4.81e-14*(1+dcjc_pnp_v100x100_mm)
+  vjc=0.458                 mjc=0.75                  fc=0.5
+  trm1=0.004                trm2=0                    compatible=hspice
+  struct=vertical
ends pnp_v100x100_mm
