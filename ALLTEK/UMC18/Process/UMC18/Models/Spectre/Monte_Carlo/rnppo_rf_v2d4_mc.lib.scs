simulator lang=spectre insensitive=yes
library mylib

section tt

parameters ddw_rnppo_rf=0
parameters drsh_rnppo_rf=0
parameters dcox_rnppo_rf=0
include "rnppo_rf_v2d4_mc.mdl.scs"

endsection tt

section ff

parameters ddw_rnppo_rf=-0.1
parameters drsh_rnppo_rf=-0.25
parameters dcox_rnppo_rf=-0.12
include "rnppo_rf_v2d4_mc.mdl.scs"

endsection ff

section ss
parameters ddw_rnppo_rf=0.1
parameters drsh_rnppo_rf=0.25
parameters dcox_rnppo_rf=0.12
include "rnppo_rf_v2d4_mc.mdl.scs"

endsection ss

endlibrary mylib
