//  ****************************************************************************************
simulator lang=spectre insensitive=yes
//          0.18um 1.8v/3.3v MIXEDMODE Twin-well technology, 3.3V NMOS Model
//            *
//  ****************************************************************************************
model n_33_mm bsim3v3 type=n
+ lmin=3.4e-7               lmax=5.0e-5               wmin=2.4e-7
+ wmax=1.0e-4               tnom=27.0                 version=3.1
+ tox=7.00e-09 + dtox_n_33_mm                         xj=2.5000000e-07
+ nch=1.6999999e+17         lln=1.0000000             lwn=1.0000000
+ wln=1.0000000             wwn=1.0000000             lint=0.00 + dlint_n_33_mm
+ ll=1.2142200e-14          lw=0.00                   lwl=-2.8856721e-22
+ wint=0.00 + dwint_n_33_mm                           wl=0.00
+ ww=-2.0097143e-16         wwl=-1.5017800e-21        mobmod=1
+ binunit=2                 xl=2.20e-08               xw=0.00
+ dwg=3.5527140e-15         dwb=6.2000000e-09         ldif=0.00
+ hdif=3.20e-7              rsh=8
+ vth0=0.5924070 + dvth0_n_33_mm                      k1=0.7137536
+ k2=-2.5826899e-02         k3=62.0000000             dvt0=4.7501960
+ dvt1=0.6340203            dvt2=-0.1139230           dvt0w=0.1500000
+ dvt1w=5.9500000e+05       dvt2w=0.00                nlx=1.2508283e-07
+ w0=5.6800000e-06          k3b=32.0000000            vsat=9.8280000e+04
+ ua=-5.8546880e-10         ub=1.6518923e-18          uc=5.5177280e-11
+ rdsw=5.9591060e+02        prwb=5.7154760e-02        prwg=2.3068622e-02
+ wr=1.0000000              u0=3.4129650e-02          a0=1.2752739
+ keta=5.0000000e-03        a1=1.0000000e-02          a2=0.9900000
+ ags=0.2678509             b0=1.0000000e-08          b1=9.0000000e-07
+ voff=-0.1360862           nfactor=1.0000000         cit=0.00
+ cdsc=2.3999999e-04        cdscb=0.00                cdscd=2.3999999e-04
+ eta0=0.1080775            etab=-1.5000000e-03       dsub=0.5210000
+ pclm=0.6318000            pdiblc1=9.4999000e-04     pdiblc2=1.0000000e-03
+ pdiblcb=0.00              drout=0.5600000           pscbe1=4.2400000e+08
+ pscbe2=1.0000000e-05      pvag=0.00                 delta=1.0000000e-02
+ alpha0=0.00               alpha1=0.00               beta0=30.0000000
+ kt1=-0.3166082            kt2=-4.4608160e-02        at=5.0000000e+02
+ ute=-1.6006135            ua1=4.2028770e-11         ub1=3.8000000e-19
+ uc1=2.8000000e-11         kt1l=0.0000000            prt=-2.7126447e+02
+ cj=7.673167e-04           mj=0.3299333              pb=0.7131242
+ cjsw=1.088665e-10         mjsw=0.1036705            pbsw=0.4347057
+ cta=1.081522e-03          ctp=7.482284e-04          pta=1.822417e-03
+ ptp=2.008567e-03          js=1.00e-05               jsw=5.1e-11
+ cgdo=2.7e-10 + dcgdo_n_33_mm
+ cgso=2.7e-10 + dcgso_n_33_mm                        cgbo=1.0e-10
+ capmod=2                  nqsmod=0                  elm=5
+ xpart=1                   cf=1.392e-10              cjswg=2.9e-10
+ tlevc=1
+ noimod=2                  noia=1.23857387117825e+21 noib=44531.5473204133
+ noic=-1.05e-14            ef=0.939634740352631      em=2063059.94272232
//  ****************************************************************************************
//          0.18um 1.8v/3.3v MIXEDMODE Twin-well technology, 3.3V PMOS Model
//            *
//  ****************************************************************************************
model p_33_mm bsim3v3 type=p
+ lmin=3.4e-7               lmax=5.0e-5               wmin=2.4e-7
+ wmax=1.0e-4               tnom=27.0                 version=3.1
+ tox=7.00000e-09 + dtox_p_33_mm                      xj=1.8000000e-07
+ nch=4.3096250e+17         lln=1.4787377             lwn=1.0000000
+ wln=1.0000000             wwn=1.6332974
+ lint=2.2396316e-08 + dlint_p_33_mm                  ll=3.3436880e-18
+ lw=0.00                   lwl=-1.4344100e-24
+ wint=3.3613110e-08 + dwint_p_33_mm                  wl=0.00
+ ww=-7.2735800e-19         wwl=9.7470860e-26         mobmod=1
+ xl=-1.0000e-08            xw=0                      dwg=-1.4371156e-08
+ dwb=5.9839220e-09         vth0= - 0.7204355 + dvth0_p_33_mm
+ k1=0.7667419              k2=5.4286610e-02          k3=2.0892601
+ dvt0=7.3947320            dvt1=0.9634880            dvt2=7.8053260e-03
+ dvt0w=1.7969700           dvt1w=2.8762723e+06       dvt2w=0.1026245
+ nlx=0.00                  w0=2.1247300e-07          k3b=1.0028400
+ vsat=1.0007731e+05        ua=-3.9782800e-10         ub=1.6947495e-18
+ uc=-3.6494700e-11         rdsw=6.1701920e+02        prwb=-0.7725255
+ prwg=3.3490300e-02        wr=0.9913232              u0=8.0758510e-03
+ a0=1.0736154              keta=-1.0346900e-02       a1=0.01
+ a2=0.9212255              ags=0.1138427             b0=4.3581280e-07
+ b1=1.7378807e-06          voff=-0.1239050           nfactor=0.9964148
+ cit=5.3336740e-04         cdsc=3.1656700e-03        cdscb=2.4630399e-03
+ cdscd=0.00                eta0=5.4210600e-02        etab=-1.8931806e-02
+ dsub=0.4594282            pclm=0.6164396            pdiblc1=1.1236120e-02
+ pdiblc2=3.5433970e-04     pdiblcb=0.1477877         drout=0.1401412
+ pscbe1=4.6427620e+08      pscbe2=2.8700000e-05      pvag=-0.1307000
+ delta=1.0000000e-02       alpha0=0.00               beta0=30.0000000
+ kt1=-0.3345865            kt2=-5.7475180e-02        at=4.9500000e+04
+ ute=-1.1277215            ua1=1.4019034e-09         ub1=-3.4171990e-18
+ uc1=-1.3930956e-10        kt1l=1.0000003e-08        prt=0.00
+ cj=1.199812e-03           mj=0.4096944              pb=0.761753
+ cjsw=2.243239e-10         mjsw=0.474468             pbsw=0.9296629
+cjswg=4.2e-10
+ cta=9.968635e-04          ctp=7.11932e-04           pta=1.503527e-03
+ ptp=1.215858e-03          js=9.00e-05               jsw=4.90e-12
+ cgdo=2.6e-10 + dcgdo_p_33_mm
+ cgso=2.6e-10 + dcgso_p_33_mm                        cgbo=1e-10
+ capmod=2                  nqsmod=0                  elm=5
+ xpart=1                   cf=1.392e-10              tlevc=1
+ hdif=3.2e-7               rsh=8
+ noimod=2                  noia=4.86325e+19          noib=142700
+ noic=1.04e-11             ef=1.117                  em=5015000
