simulator lang=spectre insensitive=yes
library mis_rf

section typ

parameters drgate_mis_rf=0
parameters dcbox_mis_rf=0
parameters dxl_mis_rf=0.0000e+00
parameters dxw_mis_rf=0.0000e+00
parameters dcj_mis_rf=0.0000e+00
parameters dcjsw_mis_rf=0.0000e+00
parameters dtox_mis_rf=0
parameters dcgdo_mis_rf=0
parameters dcgso_mis_rf=0
parameters dcf_mis_rf=0.0000e+00

include "./varmis_18_rf_v2d3.mdl.scs"

endsection typ

section min

parameters drgate_mis_rf=0.35
parameters dcbox_mis_rf=0.1
parameters dxl_mis_rf=-2e-8
parameters dxw_mis_rf=-2e-8
parameters dcj_mis_rf=0.1
parameters dcjsw_mis_rf=0.1
parameters dtox_mis_rf=1.0000e-10
parameters dcgdo_mis_rf=-0.1
parameters dcgso_mis_rf=-0.1
parameters dcf_mis_rf=-0.15

include "./varmis_18_rf_v2d3.mdl.scs"

endsection min

section max

parameters drgate_mis_rf=-0.35
parameters dcbox_mis_rf=-0.1
parameters dxl_mis_rf=2e-8
parameters dxw_mis_rf=2e-8
parameters dcj_mis_rf=-0.1
parameters dcjsw_mis_rf=-0.1
parameters dtox_mis_rf=-1.0000e-10
parameters dcgdo_mis_rf=0.1
parameters dcgso_mis_rf=0.1
parameters dcf_mis_rf=0.15

include "./varmis_18_rf_v2d3.mdl.scs"

endsection max

endlibrary mis_rf
