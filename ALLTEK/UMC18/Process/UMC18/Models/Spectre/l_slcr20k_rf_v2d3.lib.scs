simulator lang=spectre insensitive=yes
library l_slcr20k_rf

section typ

parameters dw_l_rf=0
parameters dt_l_rf=0
parameters drs_l_rf=0
parameters dcp_l_rf=0
parameters dcox_l_rf=0
parameters dls_l_rf=0

include "./l_slcr20k_rf_v2d3.mdl.scs"

endsection typ

section min

parameters dw_l_rf=-0.2
parameters dt_l_rf=-0.1
parameters drs_l_rf=0.1
parameters dcp_l_rf=-0.1
parameters dcox_l_rf=0.15
parameters dls_l_rf=-0.03

include "./l_slcr20k_rf_v2d3.mdl.scs"

endsection min

section max

parameters dw_l_rf=0.2
parameters dt_l_rf=0.1
parameters drs_l_rf=-0.1
parameters dcp_l_rf=0.1
parameters dcox_l_rf=-0.15
parameters dls_l_rf=0.03

include "./l_slcr20k_rf_v2d3.mdl.scs"

endsection max

endlibrary l_slcr20k_rf
