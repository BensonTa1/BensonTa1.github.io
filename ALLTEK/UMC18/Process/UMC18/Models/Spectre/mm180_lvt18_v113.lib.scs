simulator lang=spectre insensitive=yes
library mylib

section tt

//  ****************************************************************************************
//          0.18um 1.8v/3.3v MIXEDMODE Twin-well technology, 1.8V Low VT NMOS Model-TT
//     *
//  ****************************************************************************************
model n_lv_18_mm bsim3v3 type=n
+ lmin=2.4e-7               lmax=5.0e-5               wmin=2.4e-7
+ wmax=1.0e-4               tnom=27.0                 version=3.1
+ tox=4.20000e-09           xj=1.6000000e-07          nch=4.6371000e+17
+ lln=2.0000000             lwn=1.0000000             wln=1.0000000
+ wwn=1.0000000             lint=1.0000000e-08        ll=-2.5800000e-22
+ lw=0.00                   lwl=0.00                  wint=2.0000000e-08
+ wl=0.00                   ww=0.00                   wwl=0.00
+ mobmod=2                  binunit=2                 xl=0
+ xw=0                      dwg=2.5000000e-09         dwb=1.2441700e-09
+ hdif=2.6e-07              rsh=8                     vth0=1.6460000e-02
+ k1=0.3122200              k2=-4.3434400e-02         k3=-15.4245000
+ dvt0=1.9600000            dvt1=0.2703380            dvt2=7.0000000e-02
+ dvt0w=0.4113980           dvt1w=1.6626000e+06       dvt2w=-4.4234600e-02
+ nlx=8.3200000e-07         w0=1.0000000e-06          k3b=-0.1101380
+ vsat=9.20e+04             pvsat=1.9999999e-09       ua=5.2358400e-10
+ wua=1.0000000e-16         pua=-7.5000000e-23        ub=1.4080000e-18
+ wub=-3.0000001e-25        pub=8.0000000e-32         uc=-1.0246000e-10
+ rdsw=96.7580000           prwb=-0.2000000           prwg=5.0000000e-02
+ wr=1.0000000              u0=4.9234500e-02          wu0=2.4000000e-09
+ pu0=2.0000000e-16         a0=1.0000000              keta=4.1062700e-03
+ a1=0.00                   a2=1.0000000              ags=0.6300000
+ b0=0.00                   b1=0.00                   voff=-0.2517590
+ nfactor=1.0000000         cit=-4.5359940e-03        cdsc=1.1000000e-03
+ cdscb=0.00                cdscd=5e-4                eta0=5.5334000e-02
+ etab=-2.3552900e-02       dsub=0.5600000            pclm=2.8151700
+ pdiblc1=0.1000000         pdiblc2=8.0000000e-02     pdiblcb=0.2777778
+ drout=1.0000000           pscbe1=6.6815310e+08      pscbe2=1.0000000e-10
+ pvag=0.5000000            delta=1.0000000e-02       alpha0=0.00
+ beta0=30.0000000          kt1=-0.1999444            kt2=1.5900001e-02
+ at=3.3000000e+04          ute=-1.6873263            ua1=-1.3554663e-09
+ ub1=8.7998690e-20         uc1=3.4078270e-11         kt1l=0.00
+ prt=-1.0000000e+02        cj=0.00099                mj=0.5
+ pb=0.762                  cjsw=1.5e-10              mjsw=0.257
+ pbsw=0.639                cta=0.000902              ctp=0.000718
+ pta=0.000872              ptp=0.00385               js=1.00e-04
+ jsw=0.00                  cjswg=2.4e-10             cgdo=2.0e-10
+ cgso=2.0e-10              cgbo=0.0                  capmod=2
+ nqsmod=0                  elm=5                     xpart=1
+ cf=1.53e-10               dwc=2e-08                 tlevc=1

//  ****************************************************************************************
//          0.18um 1.8v/3.3v MIXEDMODE Twin-well technology, 1.8V Low VT PMOS Model-TT
//     *
//  ****************************************************************************************
//

model p_lv_18_mm bsim3v3 type=p
+ lmin=2.4e-7               lmax=5.0e-5               wmin=2.4e-7
+ wmax=1.0e-4               tnom=27.0                 version=3.1
+ tox=4.20000e-09           xj=1.8000000e-07          nch=2.6699999e+17
+ lln=0.2000000             lwn=1.0000000             wln=0.7966000
+ wwn=1.7867000             lint=0.00                 ll=8.9200000e-10
+ lw=-8.0000000e-14         lwl=3.7900000e-15         wint=-4.2700000e-08
+ wl=5.6500000e-14          ww=5.7000000e-24          wwl=1.8000000e-25
+ mobmod=1                  binunit=2                 xl=0
+ xw=0                      dwg=-1.0600000e-08        dwb=-1.0100000e-09
+ hdif=2.6e-07              rsh=8                     vth0=-0.2253000
+ k1=0.4604000              k2=-1.0000000e-02         k3=-6.3916000
+ dvt0=1.0400000e-03        dvt1=2.9700000e-02        dvt2=-12.2436000
+ dvt0w=0.00                dvt1w=0.00                dvt2w=0.00
+ nlx=0.00                  w0=5.5000000e-07          k3b=5.2034000
+ vsat=1.4500000e+05        ua=1.8500000e-09          ub=-4.0200000e-19
+ uc=-1.2800000e-10         rdsw=1.1024300e+02        prwb=-2.0000000
+ prwg=1.0000000            wr=1.0251000              u0=1.1700000e-02
+ a0=1.1075000              keta=-9.5500000e-03       a1=0.00
+ a2=0.4000000              ags=0.3268000             b0=4.0000000e-08
+ b1=0.00                   voff=-0.1415000           nfactor=2.0000000
+ cit=-1.4900000e-04        cdsc=1.4500000e-05        cdscb=0.00
+ cdscd=3.8500001e-04       eta0=8.1700000e-03        etab=-8.2900000e-02
+ dsub=0.6936000            pclm=1.8243001            pdiblc1=0.1000000
+ pdiblc2=1.6800000e-03     pdiblcb=0.2383000         drout=0.2853000
+ pscbe1=6.3000000e+08      pscbe2=1.0000000e-10      pvag=2.0000000
+ delta=1.0000000e-02       alpha0=0.00               beta0=30.0000000
+ kt1=-0.2842559            kt2=-2.7705010e-02        at=3.3000000e+04
+ ute=-1.4842620            ua1=-1.6085620e-09        ub1=-6.7403140e-19
+ uc1=-4.9096290e-11        kt1l=0.00                 prt=0.00
+ cj=1.060794e-03           mj=0.3802915              pb=0.7619755
+ cjsw=2.025533e-10         mjsw=0.2567205            pbsw=0.6391692
+ cta=8.437771e-04          ctp=8.053438e-04          pta=1.465745e-03
+ ptp=1.857747e-03          js=1.00e-04               jsw=0.00
+ cjswg=4.53e-10            cgdo=1.8e-10              cgso=1.8e-10
+ cgbo=0.0e+00              capmod=2                  nqsmod=0
+ elm=5                     xpart=1                   cf=1.53e-10
+ dwc=-4.27e-08             tlevc=1

endsection tt

section ss

//  ****************************************************************************************
//          0.18um 1.8v/3.3v MIXEDMODE Twin-well technology, 1.8V Low VT NMOS Model--SS
//    *
//  ****************************************************************************************
model n_lv_18_mm bsim3v3 type=n
+ lmin=2.4e-7               lmax=5.0e-5               wmin=2.4e-7
+ wmax=1.0e-4               tnom=27.0                 version=3.1
+ tox=4.20e-09 + 2.5e-10    xj=1.6000000e-07          nch=4.6371000e+17
+ lln=2.0000000             lwn=1.0000000             wln=1.0000000
+ wwn=1.0000000             lint=1.00e-08 - 2.43e-8   ll=-2.5800000e-22
+ lw=0.00                   lwl=0.00                  wint=2.0000000e-08 + 1e-8
+ wl=0.00                   ww=0.00                   wwl=0.00
+ mobmod=2                  binunit=2                 xl=0
+ xw=0                      dwg=2.5000000e-09         dwb=1.2441700e-09
+ hdif=2.6e-07              rsh=8                     vth0=1.6460e-02 + 0.05
+ k1=0.3122200              k2=-4.3434400e-02         k3=-15.4245000
+ dvt0=1.9600000            dvt1=0.2703380            dvt2=7.0000000e-02
+ dvt0w=0.4113980           dvt1w=1.6626000e+06       dvt2w=-4.4234600e-02
+ nlx=8.3200000e-07         w0=1.0000000e-06          k3b=-0.1101380
+ vsat=9.20e+04             pvsat=1.9999999e-09       ua=5.2358400e-10
+ wua=1.0000000e-16         pua=-7.5000000e-23        ub=1.4080000e-18
+ wub=-3.0000001e-25        pub=8.0000000e-32         uc=-1.0246000e-10
+ rdsw=96.7580000           prwb=-0.2000000           prwg=5.0000000e-02
+ wr=1.0000000              u0=4.9234500e-02          wu0=2.4000000e-09
+ pu0=2.0000000e-16         a0=1.0000000              keta=4.1062700e-03
+ a1=0.00                   a2=1.0000000              ags=0.6300000
+ b0=0.00                   b1=0.00                   voff=-0.2517590
+ nfactor=1.0000000         cit=-4.5359940e-03        cdsc=1.1000000e-03
+ cdscb=0.00                cdscd=5e-4                eta0=5.5334000e-02
+ etab=-2.3552900e-02       dsub=0.5600000            pclm=2.8151700
+ pdiblc1=0.1000000         pdiblc2=8.0000000e-02     pdiblcb=0.2777778
+ drout=1.0000000           pscbe1=6.6815310e+08      pscbe2=1.0000000e-10
+ pvag=0.5000000            delta=1.0000000e-02       alpha0=0.00
+ beta0=30.0000000          kt1=-0.1999444            kt2=1.5900001e-02
+ at=3.3000000e+04          ute=-1.6873263            ua1=-1.3554663e-09
+ ub1=8.7998690e-20         uc1=3.4078270e-11         kt1l=0.00
+ prt=-1.0000000e+02        cj=0.00099                mj=0.5
+ pb=0.762                  cjsw=1.5e-10              mjsw=0.257
+ pbsw=0.639                cta=0.000902              ctp=0.000718
+ pta=0.000872              ptp=0.00385               js=1.00e-04
+ jsw=0.00                  cjswg=2.4e-10             cgdo=2.0e-10 * 0.9
+ cgso=2.0e-10 * 0.9        cgbo=0.0                  capmod=2
+ nqsmod=0                  elm=5                     xpart=1
+ cf=1.53e-10               dwc=2e-08                 tlevc=1

//  ****************************************************************************************
//          0.18um 1.8v/3.3v MIXEDMODE Twin-well technology, 1.8V Low VT PMOS Model-SS
//     *
//  ****************************************************************************************
//

model p_lv_18_mm bsim3v3 type=p
+ lmin=2.4e-7               lmax=5.0e-5               wmin=2.4e-7
+ wmax=1.0e-4               tnom=27.0                 version=3.1
+ tox=4.20e-09 + 2.5e-10    xj=1.8000000e-07          nch=2.6699999e+17
+ lln=0.2000000             lwn=1.0000000             wln=0.7966000
+ wwn=1.7867000             lint=0.00 - 1.59e-8       ll=8.9200000e-10
+ lw=-8.0000000e-14         lwl=3.7900000e-15
+ wint= - 4.2700000e-08 + 1e-8                        wl=5.6500000e-14
+ ww=5.7000000e-24          wwl=1.8000000e-25         mobmod=1
+ binunit=2                 xl=0                      xw=0
+ dwg=-1.0600000e-08        dwb=-1.0100000e-09        hdif=2.6e-07
+ rsh=8                     vth0= - 0.2253 - 0.05     k1=0.4604000
+ k2=-1.0000000e-02         k3=-6.3916000             dvt0=1.0400000e-03
+ dvt1=2.9700000e-02        dvt2=-12.2436000          dvt0w=0.00
+ dvt1w=0.00                dvt2w=0.00                nlx=0.00
+ w0=5.5000000e-07          k3b=5.2034000             vsat=1.4500000e+05
+ ua=1.8500000e-09          ub=-4.0200000e-19         uc=-1.2800000e-10
+ rdsw=1.1024300e+02        prwb=-2.0000000           prwg=1.0000000
+ wr=1.0251000              u0=1.1700000e-02          a0=1.1075000
+ keta=-9.5500000e-03       a1=0.00                   a2=0.4000000
+ ags=0.3268000             b0=4.0000000e-08          b1=0.00
+ voff=-0.1415000           nfactor=2.0000000         cit=-1.4900000e-04
+ cdsc=1.4500000e-05        cdscb=0.00                cdscd=3.8500001e-04
+ eta0=8.1700000e-03        etab=-8.2900000e-02       dsub=0.6936000
+ pclm=1.8243001            pdiblc1=0.1000000         pdiblc2=1.6800000e-03
+ pdiblcb=0.2383000         drout=0.2853000           pscbe1=6.3000000e+08
+ pscbe2=1.0000000e-10      pvag=2.0000000            delta=1.0000000e-02
+ alpha0=0.00               beta0=30.0000000          kt1=-0.2842559
+ kt2=-2.7705010e-02        at=3.3000000e+04          ute=-1.4842620
+ ua1=-1.6085620e-09        ub1=-6.7403140e-19        uc1=-4.9096290e-11
+ kt1l=0.00                 prt=0.00                  cj=1.060794e-03
+ mj=0.3802915              pb=0.7619755              cjsw=2.025533e-10
+ mjsw=0.2567205            pbsw=0.6391692            cta=8.437771e-04
+ ctp=8.053438e-04          pta=1.465745e-03          ptp=1.857747e-03
+ js=1.00e-04               jsw=0.00                  cjswg=4.53e-10
+ cgdo=1.8e-10 * 0.9        cgso=1.8e-10 * 0.9        cgbo=0.0e+00
+ capmod=2                  nqsmod=0                  elm=5
+ xpart=1                   cf=1.53e-10               dwc=-4.27e-08
+ tlevc=1

endsection ss

section ff

//  ****************************************************************************************
//          0.18um 1.8v/3.3v MIXEDMODE Twin-well technology, 1.8V Low VT NMOS Model-FF
//     *
//  ****************************************************************************************
model n_lv_18_mm bsim3v3 type=n
+ lmin=2.4e-7               lmax=5.0e-5               wmin=2.4e-7
+ wmax=1.0e-4               tnom=27.0                 version=3.1
+ tox=4.20e-09 - 2.5e-10    xj=1.6000000e-07          nch=4.6371000e+17
+ lln=2.0000000             lwn=1.0000000             wln=1.0000000
+ wwn=1.0000000             lint=1.00e-08 + 1.60e-8   ll=-2.5800000e-22
+ lw=0.00                   lwl=0.00
+ wint=2.0000000e-08 - 1.0e-8                         wl=0.00
+ ww=0.00                   wwl=0.00                  mobmod=2
+ binunit=2                 xl=0                      xw=0
+ dwg=2.5000000e-09         dwb=1.2441700e-09         hdif=2.6e-07
+ rsh=8                     vth0=1.646e-02 - 0.05     k1=0.3122200
+ k2=-4.3434400e-02         k3=-15.4245000            dvt0=1.9600000
+ dvt1=0.2703380            dvt2=7.0000000e-02        dvt0w=0.4113980
+ dvt1w=1.6626000e+06       dvt2w=-4.4234600e-02      nlx=8.3200000e-07
+ w0=1.0000000e-06          k3b=-0.1101380            vsat=9.20e+04
+ pvsat=1.9999999e-09       ua=5.2358400e-10          wua=1.0000000e-16
+ pua=-7.5000000e-23        ub=1.4080000e-18          wub=-3.0000001e-25
+ pub=8.0000000e-32         uc=-1.0246000e-10         rdsw=96.7580000
+ prwb=-0.2000000           prwg=5.0000000e-02        wr=1.0000000
+ u0=4.9234500e-02          wu0=2.4000000e-09         pu0=2.0000000e-16
+ a0=1.0000000              keta=4.1062700e-03        a1=0.00
+ a2=1.0000000              ags=0.6300000             b0=0.00
+ b1=0.00                   voff=-0.2517590           nfactor=1.0000000
+ cit=-4.5359940e-03        cdsc=1.1000000e-03        cdscb=0.00
+ cdscd=5e-4                eta0=5.5334000e-02        etab=-2.3552900e-02
+ dsub=0.5600000            pclm=2.8151700            pdiblc1=0.1000000
+ pdiblc2=8.0000000e-02     pdiblcb=0.2777778         drout=1.0000000
+ pscbe1=6.6815310e+08      pscbe2=1.0000000e-10      pvag=0.5000000
+ delta=1.0000000e-02       alpha0=0.00               beta0=30.0000000
+ kt1=-0.1999444            kt2=1.5900001e-02         at=3.3000000e+04
+ ute=-1.6873263            ua1=-1.3554663e-09        ub1=8.7998690e-20
+ uc1=3.4078270e-11         kt1l=0.00                 prt=-1.0000000e+02
+ cj=0.00099                mj=0.5                    pb=0.762
+ cjsw=1.5e-10              mjsw=0.257                pbsw=0.639
+ cta=0.000902              ctp=0.000718              pta=0.000872
+ ptp=0.00385               js=1.00e-04               jsw=0.00
+ cjswg=2.4e-10             cgdo=2.0e-10 * 1.1        cgso=2.0e-10 * 1.1
+ cgbo=0.0                  capmod=2                  nqsmod=0
+ elm=5                     xpart=1                   cf=1.53e-10
+ dwc=2e-08                 tlevc=1

//  ****************************************************************************************
//          0.18um 1.8v/3.3v MIXEDMODE Twin-well technology, 1.8V Low VT PMOS Model-FF
//     *
//  ****************************************************************************************
//

model p_lv_18_mm bsim3v3 type=p
+ lmin=2.4e-7               lmax=5.0e-5               wmin=2.4e-7
+ wmax=1.0e-4               tnom=27.0                 version=3.1
+ tox=4.200e-09 - 2.5e-10   xj=1.8000000e-07          nch=2.6699999e+17
+ lln=0.2000000             lwn=1.0000000             wln=0.7966000
+ wwn=1.7867000             lint=0.00 + 0.952e-8      ll=8.9200000e-10
+ lw=-8.0000000e-14         lwl=3.7900000e-15
+ wint= - 4.2700000e-08 - 1e-8                        wl=5.6500000e-14
+ ww=5.7000000e-24          wwl=1.8000000e-25         mobmod=1
+ binunit=2                 xl=0                      xw=0
+ dwg=-1.0600000e-08        dwb=-1.0100000e-09        hdif=2.6e-07
+ rsh=8                     vth0= - 0.2253 + 0.05     k1=0.4604000
+ k2=-1.0000000e-02         k3=-6.3916000             dvt0=1.0400000e-03
+ dvt1=2.9700000e-02        dvt2=-12.2436000          dvt0w=0.00
+ dvt1w=0.00                dvt2w=0.00                nlx=0.00
+ w0=5.5000000e-07          k3b=5.2034000             vsat=1.4500000e+05
+ ua=1.8500000e-09          ub=-4.0200000e-19         uc=-1.2800000e-10
+ rdsw=1.1024300e+02        prwb=-2.0000000           prwg=1.0000000
+ wr=1.0251000              u0=1.1700000e-02          a0=1.1075000
+ keta=-9.5500000e-03       a1=0.00                   a2=0.4000000
+ ags=0.3268000             b0=4.0000000e-08          b1=0.00
+ voff=-0.1415000           nfactor=2.0000000         cit=-1.4900000e-04
+ cdsc=1.4500000e-05        cdscb=0.00                cdscd=3.8500001e-04
+ eta0=8.1700000e-03        etab=-8.2900000e-02       dsub=0.6936000
+ pclm=1.8243001            pdiblc1=0.1000000         pdiblc2=1.6800000e-03
+ pdiblcb=0.2383000         drout=0.2853000           pscbe1=6.3000000e+08
+ pscbe2=1.0000000e-10      pvag=2.0000000            delta=1.0000000e-02
+ alpha0=0.00               beta0=30.0000000          kt1=-0.2842559
+ kt2=-2.7705010e-02        at=3.3000000e+04          ute=-1.4842620
+ ua1=-1.6085620e-09        ub1=-6.7403140e-19        uc1=-4.9096290e-11
+ kt1l=0.00                 prt=0.00                  cj=1.060794e-03
+ mj=0.3802915              pb=0.7619755              cjsw=2.025533e-10
+ mjsw=0.2567205            pbsw=0.6391692            cta=8.437771e-04
+ ctp=8.053438e-04          pta=1.465745e-03          ptp=1.857747e-03
+ js=1.00e-04               jsw=0.00                  cjswg=4.53e-10
+ cgdo=1.8e-10 * 1.1        cgso=1.8e-10 * 1.1        cgbo=0.0e+00
+ capmod=2                  nqsmod=0                  elm=5
+ xpart=1                   cf=1.53e-10               dwc=-4.27e-08
+ tlevc=1

endsection ff

section snfp

//  ****************************************************************************************
//          0.18um 1.8v/3.3v MIXEDMODE Twin-well technology, 1.8V Low VT NMOS Model-SNFP
//   *
//  ****************************************************************************************
model n_lv_18_mm bsim3v3 type=n
+ lmin=2.4e-7               lmax=5.0e-5               wmin=2.4e-7
+ wmax=1.0e-4               tnom=27.0                 version=3.1
+ tox=4.20e-09              xj=1.6000000e-07          nch=4.6371000e+17
+ lln=2.0000000             lwn=1.0000000             wln=1.0000000
+ wwn=1.0000000             lint=1.00e-08 - 1.56e-8   ll=-2.5800000e-22
+ lw=0.00                   lwl=0.00                  wint=2.0e-08 + 5e-9
+ wl=0.00                   ww=0.00                   wwl=0.00
+ mobmod=2                  binunit=2                 xl=0
+ xw=0                      dwg=2.5000000e-09         dwb=1.2441700e-09
+ hdif=2.6e-07              rsh=8                     vth0=1.646e-02 + 0.03
+ k1=0.3122200              k2=-4.3434400e-02         k3=-15.4245000
+ dvt0=1.9600000            dvt1=0.2703380            dvt2=7.0000000e-02
+ dvt0w=0.4113980           dvt1w=1.6626000e+06       dvt2w=-4.4234600e-02
+ nlx=8.3200000e-07         w0=1.0000000e-06          k3b=-0.1101380
+ vsat=9.20e+04             pvsat=1.9999999e-09       ua=5.2358400e-10
+ wua=1.0000000e-16         pua=-7.5000000e-23        ub=1.4080000e-18
+ wub=-3.0000001e-25        pub=8.0000000e-32         uc=-1.0246000e-10
+ rdsw=96.7580000           prwb=-0.2000000           prwg=5.0000000e-02
+ wr=1.0000000              u0=4.9234500e-02          wu0=2.4000000e-09
+ pu0=2.0000000e-16         a0=1.0000000              keta=4.1062700e-03
+ a1=0.00                   a2=1.0000000              ags=0.6300000
+ b0=0.00                   b1=0.00                   voff=-0.2517590
+ nfactor=1.0000000         cit=-4.5359940e-03        cdsc=1.1000000e-03
+ cdscb=0.00                cdscd=5e-4                eta0=5.5334000e-02
+ etab=-2.3552900e-02       dsub=0.5600000            pclm=2.8151700
+ pdiblc1=0.1000000         pdiblc2=8.0000000e-02     pdiblcb=0.2777778
+ drout=1.0000000           pscbe1=6.6815310e+08      pscbe2=1.0000000e-10
+ pvag=0.5000000            delta=1.0000000e-02       alpha0=0.00
+ beta0=30.0000000          kt1=-0.1999444            kt2=1.5900001e-02
+ at=3.3000000e+04          ute=-1.6873263            ua1=-1.3554663e-09
+ ub1=8.7998690e-20         uc1=3.4078270e-11         kt1l=0.00
+ prt=-1.0000000e+02        cj=0.00099                mj=0.5
+ pb=0.762                  cjsw=1.5e-10              mjsw=0.257
+ pbsw=0.639                cta=0.000902              ctp=0.000718
+ pta=0.000872              ptp=0.00385               js=1.00e-04
+ jsw=0.00                  cjswg=2.4e-10             cgdo=2.0e-10
+ cgso=2.0e-10              cgbo=0.0                  capmod=2
+ nqsmod=0                  elm=5                     xpart=1
+ cf=1.53e-10               dwc=2e-08                 tlevc=1

//  ****************************************************************************************
//          0.18um 1.8v/3.3v MIXEDMODE Twin-well technology, 1.8V Low VT PMOS Model-SNFP
//   *
//  ****************************************************************************************
//

model p_lv_18_mm bsim3v3 type=p
+ lmin=2.4e-7               lmax=5.0e-5               wmin=2.4e-7
+ wmax=1.0e-4               tnom=27.0                 version=3.1
+ tox=4.20000e-09           xj=1.8000000e-07          nch=2.6699999e+17
+ lln=0.2000000             lwn=1.0000000             wln=0.7966000
+ wwn=1.7867000             lint=0.00 + 0.66e-8       ll=8.9200000e-10
+ lw=-8.0000000e-14         lwl=3.7900000e-15
+ wint= - 4.2700000e-08 - 5e-9                        wl=5.6500000e-14
+ ww=5.7000000e-24          wwl=1.8000000e-25         mobmod=1
+ binunit=2                 xl=0                      xw=0
+ dwg=-1.0600000e-08        dwb=-1.0100000e-09        hdif=2.6e-07
+ rsh=8                     vth0= - 0.2253000 + 0.03
+ k1=0.4604000              k2=-1.0000000e-02         k3=-6.3916000
+ dvt0=1.0400000e-03        dvt1=2.9700000e-02        dvt2=-12.2436000
+ dvt0w=0.00                dvt1w=0.00                dvt2w=0.00
+ nlx=0.00                  w0=5.5000000e-07          k3b=5.2034000
+ vsat=1.4500000e+05        ua=1.8500000e-09          ub=-4.0200000e-19
+ uc=-1.2800000e-10         rdsw=1.1024300e+02        prwb=-2.0000000
+ prwg=1.0000000            wr=1.0251000              u0=1.1700000e-02
+ a0=1.1075000              keta=-9.5500000e-03       a1=0.00
+ a2=0.4000000              ags=0.3268000             b0=4.0000000e-08
+ b1=0.00                   voff=-0.1415000           nfactor=2.0000000
+ cit=-1.4900000e-04        cdsc=1.4500000e-05        cdscb=0.00
+ cdscd=3.8500001e-04       eta0=8.1700000e-03        etab=-8.2900000e-02
+ dsub=0.6936000            pclm=1.8243001            pdiblc1=0.1000000
+ pdiblc2=1.6800000e-03     pdiblcb=0.2383000         drout=0.2853000
+ pscbe1=6.3000000e+08      pscbe2=1.0000000e-10      pvag=2.0000000
+ delta=1.0000000e-02       alpha0=0.00               beta0=30.0000000
+ kt1=-0.2842559            kt2=-2.7705010e-02        at=3.3000000e+04
+ ute=-1.4842620            ua1=-1.6085620e-09        ub1=-6.7403140e-19
+ uc1=-4.9096290e-11        kt1l=0.00                 prt=0.00
+ cj=1.060794e-03           mj=0.3802915              pb=0.7619755
+ cjsw=2.025533e-10         mjsw=0.2567205            pbsw=0.6391692
+ cta=8.437771e-04          ctp=8.053438e-04          pta=1.465745e-03
+ ptp=1.857747e-03          js=1.00e-04               jsw=0.00
+ cjswg=4.53e-10            cgdo=1.8e-10              cgso=1.8e-10
+ cgbo=0.0e+00              capmod=2                  nqsmod=0
+ elm=5                     xpart=1                   cf=1.53e-10
+ dwc=-4.27e-08             tlevc=1

endsection snfp

section fnsp

//  ****************************************************************************************
//          0.18um 1.8v/3.3v MIXEDMODE Twin-well technology, 1.8V Low VT NMOS Model-FNSP
//   *
//  ****************************************************************************************
model n_lv_18_mm bsim3v3 type=n
+ lmin=2.4e-7               lmax=5.0e-5               wmin=2.4e-7
+ wmax=1.0e-4               tnom=27.0                 version=3.1
+ tox=4.20000e-09           xj=1.6000000e-07          nch=4.6371000e+17
+ lln=2.0000000             lwn=1.0000000             wln=1.0000000
+ wwn=1.0000000             lint=1.00e-08 + 1.27e-8   ll=-2.5800000e-22
+ lw=0.00                   lwl=0.00                  wint=2.0000000e-08 - 6e-9
+ wl=0.00                   ww=0.00                   wwl=0.00
+ mobmod=2                  binunit=2                 xl=0
+ xw=0                      dwg=2.5000000e-09         dwb=1.2441700e-09
+ hdif=2.6e-07              rsh=8                     vth0=1.6460e-02 - 0.03
+ k1=0.3122200              k2=-4.3434400e-02         k3=-15.4245000
+ dvt0=1.9600000            dvt1=0.2703380            dvt2=7.0000000e-02
+ dvt0w=0.4113980           dvt1w=1.6626000e+06       dvt2w=-4.4234600e-02
+ nlx=8.3200000e-07         w0=1.0000000e-06          k3b=-0.1101380
+ vsat=9.20e+04             pvsat=1.9999999e-09       ua=5.2358400e-10
+ wua=1.0000000e-16         pua=-7.5000000e-23        ub=1.4080000e-18
+ wub=-3.0000001e-25        pub=8.0000000e-32         uc=-1.0246000e-10
+ rdsw=96.7580000           prwb=-0.2000000           prwg=5.0000000e-02
+ wr=1.0000000              u0=4.9234500e-02          wu0=2.4000000e-09
+ pu0=2.0000000e-16         a0=1.0000000              keta=4.1062700e-03
+ a1=0.00                   a2=1.0000000              ags=0.6300000
+ b0=0.00                   b1=0.00                   voff=-0.2517590
+ nfactor=1.0000000         cit=-4.5359940e-03        cdsc=1.1000000e-03
+ cdscb=0.00                cdscd=5e-4                eta0=5.5334000e-02
+ etab=-2.3552900e-02       dsub=0.5600000            pclm=2.8151700
+ pdiblc1=0.1000000         pdiblc2=8.0000000e-02     pdiblcb=0.2777778
+ drout=1.0000000           pscbe1=6.6815310e+08      pscbe2=1.0000000e-10
+ pvag=0.5000000            delta=1.0000000e-02       alpha0=0.00
+ beta0=30.0000000          kt1=-0.1999444            kt2=1.5900001e-02
+ at=3.3000000e+04          ute=-1.6873263            ua1=-1.3554663e-09
+ ub1=8.7998690e-20         uc1=3.4078270e-11         kt1l=0.00
+ prt=-1.0000000e+02        cj=0.00099                mj=0.5
+ pb=0.762                  cjsw=1.5e-10              mjsw=0.257
+ pbsw=0.639                cta=0.000902              ctp=0.000718
+ pta=0.000872              ptp=0.00385               js=1.00e-04
+ jsw=0.00                  cjswg=2.4e-10             cgdo=2.0e-10
+ cgso=2.0e-10              cgbo=0.0                  capmod=2
+ nqsmod=0                  elm=5                     xpart=1
+ cf=1.53e-10               dwc=2e-08                 tlevc=1

//  ****************************************************************************************
//          0.18um 1.8v/3.3v MIXEDMODE Twin-well technology, 1.8V Low VT PMOS Model-FNSP
//   *
//  ****************************************************************************************
//

model p_lv_18_mm bsim3v3 type=p
+ lmin=2.4e-7               lmax=5.0e-5               wmin=2.4e-7
+ wmax=1.0e-4               tnom=27.0                 version=3.1
+ tox=4.20000e-09           xj=1.8000000e-07          nch=2.6699999e+17
+ lln=0.2000000             lwn=1.0000000             wln=0.7966000
+ wwn=1.7867000             lint=0.00 - 0.86e-8       ll=8.9200000e-10
+ lw=-8.0000000e-14         lwl=3.7900000e-15
+ wint= - 4.2700000e-08 + 5e-9                        wl=5.6500000e-14
+ ww=5.7000000e-24          wwl=1.8000000e-25         mobmod=1
+ binunit=2                 xl=0                      xw=0
+ dwg=-1.0600000e-08        dwb=-1.0100000e-09        hdif=2.6e-07
+ rsh=8                     vth0= - 0.2253 - 0.03     k1=0.4604000
+ k2=-1.0000000e-02         k3=-6.3916000             dvt0=1.0400000e-03
+ dvt1=2.9700000e-02        dvt2=-12.2436000          dvt0w=0.00
+ dvt1w=0.00                dvt2w=0.00                nlx=0.00
+ w0=5.5000000e-07          k3b=5.2034000             vsat=1.4500000e+05
+ ua=1.8500000e-09          ub=-4.0200000e-19         uc=-1.2800000e-10
+ rdsw=1.1024300e+02        prwb=-2.0000000           prwg=1.0000000
+ wr=1.0251000              u0=1.1700000e-02          a0=1.1075000
+ keta=-9.5500000e-03       a1=0.00                   a2=0.4000000
+ ags=0.3268000             b0=4.0000000e-08          b1=0.00
+ voff=-0.1415000           nfactor=2.0000000         cit=-1.4900000e-04
+ cdsc=1.4500000e-05        cdscb=0.00                cdscd=3.8500001e-04
+ eta0=8.1700000e-03        etab=-8.2900000e-02       dsub=0.6936000
+ pclm=1.8243001            pdiblc1=0.1000000         pdiblc2=1.6800000e-03
+ pdiblcb=0.2383000         drout=0.2853000           pscbe1=6.3000000e+08
+ pscbe2=1.0000000e-10      pvag=2.0000000            delta=1.0000000e-02
+ alpha0=0.00               beta0=30.0000000          kt1=-0.2842559
+ kt2=-2.7705010e-02        at=3.3000000e+04          ute=-1.4842620
+ ua1=-1.6085620e-09        ub1=-6.7403140e-19        uc1=-4.9096290e-11
+ kt1l=0.00                 prt=0.00                  cj=1.060794e-03
+ mj=0.3802915              pb=0.7619755              cjsw=2.025533e-10
+ mjsw=0.2567205            pbsw=0.6391692            cta=8.437771e-04
+ ctp=8.053438e-04          pta=1.465745e-03          ptp=1.857747e-03
+ js=1.00e-04               jsw=0.00                  cjswg=4.53e-10
+ cgdo=1.8e-10              cgso=1.8e-10              cgbo=0.0e+00
+ capmod=2                  nqsmod=0                  elm=5
+ xpart=1                   cf=1.53e-10               dwc=-4.27e-08
+ tlevc=1

endsection fnsp

endlibrary mylib
