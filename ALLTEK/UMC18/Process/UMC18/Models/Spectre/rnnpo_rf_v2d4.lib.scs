//
simulator lang=spectre insensitive=yes
library mylib
section typ
parameters ddw_rnnpo_rf=0
parameters drsh_rnnpo_rf=0
parameters dcox_rnnpo_rf=0
include "./rnnpo_rf_v2d4.mdl.scs"
//
endsection typ
//
section min
parameters ddw_rnnpo_rf=-0.1
parameters drsh_rnnpo_rf=-0.25
parameters dcox_rnnpo_rf=-0.12
include "./rnnpo_rf_v2d4.mdl.scs"
//
endsection min
//
section max
parameters ddw_rnnpo_rf=0.1
parameters drsh_rnnpo_rf=0.25
parameters dcox_rnnpo_rf=0.12
include "./rnnpo_rf_v2d4.mdl.scs"
//
endsection max
endlibrary mylib
