// VerilogA for Verilog_A, IDEAL_VCO, veriloga

`include "constants.vams"
`include "disciplines.vams"

module IDEAL_VCO(VIN,VOUT);
	electrical VIN,VOUT;
	input VIN;
	output VOUT;

	parameter real amp=0.6;
	parameter real gain = 500M exclude 0;
	parameter real cf=1000M;
	parameter integer ppc=100;
	real wc,phase_lin,phase_nonlin;
	integer num_cycles;
	real inst_freq;

	analog begin
		@(initial_step)begin
			wc=`M_TWO_PI*cf;
		end
		phase_lin=wc*$realtime;
		num_cycles=phase_lin/`M_TWO_PI;
		phase_lin=phase_lin-num_cycles*`M_TWO_PI;
		phase_nonlin=`M_TWO_PI*gain*idtmod(V(VIN),0,1000,0);
		V(VOUT)<+amp*sin(phase_lin+phase_nonlin)+0.6;
		inst_freq=cf+gain*V(VIN);
		$bound_step(1/(ppc*inst_freq));
	end

endmodule
