// VerilogA for Verilog_A, IDEAL_OPA, veriloga

`include "constants.vams"
`include "disciplines.vams"

module IDEAL_OPA(VINP,VINN,VOUT);
	electrical VINP,VINN,VOUT;
	input VINP,VINN;
	output VOUT;

	real VDIFF;

	parameter real AV=1000;
	parameter real fp1=1e6;

	analog begin
		VDIFF=V(VINP)-V(VINN);
		V(VOUT)<+laplace_nd(VDIFF,{AV},{1,1/(fp1*`M_TWO_PI)}); //H(s)=Av/[1+(s/wp)]

	end

endmodule
