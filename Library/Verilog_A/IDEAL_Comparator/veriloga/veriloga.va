// VerilogA for Verilog_A, IDEAL_Comparator, veriloga

`include "constants.vams"
`include "disciplines.vams"

module IDEAL_Comparator(VINP,VINN,CLK,VOUTP,VOUTN);
	electrical VINP,VINN,CLK,VOUTP,VOUTN;
	input VINP,VINN,CLK;
	output VOUTP,VOUTN;

	parameter real VOH = 3.3;
	parameter real VOL = 0;
	parameter real VTH = 1.65;
	parameter real RT_FT = 100p;

	real VOP,VON;

	analog begin
		@(cross(V(CLK)-VTH,1))begin
			if(V(VINP)-V(VINN)>0)begin
				VOP=VOH;
				VON=VOL;
			end else begin
				VOP=VOL;
				VON=VOH;
			end
		end

		V(VOUTP)<+transition(VOP,0,RT_FT,RT_FT);
		V(VOUTN)<+transition(VON,0,RT_FT,RT_FT);
	end

endmodule
