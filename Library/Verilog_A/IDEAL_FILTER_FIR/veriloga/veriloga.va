`include "constants.vams"
`include "disciplines.vams"

module IDEAL_FILTER_FIR (CLK, IN, OUT);

input CLK;
input IN;
output OUT;

electrical CLK, IN, OUT;

// =========================
// FIR coefficients
// =========================
parameter integer N = 51;

parameter real h[0:50] = {-1.249047e-18, -1.056236e-03, -7.693410e-04,  9.563232e-04,  1.976083e-03,
 -2.620691e-18, -3.265385e-03, -2.568520e-03,  3.234633e-03,  6.519908e-03,
 -6.211702e-18, -9.825739e-03, -7.365685e-03,  8.881349e-03,  1.725606e-02,
 -1.065044e-17, -2.478427e-02, -1.841767e-02,  2.229953e-02,  4.422244e-02,
 -1.424145e-17, -7.146981e-02, -6.043033e-02,  9.231763e-02,  3.020273e-01,
  4.005234e-01,  3.020273e-01,  9.231763e-02, -6.043033e-02, -7.146981e-02,
 -1.424145e-17,  4.422244e-02,  2.229953e-02, -1.841767e-02, -2.478427e-02,
 -1.065044e-17,  1.725606e-02,  8.881349e-03, -7.365685e-03, -9.825739e-03,
 -6.211702e-18,  6.519908e-03,  3.234633e-03, -2.568520e-03, -3.265385e-03,
 -2.620691e-18,  1.976083e-03,  9.563232e-04, -7.693410e-04, -1.056236e-03,
 -1.249047e-18};

// =========================
// delay line
// =========================
real x_buf[0:50];
integer i;
real acc;

// =========================
// clocked behavior
// =========================
analog begin

  @(cross(V(CLK) - 0.5, +1)) begin

    // shift register
    for (i = 50; i > 0; i = i - 1) begin
      x_buf[i] = x_buf[i-1];
    end

    // new sample
    x_buf[0] = V(IN);

    // FIR accumulation
    acc = 0.0;
    for (i = 0; i < N; i = i + 1) begin
      acc = acc + h[i] * x_buf[i];
    end

  end

  V(OUT) <+ acc;

end

endmodule
