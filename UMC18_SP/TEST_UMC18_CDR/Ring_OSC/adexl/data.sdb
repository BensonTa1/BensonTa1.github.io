ADE simulation setup
Run mode: Single Run, Sweeps and Corners
Tests:
  TEST_UMC18_CDR:Ring_OSC:1: TEST_UMC18_CDR/Ring_OSC/config, simulator spectre
Global variables:
  VC = {Inclusion List}0{Inclusion List}{From/To}Auto:0:19:1.8{From/To}
