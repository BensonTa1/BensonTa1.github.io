// VerilogA for Fractional_PLL, ADDER_6BIT, veriloga

`include "constants.vams"
`include "disciplines.vams"

module ADDER_6BIT(DINA0,DINA1,DINA2,DINA3,DINA4,DINA5,DINB0,DINB1,DINB2,DINB3,DINB4,DINB5,DOUT0,DOUT1,DOUT2,DOUT3,DOUT4,DOUT5);
	electrical DINA0,DINA1,DINA2,DINA3,DINA4,DINA5,DINB0,DINB1,DINB2,DINB3,DINB4,DINB5,DOUT0,DOUT1,DOUT2,DOUT3,DOUT4,DOUT5;
	input DINA0,DINA1,DINA2,DINA3,DINA4,DINA5,DINB0,DINB1,DINB2,DINB3,DINB4,DINB5;
	output DOUT0,DOUT1,DOUT2,DOUT3,DOUT4,DOUT5;

	parameter real VOH=1;
	parameter real VOL=0;
	parameter real VTH=0.5;

	integer DA0,DA1,DA2,DA3,DA4,DA5;
	integer DB0,DB1,DB2,DB3,DB4,DB5;
	integer DD0,DD1,DD2,DD3,DD4,DD5;
	integer C1,C2,C3,C4,C5;

	analog begin

		DA0=(V(DINA0)>VTH)?1:0;DA1=(V(DINA1)>VTH)?1:0;DA2=(V(DINA2)>VTH)?1:0;DA3=(V(DINA3)>VTH)?1:0;DA4=(V(DINA4)>VTH)?1:0;DA5=(V(DINA5)>VTH)?1:0;
		DB0=(V(DINB0)>VTH)?1:0;DB1=(V(DINB1)>VTH)?1:0;DB2=(V(DINB2)>VTH)?1:0;DB3=(V(DINB3)>VTH)?1:0;DB4=(V(DINB4)>VTH)?1:0;DB5=(V(DINB5)>VTH)?1:0;

		DD0=DA0^DB0;		C1=DA0&&DB0;
		DD1=DA1^DB1^C1;	C2=DA1&DB1+DA1&C1+DB1+C1;
		DD2=DA2^DB2^C2;	C3=DA2&DB2+DA2&C2+DB2+C2;
		DD3=DA3^DB3^C3;	C4=DA3&DB3+DA3&C3+DB3+C3;
		DD4=DA4^DB4^C4;	C5=DA4&DB4+DA4&C4+DB4+C4;
		DD5=DA5^DB5^C5;

		V(DOUT5)<+DD5; V(DOUT4)<+DD4; V(DOUT3)<+DD3; V(DOUT2)<+DD2; V(DOUT1)<+DD1; V(DOUT0)<+DD0;

	end

endmodule
