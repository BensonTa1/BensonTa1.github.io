ADE simulation setup
Run mode: Monte Carlo Sampling
Tests:
  TEST_UMC18_RRIO_OPA:CONSTANT_GM:1: TEST_UMC18_RRIO_OPA/CONSTANT_GM/schematic, simulator spectre
Global variables:
  sigma = 3
Corners:
  model folders: /home/IC/Desktop/virtuoso/Process/UMC18/Models/Spectre, /home/IC/Desktop/virtuoso/Process/UMC18/Models/Spectre/Monte_Carlo
  C0: mm180_reg18_v124.lib.scs[tt], rnnpo_rf_v2d4_mc_corner.lib.scs[mc]
