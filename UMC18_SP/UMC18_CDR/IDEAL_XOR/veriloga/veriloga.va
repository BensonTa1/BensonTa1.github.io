// VerilogA for CDR, IDEAL_DFF_POS_ET, veriloga

`include "constants.vams"
`include "disciplines.vams"

module IDEAL_XOR(A,B,Y);

	input A,B;
	output Y;
	electrical A,B,Y;
	real status;

	parameter real VOH=1.8;
	parameter real VOL=1.0;

	parameter real VTH=1.4;

	analog begin

		if(V(A)>1.4&&V(B)>1.4||V(A)<=1.4&&V(B)<=1.4)
			status=VOL;

		if(V(A)>1.4&&V(B)<=1.4||V(A)<=1.4&&V(B)>1.4)
			status=VOH;

		V(Y)<+transition(status,0,10p,10p);

	end

endmodule
