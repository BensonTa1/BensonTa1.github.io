ADE simulation setup
Run mode: Monte Carlo Sampling
Tests:
  TEST_Adaptive_CTLE:Rectifier_LP_DIF:1: TEST_Adaptive_CTLE/Rectifier_LP_DIF/schematic, simulator spectre
Global variables:
  tempurature = {Exclusion List}30{Exclusion List}{From/To}Auto:-100:10:200{From/To} (off)
  sigma = 3
  VDM = 0
  VCM = 900m
Corners (nominal off):
  model folders: /home/m10912086/UM180FDKMFC0000OA_A02_EQ/Models/Spectre, /home/m10912086/UM180FDKMFC0000OA_A02_EQ/Models/Spectre/Monte_Carlo
  Corner (off): varmis_18_rf_v2d3.lib.scs[typ], vardiop_rf_v2d3.lib.scs[typ], rnppo_rf_v2d4.lib.scs[typ], rnnpo_rf_v2d4.lib.scs[typ], rnhr_rf_v2d4.lib.scs[typ], pad_rf_v2d3.lib.scs[typ], mm180_reg33_v114.lib.scs[tt], mm180_mimcap_v101.lib.scs[mimcaps_typ], mm180_bjt_v121.lib.scs[tt_bip], mimcapm_rf_v2d3.lib.scs[typ], l_slcr20k_rf_v2d3.lib.scs[typ], io_rf_v2d3.lib.scs[tt], core_rf_v2d4.lib.scs[tt], mm180_zvt33_v113.lib.scs[tt], mm180_zvt18_v121.lib.scs[tt], mm180_res_v141.lib.scs[res_typ], mm180_reg33bpw_v123.lib.scs[tt], mm180_reg18_v124.lib.scs[tt ff ss fnsp snfp], mm180_reg18bpw_v123.lib.scs[tt], mm180_lvt18_v113.lib.scs[tt]
  MC: mm180_reg18_v124_mc_corner.lib.scs[mc], mm180_res_v141_mc_corner.lib.scs[mc], rnppo_rf_v2d4_mc_corner.lib.scs[mc], rnnpo_rf_v2d4_mc_corner.lib.scs[mc], varmis_18_rf_v2d3.lib.scs[typ], vardiop_rf_v2d3.lib.scs[typ], rnhr_rf_v2d4.lib.scs[typ], pad_rf_v2d3.lib.scs[typ], mm180_reg33_v114.lib.scs[tt], mm180_mimcap_v101.lib.scs[mimcaps_typ], mm180_bjt_v121.lib.scs[tt_bip], mimcapm_rf_v2d3.lib.scs[typ], l_slcr20k_rf_v2d3.lib.scs[typ], io_rf_v2d3.lib.scs[tt], core_rf_v2d4.lib.scs[tt], mm180_zvt33_v113.lib.scs[tt], mm180_zvt18_v121.lib.scs[tt], mm180_reg33bpw_v123.lib.scs[tt], mm180_reg18bpw_v123.lib.scs[tt], mm180_lvt33_v113.lib.scs[tt], mm180_lvt18_v113.lib.scs[tt]
Monte Carlo Sampling options: mcmethod=all, mcnumpoints=200
