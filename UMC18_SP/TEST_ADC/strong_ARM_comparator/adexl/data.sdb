ADE simulation setup
Run mode: Single Run, Sweeps and Corners
Tests:
  TEST_ADC:strong_ARM_comparator:1: TEST_ADC/strong_ARM_comparator/schematic, simulator spectre
Global variables:
  VCM = 0.9 (off)
  VDM = {Inclusion List}1m{Inclusion List} (off)
  sigma = 1
Corners:
  model folders: /home/m10912086/UM180FDKMFC0000OA_A02_EQ/Models/Spectre, /home/m10912086/UM180FDKMFC0000OA_A02_EQ/Models/Spectre/Monte_Carlo
  C0 (off): mm180_reg18_v124_mc_corner.lib.scs[tt_g]
  C1: varmis_18_rf_v2d3.lib.scs[typ], vardiop_rf_v2d3.lib.scs[typ], rnppo_rf_v2d4.lib.scs[typ], rnnpo_rf_v2d4.lib.scs[typ], rnhr_rf_v2d4.lib.scs[typ], pad_rf_v2d3.lib.scs[typ], mm180_zvt33_v113.lib.scs[tt], mm180_zvt18_v121.lib.scs[tt], mm180_res_v141.lib.scs[res_typ], mm180_reg33_v114.lib.scs[tt], mm180_reg33bpw_v123.lib.scs[tt], mm180_reg18_v124.lib.scs[tt ff ss snfp fnsp], mm180_reg18bpw_v123.lib.scs[tt], mm180_mimcap_v101.lib.scs[mimcaps_typ], mm180_lvt33_v113.lib.scs[tt], mm180_lvt18_v113.lib.scs[tt], mm180_bjt_v121.lib.scs[tt_bip], mimcapm_rf_v2d3.lib.scs[typ], l_slcr20k_rf_v2d3.lib.scs[typ], io_rf_v2d3.lib.scs[tt], core_rf_v2d4.lib.scs[tt]
