ADE simulation setup
Run mode: Single Run, Sweeps and Corners
Tests:
  TEST_ADC:IDEAL_CIFF:1: TEST_ADC/IDEAL_CIFF/schematic, simulator spectre
Global variables:
  TS = 100n
  CU = 100f
  N1 = 7
  N2 = 1
  VCM = 900m
  VDM = {Exclusion List}1.45{Exclusion List}{From/To}Logarithmic:0.5u:30:1.8{From/To}
