ADE simulation setup
Run mode: Monte Carlo Sampling
Tests:
  TEST_ADC:Comparator_Offset_TB:1: TEST_ADC/Comparator_Offset_TB/schematic, simulator spectre
Global variables:
  VOS = 0
  Ts = 100n
  sigma = 1
Corners (nominal off):
  model folders: /home/m10912086/UM180FDKMFC0000OA_A02_EQ/Models/Spectre/Monte_Carlo
  C0: mm180_reg18_v124_mc_corner.lib.scs[tt_g]
Monte Carlo Sampling options: mcmethod=mismatch, mcnumpoints=1000
