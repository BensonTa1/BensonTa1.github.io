//
simulator lang=spectre insensitive=yes
parameters mc_res_ma_nppo_rf=0
statistics {
mismatch {
vary mc_res_ma_nppo_rf dist=gauss std=1/1
 }
}
