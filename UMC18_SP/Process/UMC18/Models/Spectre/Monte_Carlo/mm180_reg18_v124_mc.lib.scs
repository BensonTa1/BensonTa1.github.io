simulator lang=spectre insensitive=yes
library mylib

section tt
parameters dtox_n_18_mm_t=0.0000e+00
parameters dxl_n_18_mm_t=0.0000e+00
parameters dxw_n_18_mm_t=0.0000e+00
parameters dvth0_n_18_mm_t=0.0000e+00
parameters du0_n_18_mm_t=0.0000e+00
parameters dlvth0_n_18_mm_t=0.0000e+00
parameters dwvth0_n_18_mm_t=0.0000e+00
parameters dwu0_n_18_mm_t=0.0000e+00
parameters dpvth0_n_18_mm_t=0.0000e+00
parameters dpvsat_n_18_mm_t=0.0000e+00
parameters dcgdo_n_18_mm_t=0.0000e+00
parameters dcgso_n_18_mm_t=0.0000e+00
parameters dcj_n_18_mm_t=0.0000e+00
parameters dcjsw_n_18_mm_t=0.0000e+00
parameters dcjgate_n_18_mm_t=0.0000e+00
parameters dtox_p_18_mm_t=0.0000e+00
parameters du0_p_18_mm_t=0.0000e+00
parameters dxl_p_18_mm_t=0.0000e+00
parameters dxw_p_18_mm_t=0.0000e+00
parameters dvth0_p_18_mm_t=0.0000e+00
parameters dlvth0_p_18_mm_t=0.0000e+00
parameters dwvth0_p_18_mm_t=0.0000e+00
parameters dpvth0_p_18_mm_t=0.0000e+00
parameters dpvsat_p_18_mm_t=0.0000e+00
parameters dcgdo_p_18_mm_t=0.0000e+00
parameters dcgso_p_18_mm_t=0.0000e+00
parameters dcj_p_18_mm_t=0.0000e+00
parameters dcjsw_p_18_mm_t=0.0000e+00
parameters dcjgate_p_18_mm_t=0.0000e+00

endsection tt

section ss
parameters dtox_n_18_mm_t=1.0000e-10
parameters dxl_n_18_mm_t=2.2000e-08
parameters dxw_n_18_mm_t=-2.0000e-08
parameters dvth0_n_18_mm_t=1.4500e-02
parameters du0_n_18_mm_t=-1.0000e+01
parameters dlvth0_n_18_mm_t=1.4000e-03
parameters dwvth0_n_18_mm_t=1.1000e-02
parameters dwu0_n_18_mm_t=-4.5000e+00
parameters dpvth0_n_18_mm_t=-1.0000e-03
parameters dpvsat_n_18_mm_t=1.4000e+02
parameters dcgdo_n_18_mm_t=-2.3500e-11
parameters dcgso_n_18_mm_t=-2.3500e-11
parameters dcj_n_18_mm_t=1.0300e-04
parameters dcjsw_n_18_mm_t=1.3400e-11
parameters dcjgate_n_18_mm_t=5.0000e-11
parameters dtox_p_18_mm_t=1.0000e-10
parameters du0_p_18_mm_t=-3.0000e+00
parameters dxl_p_18_mm_t=1.0000e-08
parameters dxw_p_18_mm_t=-2.0000e-08
parameters dvth0_p_18_mm_t=-1.4000e-02
parameters dlvth0_p_18_mm_t=0.0000e-00
parameters dwvth0_p_18_mm_t=-1.0000e-02
parameters dpvth0_p_18_mm_t=3.0000e-04
parameters dpvsat_p_18_mm_t=5.8000e+01
parameters dcgdo_p_18_mm_t=-2.0540e-11
parameters dcgso_p_18_mm_t=-2.0540e-11
parameters dcj_p_18_mm_t=1.1400e-04
parameters dcjsw_p_18_mm_t=1.7400e-11
parameters dcjgate_p_18_mm_t=4.2000e-11

endsection ss

section ff
parameters dtox_n_18_mm_t=-1.0000e-10
parameters dxl_n_18_mm_t=-1.3600e-08
parameters dxw_n_18_mm_t=2.0000e-08
parameters dvth0_n_18_mm_t=-1.4500e-02
parameters du0_n_18_mm_t=1.0000e+01
parameters dlvth0_n_18_mm_t=-7.0000e-04
parameters dwvth0_n_18_mm_t=-1.0100e-02
parameters dwu0_n_18_mm_t=2.0000e+00
parameters dpvth0_n_18_mm_t=6.5000e-04
parameters dpvsat_n_18_mm_t=-8.0000e+01
parameters dcgdo_n_18_mm_t=2.3500e-11
parameters dcgso_n_18_mm_t=2.3500e-11
parameters dcj_n_18_mm_t=-1.0300e-04
parameters dcjsw_n_18_mm_t=-1.3400e-11
parameters dcjgate_n_18_mm_t=-5.0000e-11
parameters dtox_p_18_mm_t=-1.0000e-10
parameters du0_p_18_mm_t=3.0000e+00
parameters dxl_p_18_mm_t=-8.0000e-09
parameters dxw_p_18_mm_t=1.5000e-08
parameters dvth0_p_18_mm_t=1.8000e-02
parameters dlvth0_p_18_mm_t=-1.0000e-03
parameters dwvth0_p_18_mm_t=8.5000e-03
parameters dpvth0_p_18_mm_t=1.0000e-05
parameters dpvsat_p_18_mm_t=-2.7000e+01
parameters dcgdo_p_18_mm_t=2.0540e-11
parameters dcgso_p_18_mm_t=2.0540e-11
parameters dcj_p_18_mm_t=-1.1400e-04
parameters dcjsw_p_18_mm_t=-1.7400e-11
parameters dcjgate_p_18_mm_t=-4.2000e-11

endsection ff

section snfp
parameters dtox_n_18_mm_t=0.0000e+00
parameters dxl_n_18_mm_t=1.1000e-08
parameters dxw_n_18_mm_t=-1.0000e-08
parameters dvth0_n_18_mm_t=1.3000e-02
parameters du0_n_18_mm_t=-5.0000e+00
parameters dlvth0_n_18_mm_t=1.1000e-03
parameters dwvth0_n_18_mm_t=4.7000e-03
parameters dwu0_n_18_mm_t=-2.0000e+00
parameters dpvth0_n_18_mm_t=-5.5000e-04
parameters dpvsat_n_18_mm_t=6.0000e+01
parameters dcgdo_n_18_mm_t=0.0000e+00
parameters dcgso_n_18_mm_t=0.0000e+00
parameters dcj_n_18_mm_t=1.0300e-04
parameters dcjsw_n_18_mm_t=1.3400e-11
parameters dcjgate_n_18_mm_t=5.0000e-11
parameters dtox_p_18_mm_t=0.0000e+00
parameters du0_p_18_mm_t=2.0000e+00
parameters dxl_p_18_mm_t=-4.0000e-09
parameters dxw_p_18_mm_t=1.0000e-08
parameters dvth0_p_18_mm_t=1.7000e-02
parameters dlvth0_p_18_mm_t=-3.0000e-04
parameters dwvth0_p_18_mm_t=3.5000e-03
parameters dpvth0_p_18_mm_t=9.0000e-05
parameters dpvsat_p_18_mm_t=-3.0000e+01
parameters dcgdo_p_18_mm_t=0.0000e+00
parameters dcgso_p_18_mm_t=0.0000e+00
parameters dcj_p_18_mm_t=-1.1400e-04
parameters dcjsw_p_18_mm_t=-1.7400e-11
parameters dcjgate_p_18_mm_t=-4.2000e-11

endsection snfp

section fnsp
parameters dtox_n_18_mm_t=0.0000e+00
parameters dxl_n_18_mm_t=-9.5000e-09
parameters dxw_n_18_mm_t=1.0000e-08
parameters du0_n_18_mm_t=6.0000e+00
parameters dvth0_n_18_mm_t=-1.2300e-02
parameters dlvth0_n_18_mm_t=-7.0000e-04
parameters dwvth0_n_18_mm_t=-4.6000e-03
parameters dwu0_n_18_mm_t=1.7000e+00
parameters dpvth0_n_18_mm_t=4.1000e-04
parameters dpvsat_n_18_mm_t=-7.0000e+01
parameters dcgdo_n_18_mm_t=0.0000e+00
parameters dcgso_n_18_mm_t=0.0000e+00
parameters dcj_n_18_mm_t=-1.0300e-04
parameters dcjsw_n_18_mm_t=-1.3400e-11
parameters dcjgate_n_18_mm_t=-5.0000e-11
parameters dtox_p_18_mm_t=0.0000e+00
parameters dxl_p_18_mm_t=4.5000e-09
parameters dxw_p_18_mm_t=-1.0000e-08
parameters dvth0_p_18_mm_t=-1.3000e-02
parameters du0_p_18_mm_t=-2.5000e+00
parameters dlvth0_p_18_mm_t=-3.0000e-04
parameters dwvth0_p_18_mm_t=-5.0000e-03
parameters dpvth0_p_18_mm_t=1.3000e-04
parameters dpvsat_p_18_mm_t=3.4000e+01
parameters dcgdo_p_18_mm_t=0.0000e+00
parameters dcgso_p_18_mm_t=0.0000e+00
parameters dcj_p_18_mm_t=1.1400e-04
parameters dcjsw_p_18_mm_t=1.7400e-11
parameters dcjgate_p_18_mm_t=4.2000e-11

endsection fnsp

section tt_g
parameters dtox_n_18_mm_g=0.0000e+00
parameters dxl_n_18_mm_g=0.0000e+00
parameters dxw_n_18_mm_g=0.0000e+00
parameters dvth0_n_18_mm_g=0.0000e+00
parameters du0_n_18_mm_g=0.0000e+00
parameters dlvth0_n_18_mm_g=0.0000e+00
parameters dwvth0_n_18_mm_g=0.0000e+00
parameters dwu0_n_18_mm_g=0.0000e+00
parameters dpvth0_n_18_mm_g=0.0000e+00
parameters dpvsat_n_18_mm_g=0.0000e+00
parameters dcgdo_n_18_mm_g=0.0000e+00
parameters dcgso_n_18_mm_g=0.0000e+00
parameters dcj_n_18_mm_g=0.0000e+00
parameters dcjsw_n_18_mm_g=0.0000e+00
parameters dcjgate_n_18_mm_g=0.0000e+00
parameters dtox_p_18_mm_g=0.0000e+00
parameters du0_p_18_mm_g=0.0000e+00
parameters dxl_p_18_mm_g=0.0000e+00
parameters dxw_p_18_mm_g=0.0000e+00
parameters dvth0_p_18_mm_g=0.0000e+00
parameters dlvth0_p_18_mm_g=0.0000e+00
parameters dwvth0_p_18_mm_g=0.0000e+00
parameters dpvth0_p_18_mm_g=0.0000e+00
parameters dpvsat_p_18_mm_g=0.0000e+00
parameters dcgdo_p_18_mm_g=0.0000e+00
parameters dcgso_p_18_mm_g=0.0000e+00
parameters dcj_p_18_mm_g=0.0000e+00
parameters dcjsw_p_18_mm_g=0.0000e+00
parameters dcjgate_p_18_mm_g=0.0000e+00

endsection tt_g

section ss_g
parameters dtox_n_18_mm_g=1.0000e-10
parameters dxl_n_18_mm_g=2.2000e-08
parameters dxw_n_18_mm_g=-2.0000e-08
parameters dvth0_n_18_mm_g=1.4450e-02
parameters du0_n_18_mm_g=-1.0000e+01
parameters dlvth0_n_18_mm_g=1.4000e-03
parameters dwvth0_n_18_mm_g=1.1000e-02
parameters dwu0_n_18_mm_g=-4.5000e+00
parameters dpvth0_n_18_mm_g=-1.0000e-03
parameters dpvsat_n_18_mm_g=1.4000e+02
parameters dcgdo_n_18_mm_g=-2.3500e-11
parameters dcgso_n_18_mm_g=-2.3500e-11
parameters dcj_n_18_mm_g=1.0300e-04
parameters dcjsw_n_18_mm_g=1.3400e-11
parameters dcjgate_n_18_mm_g=5.0000e-11
parameters dtox_p_18_mm_g=1.0000e-10
parameters du0_p_18_mm_g=-2.9800e+00
parameters dxl_p_18_mm_g=1.0000e-08
parameters dxw_p_18_mm_g=-2.0000e-08
parameters dvth0_p_18_mm_g=-1.3970e-02
parameters dlvth0_p_18_mm_g=0.0000e-00
parameters dwvth0_p_18_mm_g=-1.0000e-02
parameters dpvth0_p_18_mm_g=3.0000e-04
parameters dpvsat_p_18_mm_g=5.8000e+01
parameters dcgdo_p_18_mm_g=-2.0540e-11
parameters dcgso_p_18_mm_g=-2.0540e-11
parameters dcj_p_18_mm_g=1.1400e-04
parameters dcjsw_p_18_mm_g=1.7400e-11
parameters dcjgate_p_18_mm_g=4.2000e-11

endsection ss_g

section ff_g
parameters dtox_n_18_mm_g=-1.0000e-10
parameters dxl_n_18_mm_g=-1.3600e-08
parameters dxw_n_18_mm_g=2.0000e-08
parameters dvth0_n_18_mm_g=-1.4450e-02
parameters du0_n_18_mm_g=1.0000e+01
parameters dlvth0_n_18_mm_g=-7.0000e-04
parameters dwvth0_n_18_mm_g=-1.0100e-02
parameters dwu0_n_18_mm_g=2.0000e+00
parameters dpvth0_n_18_mm_g=6.5000e-04
parameters dpvsat_n_18_mm_g=-8.0000e+01
parameters dcgdo_n_18_mm_g=2.3500e-11
parameters dcgso_n_18_mm_g=2.3500e-11
parameters dcj_n_18_mm_g=-1.0300e-04
parameters dcjsw_n_18_mm_g=-1.3400e-11
parameters dcjgate_n_18_mm_g=-5.0000e-11
parameters dtox_p_18_mm_g=-1.0000e-10
parameters du0_p_18_mm_g=2.9800e+00
parameters dxl_p_18_mm_g=-8.0000e-09
parameters dxw_p_18_mm_g=1.5000e-08
parameters dvth0_p_18_mm_g=1.7970e-02
parameters dlvth0_p_18_mm_g=-1.0000e-03
parameters dwvth0_p_18_mm_g=8.5000e-03
parameters dpvth0_p_18_mm_g=1.0000e-05
parameters dpvsat_p_18_mm_g=-2.7000e+01
parameters dcgdo_p_18_mm_g=2.0540e-11
parameters dcgso_p_18_mm_g=2.0540e-11
parameters dcj_p_18_mm_g=-1.1400e-04
parameters dcjsw_p_18_mm_g=-1.7400e-11
parameters dcjgate_p_18_mm_g=-4.2000e-11

endsection ff_g

section snfp_g
parameters dtox_n_18_mm_g=0.0000e+00
parameters dxl_n_18_mm_g=1.1000e-08
parameters dxw_n_18_mm_g=-1.0000e-08
parameters dvth0_n_18_mm_g=1.2950e-02
parameters du0_n_18_mm_g=-5.0000e+00
parameters dlvth0_n_18_mm_g=1.1000e-03
parameters dwvth0_n_18_mm_g=4.7000e-03
parameters dwu0_n_18_mm_g=-2.0000e+00
parameters dpvth0_n_18_mm_g=-5.5000e-04
parameters dpvsat_n_18_mm_g=6.0000e+01
parameters dcgdo_n_18_mm_g=0.0000e+00
parameters dcgso_n_18_mm_g=0.0000e+00
parameters dcj_n_18_mm_g=1.0300e-04
parameters dcjsw_n_18_mm_g=1.3400e-11
parameters dcjgate_n_18_mm_g=5.0000e-11
parameters dtox_p_18_mm_g=0.0000e+00
parameters du0_p_18_mm_g=2.0000e+00
parameters dxl_p_18_mm_g=-4.0000e-09
parameters dxw_p_18_mm_g=1.0000e-08
parameters dvth0_p_18_mm_g=1.6900e-02
parameters dlvth0_p_18_mm_g=-3.0000e-04
parameters dwvth0_p_18_mm_g=3.5000e-03
parameters dpvth0_p_18_mm_g=9.0000e-05
parameters dpvsat_p_18_mm_g=-3.0000e+01
parameters dcgdo_p_18_mm_g=0.0000e+00
parameters dcgso_p_18_mm_g=0.0000e+00
parameters dcj_p_18_mm_g=-1.1400e-04
parameters dcjsw_p_18_mm_g=-1.7400e-11
parameters dcjgate_p_18_mm_g=-4.2000e-11

endsection snfp_g

section fnsp_g
parameters dtox_n_18_mm_g=0.0000e+00
parameters dxl_n_18_mm_g=-9.5000e-09
parameters dxw_n_18_mm_g=1.0000e-08
parameters du0_n_18_mm_g=6.0000e+00
parameters dvth0_n_18_mm_g=-1.2250e-02
parameters dlvth0_n_18_mm_g=-7.0000e-04
parameters dwvth0_n_18_mm_g=-4.6000e-03
parameters dwu0_n_18_mm_g=1.7000e+00
parameters dpvth0_n_18_mm_g=4.1000e-04
parameters dpvsat_n_18_mm_g=-7.0000e+01
parameters dcgdo_n_18_mm_g=0.0000e+00
parameters dcgso_n_18_mm_g=0.0000e+00
parameters dcj_n_18_mm_g=-1.0300e-04
parameters dcjsw_n_18_mm_g=-1.3400e-11
parameters dcjgate_n_18_mm_g=-5.0000e-11
parameters dtox_p_18_mm_g=0.0000e+00
parameters dxl_p_18_mm_g=4.5000e-09
parameters dxw_p_18_mm_g=-1.0000e-08
parameters dvth0_p_18_mm_g=-1.2900e-02
parameters du0_p_18_mm_g=-2.5000e+00
parameters dlvth0_p_18_mm_g=-3.0000e-04
parameters dwvth0_p_18_mm_g=-5.0000e-03
parameters dpvth0_p_18_mm_g=1.3000e-04
parameters dpvsat_p_18_mm_g=3.4000e+01
parameters dcgdo_p_18_mm_g=0.0000e+00
parameters dcgso_p_18_mm_g=0.0000e+00
parameters dcj_p_18_mm_g=1.1400e-04
parameters dcjsw_p_18_mm_g=1.7400e-11
parameters dcjgate_p_18_mm_g=4.2000e-11

endsection fnsp_g
endlibrary mylib
