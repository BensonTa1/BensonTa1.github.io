simulator lang=spectre insensitive=yes
parameters  mc_bf_pnp_50x50 = 0
parameters  mc_is_pnp_50x50 = 0
parameters  mc_bf_pnp_100x100 = 0
parameters  mc_is_pnp_100x100 = 0
statistics {
mismatch {
vary mc_bf_pnp_50x50 dist=gauss std=1/1
vary mc_is_pnp_50x50 dist=gauss std=1/1
vary mc_bf_pnp_100x100 dist=gauss std=1/1
vary mc_is_pnp_100x100 dist=gauss std=1/1
 }
}
