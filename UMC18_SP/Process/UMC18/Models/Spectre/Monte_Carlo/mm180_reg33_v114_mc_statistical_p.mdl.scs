simulator lang=spectre insensitive=yes
//
parameters alpha_n_33_mm = 0.2
parameters alpha_p_33_mm = 0.2

parameters ap1_np_33_mm_xx = 0
parameters ap2_np_33_mm_xx = 0
parameters ap3_np_33_mm_xx = 0
parameters ap4_np_33_mm_xx = 0
parameters ap5_np_33_mm_xx = 0
statistics {
process {
vary ap1_np_33_mm_xx dist=gauss std=sigma/3
vary ap2_np_33_mm_xx dist=gauss std=sigma/3
vary ap3_np_33_mm_xx dist=gauss std=sigma/3
vary ap4_np_33_mm_xx dist=gauss std=sigma/3
vary ap5_np_33_mm_xx dist=gauss std=sigma/3
 }
}
parameters a1_np_33_mm = ap1_np_33_mm_xx
parameters a2_np_33_mm = ap2_np_33_mm_xx
parameters a3_np_33_mm = ap3_np_33_mm_xx
parameters a4_np_33_mm = ap4_np_33_mm_xx
parameters a5_np_33_mm = ap5_np_33_mm_xx
parameters comp1_np_33_mm	= 6.62321468806189
parameters comp2_np_33_mm	= 4.43614955562083
parameters comp3_np_33_mm	= 0.549506766337999
parameters comp4_np_33_mm	= 0.389418322314176
parameters comp5_np_33_mm	= 1.11924119172638e-14
parameters 	dtox_n_33_mm_g	  =	alpha_n_33_mm*(1.06295603468138e-10*a1_np_33_mm*comp1_np_33_mm+1.38096243370356e-11*a2_np_33_mm*comp2_np_33_mm+-2.98719192387349e-11*a3_np_33_mm*comp3_np_33_mm+-4.7027732028164e-11*a4_np_33_mm*comp4_np_33_mm+1.44432879593303e-10*a5_np_33_mm*comp5_np_33_mm)
parameters 	dlint_n_33_mm_g	  =	alpha_n_33_mm*(-2.4726761113281e-09*a1_np_33_mm*comp1_np_33_mm+2.40561916502988e-09*a2_np_33_mm*comp2_np_33_mm+3.59017071547066e-10*a3_np_33_mm*comp3_np_33_mm+-4.0990026640998e-09*a4_np_33_mm*comp4_np_33_mm+-1.27312651287946e-09*a5_np_33_mm*comp5_np_33_mm)
parameters 	dwint_n_33_mm_g	  =	alpha_n_33_mm*(1.26051863551703e-09*a1_np_33_mm*comp1_np_33_mm+-1.2788397922297e-09*a2_np_33_mm*comp2_np_33_mm+3.67877242110656e-09*a3_np_33_mm*comp3_np_33_mm+-4.34301355358713e-10*a4_np_33_mm*comp4_np_33_mm+-2.64725535464419e-10*a5_np_33_mm*comp5_np_33_mm)
parameters 	dvth0_n_33_mm_g	  =	alpha_n_33_mm*(1.12682144720383e-02*a1_np_33_mm*comp1_np_33_mm+-9.82696956130786e-03*a2_np_33_mm*comp2_np_33_mm+1.45512700143692e-03*a3_np_33_mm*comp3_np_33_mm+-1.98522093297056e-02*a4_np_33_mm*comp4_np_33_mm+5.35157925771174e-03*a5_np_33_mm*comp5_np_33_mm)
parameters 	dcgdo_n_33_mm_g	  =	alpha_n_33_mm*(-5.73996258727945e-12*a1_np_33_mm*comp1_np_33_mm+-7.45719714199924e-13*a2_np_33_mm*comp2_np_33_mm+1.61308363889169e-12*a3_np_33_mm*comp3_np_33_mm+2.53949752952085e-12*a4_np_33_mm*comp4_np_33_mm+1.18130104828392e-12*a5_np_33_mm*comp5_np_33_mm)
parameters 	dcgso_n_33_mm_g	  =	alpha_n_33_mm*(-5.73996258727945e-12*a1_np_33_mm*comp1_np_33_mm+-7.45719714199924e-13*a2_np_33_mm*comp2_np_33_mm+1.61308363889169e-12*a3_np_33_mm*comp3_np_33_mm+2.53949752952085e-12*a4_np_33_mm*comp4_np_33_mm+1.18130104828392e-12*a5_np_33_mm*comp5_np_33_mm)
parameters 	du0_n_33_mm_g	  =	alpha_n_33_mm*(0*a1_np_33_mm*comp1_np_33_mm+0*a2_np_33_mm*comp2_np_33_mm+0*a3_np_33_mm*comp3_np_33_mm+0*a4_np_33_mm*comp4_np_33_mm+0*a5_np_33_mm*comp5_np_33_mm)
parameters 	drdsw_n_33_mm_g	  =	alpha_n_33_mm*(0*a1_np_33_mm*comp1_np_33_mm+0*a2_np_33_mm*comp2_np_33_mm+0*a3_np_33_mm*comp3_np_33_mm+0*a4_np_33_mm*comp4_np_33_mm+0*a5_np_33_mm*comp5_np_33_mm)
parameters 	dpvth0_n_33_mm_g	  =	alpha_n_33_mm*(-3.34781328347346e-16*a1_np_33_mm*comp1_np_33_mm+6.85251492063232e-16*a2_np_33_mm*comp2_np_33_mm+4.93340154117156e-16*a3_np_33_mm*comp3_np_33_mm+-5.97744614146693e-16*a4_np_33_mm*comp4_np_33_mm+-2.48428288897457e-16*a5_np_33_mm*comp5_np_33_mm)
parameters 	dwwl_n_33_mm_g	  =	alpha_n_33_mm*(1.51156770509051e-23*a1_np_33_mm*comp1_np_33_mm+-2.97417318653423e-23*a2_np_33_mm*comp2_np_33_mm+-3.03614536903336e-23*a3_np_33_mm*comp3_np_33_mm+2.43240137368363e-23*a4_np_33_mm*comp4_np_33_mm+-2.15739551863485e-23*a5_np_33_mm*comp5_np_33_mm)
parameters 	dtox_p_33_mm_g	  =	alpha_p_33_mm*(1.06295603468138e-10*a1_np_33_mm*comp1_np_33_mm+1.38096243370356e-11*a2_np_33_mm*comp2_np_33_mm+-2.98719192387348e-11*a3_np_33_mm*comp3_np_33_mm+-4.70277320281636e-11*a4_np_33_mm*comp4_np_33_mm+1.47642683786708e-10*a5_np_33_mm*comp5_np_33_mm)
parameters 	dlint_p_33_mm_g	  =	alpha_p_33_mm*(-2.35953037449957e-09*a1_np_33_mm*comp1_np_33_mm+-2.84064749710151e-09*a2_np_33_mm*comp2_np_33_mm+-1.02766155774443e-09*a3_np_33_mm*comp3_np_33_mm+-2.36903755707158e-09*a4_np_33_mm*comp4_np_33_mm+-1.80387248332721e-10*a5_np_33_mm*comp5_np_33_mm)
parameters 	dwint_p_33_mm_g	  =	alpha_p_33_mm*(3.07316946174e-09*a1_np_33_mm*comp1_np_33_mm+2.78693830100701e-09*a2_np_33_mm*comp2_np_33_mm+5.03470177167302e-09*a3_np_33_mm*comp3_np_33_mm+5.85544522830842e-09*a4_np_33_mm*comp4_np_33_mm+3.09848032821716e-10*a5_np_33_mm*comp5_np_33_mm)
parameters 	dvth0_p_33_mm_g	  =	alpha_p_33_mm*(-1.02614261581186e-02*a1_np_33_mm*comp1_np_33_mm+-7.73237348593698e-03*a2_np_33_mm*comp2_np_33_mm+2.74521877970072e-03*a3_np_33_mm*comp3_np_33_mm+3.67202647070814e-03*a4_np_33_mm*comp4_np_33_mm+0.024603407757092*a5_np_33_mm*comp5_np_33_mm)
parameters 	dcgdo_p_33_mm_g	  =	alpha_p_33_mm*(-5.52737138034317e-12*a1_np_33_mm*comp1_np_33_mm+-7.18100465525853e-13*a2_np_33_mm*comp2_np_33_mm+1.55333980041423e-12*a3_np_33_mm*comp3_np_33_mm+2.44544206546457e-12*a4_np_33_mm*comp4_np_33_mm+2.74697201698167e-12*a5_np_33_mm*comp5_np_33_mm)
parameters 	dcgso_p_33_mm_g	  =	alpha_p_33_mm*(-5.52737138034317e-12*a1_np_33_mm*comp1_np_33_mm+-7.18100465525853e-13*a2_np_33_mm*comp2_np_33_mm+1.55333980041423e-12*a3_np_33_mm*comp3_np_33_mm+2.44544206546457e-12*a4_np_33_mm*comp4_np_33_mm+2.74697201698167e-12*a5_np_33_mm*comp5_np_33_mm)
parameters 	du0_p_33_mm_g	  =	alpha_p_33_mm*(0*a1_np_33_mm*comp1_np_33_mm+0*a2_np_33_mm*comp2_np_33_mm+0*a3_np_33_mm*comp3_np_33_mm+0*a4_np_33_mm*comp4_np_33_mm+0*a5_np_33_mm*comp5_np_33_mm)
parameters 	drdsw_p_33_mm_g	  =	alpha_p_33_mm*(0*a1_np_33_mm*comp1_np_33_mm+0*a2_np_33_mm*comp2_np_33_mm+0*a3_np_33_mm*comp3_np_33_mm+0*a4_np_33_mm*comp4_np_33_mm+0*a5_np_33_mm*comp5_np_33_mm)
parameters 	dpvth0_p_33_mm_g	  =	alpha_p_33_mm*(4.47981743072858e-05*a1_np_33_mm*comp1_np_33_mm+2.46397998216844e-04*a2_np_33_mm*comp2_np_33_mm+-7.15554644781675e-05*a3_np_33_mm*comp3_np_33_mm+6.95206591624116e-05*a4_np_33_mm*comp4_np_33_mm+-1.16845368418492e-05*a5_np_33_mm*comp5_np_33_mm)
parameters 	dwwl_p_33_mm_g	  =	alpha_p_33_mm*(1.95698756055897e-28*a1_np_33_mm*comp1_np_33_mm+1.499213439429e-27*a2_np_33_mm*comp2_np_33_mm+-6.50985357547185e-28*a3_np_33_mm*comp3_np_33_mm+1.15466918372069e-28*a4_np_33_mm*comp4_np_33_mm+8.88471659001099e-28*a5_np_33_mm*comp5_np_33_mm)
