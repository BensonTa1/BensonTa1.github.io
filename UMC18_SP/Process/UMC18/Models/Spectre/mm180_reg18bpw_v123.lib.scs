simulator lang=spectre insensitive=yes
library mylib

section tt
parameters dtox_n_bpw_18_mm=0.0000e+00
parameters dxl_n_bpw_18_mm=0.0000e+00
parameters dxw_n_bpw_18_mm=0.0000e+00
parameters dvth0_n_bpw_18_mm=0.0000e+00
parameters du0_n_bpw_18_mm=0.0000e+00
parameters dlvth0_n_bpw_18_mm=0.0000e+00
parameters dwvth0_n_bpw_18_mm=0.0000e+00
parameters dwu0_n_bpw_18_mm=0.0000e+00
parameters dpvth0_n_bpw_18_mm=0.0000e+00
parameters dpvsat_n_bpw_18_mm=0.0000e+00
parameters dcgdo_n_bpw_18_mm=0.0000e+00
parameters dcgso_n_bpw_18_mm=0.0000e+00
parameters dcj_n_bpw_18_mm=0.0000e+00
parameters dcjsw_n_bpw_18_mm=0.0000e+00
parameters dcjgate_n_bpw_18_mm=0.0000e+00

include "./mm180_reg18bpw_v123.mdl.scs"

endsection tt

section ss
parameters dtox_n_bpw_18_mm=1.0000e-10
parameters dxl_n_bpw_18_mm=2.2000e-08
parameters dxw_n_bpw_18_mm=-2.0000e-08
parameters dvth0_n_bpw_18_mm=1.4500e-02
parameters du0_n_bpw_18_mm=-1.0000e+01
parameters dlvth0_n_bpw_18_mm=1.4000e-03
parameters dwvth0_n_bpw_18_mm=1.1000e-02
parameters dwu0_n_bpw_18_mm=-4.5000e+00
parameters dpvth0_n_bpw_18_mm=-1.0000e-03
parameters dpvsat_n_bpw_18_mm=1.4000e+02
parameters dcgdo_n_bpw_18_mm=-2.3500e-11
parameters dcgso_n_bpw_18_mm=-2.3500e-11
parameters dcj_n_bpw_18_mm=1.0300e-04
parameters dcjsw_n_bpw_18_mm=1.3400e-11
parameters dcjgate_n_bpw_18_mm=5.0000e-11

include "./mm180_reg18bpw_v123.mdl.scs"

endsection ss

section ff
parameters dtox_n_bpw_18_mm=-1.0000e-10
parameters dxl_n_bpw_18_mm=-1.3600e-08
parameters dxw_n_bpw_18_mm=2.0000e-08
parameters dvth0_n_bpw_18_mm=-1.4500e-02
parameters du0_n_bpw_18_mm=1.0000e+01
parameters dlvth0_n_bpw_18_mm=-7.0000e-04
parameters dwvth0_n_bpw_18_mm=-1.0100e-02
parameters dwu0_n_bpw_18_mm=2.0000e+00
parameters dpvth0_n_bpw_18_mm=6.5000e-04
parameters dpvsat_n_bpw_18_mm=-8.0000e+01
parameters dcgdo_n_bpw_18_mm=2.3500e-11
parameters dcgso_n_bpw_18_mm=2.3500e-11
parameters dcj_n_bpw_18_mm=-1.0300e-04
parameters dcjsw_n_bpw_18_mm=-1.3400e-11
parameters dcjgate_n_bpw_18_mm=-5.0000e-11

include "./mm180_reg18bpw_v123.mdl.scs"

endsection ff

section snfp
parameters dtox_n_bpw_18_mm=0.0000e+00
parameters dxl_n_bpw_18_mm=1.1000e-08
parameters dxw_n_bpw_18_mm=-1.0000e-08
parameters dvth0_n_bpw_18_mm=1.3000e-02
parameters du0_n_bpw_18_mm=-5.0000e+00
parameters dlvth0_n_bpw_18_mm=1.1000e-03
parameters dwvth0_n_bpw_18_mm=4.7000e-03
parameters dwu0_n_bpw_18_mm=-2.0000e+00
parameters dpvth0_n_bpw_18_mm=-5.5000e-04
parameters dpvsat_n_bpw_18_mm=6.0000e+01
parameters dcgdo_n_bpw_18_mm=0.0000e+00
parameters dcgso_n_bpw_18_mm=0.0000e+00
parameters dcj_n_bpw_18_mm=1.0300e-04
parameters dcjsw_n_bpw_18_mm=1.3400e-11
parameters dcjgate_n_bpw_18_mm=5.0000e-11

include "./mm180_reg18bpw_v123.mdl.scs"

endsection snfp

section fnsp
parameters dtox_n_bpw_18_mm=0.0000e+00
parameters dxl_n_bpw_18_mm=-9.5000e-09
parameters dxw_n_bpw_18_mm=1.0000e-08
parameters du0_n_bpw_18_mm=6.0000e+00
parameters dvth0_n_bpw_18_mm=-1.2300e-02
parameters dlvth0_n_bpw_18_mm=-7.0000e-04
parameters dwvth0_n_bpw_18_mm=-4.6000e-03
parameters dwu0_n_bpw_18_mm=1.7000e+00
parameters dpvth0_n_bpw_18_mm=4.1000e-04
parameters dpvsat_n_bpw_18_mm=-7.0000e+01
parameters dcgdo_n_bpw_18_mm=0.0000e+00
parameters dcgso_n_bpw_18_mm=0.0000e+00
parameters dcj_n_bpw_18_mm=-1.0300e-04
parameters dcjsw_n_bpw_18_mm=-1.3400e-11
parameters dcjgate_n_bpw_18_mm=-5.0000e-11

include "./mm180_reg18bpw_v123.mdl.scs"

endsection fnsp
endlibrary mylib
