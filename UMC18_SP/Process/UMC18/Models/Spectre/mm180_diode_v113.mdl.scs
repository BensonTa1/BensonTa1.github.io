//  *****************************************************************************************
simulator lang=spectre insensitive=yes
//                           0.18um MIXEDMODE N+/PWELL Diode Model
//            *
//  ****************************************************************************************
model dion_mm diode
+ level=1                   area=8e-09                perim=0.00036
+ is=2.82e-07               isw=3.33e-13              n=1.03
+ rs=4e-08                  ik=2.3e+04                ikp=1230
+ bv=9.22                   ibv=1e-3                  tnom=27
+ tlev=1                    eg=1.18                   xti=3.0
+ trs=1e-06                 cjo=0.00119                mj=0.515
+ cta  = 0.000919        ctp=0.000914        pta=0.00158
+ ptp  = 0.000924
+ pb=0.79                   cjsw=1.6e-10              mjsw=0.381
+ vjsw=0.705                tlevc=1                   imax=1e+14

//  ****************************************************************************************
//                           0.18um MIXEDMODE P+/NWELL Diode Model
//            *
//  ****************************************************************************************
model diop_mm diode
+ level=1                   area=8e-09                perim=0.00036
+ is=1.17e-07               isw=2.1e-13               n=1.01
+ rs=3.1e-08                ik=3.6e+04                ikp=1270
+ bv=9.11                   ibv=1e-3                  tnom=27
+ tlev=1                    eg=1.17                   xti=3
+ trs=0.00049               cjo=0.00114                mj=0.395
+ cta=0.001                 ctp=7.53e-04
+ pta=1.55e-03              ptp=1.24e-03
+ pb=0.762                  cjsw=1.74e-10             mjsw=0.324
+ vjsw=0.665                tlevc=1                   imax=1e+14
//
//  ****************************************************************************************
//                         0.18um MIXEDMODE NWELL/PSUB Diode Model
//            *
//  ****************************************************************************************
//
model dionw_mm diode
+ level=1                   area=9.72e-08             perim=0.00234
+ is=4.204e-06              isw=3.231e-12             n=1.02
+ rs=9.223e-06              ik=400                    ikp=3.4e+04
+ bv=14.38                  ibv=1e-3                  tnom=27
+ tlev=1                    eg=1.17                   xti=3
+ trs=0.00249               cjo=0.000107               mj=0.458
+ pb=0.75                   cjsw=2.4e-11              mjsw=0.384
+ vjsw=0.75                 tlevc=1                   imax=1e+14
//
