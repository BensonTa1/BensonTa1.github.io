simulator lang=spectre insensitive=yes
library core_rf

section tt
parameters dcd_n_18_rf=0
parameters dcgs_n_18_rf=0
parameters drgate_n_18_rf=0
parameters dtox_n_18_rf=0.0000e+00
parameters dxl_n_18_rf=0.0000e+00
parameters dxw_n_18_rf=0.0000e+00
parameters dvth0_n_18_rf=0.0000e+00
parameters du0_n_18_rf=0.0000e+00
parameters dlvth0_n_18_rf=0.0000e+00
parameters dwvth0_n_18_rf=0.0000e+00
parameters dwu0_n_18_rf=0.0000e+00
parameters dpvth0_n_18_rf=0.0000e+00
parameters dpvsat_n_18_rf=0.0000e+00
parameters dcf_n_18_rf=0.0000e+00
parameters dcgdo_n_18_rf=0.0000e+00
parameters dcgdl_n_18_rf=0.0000e+00
parameters dcgso_n_18_rf=0.0000e+00
parameters dcgsl_n_18_rf=0.0000e+00
parameters dcj_n_18_rf=0.0000e+00
parameters dcjsw_n_18_rf=0.0000e+00
parameters dcjgate_n_18_rf=0.0000e+00

parameters dcd_p_18_rf=0
parameters dcgs_p_18_rf=0
parameters drgate_p_18_rf=0
parameters dcgdl_p_18_rf=0.0000e+00
parameters dcgsl_p_18_rf=0.0000e+00
parameters dcf_p_18_rf=0.0000e+00
parameters dtox_p_18_rf=0.0000e+00
parameters du0_p_18_rf=0.0000e+00
parameters dxl_p_18_rf=0.0000e+00
parameters dxw_p_18_rf=0.0000e+00
parameters dvth0_p_18_rf=0.0000e+00
parameters dlvth0_p_18_rf=0.0000e+00
parameters dwvth0_p_18_rf=0.0000e+00
parameters dpvth0_p_18_rf=0.0000e+00
parameters dpvsat_p_18_rf=0.0000e+00
parameters dcgdo_p_18_rf=0.0000e+00
parameters dcgso_p_18_rf=0.0000e+00
parameters dcj_p_18_rf=0.0000e+00
parameters dcjsw_p_18_rf=0.0000e+00
parameters dcjgate_p_18_rf=0.0000e+00

include "./core_rf_v2d4.mdl.scs"

endsection tt

section ss
parameters dcd_n_18_rf=0.1
parameters dcgs_n_18_rf=0.15
parameters drgate_n_18_rf=0.35
parameters dtox_n_18_rf=1.0000e-10
parameters dxl_n_18_rf=2.2000e-08
parameters dxw_n_18_rf=-2.0000e-08
parameters dvth0_n_18_rf=1.4500e-02
parameters du0_n_18_rf=-1.0000e+01
parameters dlvth0_n_18_rf=1.4000e-03
parameters dwvth0_n_18_rf=1.1000e-02
parameters dwu0_n_18_rf=-4.5000e+00
parameters dpvth0_n_18_rf=-1.0000e-03
parameters dpvsat_n_18_rf=1.4000e+02
parameters dcgdo_n_18_rf=-0.1
parameters dcgso_n_18_rf=-0.1
parameters dcgdl_n_18_rf=-0.1
parameters dcgsl_n_18_rf=-0.1
parameters dcf_n_18_rf=0.15
parameters dcj_n_18_rf=0.1
parameters dcjsw_n_18_rf=0.1
parameters dcjgate_n_18_rf=0.1

parameters dcd_p_18_rf=0.1
parameters dcgs_p_18_rf=0.15
parameters drgate_p_18_rf=0.35
parameters dcgdl_p_18_rf=-0.1
parameters dcgsl_p_18_rf=-0.1
parameters dcf_p_18_rf=0.15
parameters dtox_p_18_rf=1.0000e-10
parameters du0_p_18_rf=-0.0e+00
parameters dxl_p_18_rf=1.0000e-08
parameters dxw_p_18_rf=-2.0000e-08
parameters dvth0_p_18_rf=-1.4000e-02
parameters dlvth0_p_18_rf=0.0000e-00
parameters dwvth0_p_18_rf=-1.0000e-02
parameters dpvth0_p_18_rf=3.0000e-04
parameters dpvsat_p_18_rf=4.6000e+01
parameters dcgdo_p_18_rf=-0.1
parameters dcgso_p_18_rf=-0.1
parameters dcj_p_18_rf=0.1
parameters dcjsw_p_18_rf=0.1
parameters dcjgate_p_18_rf=0.1

include "./core_rf_v2d4.mdl.scs"

endsection ss

section ff
parameters dcd_n_18_rf=-0.1
parameters dcgs_n_18_rf=-0.15
parameters drgate_n_18_rf=-0.35
parameters dtox_n_18_rf=-1.0000e-10
parameters dxl_n_18_rf=-1.3600e-08
parameters dxw_n_18_rf=2.0000e-08
parameters dvth0_n_18_rf=-1.4500e-02
parameters du0_n_18_rf=1.0000e+01
parameters dlvth0_n_18_rf=-7.0000e-04
parameters dwvth0_n_18_rf=-1.0100e-02
parameters dwu0_n_18_rf=2.0000e+00
parameters dpvth0_n_18_rf=6.5000e-04
parameters dpvsat_n_18_rf=-8.0000e+01
parameters dcgdo_n_18_rf=0.1
parameters dcgso_n_18_rf=0.1
parameters dcgdl_n_18_rf=0.1
parameters dcgsl_n_18_rf=0.1
parameters dcf_n_18_rf=-0.15
parameters dcj_n_18_rf=-0.1
parameters dcjsw_n_18_rf=-0.1
parameters dcjgate_n_18_rf=-0.1

parameters dcd_p_18_rf=-0.1
parameters dcgs_p_18_rf=-0.15
parameters drgate_p_18_rf=-0.35
parameters dcgdl_p_18_rf=0.1
parameters dcgsl_p_18_rf=0.1
parameters dcf_p_18_rf=-0.15
parameters dtox_p_18_rf=-1.0000e-10
parameters du0_p_18_rf=0
parameters dxl_p_18_rf=-8.0000e-09
parameters dxw_p_18_rf=1.5000e-08
parameters dvth0_p_18_rf=1.8000e-02
parameters dlvth0_p_18_rf=-1.0000e-03
parameters dwvth0_p_18_rf=8.5000e-03
parameters dpvth0_p_18_rf=1.0000e-05
parameters dpvsat_p_18_rf=-2.1000e+01
parameters dcgdo_p_18_rf=0.1
parameters dcgso_p_18_rf=0.1
parameters dcj_p_18_rf=-0.1
parameters dcjsw_p_18_rf=-0.1
parameters dcjgate_p_18_rf=-0.1

include "./core_rf_v2d4.mdl.scs"

endsection ff

section snfp
parameters dcd_n_18_rf=0.05
parameters dcgs_n_18_rf=0.075
parameters drgate_n_18_rf=0.175
parameters dtox_n_18_rf=0.0000e+00
parameters dxl_n_18_rf=1.1000e-08
parameters dxw_n_18_rf=-1.0000e-08
parameters dvth0_n_18_rf=1.3000e-02
parameters du0_n_18_rf=-5.0000e+00
parameters dlvth0_n_18_rf=1.1000e-03
parameters dwvth0_n_18_rf=4.7000e-03
parameters dwu0_n_18_rf=-2.0000e+00
parameters dpvth0_n_18_rf=-5.5000e-04
parameters dpvsat_n_18_rf=6.0000e+01
parameters dcgdo_n_18_rf=0.0000e+00
parameters dcgso_n_18_rf=0.0000e+00
parameters dcgdl_n_18_rf=0.0000e+00
parameters dcgsl_n_18_rf=0.0000e+00
parameters dcf_n_18_rf=0.075
parameters dcj_n_18_rf=0.05
parameters dcjsw_n_18_rf=0.05
parameters dcjgate_n_18_rf=0.05

parameters dcd_p_18_rf=-0.05
parameters dcgs_p_18_rf=-0.075
parameters drgate_p_18_rf=-0.175
parameters dcgdl_p_18_rf=0
parameters dcgsl_p_18_rf=0
parameters dcf_p_18_rf=-0.075
parameters dtox_p_18_rf=0.0000e+00
parameters du0_p_18_rf=0
parameters dxl_p_18_rf=-4.0000e-09
parameters dxw_p_18_rf=1.0000e-08
parameters dvth0_p_18_rf=1.7000e-02
parameters dlvth0_p_18_rf=-3.0000e-04
parameters dwvth0_p_18_rf=3.5000e-03
parameters dpvth0_p_18_rf=9.0000e-05
parameters dpvsat_p_18_rf=-3.0000e+01
parameters dcgdo_p_18_rf=0.0000e+00
parameters dcgso_p_18_rf=0.0000e+00
parameters dcj_p_18_rf=-0.05
parameters dcjsw_p_18_rf=-0.05
parameters dcjgate_p_18_rf=-0.05

include "./core_rf_v2d4.mdl.scs"

endsection snfp

section fnsp
parameters dcd_n_18_rf=-0.05
parameters dcgs_n_18_rf=-0.075
parameters drgate_n_18_rf=-0.175
parameters dtox_n_18_rf=0.0000e+00
parameters dxl_n_18_rf=-9.5000e-09
parameters dxw_n_18_rf=1.0000e-08
parameters du0_n_18_rf=6.0000e+00
parameters dvth0_n_18_rf=-1.2300e-02
parameters dlvth0_n_18_rf=-7.0000e-04
parameters dwvth0_n_18_rf=-4.6000e-03
parameters dwu0_n_18_rf=1.7000e+00
parameters dpvth0_n_18_rf=4.1000e-04
parameters dpvsat_n_18_rf=-7.0000e+01
parameters dcgdo_n_18_rf=0.0000e+00
parameters dcgso_n_18_rf=0.0000e+00
parameters dcgdl_n_18_rf=0.0000e+00
parameters dcgsl_n_18_rf=0.0000e+00
parameters dcf_n_18_rf=-0.075
parameters dcj_n_18_rf=-0.05
parameters dcjsw_n_18_rf=-0.05
parameters dcjgate_n_18_rf=-0.05

parameters dcd_p_18_rf=0.05
parameters dcgs_p_18_rf=0.075
parameters drgate_p_18_rf=0.175
parameters dcgdl_p_18_rf=0
parameters dcgsl_p_18_rf=0
parameters dcf_p_18_rf=0.075
parameters dtox_p_18_rf=0.0000e+00
parameters dxl_p_18_rf=4.5000e-09
parameters dxw_p_18_rf=-1.0000e-08
parameters dvth0_p_18_rf=-1.3000e-02
parameters du0_p_18_rf=0
parameters dlvth0_p_18_rf=-3.0000e-04
parameters dwvth0_p_18_rf=-5.0000e-03
parameters dpvth0_p_18_rf=1.3000e-04
parameters dpvsat_p_18_rf=3.4000e+01
parameters dcgdo_p_18_rf=0.0000e+00
parameters dcgso_p_18_rf=0.0000e+00
parameters dcj_p_18_rf=0.05
parameters dcjsw_p_18_rf=0.05
parameters dcjgate_p_18_rf=0.05

include "./core_rf_v2d4.mdl.scs"
endsection fnsp
endlibrary core_rf
