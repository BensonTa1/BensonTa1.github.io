//  ******************************************************************************
//  TT: Typical n-ch MOSFET and Typical p-ch MOSFET
//  FF: Fast n-ch MOSFET and Fast p-ch MOSFET
//  SS: Slow n-ch MOSFET and Slow p-ch MOSFET
//  FNSP: Fast n-ch MOSFET and Slow p-ch MOSFET
//  SNFP: Slow n-ch MOSFET and Fast p-ch MOSFET
//  ******************************************************************************
simulator lang=spectre insensitive=yes
//
library mylib

section tt_bip
parameters dis_pnp_v50x50_mm=1.0000000e+000
parameters dbf_pnp_v50x50_mm=1.0000000e+000
parameters dnf_pnp_v50x50_mm=1.0000000e+000
parameters dre_pnp_v50x50_mm=1.0000000e+000
parameters drc_pnp_v50x50_mm=1.0000000e+000
parameters dcjc_pnp_v50x50_mm=1.0000000e+000
parameters dcje_pnp_v50x50_mm=1.0000000e+000
parameters dis_pnp_v100x100_mm=1.0000000e+000
parameters dbf_pnp_v100x100_mm=1.0000000e+000
parameters dnf_pnp_v100x100_mm=1.0000000e+000
parameters dre_pnp_v100x100_mm=1.0000000e+000
parameters drc_pnp_v100x100_mm=1.0000000e+000
parameters dcjc_pnp_v100x100_mm=1.0000000e+000
parameters dcje_pnp_v100x100_mm=1.0000000e+000
//
include "mm180_bjt_v121.mdl.scs"
//
endsection tt_bip
//
section ff_bip
parameters dis_pnp_v50x50_mm=0.8000000e+000
parameters dbf_pnp_v50x50_mm=1.1500000e+000
parameters dnf_pnp_v50x50_mm=0.9950000e+000
parameters dre_pnp_v50x50_mm=0.8000000e+000
parameters drc_pnp_v50x50_mm=0.8000000e+000
parameters dcjc_pnp_v50x50_mm=0.9000000e+000
parameters dcje_pnp_v50x50_mm=0.9000000e+000
parameters dis_pnp_v100x100_mm=0.8000000e+000
parameters dbf_pnp_v100x100_mm=1.1500000e+000
parameters dnf_pnp_v100x100_mm=0.9950000e+000
parameters dre_pnp_v100x100_mm=0.8000000e+000
parameters drc_pnp_v100x100_mm=0.8000000e+000
parameters dcjc_pnp_v100x100_mm=0.9000000e+000
parameters dcje_pnp_v100x100_mm=0.9000000e+000
//
include "mm180_bjt_v121.mdl.scs"
//
endsection ff_bip
//
section ss_bip
parameters dis_pnp_v50x50_mm=1.2000000e+000
parameters dbf_pnp_v50x50_mm=0.8500000e+000
parameters dnf_pnp_v50x50_mm=1.0050000e+000
parameters dre_pnp_v50x50_mm=1.2000000e+000
parameters drc_pnp_v50x50_mm=1.2000000e+000
parameters dcjc_pnp_v50x50_mm=1.1000000e+000
parameters dcje_pnp_v50x50_mm=1.1000000e+000
parameters dis_pnp_v100x100_mm=1.2000000e+000
parameters dbf_pnp_v100x100_mm=0.8500000e+000
parameters dnf_pnp_v100x100_mm=1.0050000e+000
parameters dre_pnp_v100x100_mm=1.2000000e+000
parameters drc_pnp_v100x100_mm=1.2000000e+000
parameters dcjc_pnp_v100x100_mm=1.1000000e+000
parameters dcje_pnp_v100x100_mm=1.1000000e+000
//
include "mm180_bjt_v121.mdl.scs"
//
endsection ss_bip
endlibrary mylib
