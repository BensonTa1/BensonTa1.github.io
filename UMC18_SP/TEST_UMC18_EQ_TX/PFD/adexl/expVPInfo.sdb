ADE simulation setup
Global variables:
  Ts = 1000n (off)
  TD = 80n
  VDD = {Exclusion List}1.8{Exclusion List}{Center/Span%}Auto:1.8:3:10{Center/Span%}
