ADE simulation setup
Run mode: Monte Carlo Sampling
Tests:
  TEST:MC_TEST:1: TEST/MC_TEST/schematic, simulator spectre
Global variables:
  sigma = 1
Corners (nominal off):
  model folders: /home/m10912086/UM180FDKMFC0000OA_A02_EQ/Models/Spectre/Monte_Carlo
  C0: mm180_reg18_v124_mc_corner.lib.scs[ff_g ss_g tt_g]
Monte Carlo Sampling options: mcmethod=mismatch, mcnumpoints=200
