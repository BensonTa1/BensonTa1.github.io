ADE simulation setup
Global variables:
  VC = 0
  VDIF = 200m
