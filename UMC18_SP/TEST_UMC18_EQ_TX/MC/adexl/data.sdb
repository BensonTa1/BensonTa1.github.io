ADE simulation setup
Run mode: Monte Carlo Sampling
Tests:
  TEST:MC:1: TEST/MC/schematic, simulator spectre
    Outputs: IDC("/IPRB1/PLUS")
Global variables:
  sigma = 3
Corners (nominal off):
  model folders: /home/m10912086/UM180FDKMFC0000OA_A02_EQ/Models/Spectre/Monte_Carlo
  C0: mm180_reg18_v124_mc_corner.lib.scs[tt_g]
Monte Carlo Sampling options: mcmethod=mismatch, mcnumpoints=200
