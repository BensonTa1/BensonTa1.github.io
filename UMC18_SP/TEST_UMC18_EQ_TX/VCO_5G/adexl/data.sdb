ADE simulation setup
Run mode: Single Run, Sweeps and Corners
Tests:
  TEST:VCO_5G:1: TEST/VCO_5G/schematic, simulator spectre
Global variables:
  VDD = 1.8
  VC = {Exclusion List}0.9{Exclusion List}{From/To}Auto:0:3:1.8{From/To}
  temperature = {Exclusion List}30{Exclusion List}{From/To}Auto:-100:5:200{From/To}
Corners:
  model folders: /home/m10912086/UM180FDKMFC0000OA_A02_EQ/Models/Spectre
  C1 (off): varmis_18_rf_v2d3.lib.scs[typ], vardiop_rf_v2d3.lib.scs[typ], rnppo_rf_v2d4.lib.scs[typ], rnnpo_rf_v2d4.lib.scs[typ], rnhr_rf_v2d4.lib.scs[typ], pad_rf_v2d3.lib.scs[typ], mm180_zvt33_v113.lib.scs[tt], mm180_zvt18_v121.lib.scs[tt], mm180_res_v141.lib.scs[res_typ], mm180_reg33_v114.lib.scs[tt], mm180_reg33bpw_v123.lib.scs[tt], mm180_reg18_v124.lib.scs[tt ff ss snfp fnsp], mm180_reg18bpw_v123.lib.scs[tt], mm180_mimcap_v101.lib.scs[mimcaps_typ], mm180_lvt33_v113.lib.scs[tt], mm180_lvt18_v113.lib.scs[tt], mm180_bjt_v121.lib.scs[tt_bip], mimcapm_rf_v2d3.lib.scs[typ], l_slcr20k_rf_v2d3.lib.scs[typ], io_rf_v2d3.lib.scs[tt], core_rf_v2d4.lib.scs[tt]
  C1_0: varmis_18_rf_v2d3.lib.scs[typ], vardiop_rf_v2d3.lib.scs[typ], rnppo_rf_v2d4.lib.scs[typ], rnnpo_rf_v2d4.lib.scs[typ], rnhr_rf_v2d4.lib.scs[typ], pad_rf_v2d3.lib.scs[typ], mm180_zvt33_v113.lib.scs[tt], mm180_zvt18_v121.lib.scs[tt], mm180_res_v141.lib.scs[res_typ], mm180_reg33_v114.lib.scs[tt], mm180_reg33bpw_v123.lib.scs[tt], mm180_reg18_v124.lib.scs[tt], mm180_reg18bpw_v123.lib.scs[tt], mm180_mimcap_v101.lib.scs[mimcaps_typ], mm180_lvt33_v113.lib.scs[tt], mm180_lvt18_v113.lib.scs[tt], mm180_bjt_v121.lib.scs[tt_bip], mimcapm_rf_v2d3.lib.scs[typ], l_slcr20k_rf_v2d3.lib.scs[typ max min], io_rf_v2d3.lib.scs[tt], core_rf_v2d4.lib.scs[tt ff ss snfp fnsp]
