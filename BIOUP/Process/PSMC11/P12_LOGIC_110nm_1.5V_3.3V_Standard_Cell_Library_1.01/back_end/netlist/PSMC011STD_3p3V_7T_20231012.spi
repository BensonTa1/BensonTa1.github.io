***
***  Library: PSMC011STD_3p3V_7T
***  Date: 2023.10.12
***

*.GLOBAL VDD GND

.SUBCKT AND2B1X1 O B2 I1
M0 VDD I1 1 VDD hvp L=3.0e-07 W=1e-06
M1 3 1 VDD VDD hvp L=3.0e-07 W=1e-06
M2 O B2 3 VDD hvp L=3.0e-07 W=1e-06
M3 5 B2 O VDD hvp L=3.0e-07 W=1e-06
M4 VDD 1 5 VDD hvp L=3.0e-07 W=1e-06
M5 GND I1 1 GND hvn L=3.5e-07 W=0.65e-06
M6 O 1 GND GND hvn L=3.5e-07 W=0.65e-06
M7 GND B2 O GND hvn L=3.5e-07 W=0.65e-06
.ENDS AND2B1X1

.SUBCKT AND2B1X2 O B2 I1
M0 VDD B2 1 VDD hvp L=3.0e-07 W=1e-06
M1 3 I1 VDD VDD hvp L=3.0e-07 W=1e-06
M2 VDD 1 3 VDD hvp L=3.0e-07 W=1e-06
M3 O 3 VDD VDD hvp L=3.0e-07 W=1e-06
M4 VDD 3 O VDD hvp L=3.0e-07 W=1e-06
M5 1 B2 GND GND hvn L=3.5e-07 W=0.65e-06
M6 6 I1 3 GND hvn L=3.5e-07 W=0.65e-06
M7 GND 1 6 GND hvn L=3.5e-07 W=0.65e-06
M8 O 3 GND GND hvn L=3.5e-07 W=0.65e-06
M9 GND 3 O GND hvn L=3.5e-07 W=0.65e-06
.ENDS AND2B1X2

.SUBCKT AND2B1X4 O B2 I1
M0 2 B2 VDD VDD hvp L=3.0e-07 W=1e-06
M1 3 I1 VDD VDD hvp L=3.0e-07 W=1e-06
M2 VDD 2 3 VDD hvp L=3.0e-07 W=1e-06
M3 O 3 VDD VDD hvp L=3.0e-07 W=1e-06
M4 VDD 3 O VDD hvp L=3.0e-07 W=1e-06
M5 O 3 VDD VDD hvp L=3.0e-07 W=1e-06
M6 VDD 3 O VDD hvp L=3.0e-07 W=1e-06
M7 2 B2 GND GND hvn L=3.5e-07 W=0.65e-06
M8 6 I1 3 GND hvn L=3.5e-07 W=0.65e-06
M9 GND 2 6 GND hvn L=3.5e-07 W=0.65e-06
M10 O 3 GND GND hvn L=3.5e-07 W=0.65e-06
M11 GND 3 O GND hvn L=3.5e-07 W=0.65e-06
M12 O 3 GND GND hvn L=3.5e-07 W=0.65e-06
M13 GND 3 O GND hvn L=3.5e-07 W=0.65e-06
.ENDS AND2B1X4

.SUBCKT AND2DFFQBX1 QB D1 D2 CK
M0 2 D1 VDD VDD hvp L=3.0e-07 W=1e-06
M1 VDD D2 2 VDD hvp L=3.0e-07 W=1e-06
M2 3 CK VDD VDD hvp L=3.0e-07 W=0.35e-06
M3 4 3 VDD VDD hvp L=3.0e-07 W=0.6e-06
M4 5 4 2 VDD hvp L=3.0e-07 W=0.57e-06
M5 6 3 5 VDD hvp L=3.0e-07 W=0.35e-06
M6 VDD 7 6 VDD hvp L=3.0e-07 W=0.35e-06
M7 7 5 VDD VDD hvp L=3.0e-07 W=0.5e-06
M8 8 3 7 VDD hvp L=3.0e-07 W=0.5e-06
M9 9 4 8 VDD hvp L=3.0e-07 W=0.3e-06
M10 VDD 10 9 VDD hvp L=3.0e-07 W=0.3e-06
M11 10 8 VDD VDD hvp L=3.0e-07 W=0.3e-06
M12 QB 8 VDD VDD hvp L=3.0e-07 W=1e-06
M13 12 D1 2 GND hvn L=3.5e-07 W=0.65e-06
M14 GND D2 12 GND hvn L=3.5e-07 W=0.65e-06
M15 3 CK GND GND hvn L=3.5e-07 W=0.6e-06
M16 4 3 GND GND hvn L=3.5e-07 W=0.3e-06
M17 5 3 2 GND hvn L=3.5e-07 W=0.6e-06
M18 14 4 5 GND hvn L=3.5e-07 W=0.3e-06
M19 GND 7 14 GND hvn L=3.5e-07 W=0.3e-06
M20 7 5 GND GND hvn L=3.5e-07 W=0.3e-06
M21 8 4 7 GND hvn L=3.5e-07 W=0.4e-06
M22 15 3 8 GND hvn L=3.5e-07 W=0.3e-06
M23 GND 10 15 GND hvn L=3.5e-07 W=0.3e-06
M24 10 8 GND GND hvn L=3.5e-07 W=0.3e-06
M25 QB 8 GND GND hvn L=3.5e-07 W=0.65e-06
.ENDS AND2DFFQBX1

.SUBCKT AND2DFFQBX2 QB D1 D2 CK
M0 2 D1 VDD VDD hvp L=3.0e-07 W=1e-06
M1 VDD D2 2 VDD hvp L=3.0e-07 W=1e-06
M2 3 CK VDD VDD hvp L=3.0e-07 W=0.35e-06
M3 4 3 VDD VDD hvp L=3.0e-07 W=0.6e-06
M4 5 4 2 VDD hvp L=3.0e-07 W=0.57e-06
M5 6 3 5 VDD hvp L=3.0e-07 W=0.35e-06
M6 VDD 7 6 VDD hvp L=3.0e-07 W=0.35e-06
M7 7 5 VDD VDD hvp L=3.0e-07 W=0.5e-06
M8 8 3 7 VDD hvp L=3.0e-07 W=0.5e-06
M9 9 4 8 VDD hvp L=3.0e-07 W=0.3e-06
M10 VDD 10 9 VDD hvp L=3.0e-07 W=0.3e-06
M11 10 8 VDD VDD hvp L=3.0e-07 W=0.3e-06
M12 QB 8 VDD VDD hvp L=3.0e-07 W=1e-06
M13 VDD 8 QB VDD hvp L=3.0e-07 W=1e-06
M14 12 D1 2 GND hvn L=3.5e-07 W=0.65e-06
M15 GND D2 12 GND hvn L=3.5e-07 W=0.65e-06
M16 3 CK GND GND hvn L=3.5e-07 W=0.6e-06
M17 4 3 GND GND hvn L=3.5e-07 W=0.3e-06
M18 5 3 2 GND hvn L=3.5e-07 W=0.6e-06
M19 14 4 5 GND hvn L=3.5e-07 W=0.3e-06
M20 GND 7 14 GND hvn L=3.5e-07 W=0.3e-06
M21 7 5 GND GND hvn L=3.5e-07 W=0.3e-06
M22 8 4 7 GND hvn L=3.5e-07 W=0.4e-06
M23 15 3 8 GND hvn L=3.5e-07 W=0.3e-06
M24 GND 10 15 GND hvn L=3.5e-07 W=0.3e-06
M25 10 8 GND GND hvn L=3.5e-07 W=0.3e-06
M26 QB 8 GND GND hvn L=3.5e-07 W=0.65e-06
M27 GND 8 QB GND hvn L=3.5e-07 W=0.65e-06
.ENDS AND2DFFQBX2

.SUBCKT AND2DFFQBX4 QB D1 D2 CK
M0 2 D1 VDD VDD hvp L=3.0e-07 W=1e-06
M1 VDD D2 2 VDD hvp L=3.0e-07 W=1e-06
M2 3 CK VDD VDD hvp L=3.0e-07 W=0.35e-06
M3 4 3 VDD VDD hvp L=3.0e-07 W=0.6e-06
M4 5 4 2 VDD hvp L=3.0e-07 W=0.57e-06
M5 6 3 5 VDD hvp L=3.0e-07 W=0.35e-06
M6 VDD 7 6 VDD hvp L=3.0e-07 W=0.35e-06
M7 7 5 VDD VDD hvp L=3.0e-07 W=0.5e-06
M8 8 3 7 VDD hvp L=3.0e-07 W=0.5e-06
M9 9 4 8 VDD hvp L=3.0e-07 W=0.3e-06
M10 VDD 10 9 VDD hvp L=3.0e-07 W=0.3e-06
M11 10 8 VDD VDD hvp L=3.0e-07 W=0.3e-06
M12 QB 8 VDD VDD hvp L=3.0e-07 W=1e-06
M13 VDD 8 QB VDD hvp L=3.0e-07 W=1e-06
M14 QB 8 VDD VDD hvp L=3.0e-07 W=1e-06
M15 VDD 8 QB VDD hvp L=3.0e-07 W=1e-06
M16 12 D1 2 GND hvn L=3.5e-07 W=0.65e-06
M17 GND D2 12 GND hvn L=3.5e-07 W=0.65e-06
M18 3 CK GND GND hvn L=3.5e-07 W=0.6e-06
M19 4 3 GND GND hvn L=3.5e-07 W=0.3e-06
M20 5 3 2 GND hvn L=3.5e-07 W=0.6e-06
M21 14 4 5 GND hvn L=3.5e-07 W=0.3e-06
M22 GND 7 14 GND hvn L=3.5e-07 W=0.3e-06
M23 7 5 GND GND hvn L=3.5e-07 W=0.3e-06
M24 8 4 7 GND hvn L=3.5e-07 W=0.4e-06
M25 15 3 8 GND hvn L=3.5e-07 W=0.3e-06
M26 GND 10 15 GND hvn L=3.5e-07 W=0.3e-06
M27 10 8 GND GND hvn L=3.5e-07 W=0.3e-06
M28 QB 8 GND GND hvn L=3.5e-07 W=0.65e-06
M29 GND 8 QB GND hvn L=3.5e-07 W=0.65e-06
M30 QB 8 GND GND hvn L=3.5e-07 W=0.65e-06
M31 GND 8 QB GND hvn L=3.5e-07 W=0.65e-06
.ENDS AND2DFFQBX4

.SUBCKT AND2DFFQX1 Q D1 D2 CK
M0 2 D1 VDD VDD hvp L=3.0e-07 W=1e-06
M1 VDD D2 2 VDD hvp L=3.0e-07 W=1e-06
M2 3 CK VDD VDD hvp L=3.0e-07 W=0.35e-06
M3 4 3 VDD VDD hvp L=3.0e-07 W=0.6e-06
M4 5 4 2 VDD hvp L=3.0e-07 W=0.57e-06
M5 6 3 5 VDD hvp L=3.0e-07 W=0.35e-06
M6 VDD 7 6 VDD hvp L=3.0e-07 W=0.35e-06
M7 7 5 VDD VDD hvp L=3.0e-07 W=0.5e-06
M8 8 3 7 VDD hvp L=3.0e-07 W=0.5e-06
M9 9 4 8 VDD hvp L=3.0e-07 W=0.3e-06
M10 VDD 10 9 VDD hvp L=3.0e-07 W=0.3e-06
M11 VDD 8 10 VDD hvp L=3.0e-07 W=0.85e-06
M12 Q 10 VDD VDD hvp L=3.0e-07 W=1e-06
M13 12 D1 2 GND hvn L=3.5e-07 W=0.65e-06
M14 GND D2 12 GND hvn L=3.5e-07 W=0.65e-06
M15 3 CK GND GND hvn L=3.5e-07 W=0.6e-06
M16 4 3 GND GND hvn L=3.5e-07 W=0.3e-06
M17 5 3 2 GND hvn L=3.5e-07 W=0.6e-06
M18 14 4 5 GND hvn L=3.5e-07 W=0.3e-06
M19 GND 7 14 GND hvn L=3.5e-07 W=0.3e-06
M20 7 5 GND GND hvn L=3.5e-07 W=0.3e-06
M21 8 4 7 GND hvn L=3.5e-07 W=0.4e-06
M22 15 3 8 GND hvn L=3.5e-07 W=0.3e-06
M23 GND 10 15 GND hvn L=3.5e-07 W=0.3e-06
M24 GND 8 10 GND hvn L=3.5e-07 W=0.56e-06
M25 Q 10 GND GND hvn L=3.5e-07 W=0.65e-06
.ENDS AND2DFFQX1

.SUBCKT AND2DFFQX2 Q D1 D2 CK
M0 2 D1 VDD VDD hvp L=3.0e-07 W=1e-06
M1 VDD D2 2 VDD hvp L=3.0e-07 W=1e-06
M2 3 CK VDD VDD hvp L=3.0e-07 W=0.35e-06
M3 4 3 VDD VDD hvp L=3.0e-07 W=0.6e-06
M4 5 4 2 VDD hvp L=3.0e-07 W=0.57e-06
M5 6 3 5 VDD hvp L=3.0e-07 W=0.35e-06
M6 VDD 7 6 VDD hvp L=3.0e-07 W=0.35e-06
M7 7 5 VDD VDD hvp L=3.0e-07 W=0.5e-06
M8 8 3 7 VDD hvp L=3.0e-07 W=0.5e-06
M9 9 4 8 VDD hvp L=3.0e-07 W=0.3e-06
M10 VDD 10 9 VDD hvp L=3.0e-07 W=0.3e-06
M11 VDD 8 10 VDD hvp L=3.0e-07 W=0.85e-06
M12 Q 10 VDD VDD hvp L=3.0e-07 W=1e-06
M13 VDD 10 Q VDD hvp L=3.0e-07 W=1e-06
M14 12 D1 2 GND hvn L=3.5e-07 W=0.65e-06
M15 GND D2 12 GND hvn L=3.5e-07 W=0.65e-06
M16 3 CK GND GND hvn L=3.5e-07 W=0.6e-06
M17 4 3 GND GND hvn L=3.5e-07 W=0.3e-06
M18 5 3 2 GND hvn L=3.5e-07 W=0.6e-06
M19 14 4 5 GND hvn L=3.5e-07 W=0.3e-06
M20 GND 7 14 GND hvn L=3.5e-07 W=0.3e-06
M21 7 5 GND GND hvn L=3.5e-07 W=0.3e-06
M22 8 4 7 GND hvn L=3.5e-07 W=0.4e-06
M23 15 3 8 GND hvn L=3.5e-07 W=0.3e-06
M24 GND 10 15 GND hvn L=3.5e-07 W=0.3e-06
M25 GND 8 10 GND hvn L=3.5e-07 W=0.56e-06
M26 Q 10 GND GND hvn L=3.5e-07 W=0.65e-06
M27 GND 10 Q GND hvn L=3.5e-07 W=0.65e-06
.ENDS AND2DFFQX2

.SUBCKT AND2DFFQX4 Q D1 D2 CK
M0 2 D1 VDD VDD hvp L=3.0e-07 W=1e-06
M1 VDD D2 2 VDD hvp L=3.0e-07 W=1e-06
M2 3 CK VDD VDD hvp L=3.0e-07 W=0.35e-06
M3 4 3 VDD VDD hvp L=3.0e-07 W=0.6e-06
M4 5 4 2 VDD hvp L=3.0e-07 W=0.57e-06
M5 6 3 5 VDD hvp L=3.0e-07 W=0.35e-06
M6 VDD 7 6 VDD hvp L=3.0e-07 W=0.35e-06
M7 7 5 VDD VDD hvp L=3.0e-07 W=0.5e-06
M8 8 3 7 VDD hvp L=3.0e-07 W=0.5e-06
M9 9 4 8 VDD hvp L=3.0e-07 W=0.3e-06
M10 VDD 10 9 VDD hvp L=3.0e-07 W=0.3e-06
M11 VDD 8 10 VDD hvp L=3.0e-07 W=0.85e-06
M12 Q 10 VDD VDD hvp L=3.0e-07 W=1e-06
M13 VDD 10 Q VDD hvp L=3.0e-07 W=1e-06
M14 Q 10 VDD VDD hvp L=3.0e-07 W=1e-06
M15 VDD 10 Q VDD hvp L=3.0e-07 W=1e-06
M16 12 D1 2 GND hvn L=3.5e-07 W=0.65e-06
M17 GND D2 12 GND hvn L=3.5e-07 W=0.65e-06
M18 3 CK GND GND hvn L=3.5e-07 W=0.6e-06
M19 4 3 GND GND hvn L=3.5e-07 W=0.3e-06
M20 5 3 2 GND hvn L=3.5e-07 W=0.6e-06
M21 14 4 5 GND hvn L=3.5e-07 W=0.3e-06
M22 GND 7 14 GND hvn L=3.5e-07 W=0.3e-06
M23 7 5 GND GND hvn L=3.5e-07 W=0.3e-06
M24 8 4 7 GND hvn L=3.5e-07 W=0.4e-06
M25 15 3 8 GND hvn L=3.5e-07 W=0.3e-06
M26 GND 10 15 GND hvn L=3.5e-07 W=0.3e-06
M27 GND 8 10 GND hvn L=3.5e-07 W=0.56e-06
M28 Q 10 GND GND hvn L=3.5e-07 W=0.65e-06
M29 GND 10 Q GND hvn L=3.5e-07 W=0.65e-06
M30 Q 10 GND GND hvn L=3.5e-07 W=0.65e-06
M31 GND 10 Q GND hvn L=3.5e-07 W=0.65e-06
.ENDS AND2DFFQX4

.SUBCKT AND2DFFRBQBX1 QB D1 D2 RB CK
M0 2 D1 VDD VDD hvp L=3.0e-07 W=1e-06
M1 VDD D2 2 VDD hvp L=3.0e-07 W=1e-06
M2 3 CK VDD VDD hvp L=3.0e-07 W=0.35e-06
M3 4 3 VDD VDD hvp L=3.0e-07 W=0.6e-06
M4 5 4 2 VDD hvp L=3.0e-07 W=0.6e-06
M5 6 3 5 VDD hvp L=3.0e-07 W=0.6e-06
M6 VDD RB 6 VDD hvp L=3.0e-07 W=0.6e-06
M7 6 7 VDD VDD hvp L=3.0e-07 W=0.3e-06
M8 7 5 VDD VDD hvp L=3.0e-07 W=0.56e-06
M9 8 3 7 VDD hvp L=3.0e-07 W=0.3e-06
M10 9 4 8 VDD hvp L=3.0e-07 W=0.3e-06
M11 VDD 10 9 VDD hvp L=3.0e-07 W=0.3e-06
M12 10 RB VDD VDD hvp L=3.0e-07 W=0.3e-06
M13 VDD 8 10 VDD hvp L=3.0e-07 W=0.3e-06
M14 QB 8 VDD VDD hvp L=3.0e-07 W=1e-06
M15 12 D1 2 GND hvn L=3.5e-07 W=0.65e-06
M16 GND D2 12 GND hvn L=3.5e-07 W=0.65e-06
M17 3 CK GND GND hvn L=3.5e-07 W=0.6e-06
M18 4 3 GND GND hvn L=3.5e-07 W=0.3e-06
M19 5 3 2 GND hvn L=3.5e-07 W=0.3e-06
M20 6 4 5 GND hvn L=3.5e-07 W=0.6e-06
M21 14 RB 6 GND hvn L=3.5e-07 W=0.3e-06
M22 GND 7 14 GND hvn L=3.5e-07 W=0.3e-06
M23 7 5 GND GND hvn L=3.5e-07 W=0.28e-06
M24 8 4 7 GND hvn L=3.5e-07 W=0.3e-06
M25 15 3 8 GND hvn L=3.5e-07 W=0.3e-06
M26 GND 10 15 GND hvn L=3.5e-07 W=0.3e-06
M27 16 RB GND GND hvn L=3.5e-07 W=0.3e-06
M28 10 8 16 GND hvn L=3.5e-07 W=0.3e-06
M29 QB 8 GND GND hvn L=3.5e-07 W=0.65e-06
.ENDS AND2DFFRBQBX1

.SUBCKT AND2DFFRBQBX2 QB D1 D2 RB CK
M0 2 D1 VDD VDD hvp L=3.0e-07 W=1e-06
M1 VDD D2 2 VDD hvp L=3.0e-07 W=1e-06
M2 3 CK VDD VDD hvp L=3.0e-07 W=0.35e-06
M3 4 3 VDD VDD hvp L=3.0e-07 W=0.6e-06
M4 5 4 2 VDD hvp L=3.0e-07 W=0.6e-06
M5 6 3 5 VDD hvp L=3.0e-07 W=0.6e-06
M6 VDD RB 6 VDD hvp L=3.0e-07 W=0.6e-06
M7 6 7 VDD VDD hvp L=3.0e-07 W=0.3e-06
M8 7 5 VDD VDD hvp L=3.0e-07 W=0.56e-06
M9 8 3 7 VDD hvp L=3.0e-07 W=0.3e-06
M10 9 4 8 VDD hvp L=3.0e-07 W=0.3e-06
M11 VDD 10 9 VDD hvp L=3.0e-07 W=0.3e-06
M12 10 RB VDD VDD hvp L=3.0e-07 W=0.3e-06
M13 VDD 8 10 VDD hvp L=3.0e-07 W=0.3e-06
M14 QB 8 VDD VDD hvp L=3.0e-07 W=1e-06
M15 VDD 8 QB VDD hvp L=3.0e-07 W=1e-06
M16 12 D1 2 GND hvn L=3.5e-07 W=0.65e-06
M17 GND D2 12 GND hvn L=3.5e-07 W=0.65e-06
M18 3 CK GND GND hvn L=3.5e-07 W=0.6e-06
M19 4 3 GND GND hvn L=3.5e-07 W=0.3e-06
M20 5 3 2 GND hvn L=3.5e-07 W=0.3e-06
M21 6 4 5 GND hvn L=3.5e-07 W=0.6e-06
M22 14 RB 6 GND hvn L=3.5e-07 W=0.3e-06
M23 GND 7 14 GND hvn L=3.5e-07 W=0.3e-06
M24 7 5 GND GND hvn L=3.5e-07 W=0.28e-06
M25 8 4 7 GND hvn L=3.5e-07 W=0.3e-06
M26 15 3 8 GND hvn L=3.5e-07 W=0.3e-06
M27 GND 10 15 GND hvn L=3.5e-07 W=0.3e-06
M28 16 RB GND GND hvn L=3.5e-07 W=0.3e-06
M29 10 8 16 GND hvn L=3.5e-07 W=0.3e-06
M30 QB 8 GND GND hvn L=3.5e-07 W=0.65e-06
M31 GND 8 QB GND hvn L=3.5e-07 W=0.65e-06
.ENDS AND2DFFRBQBX2

.SUBCKT AND2DFFRBQBX4 QB D1 D2 RB CK
M0 2 D1 VDD VDD hvp L=3.0e-07 W=1e-06
M1 VDD D2 2 VDD hvp L=3.0e-07 W=1e-06
M2 3 CK VDD VDD hvp L=3.0e-07 W=0.35e-06
M3 4 3 VDD VDD hvp L=3.0e-07 W=0.6e-06
M4 5 4 2 VDD hvp L=3.0e-07 W=0.6e-06
M5 6 3 5 VDD hvp L=3.0e-07 W=0.6e-06
M6 VDD RB 6 VDD hvp L=3.0e-07 W=0.6e-06
M7 6 7 VDD VDD hvp L=3.0e-07 W=0.3e-06
M8 7 5 VDD VDD hvp L=3.0e-07 W=0.56e-06
M9 8 3 7 VDD hvp L=3.0e-07 W=0.3e-06
M10 9 4 8 VDD hvp L=3.0e-07 W=0.3e-06
M11 VDD 10 9 VDD hvp L=3.0e-07 W=0.3e-06
M12 10 RB VDD VDD hvp L=3.0e-07 W=0.3e-06
M13 VDD 8 10 VDD hvp L=3.0e-07 W=0.3e-06
M14 QB 8 VDD VDD hvp L=3.0e-07 W=1e-06
M15 VDD 8 QB VDD hvp L=3.0e-07 W=1e-06
M16 QB 8 VDD VDD hvp L=3.0e-07 W=1e-06
M17 VDD 8 QB VDD hvp L=3.0e-07 W=1e-06
M18 12 D1 2 GND hvn L=3.5e-07 W=0.65e-06
M19 GND D2 12 GND hvn L=3.5e-07 W=0.65e-06
M20 3 CK GND GND hvn L=3.5e-07 W=0.6e-06
M21 4 3 GND GND hvn L=3.5e-07 W=0.3e-06
M22 5 3 2 GND hvn L=3.5e-07 W=0.3e-06
M23 6 4 5 GND hvn L=3.5e-07 W=0.6e-06
M24 14 RB 6 GND hvn L=3.5e-07 W=0.3e-06
M25 GND 7 14 GND hvn L=3.5e-07 W=0.3e-06
M26 7 5 GND GND hvn L=3.5e-07 W=0.28e-06
M27 8 4 7 GND hvn L=3.5e-07 W=0.3e-06
M28 15 3 8 GND hvn L=3.5e-07 W=0.3e-06
M29 GND 10 15 GND hvn L=3.5e-07 W=0.3e-06
M30 16 RB GND GND hvn L=3.5e-07 W=0.3e-06
M31 10 8 16 GND hvn L=3.5e-07 W=0.3e-06
M32 QB 8 GND GND hvn L=3.5e-07 W=0.65e-06
M33 GND 8 QB GND hvn L=3.5e-07 W=0.65e-06
M34 QB 8 GND GND hvn L=3.5e-07 W=0.65e-06
M35 GND 8 QB GND hvn L=3.5e-07 W=0.65e-06
.ENDS AND2DFFRBQBX4

.SUBCKT AND2DFFRBQX1 Q D1 D2 RB CK
M0 2 D1 VDD VDD hvp L=3.0e-07 W=1e-06
M1 VDD D2 2 VDD hvp L=3.0e-07 W=1e-06
M2 3 CK VDD VDD hvp L=3.0e-07 W=0.35e-06
M3 4 3 VDD VDD hvp L=3.0e-07 W=0.6e-06
M4 5 4 2 VDD hvp L=3.0e-07 W=0.55e-06
M5 6 3 5 VDD hvp L=3.0e-07 W=0.3e-06
M6 VDD RB 6 VDD hvp L=3.0e-07 W=0.3e-06
M7 6 7 VDD VDD hvp L=3.0e-07 W=0.3e-06
M8 7 5 VDD VDD hvp L=3.0e-07 W=0.52e-06
M9 8 3 7 VDD hvp L=3.0e-07 W=0.52e-06
M10 9 4 8 VDD hvp L=3.0e-07 W=0.3e-06
M11 VDD 10 9 VDD hvp L=3.0e-07 W=0.3e-06
M12 10 RB VDD VDD hvp L=3.0e-07 W=0.72e-06
M13 VDD 8 10 VDD hvp L=3.0e-07 W=0.72e-06
M14 Q 10 VDD VDD hvp L=3.0e-07 W=1e-06
M15 12 D1 2 GND hvn L=3.5e-07 W=0.65e-06
M16 GND D2 12 GND hvn L=3.5e-07 W=0.65e-06
M17 3 CK GND GND hvn L=3.5e-07 W=0.6e-06
M18 4 3 GND GND hvn L=3.5e-07 W=0.3e-06
M19 5 3 2 GND hvn L=3.5e-07 W=0.6e-06
M20 6 4 5 GND hvn L=3.5e-07 W=0.3e-06
M21 14 RB 6 GND hvn L=3.5e-07 W=0.28e-06
M22 GND 7 14 GND hvn L=3.5e-07 W=0.28e-06
M23 7 5 GND GND hvn L=3.5e-07 W=0.3e-06
M24 8 4 7 GND hvn L=3.5e-07 W=0.34e-06
M25 15 3 8 GND hvn L=3.5e-07 W=0.34e-06
M26 GND 10 15 GND hvn L=3.5e-07 W=0.34e-06
M27 16 RB GND GND hvn L=3.5e-07 W=0.34e-06
M28 10 8 16 GND hvn L=3.5e-07 W=0.34e-06
M29 Q 10 GND GND hvn L=3.5e-07 W=0.65e-06
.ENDS AND2DFFRBQX1

.SUBCKT AND2DFFRBQX2 Q D1 D2 RB CK
M0 2 D1 VDD VDD hvp L=3.0e-07 W=1e-06
M1 VDD D2 2 VDD hvp L=3.0e-07 W=1e-06
M2 3 CK VDD VDD hvp L=3.0e-07 W=0.35e-06
M3 4 3 VDD VDD hvp L=3.0e-07 W=0.6e-06
M4 5 4 2 VDD hvp L=3.0e-07 W=0.55e-06
M5 6 3 5 VDD hvp L=3.0e-07 W=0.3e-06
M6 VDD RB 6 VDD hvp L=3.0e-07 W=0.3e-06
M7 6 7 VDD VDD hvp L=3.0e-07 W=0.3e-06
M8 7 5 VDD VDD hvp L=3.0e-07 W=0.52e-06
M9 8 3 7 VDD hvp L=3.0e-07 W=0.52e-06
M10 9 4 8 VDD hvp L=3.0e-07 W=0.3e-06
M11 VDD 10 9 VDD hvp L=3.0e-07 W=0.3e-06
M12 10 RB VDD VDD hvp L=3.0e-07 W=0.72e-06
M13 VDD 8 10 VDD hvp L=3.0e-07 W=0.72e-06
M14 Q 10 VDD VDD hvp L=3.0e-07 W=1e-06
M15 VDD 10 Q VDD hvp L=3.0e-07 W=1e-06
M16 12 D1 2 GND hvn L=3.5e-07 W=0.65e-06
M17 GND D2 12 GND hvn L=3.5e-07 W=0.65e-06
M18 3 CK GND GND hvn L=3.5e-07 W=0.6e-06
M19 4 3 GND GND hvn L=3.5e-07 W=0.3e-06
M20 5 3 2 GND hvn L=3.5e-07 W=0.6e-06
M21 6 4 5 GND hvn L=3.5e-07 W=0.3e-06
M22 14 RB 6 GND hvn L=3.5e-07 W=0.28e-06
M23 GND 7 14 GND hvn L=3.5e-07 W=0.28e-06
M24 7 5 GND GND hvn L=3.5e-07 W=0.3e-06
M25 8 4 7 GND hvn L=3.5e-07 W=0.34e-06
M26 15 3 8 GND hvn L=3.5e-07 W=0.34e-06
M27 GND 10 15 GND hvn L=3.5e-07 W=0.34e-06
M28 16 RB GND GND hvn L=3.5e-07 W=0.34e-06
M29 10 8 16 GND hvn L=3.5e-07 W=0.34e-06
M30 Q 10 GND GND hvn L=3.5e-07 W=0.65e-06
M31 GND 10 Q GND hvn L=3.5e-07 W=0.65e-06
.ENDS AND2DFFRBQX2

.SUBCKT AND2DFFRBQX4 Q D1 D2 RB CK
M0 2 D1 VDD VDD hvp L=3.0e-07 W=1e-06
M1 VDD D2 2 VDD hvp L=3.0e-07 W=1e-06
M2 3 CK VDD VDD hvp L=3.0e-07 W=0.35e-06
M3 4 3 VDD VDD hvp L=3.0e-07 W=0.6e-06
M4 5 4 2 VDD hvp L=3.0e-07 W=0.55e-06
M5 6 3 5 VDD hvp L=3.0e-07 W=0.3e-06
M6 VDD RB 6 VDD hvp L=3.0e-07 W=0.3e-06
M7 6 7 VDD VDD hvp L=3.0e-07 W=0.3e-06
M8 7 5 VDD VDD hvp L=3.0e-07 W=0.52e-06
M9 8 3 7 VDD hvp L=3.0e-07 W=0.52e-06
M10 9 4 8 VDD hvp L=3.0e-07 W=0.3e-06
M11 VDD 10 9 VDD hvp L=3.0e-07 W=0.3e-06
M12 10 RB VDD VDD hvp L=3.0e-07 W=0.72e-06
M13 VDD 8 10 VDD hvp L=3.0e-07 W=0.72e-06
M14 Q 10 VDD VDD hvp L=3.0e-07 W=1e-06
M15 VDD 10 Q VDD hvp L=3.0e-07 W=1e-06
M16 Q 10 VDD VDD hvp L=3.0e-07 W=1e-06
M17 VDD 10 Q VDD hvp L=3.0e-07 W=1e-06
M18 12 D1 2 GND hvn L=3.5e-07 W=0.65e-06
M19 GND D2 12 GND hvn L=3.5e-07 W=0.65e-06
M20 3 CK GND GND hvn L=3.5e-07 W=0.6e-06
M21 4 3 GND GND hvn L=3.5e-07 W=0.3e-06
M22 5 3 2 GND hvn L=3.5e-07 W=0.6e-06
M23 6 4 5 GND hvn L=3.5e-07 W=0.3e-06
M24 14 RB 6 GND hvn L=3.5e-07 W=0.28e-06
M25 GND 7 14 GND hvn L=3.5e-07 W=0.28e-06
M26 7 5 GND GND hvn L=3.5e-07 W=0.3e-06
M27 8 4 7 GND hvn L=3.5e-07 W=0.34e-06
M28 15 3 8 GND hvn L=3.5e-07 W=0.34e-06
M29 GND 10 15 GND hvn L=3.5e-07 W=0.34e-06
M30 16 RB GND GND hvn L=3.5e-07 W=0.34e-06
M31 10 8 16 GND hvn L=3.5e-07 W=0.34e-06
M32 Q 10 GND GND hvn L=3.5e-07 W=0.65e-06
M33 GND 10 Q GND hvn L=3.5e-07 W=0.65e-06
M34 Q 10 GND GND hvn L=3.5e-07 W=0.65e-06
M35 GND 10 Q GND hvn L=3.5e-07 W=0.65e-06
.ENDS AND2DFFRBQX4

.SUBCKT AND2SFFQBX1 QB D1 D2 SEL TD CK
M0 2 SEL VDD VDD hvp L=3.0e-07 W=0.3e-06
M1 4 TD 3 VDD hvp L=3.0e-07 W=0.9e-06
M2 VDD 2 4 VDD hvp L=3.0e-07 W=0.9e-06
M3 5 SEL VDD VDD hvp L=3.0e-07 W=0.9e-06
M4 3 D1 5 VDD hvp L=3.0e-07 W=0.9e-06
M5 6 D2 3 VDD hvp L=3.0e-07 W=0.9e-06
M6 VDD SEL 6 VDD hvp L=3.0e-07 W=0.9e-06
M7 7 CK VDD VDD hvp L=3.0e-07 W=0.28e-06
M8 8 7 VDD VDD hvp L=3.0e-07 W=0.6e-06
M9 9 8 3 VDD hvp L=3.0e-07 W=0.6e-06
M10 10 7 9 VDD hvp L=3.0e-07 W=0.35e-06
M11 VDD 11 10 VDD hvp L=3.0e-07 W=0.35e-06
M12 11 9 VDD VDD hvp L=3.0e-07 W=0.35e-06
M13 12 7 11 VDD hvp L=3.0e-07 W=0.35e-06
M14 13 8 12 VDD hvp L=3.0e-07 W=0.3e-06
M15 VDD 14 13 VDD hvp L=3.0e-07 W=0.3e-06
M16 14 12 VDD VDD hvp L=3.0e-07 W=0.3e-06
M17 QB 12 VDD VDD hvp L=3.0e-07 W=1e-06
M18 2 SEL GND GND hvn L=3.5e-07 W=0.3e-06
M19 17 TD GND GND hvn L=3.5e-07 W=0.5e-06
M20 3 SEL 17 GND hvn L=3.5e-07 W=0.5e-06
M21 18 D1 3 GND hvn L=3.5e-07 W=0.35e-06
M22 19 D2 18 GND hvn L=3.5e-07 W=0.35e-06
M23 GND 2 19 GND hvn L=3.5e-07 W=0.35e-06
M24 7 CK GND GND hvn L=3.5e-07 W=0.6e-06
M25 8 7 GND GND hvn L=3.5e-07 W=0.3e-06
M26 9 7 3 GND hvn L=3.5e-07 W=0.6e-06
M27 20 8 9 GND hvn L=3.5e-07 W=0.3e-06
M28 GND 11 20 GND hvn L=3.5e-07 W=0.3e-06
M29 11 9 GND GND hvn L=3.5e-07 W=0.28e-06
M30 12 8 11 GND hvn L=3.5e-07 W=0.28e-06
M31 21 7 12 GND hvn L=3.5e-07 W=0.3e-06
M32 GND 14 21 GND hvn L=3.5e-07 W=0.3e-06
M33 14 12 GND GND hvn L=3.5e-07 W=0.3e-06
M34 QB 12 GND GND hvn L=3.5e-07 W=0.65e-06
.ENDS AND2SFFQBX1

.SUBCKT AND2SFFQBX2 QB D1 D2 SEL TD CK
M0 2 SEL VDD VDD hvp L=3.0e-07 W=0.3e-06
M1 4 TD 3 VDD hvp L=3.0e-07 W=0.9e-06
M2 VDD 2 4 VDD hvp L=3.0e-07 W=0.9e-06
M3 5 SEL VDD VDD hvp L=3.0e-07 W=0.9e-06
M4 3 D1 5 VDD hvp L=3.0e-07 W=0.9e-06
M5 6 D2 3 VDD hvp L=3.0e-07 W=0.9e-06
M6 VDD SEL 6 VDD hvp L=3.0e-07 W=0.9e-06
M7 7 CK VDD VDD hvp L=3.0e-07 W=0.28e-06
M8 8 7 VDD VDD hvp L=3.0e-07 W=0.6e-06
M9 9 8 3 VDD hvp L=3.0e-07 W=0.6e-06
M10 10 7 9 VDD hvp L=3.0e-07 W=0.35e-06
M11 VDD 11 10 VDD hvp L=3.0e-07 W=0.35e-06
M12 11 9 VDD VDD hvp L=3.0e-07 W=0.35e-06
M13 12 7 11 VDD hvp L=3.0e-07 W=0.35e-06
M14 13 8 12 VDD hvp L=3.0e-07 W=0.3e-06
M15 VDD 14 13 VDD hvp L=3.0e-07 W=0.3e-06
M16 14 12 VDD VDD hvp L=3.0e-07 W=0.3e-06
M17 QB 12 VDD VDD hvp L=3.0e-07 W=1e-06
M18 VDD 12 QB VDD hvp L=3.0e-07 W=1e-06
M19 2 SEL GND GND hvn L=3.5e-07 W=0.3e-06
M20 17 TD GND GND hvn L=3.5e-07 W=0.5e-06
M21 3 SEL 17 GND hvn L=3.5e-07 W=0.5e-06
M22 18 D1 3 GND hvn L=3.5e-07 W=0.35e-06
M23 19 D2 18 GND hvn L=3.5e-07 W=0.35e-06
M24 GND 2 19 GND hvn L=3.5e-07 W=0.35e-06
M25 7 CK GND GND hvn L=3.5e-07 W=0.6e-06
M26 8 7 GND GND hvn L=3.5e-07 W=0.3e-06
M27 9 7 3 GND hvn L=3.5e-07 W=0.6e-06
M28 20 8 9 GND hvn L=3.5e-07 W=0.3e-06
M29 GND 11 20 GND hvn L=3.5e-07 W=0.3e-06
M30 11 9 GND GND hvn L=3.5e-07 W=0.28e-06
M31 12 8 11 GND hvn L=3.5e-07 W=0.28e-06
M32 21 7 12 GND hvn L=3.5e-07 W=0.3e-06
M33 GND 14 21 GND hvn L=3.5e-07 W=0.3e-06
M34 14 12 GND GND hvn L=3.5e-07 W=0.3e-06
M35 QB 12 GND GND hvn L=3.5e-07 W=0.65e-06
M36 GND 12 QB GND hvn L=3.5e-07 W=0.65e-06
.ENDS AND2SFFQBX2

.SUBCKT AND2SFFQBX4 QB D1 D2 SEL TD CK
M0 2 SEL VDD VDD hvp L=3.0e-07 W=0.3e-06
M1 4 TD 3 VDD hvp L=3.0e-07 W=0.9e-06
M2 VDD 2 4 VDD hvp L=3.0e-07 W=0.9e-06
M3 5 SEL VDD VDD hvp L=3.0e-07 W=0.9e-06
M4 3 D1 5 VDD hvp L=3.0e-07 W=0.9e-06
M5 6 D2 3 VDD hvp L=3.0e-07 W=0.9e-06
M6 VDD SEL 6 VDD hvp L=3.0e-07 W=0.9e-06
M7 7 CK VDD VDD hvp L=3.0e-07 W=0.28e-06
M8 8 7 VDD VDD hvp L=3.0e-07 W=0.6e-06
M9 9 8 3 VDD hvp L=3.0e-07 W=0.6e-06
M10 10 7 9 VDD hvp L=3.0e-07 W=0.35e-06
M11 VDD 11 10 VDD hvp L=3.0e-07 W=0.35e-06
M12 11 9 VDD VDD hvp L=3.0e-07 W=0.35e-06
M13 12 7 11 VDD hvp L=3.0e-07 W=0.35e-06
M14 13 8 12 VDD hvp L=3.0e-07 W=0.3e-06
M15 VDD 14 13 VDD hvp L=3.0e-07 W=0.3e-06
M16 14 12 VDD VDD hvp L=3.0e-07 W=0.3e-06
M17 QB 12 VDD VDD hvp L=3.0e-07 W=1e-06
M18 VDD 12 QB VDD hvp L=3.0e-07 W=1e-06
M19 QB 12 VDD VDD hvp L=3.0e-07 W=1e-06
M20 VDD 12 QB VDD hvp L=3.0e-07 W=1e-06
M21 2 SEL GND GND hvn L=3.5e-07 W=0.3e-06
M22 17 TD GND GND hvn L=3.5e-07 W=0.5e-06
M23 3 SEL 17 GND hvn L=3.5e-07 W=0.5e-06
M24 18 D1 3 GND hvn L=3.5e-07 W=0.35e-06
M25 19 D2 18 GND hvn L=3.5e-07 W=0.35e-06
M26 GND 2 19 GND hvn L=3.5e-07 W=0.35e-06
M27 7 CK GND GND hvn L=3.5e-07 W=0.6e-06
M28 8 7 GND GND hvn L=3.5e-07 W=0.3e-06
M29 9 7 3 GND hvn L=3.5e-07 W=0.6e-06
M30 20 8 9 GND hvn L=3.5e-07 W=0.3e-06
M31 GND 11 20 GND hvn L=3.5e-07 W=0.3e-06
M32 11 9 GND GND hvn L=3.5e-07 W=0.28e-06
M33 12 8 11 GND hvn L=3.5e-07 W=0.28e-06
M34 21 7 12 GND hvn L=3.5e-07 W=0.3e-06
M35 GND 14 21 GND hvn L=3.5e-07 W=0.3e-06
M36 14 12 GND GND hvn L=3.5e-07 W=0.3e-06
M37 QB 12 GND GND hvn L=3.5e-07 W=0.65e-06
M38 GND 12 QB GND hvn L=3.5e-07 W=0.65e-06
M39 QB 12 GND GND hvn L=3.5e-07 W=0.65e-06
M40 GND 12 QB GND hvn L=3.5e-07 W=0.65e-06
.ENDS AND2SFFQBX4

.SUBCKT AND2SFFQX1 Q D1 D2 SEL TD CK
M0 2 SEL VDD VDD hvp L=3.0e-07 W=0.3e-06
M1 4 TD 3 VDD hvp L=3.0e-07 W=0.9e-06
M2 VDD 2 4 VDD hvp L=3.0e-07 W=0.9e-06
M3 5 SEL VDD VDD hvp L=3.0e-07 W=0.9e-06
M4 3 D1 5 VDD hvp L=3.0e-07 W=0.9e-06
M5 6 D2 3 VDD hvp L=3.0e-07 W=0.9e-06
M6 VDD SEL 6 VDD hvp L=3.0e-07 W=0.9e-06
M7 7 CK VDD VDD hvp L=3.0e-07 W=0.28e-06
M8 8 7 VDD VDD hvp L=3.0e-07 W=0.6e-06
M9 9 8 3 VDD hvp L=3.0e-07 W=0.6e-06
M10 10 7 9 VDD hvp L=3.0e-07 W=0.35e-06
M11 VDD 11 10 VDD hvp L=3.0e-07 W=0.35e-06
M12 11 9 VDD VDD hvp L=3.0e-07 W=0.35e-06
M13 12 7 11 VDD hvp L=3.0e-07 W=0.35e-06
M14 13 8 12 VDD hvp L=3.0e-07 W=0.3e-06
M15 VDD 14 13 VDD hvp L=3.0e-07 W=0.3e-06
M16 VDD 12 14 VDD hvp L=3.0e-07 W=1e-06
M17 Q 14 VDD VDD hvp L=3.0e-07 W=1e-06
M18 2 SEL GND GND hvn L=3.5e-07 W=0.3e-06
M19 17 TD GND GND hvn L=3.5e-07 W=0.5e-06
M20 3 SEL 17 GND hvn L=3.5e-07 W=0.5e-06
M21 18 D1 3 GND hvn L=3.5e-07 W=0.35e-06
M22 19 D2 18 GND hvn L=3.5e-07 W=0.35e-06
M23 GND 2 19 GND hvn L=3.5e-07 W=0.35e-06
M24 7 CK GND GND hvn L=3.5e-07 W=0.6e-06
M25 8 7 GND GND hvn L=3.5e-07 W=0.3e-06
M26 9 7 3 GND hvn L=3.5e-07 W=0.6e-06
M27 20 8 9 GND hvn L=3.5e-07 W=0.3e-06
M28 GND 11 20 GND hvn L=3.5e-07 W=0.3e-06
M29 11 9 GND GND hvn L=3.5e-07 W=0.28e-06
M30 12 8 11 GND hvn L=3.5e-07 W=0.28e-06
M31 21 7 12 GND hvn L=3.5e-07 W=0.3e-06
M32 GND 14 21 GND hvn L=3.5e-07 W=0.3e-06
M33 GND 12 14 GND hvn L=3.5e-07 W=0.65e-06
M34 Q 14 GND GND hvn L=3.5e-07 W=0.65e-06
.ENDS AND2SFFQX1

.SUBCKT AND2SFFQX2 Q D1 D2 SEL TD CK
M0 2 SEL VDD VDD hvp L=3.0e-07 W=0.3e-06
M1 4 TD 3 VDD hvp L=3.0e-07 W=0.9e-06
M2 VDD 2 4 VDD hvp L=3.0e-07 W=0.9e-06
M3 5 SEL VDD VDD hvp L=3.0e-07 W=0.9e-06
M4 3 D1 5 VDD hvp L=3.0e-07 W=0.9e-06
M5 6 D2 3 VDD hvp L=3.0e-07 W=0.9e-06
M6 VDD SEL 6 VDD hvp L=3.0e-07 W=0.9e-06
M7 7 CK VDD VDD hvp L=3.0e-07 W=0.28e-06
M8 8 7 VDD VDD hvp L=3.0e-07 W=0.6e-06
M9 9 8 3 VDD hvp L=3.0e-07 W=0.6e-06
M10 10 7 9 VDD hvp L=3.0e-07 W=0.35e-06
M11 VDD 11 10 VDD hvp L=3.0e-07 W=0.35e-06
M12 11 9 VDD VDD hvp L=3.0e-07 W=0.35e-06
M13 12 7 11 VDD hvp L=3.0e-07 W=0.35e-06
M14 13 8 12 VDD hvp L=3.0e-07 W=0.3e-06
M15 VDD 14 13 VDD hvp L=3.0e-07 W=0.3e-06
M16 VDD 12 14 VDD hvp L=3.0e-07 W=1e-06
M17 Q 14 VDD VDD hvp L=3.0e-07 W=1e-06
M18 VDD 14 Q VDD hvp L=3.0e-07 W=1e-06
M19 2 SEL GND GND hvn L=3.5e-07 W=0.3e-06
M20 17 TD GND GND hvn L=3.5e-07 W=0.5e-06
M21 3 SEL 17 GND hvn L=3.5e-07 W=0.5e-06
M22 18 D1 3 GND hvn L=3.5e-07 W=0.35e-06
M23 19 D2 18 GND hvn L=3.5e-07 W=0.35e-06
M24 GND 2 19 GND hvn L=3.5e-07 W=0.35e-06
M25 7 CK GND GND hvn L=3.5e-07 W=0.6e-06
M26 8 7 GND GND hvn L=3.5e-07 W=0.3e-06
M27 9 7 3 GND hvn L=3.5e-07 W=0.6e-06
M28 20 8 9 GND hvn L=3.5e-07 W=0.3e-06
M29 GND 11 20 GND hvn L=3.5e-07 W=0.3e-06
M30 11 9 GND GND hvn L=3.5e-07 W=0.28e-06
M31 12 8 11 GND hvn L=3.5e-07 W=0.28e-06
M32 21 7 12 GND hvn L=3.5e-07 W=0.3e-06
M33 GND 14 21 GND hvn L=3.5e-07 W=0.3e-06
M34 GND 12 14 GND hvn L=3.5e-07 W=0.65e-06
M35 Q 14 GND GND hvn L=3.5e-07 W=0.65e-06
M36 GND 14 Q GND hvn L=3.5e-07 W=0.65e-06
.ENDS AND2SFFQX2

.SUBCKT AND2SFFQX4 Q D1 D2 SEL TD CK
M0 2 SEL VDD VDD hvp L=3.0e-07 W=0.3e-06
M1 4 TD 3 VDD hvp L=3.0e-07 W=0.9e-06
M2 VDD 2 4 VDD hvp L=3.0e-07 W=0.9e-06
M3 5 SEL VDD VDD hvp L=3.0e-07 W=0.9e-06
M4 3 D1 5 VDD hvp L=3.0e-07 W=0.9e-06
M5 6 D2 3 VDD hvp L=3.0e-07 W=0.9e-06
M6 VDD SEL 6 VDD hvp L=3.0e-07 W=0.9e-06
M7 7 CK VDD VDD hvp L=3.0e-07 W=0.28e-06
M8 8 7 VDD VDD hvp L=3.0e-07 W=0.6e-06
M9 9 8 3 VDD hvp L=3.0e-07 W=0.6e-06
M10 10 7 9 VDD hvp L=3.0e-07 W=0.35e-06
M11 VDD 11 10 VDD hvp L=3.0e-07 W=0.35e-06
M12 11 9 VDD VDD hvp L=3.0e-07 W=0.35e-06
M13 12 7 11 VDD hvp L=3.0e-07 W=0.35e-06
M14 13 8 12 VDD hvp L=3.0e-07 W=0.3e-06
M15 VDD 14 13 VDD hvp L=3.0e-07 W=0.3e-06
M16 VDD 12 14 VDD hvp L=3.0e-07 W=1e-06
M17 Q 14 VDD VDD hvp L=3.0e-07 W=1e-06
M18 VDD 14 Q VDD hvp L=3.0e-07 W=1e-06
M19 Q 14 VDD VDD hvp L=3.0e-07 W=1e-06
M20 VDD 14 Q VDD hvp L=3.0e-07 W=1e-06
M21 2 SEL GND GND hvn L=3.5e-07 W=0.3e-06
M22 17 TD GND GND hvn L=3.5e-07 W=0.5e-06
M23 3 SEL 17 GND hvn L=3.5e-07 W=0.5e-06
M24 18 D1 3 GND hvn L=3.5e-07 W=0.35e-06
M25 19 D2 18 GND hvn L=3.5e-07 W=0.35e-06
M26 GND 2 19 GND hvn L=3.5e-07 W=0.35e-06
M27 7 CK GND GND hvn L=3.5e-07 W=0.6e-06
M28 8 7 GND GND hvn L=3.5e-07 W=0.3e-06
M29 9 7 3 GND hvn L=3.5e-07 W=0.6e-06
M30 20 8 9 GND hvn L=3.5e-07 W=0.3e-06
M31 GND 11 20 GND hvn L=3.5e-07 W=0.3e-06
M32 11 9 GND GND hvn L=3.5e-07 W=0.28e-06
M33 12 8 11 GND hvn L=3.5e-07 W=0.28e-06
M34 21 7 12 GND hvn L=3.5e-07 W=0.3e-06
M35 GND 14 21 GND hvn L=3.5e-07 W=0.3e-06
M36 GND 12 14 GND hvn L=3.5e-07 W=0.65e-06
M37 Q 14 GND GND hvn L=3.5e-07 W=0.65e-06
M38 GND 14 Q GND hvn L=3.5e-07 W=0.65e-06
M39 Q 14 GND GND hvn L=3.5e-07 W=0.65e-06
M40 GND 14 Q GND hvn L=3.5e-07 W=0.65e-06
.ENDS AND2SFFQX4

.SUBCKT AND2SFFRBQBX1 QB D1 D2 SEL TD RB CK
M0 VDD SEL 1 VDD hvp L=3.0e-07 W=0.3e-06
M1 3 SEL VDD VDD hvp L=3.0e-07 W=0.9e-06
M2 4 D2 3 VDD hvp L=3.0e-07 W=0.9e-06
M3 5 D1 4 VDD hvp L=3.0e-07 W=0.9e-06
M4 VDD SEL 5 VDD hvp L=3.0e-07 W=0.9e-06
M5 6 1 VDD VDD hvp L=3.0e-07 W=0.9e-06
M6 4 TD 6 VDD hvp L=3.0e-07 W=0.9e-06
M7 VDD CK 7 VDD hvp L=3.0e-07 W=0.28e-06
M8 8 7 VDD VDD hvp L=3.0e-07 W=0.6e-06
M9 9 8 4 VDD hvp L=3.0e-07 W=0.60e-06
M10 10 7 9 VDD hvp L=3.0e-07 W=0.3e-06
M11 VDD RB 10 VDD hvp L=3.0e-07 W=0.3e-06
M12 10 11 VDD VDD hvp L=3.0e-07 W=0.3e-06
M13 11 9 VDD VDD hvp L=3.0e-07 W=0.56e-06
M14 12 7 11 VDD hvp L=3.0e-07 W=0.56e-06
M15 13 8 12 VDD hvp L=3.0e-07 W=0.28e-06
M16 VDD 14 13 VDD hvp L=3.0e-07 W=0.28e-06
M17 14 RB VDD VDD hvp L=3.0e-07 W=0.63e-06
M18 VDD 12 14 VDD hvp L=3.0e-07 W=0.75e-06
M19 QB 12 VDD VDD hvp L=3.0e-07 W=1e-06
M20 GND SEL 1 GND hvn L=3.5e-07 W=0.3e-06
M21 17 1 GND GND hvn L=3.5e-07 W=0.35e-06
M22 18 D2 17 GND hvn L=3.5e-07 W=0.35e-06
M23 4 D1 18 GND hvn L=3.5e-07 W=0.35e-06
M24 19 SEL 4 GND hvn L=3.5e-07 W=0.5e-06
M25 GND TD 19 GND hvn L=3.5e-07 W=0.5e-06
M26 7 CK GND GND hvn L=3.5e-07 W=0.6e-06
M27 8 7 GND GND hvn L=3.5e-07 W=0.3e-06
M28 9 7 4 GND hvn L=3.5e-07 W=0.6e-06
M29 10 8 9 GND hvn L=3.5e-07 W=0.28e-06
M30 20 RB 10 GND hvn L=3.5e-07 W=0.3e-06
M31 GND 11 20 GND hvn L=3.5e-07 W=0.3e-06
M32 11 9 GND GND hvn L=3.5e-07 W=0.28e-06
M33 12 8 11 GND hvn L=3.5e-07 W=0.3e-06
M34 21 7 12 GND hvn L=3.5e-07 W=0.28e-06
M35 GND 14 21 GND hvn L=3.5e-07 W=0.3e-06
M36 22 RB GND GND hvn L=3.5e-07 W=0.46e-06
M37 14 12 22 GND hvn L=3.5e-07 W=0.46e-06
M38 QB 12 GND GND hvn L=3.5e-07 W=0.65e-06
.ENDS AND2SFFRBQBX1

.SUBCKT AND2SFFRBQBX2 QB D1 D2 SEL TD RB CK
M0 VDD SEL 1 VDD hvp L=3.0e-07 W=0.3e-06
M1 3 SEL VDD VDD hvp L=3.0e-07 W=0.9e-06
M2 4 D2 3 VDD hvp L=3.0e-07 W=0.9e-06
M3 5 D1 4 VDD hvp L=3.0e-07 W=0.9e-06
M4 VDD SEL 5 VDD hvp L=3.0e-07 W=0.9e-06
M5 6 1 VDD VDD hvp L=3.0e-07 W=0.9e-06
M6 4 TD 6 VDD hvp L=3.0e-07 W=0.9e-06
M7 VDD CK 7 VDD hvp L=3.0e-07 W=0.28e-06
M8 8 7 VDD VDD hvp L=3.0e-07 W=0.6e-06
M9 9 8 4 VDD hvp L=3.0e-07 W=0.6e-06
M10 10 7 9 VDD hvp L=3.0e-07 W=0.3e-06
M11 VDD RB 10 VDD hvp L=3.0e-07 W=0.3e-06
M12 10 11 VDD VDD hvp L=3.0e-07 W=0.3e-06
M13 11 9 VDD VDD hvp L=3.0e-07 W=0.56e-06
M14 12 7 11 VDD hvp L=3.0e-07 W=0.56e-06
M15 13 8 12 VDD hvp L=3.0e-07 W=0.28e-06
M16 VDD 14 13 VDD hvp L=3.0e-07 W=0.28e-06
M17 14 RB VDD VDD hvp L=3.0e-07 W=0.63e-06
M18 VDD 12 14 VDD hvp L=3.0e-07 W=0.75e-06
M19 QB 12 VDD VDD hvp L=3.0e-07 W=1e-06
M20 VDD 12 QB VDD hvp L=3.0e-07 W=1e-06
M21 GND SEL 1 GND hvn L=3.5e-07 W=0.3e-06
M22 17 1 GND GND hvn L=3.5e-07 W=0.35e-06
M23 18 D2 17 GND hvn L=3.5e-07 W=0.35e-06
M24 4 D1 18 GND hvn L=3.5e-07 W=0.35e-06
M25 19 SEL 4 GND hvn L=3.5e-07 W=0.5e-06
M26 GND TD 19 GND hvn L=3.5e-07 W=0.5e-06
M27 7 CK GND GND hvn L=3.5e-07 W=0.6e-06
M28 8 7 GND GND hvn L=3.5e-07 W=0.3e-06
M29 9 7 4 GND hvn L=3.5e-07 W=0.6e-06
M30 10 8 9 GND hvn L=3.5e-07 W=0.28e-06
M31 20 RB 10 GND hvn L=3.5e-07 W=0.3e-06
M32 GND 11 20 GND hvn L=3.5e-07 W=0.3e-06
M33 11 9 GND GND hvn L=3.5e-07 W=0.28e-06
M34 12 8 11 GND hvn L=3.5e-07 W=0.3e-06
M35 21 7 12 GND hvn L=3.5e-07 W=0.28e-06
M36 GND 14 21 GND hvn L=3.5e-07 W=0.3e-06
M37 22 RB GND GND hvn L=3.5e-07 W=0.46e-06
M38 14 12 22 GND hvn L=3.5e-07 W=0.46e-06
M39 QB 12 GND GND hvn L=3.5e-07 W=0.65e-06
M40 GND 12 QB GND hvn L=3.5e-07 W=0.65e-06
.ENDS AND2SFFRBQBX2

.SUBCKT AND2SFFRBQBX4 QB D1 D2 SEL TD RB CK
M0 VDD SEL 1 VDD hvp L=3.0e-07 W=0.3e-06
M1 3 SEL VDD VDD hvp L=3.0e-07 W=0.9e-06
M2 4 D2 3 VDD hvp L=3.0e-07 W=0.9e-06
M3 5 D1 4 VDD hvp L=3.0e-07 W=0.9e-06
M4 VDD SEL 5 VDD hvp L=3.0e-07 W=0.9e-06
M5 6 1 VDD VDD hvp L=3.0e-07 W=0.9e-06
M6 4 TD 6 VDD hvp L=3.0e-07 W=0.9e-06
M7 VDD CK 7 VDD hvp L=3.0e-07 W=0.28e-06
M8 8 7 VDD VDD hvp L=3.0e-07 W=0.6e-06
M9 9 8 4 VDD hvp L=3.0e-07 W=0.60e-06
M10 10 7 9 VDD hvp L=3.0e-07 W=0.3e-06
M11 VDD RB 10 VDD hvp L=3.0e-07 W=0.3e-06
M12 10 11 VDD VDD hvp L=3.0e-07 W=0.3e-06
M13 11 9 VDD VDD hvp L=3.0e-07 W=0.56e-06
M14 12 7 11 VDD hvp L=3.0e-07 W=0.56e-06
M15 13 8 12 VDD hvp L=3.0e-07 W=0.28e-06
M16 VDD 14 13 VDD hvp L=3.0e-07 W=0.28e-06
M17 14 RB VDD VDD hvp L=3.0e-07 W=0.63e-06
M18 VDD 12 14 VDD hvp L=3.0e-07 W=0.75e-06
M19 QB 12 VDD VDD hvp L=3.0e-07 W=1e-06
M20 VDD 12 QB VDD hvp L=3.0e-07 W=1e-06
M21 QB 12 VDD VDD hvp L=3.0e-07 W=1e-06
M22 VDD 12 QB VDD hvp L=3.0e-07 W=1e-06
M23 GND SEL 1 GND hvn L=3.5e-07 W=0.3e-06
M24 17 1 GND GND hvn L=3.5e-07 W=0.35e-06
M25 18 D2 17 GND hvn L=3.5e-07 W=0.35e-06
M26 4 D1 18 GND hvn L=3.5e-07 W=0.35e-06
M27 19 SEL 4 GND hvn L=3.5e-07 W=0.5e-06
M28 GND TD 19 GND hvn L=3.5e-07 W=0.5e-06
M29 7 CK GND GND hvn L=3.5e-07 W=0.6e-06
M30 8 7 GND GND hvn L=3.5e-07 W=0.3e-06
M31 9 7 4 GND hvn L=3.5e-07 W=0.6e-06
M32 10 8 9 GND hvn L=3.5e-07 W=0.28e-06
M33 20 RB 10 GND hvn L=3.5e-07 W=0.3e-06
M34 GND 11 20 GND hvn L=3.5e-07 W=0.3e-06
M35 11 9 GND GND hvn L=3.5e-07 W=0.28e-06
M36 12 8 11 GND hvn L=3.5e-07 W=0.3e-06
M37 21 7 12 GND hvn L=3.5e-07 W=0.28e-06
M38 GND 14 21 GND hvn L=3.5e-07 W=0.3e-06
M39 22 RB GND GND hvn L=3.5e-07 W=0.46e-06
M40 14 12 22 GND hvn L=3.5e-07 W=0.46e-06
M41 QB 12 GND GND hvn L=3.5e-07 W=0.65e-06
M42 GND 12 QB GND hvn L=3.5e-07 W=0.65e-06
M43 QB 12 GND GND hvn L=3.5e-07 W=0.65e-06
M44 GND 12 QB GND hvn L=3.5e-07 W=0.65e-06
.ENDS AND2SFFRBQBX4

.SUBCKT AND2SFFRBQX1 Q D1 D2 SEL TD RB CK
M0 VDD SEL 1 VDD hvp L=3.0e-07 W=0.3e-06
M1 3 SEL VDD VDD hvp L=3.0e-07 W=0.9e-06
M2 4 D2 3 VDD hvp L=3.0e-07 W=0.9e-06
M3 5 D1 4 VDD hvp L=3.0e-07 W=0.9e-06
M4 VDD SEL 5 VDD hvp L=3.0e-07 W=0.9e-06
M5 6 1 VDD VDD hvp L=3.0e-07 W=0.9e-06
M6 4 TD 6 VDD hvp L=3.0e-07 W=0.9e-06
M7 VDD CK 7 VDD hvp L=3.0e-07 W=0.28e-06
M8 8 7 VDD VDD hvp L=3.0e-07 W=0.6e-06
M9 9 8 4 VDD hvp L=3.0e-07 W=0.6e-06
M10 10 7 9 VDD hvp L=3.0e-07 W=0.3e-06
M11 VDD RB 10 VDD hvp L=3.0e-07 W=0.3e-06
M12 10 11 VDD VDD hvp L=3.0e-07 W=0.3e-06
M13 11 9 VDD VDD hvp L=3.0e-07 W=0.56e-06
M14 12 7 11 VDD hvp L=3.0e-07 W=0.56e-06
M15 13 8 12 VDD hvp L=3.0e-07 W=0.28e-06
M16 VDD 14 13 VDD hvp L=3.0e-07 W=0.28e-06
M17 14 RB VDD VDD hvp L=3.0e-07 W=0.63e-06
M18 VDD 12 14 VDD hvp L=3.0e-07 W=0.75e-06
M19 Q 14 VDD VDD hvp L=3.0e-07 W=1e-06
M20 GND SEL 1 GND hvn L=3.5e-07 W=0.3e-06
M21 17 1 GND GND hvn L=3.5e-07 W=0.35e-06
M22 18 D2 17 GND hvn L=3.5e-07 W=0.35e-06
M23 4 D1 18 GND hvn L=3.5e-07 W=0.35e-06
M24 19 SEL 4 GND hvn L=3.5e-07 W=0.5e-06
M25 GND TD 19 GND hvn L=3.5e-07 W=0.5e-06
M26 7 CK GND GND hvn L=3.5e-07 W=0.6e-06
M27 8 7 GND GND hvn L=3.5e-07 W=0.3e-06
M28 9 7 4 GND hvn L=3.5e-07 W=0.6e-06
M29 10 8 9 GND hvn L=3.5e-07 W=0.28e-06
M30 20 RB 10 GND hvn L=3.5e-07 W=0.3e-06
M31 GND 11 20 GND hvn L=3.5e-07 W=0.3e-06
M32 11 9 GND GND hvn L=3.5e-07 W=0.28e-06
M33 12 8 11 GND hvn L=3.5e-07 W=0.3e-06
M34 21 7 12 GND hvn L=3.5e-07 W=0.28e-06
M35 GND 14 21 GND hvn L=3.5e-07 W=0.3e-06
M36 22 RB GND GND hvn L=3.5e-07 W=0.46e-06
M37 14 12 22 GND hvn L=3.5e-07 W=0.46e-06
M38 Q 14 GND GND hvn L=3.5e-07 W=0.65e-06
.ENDS AND2SFFRBQX1

.SUBCKT AND2SFFRBQX2 Q D1 D2 SEL TD RB CK
M0 VDD SEL 1 VDD hvp L=3.0e-07 W=0.3e-06
M1 3 SEL VDD VDD hvp L=3.0e-07 W=0.9e-06
M2 4 D2 3 VDD hvp L=3.0e-07 W=0.9e-06
M3 5 D1 4 VDD hvp L=3.0e-07 W=0.9e-06
M4 VDD SEL 5 VDD hvp L=3.0e-07 W=0.9e-06
M5 6 1 VDD VDD hvp L=3.0e-07 W=0.9e-06
M6 4 TD 6 VDD hvp L=3.0e-07 W=0.9e-06
M7 VDD CK 7 VDD hvp L=3.0e-07 W=0.28e-06
M8 8 7 VDD VDD hvp L=3.0e-07 W=0.6e-06
M9 9 8 4 VDD hvp L=3.0e-07 W=0.6e-06
M10 10 7 9 VDD hvp L=3.0e-07 W=0.3e-06
M11 VDD RB 10 VDD hvp L=3.0e-07 W=0.3e-06
M12 10 11 VDD VDD hvp L=3.0e-07 W=0.3e-06
M13 11 9 VDD VDD hvp L=3.0e-07 W=0.56e-06
M14 12 7 11 VDD hvp L=3.0e-07 W=0.56e-06
M15 13 8 12 VDD hvp L=3.0e-07 W=0.28e-06
M16 VDD 14 13 VDD hvp L=3.0e-07 W=0.28e-06
M17 14 RB VDD VDD hvp L=3.0e-07 W=0.63e-06
M18 VDD 12 14 VDD hvp L=3.0e-07 W=0.75e-06
M19 Q 14 VDD VDD hvp L=3.0e-07 W=1e-06
M20 VDD 14 Q VDD hvp L=3.0e-07 W=1e-06
M21 GND SEL 1 GND hvn L=3.5e-07 W=0.3e-06
M22 17 1 GND GND hvn L=3.5e-07 W=0.35e-06
M23 18 D2 17 GND hvn L=3.5e-07 W=0.35e-06
M24 4 D1 18 GND hvn L=3.5e-07 W=0.35e-06
M25 19 SEL 4 GND hvn L=3.5e-07 W=0.5e-06
M26 GND TD 19 GND hvn L=3.5e-07 W=0.5e-06
M27 7 CK GND GND hvn L=3.5e-07 W=0.6e-06
M28 8 7 GND GND hvn L=3.5e-07 W=0.3e-06
M29 9 7 4 GND hvn L=3.5e-07 W=0.6e-06
M30 10 8 9 GND hvn L=3.5e-07 W=0.28e-06
M31 20 RB 10 GND hvn L=3.5e-07 W=0.3e-06
M32 GND 11 20 GND hvn L=3.5e-07 W=0.3e-06
M33 11 9 GND GND hvn L=3.5e-07 W=0.28e-06
M34 12 8 11 GND hvn L=3.5e-07 W=0.3e-06
M35 21 7 12 GND hvn L=3.5e-07 W=0.28e-06
M36 GND 14 21 GND hvn L=3.5e-07 W=0.3e-06
M37 22 RB GND GND hvn L=3.5e-07 W=0.46e-06
M38 14 12 22 GND hvn L=3.5e-07 W=0.46e-06
M39 Q 14 GND GND hvn L=3.5e-07 W=0.65e-06
M40 GND 14 Q GND hvn L=3.5e-07 W=0.65e-06
.ENDS AND2SFFRBQX2

.SUBCKT AND2SFFRBQX4 Q D1 D2 SEL TD RB CK
M0 VDD SEL 1 VDD hvp L=3.0e-07 W=0.3e-06
M1 3 SEL VDD VDD hvp L=3.0e-07 W=0.9e-06
M2 4 D2 3 VDD hvp L=3.0e-07 W=0.9e-06
M3 5 D1 4 VDD hvp L=3.0e-07 W=0.9e-06
M4 VDD SEL 5 VDD hvp L=3.0e-07 W=0.9e-06
M5 6 1 VDD VDD hvp L=3.0e-07 W=0.9e-06
M6 4 TD 6 VDD hvp L=3.0e-07 W=0.9e-06
M7 VDD CK 7 VDD hvp L=3.0e-07 W=0.28e-06
M8 8 7 VDD VDD hvp L=3.0e-07 W=0.6e-06
M9 9 8 4 VDD hvp L=3.0e-07 W=0.6e-06
M10 10 7 9 VDD hvp L=3.0e-07 W=0.3e-06
M11 VDD RB 10 VDD hvp L=3.0e-07 W=0.3e-06
M12 10 11 VDD VDD hvp L=3.0e-07 W=0.3e-06
M13 11 9 VDD VDD hvp L=3.0e-07 W=0.56e-06
M14 12 7 11 VDD hvp L=3.0e-07 W=0.56e-06
M15 13 8 12 VDD hvp L=3.0e-07 W=0.28e-06
M16 VDD 14 13 VDD hvp L=3.0e-07 W=0.28e-06
M17 14 RB VDD VDD hvp L=3.0e-07 W=0.63e-06
M18 VDD 12 14 VDD hvp L=3.0e-07 W=0.75e-06
M19 Q 14 VDD VDD hvp L=3.0e-07 W=1e-06
M20 VDD 14 Q VDD hvp L=3.0e-07 W=1e-06
M21 Q 14 VDD VDD hvp L=3.0e-07 W=1e-06
M22 VDD 14 Q VDD hvp L=3.0e-07 W=1e-06
M23 GND SEL 1 GND hvn L=3.5e-07 W=0.3e-06
M24 17 1 GND GND hvn L=3.5e-07 W=0.35e-06
M25 18 D2 17 GND hvn L=3.5e-07 W=0.35e-06
M26 4 D1 18 GND hvn L=3.5e-07 W=0.35e-06
M27 19 SEL 4 GND hvn L=3.5e-07 W=0.5e-06
M28 GND TD 19 GND hvn L=3.5e-07 W=0.5e-06
M29 7 CK GND GND hvn L=3.5e-07 W=0.6e-06
M30 8 7 GND GND hvn L=3.5e-07 W=0.3e-06
M31 9 7 4 GND hvn L=3.5e-07 W=0.6e-06
M32 10 8 9 GND hvn L=3.5e-07 W=0.28e-06
M33 20 RB 10 GND hvn L=3.5e-07 W=0.3e-06
M34 GND 11 20 GND hvn L=3.5e-07 W=0.3e-06
M35 11 9 GND GND hvn L=3.5e-07 W=0.28e-06
M36 12 8 11 GND hvn L=3.5e-07 W=0.3e-06
M37 21 7 12 GND hvn L=3.5e-07 W=0.28e-06
M38 GND 14 21 GND hvn L=3.5e-07 W=0.3e-06
M39 22 RB GND GND hvn L=3.5e-07 W=0.46e-06
M40 14 12 22 GND hvn L=3.5e-07 W=0.46e-06
M41 Q 14 GND GND hvn L=3.5e-07 W=0.65e-06
M42 GND 14 Q GND hvn L=3.5e-07 W=0.65e-06
M43 Q 14 GND GND hvn L=3.5e-07 W=0.65e-06
M44 GND 14 Q GND hvn L=3.5e-07 W=0.65e-06
.ENDS AND2SFFRBQX4

.SUBCKT AND2X1 O I1 I2
M0 2 I1 VDD VDD hvp L=3.0e-07 W=1e-06
M1 VDD I2 2 VDD hvp L=3.0e-07 W=1e-06
M2 O 2 VDD VDD hvp L=3.0e-07 W=1e-06
M3 4 I1 2 GND hvn L=3.5e-07 W=0.65e-06
M4 GND I2 4 GND hvn L=3.5e-07 W=0.65e-06
M5 O 2 GND GND hvn L=3.5e-07 W=0.65e-06
.ENDS AND2X1

.SUBCKT AND2X2 O I1 I2
M0 2 I1 VDD VDD hvp L=3.0e-07 W=1e-06
M1 VDD I2 2 VDD hvp L=3.0e-07 W=1e-06
M2 O 2 VDD VDD hvp L=3.0e-07 W=1e-06
M3 VDD 2 O VDD hvp L=3.0e-07 W=1e-06
M4 4 I1 2 GND hvn L=3.5e-07 W=0.65e-06
M5 GND I2 4 GND hvn L=3.5e-07 W=0.65e-06
M6 O 2 GND GND hvn L=3.5e-07 W=0.65e-06
M7 GND 2 O GND hvn L=3.5e-07 W=0.65e-06
.ENDS AND2X2

.SUBCKT AND2X3 O I1 I2
M0 2 I1 VDD VDD hvp L=3.0e-07 W=1e-06
M1 VDD I2 2 VDD hvp L=3.0e-07 W=1e-06
M2 O 2 VDD VDD hvp L=3.0e-07 W=1e-06
M3 VDD 2 O VDD hvp L=3.0e-07 W=1e-06
M4 O 2 VDD VDD hvp L=3.0e-07 W=1e-06
M5 4 I1 2 GND hvn L=3.5e-07 W=0.65e-06
M6 GND I2 4 GND hvn L=3.5e-07 W=0.65e-06
M7 O 2 GND GND hvn L=3.5e-07 W=0.65e-06
M8 GND 2 O GND hvn L=3.5e-07 W=0.65e-06
M9 O 2 GND GND hvn L=3.5e-07 W=0.65e-06
.ENDS AND2X3

.SUBCKT AND2X4 O I1 I2
M0 2 I1 VDD VDD hvp L=3.0e-07 W=1e-06
M1 VDD I2 2 VDD hvp L=3.0e-07 W=1e-06
M2 O 2 VDD VDD hvp L=3.0e-07 W=1e-06
M3 VDD 2 O VDD hvp L=3.0e-07 W=1e-06
M4 O 2 VDD VDD hvp L=3.0e-07 W=1e-06
M5 VDD 2 O VDD hvp L=3.0e-07 W=1e-06
M6 4 I1 2 GND hvn L=3.5e-07 W=0.65e-06
M7 GND I2 4 GND hvn L=3.5e-07 W=0.65e-06
M8 O 2 GND GND hvn L=3.5e-07 W=0.65e-06
M9 GND 2 O GND hvn L=3.5e-07 W=0.65e-06
M10 O 2 GND GND hvn L=3.5e-07 W=0.65e-06
M11 GND 2 O GND hvn L=3.5e-07 W=0.65e-06
.ENDS AND2X4

.SUBCKT AND2X6 O I1 I2
M0 2 I1 VDD VDD hvp L=3.0e-07 W=1e-06
M1 VDD I2 2 VDD hvp L=3.0e-07 W=1e-06
M2 O 2 VDD VDD hvp L=3.0e-07 W=1e-06
M3 VDD 2 O VDD hvp L=3.0e-07 W=1e-06
M4 O 2 VDD VDD hvp L=3.0e-07 W=1e-06
M5 VDD 2 O VDD hvp L=3.0e-07 W=1e-06
M6 O 2 VDD VDD hvp L=3.0e-07 W=1e-06
M7 VDD 2 O VDD hvp L=3.0e-07 W=1e-06
M8 4 I1 2 GND hvn L=3.5e-07 W=0.65e-06
M9 GND I2 4 GND hvn L=3.5e-07 W=0.65e-06
M10 O 2 GND GND hvn L=3.5e-07 W=0.65e-06
M11 GND 2 O GND hvn L=3.5e-07 W=0.65e-06
M12 O 2 GND GND hvn L=3.5e-07 W=0.65e-06
M13 GND 2 O GND hvn L=3.5e-07 W=0.65e-06
M14 O 2 GND GND hvn L=3.5e-07 W=0.65e-06
M15 GND 2 O GND hvn L=3.5e-07 W=0.65e-06
.ENDS AND2X6

.SUBCKT AND3B1X1 O B3 I1 I2
M0 2 I1 VDD VDD hvp L=3.0e-07 W=0.9e-06
M1 VDD I2 2 VDD hvp L=3.0e-07 W=0.9e-06
M2 3 B3 VDD VDD hvp L=3.0e-07 W=0.9e-06
M3 O 2 3 VDD hvp L=3.0e-07 W=0.9e-06
M4 5 I1 2 GND hvn L=3.5e-07 W=0.6e-06
M5 GND I2 5 GND hvn L=3.5e-07 W=0.6e-06
M6 O B3 GND GND hvn L=3.5e-07 W=0.6e-06
M7 GND 2 O GND hvn L=3.5e-07 W=0.6e-06
.ENDS AND3B1X1

.SUBCKT AND3B1X2 O B3 I1 I2
M0 VDD I2 1 VDD hvp L=3.0e-07 W=0.9e-06
M1 1 I1 VDD VDD hvp L=3.0e-07 W=0.9e-06
M2 4 1 O VDD hvp L=3.0e-07 W=0.9e-06
M3 VDD B3 4 VDD hvp L=3.0e-07 W=0.9e-06
M4 5 B3 VDD VDD hvp L=3.0e-07 W=0.9e-06
M5 O 1 5 VDD hvp L=3.0e-07 W=0.9e-06
M6 7 I2 GND GND hvn L=3.5e-07 W=0.6e-06
M7 1 I1 7 GND hvn L=3.5e-07 W=0.6e-06
M8 GND 1 O GND hvn L=3.5e-07 W=0.6e-06
M9 O B3 GND GND hvn L=3.5e-07 W=0.6e-06
M10 GND B3 O GND hvn L=3.5e-07 W=0.6e-06
M11 O 1 GND GND hvn L=3.5e-07 W=0.6e-06
.ENDS AND3B1X2

.SUBCKT AND3B1X4 O B3 I1 I2
M0 VDD I2 1 VDD hvp L=3.0e-07 W=0.9e-06
M1 1 I1 VDD VDD hvp L=3.0e-07 W=0.9e-06
M2 4 1 O VDD hvp L=3.0e-07 W=0.9e-06
M3 VDD B3 4 VDD hvp L=3.0e-07 W=0.9e-06
M4 5 B3 VDD VDD hvp L=3.0e-07 W=0.9e-06
M5 O 1 5 VDD hvp L=3.0e-07 W=0.9e-06
M6 6 1 O VDD hvp L=3.0e-07 W=0.9e-06
M7 VDD B3 6 VDD hvp L=3.0e-07 W=0.9e-06
M8 7 B3 VDD VDD hvp L=3.0e-07 W=0.9e-06
M9 O 1 7 VDD hvp L=3.0e-07 W=0.9e-06
M10 9 I2 GND GND hvn L=3.5e-07 W=0.6e-06
M11 1 I1 9 GND hvn L=3.5e-07 W=0.6e-06
M12 GND 1 O GND hvn L=3.5e-07 W=0.6e-06
M13 O B3 GND GND hvn L=3.5e-07 W=0.6e-06
M14 GND B3 O GND hvn L=3.5e-07 W=0.6e-06
M15 O 1 GND GND hvn L=3.5e-07 W=0.6e-06
M16 GND 1 O GND hvn L=3.5e-07 W=0.6e-06
M17 O B3 GND GND hvn L=3.5e-07 W=0.6e-06
M18 GND B3 O GND hvn L=3.5e-07 W=0.6e-06
M19 O 1 GND GND hvn L=3.5e-07 W=0.6e-06
.ENDS AND3B1X4

.SUBCKT AND3B2X1 O B2 B3 I1
M0 VDD I1 1 VDD hvp L=3.0e-07 W=1e-06
M1 3 B2 VDD VDD hvp L=3.0e-07 W=1e-06
M2 4 B3 3 VDD hvp L=3.0e-07 W=1e-06
M3 O 1 4 VDD hvp L=3.0e-07 W=1e-06
M4 GND I1 1 GND hvn L=3.5e-07 W=0.65e-06
M5 O B2 GND GND hvn L=3.5e-07 W=0.65e-06
M6 GND B3 O GND hvn L=3.5e-07 W=0.65e-06
M7 O 1 GND GND hvn L=3.5e-07 W=0.65e-06
.ENDS AND3B2X1

.SUBCKT AND3B2X2 O B2 B3 I1
M0 VDD I1 1 VDD hvp L=3.0e-07 W=0.9e-06
M1 3 B2 VDD VDD hvp L=3.0e-07 W=0.9e-06
M2 4 B3 3 VDD hvp L=3.0e-07 W=0.9e-06
M3 O 1 4 VDD hvp L=3.0e-07 W=0.9e-06
M4 6 1 O VDD hvp L=3.0e-07 W=0.9e-06
M5 7 B2 6 VDD hvp L=3.0e-07 W=0.9e-06
M6 VDD B3 7 VDD hvp L=3.0e-07 W=0.9e-06
M7 GND I1 1 GND hvn L=3.5e-07 W=0.6e-06
M8 O B2 GND GND hvn L=3.5e-07 W=0.6e-06
M9 GND B3 O GND hvn L=3.5e-07 W=0.6e-06
M10 O 1 GND GND hvn L=3.5e-07 W=0.6e-06
M11 GND 1 O GND hvn L=3.5e-07 W=0.6e-06
M12 O B2 GND GND hvn L=3.5e-07 W=0.6e-06
M13 GND B3 O GND hvn L=3.5e-07 W=0.6e-06
.ENDS AND3B2X2

.SUBCKT AND3B2X4 O B2 B3 I1
M0 VDD I1 1 VDD hvp L=3.0e-07 W=0.55e-06
M1 3 B2 VDD VDD hvp L=3.0e-07 W=0.55e-06
M2 4 B3 3 VDD hvp L=3.0e-07 W=0.55e-06
M3 O 1 4 VDD hvp L=3.0e-07 W=0.55e-06
M4 6 1 O VDD hvp L=3.0e-07 W=0.55e-06
M5 7 B2 6 VDD hvp L=3.0e-07 W=0.55e-06
M6 VDD B3 7 VDD hvp L=3.0e-07 W=0.55e-06
M7 8 B3 VDD VDD hvp L=3.0e-07 W=0.55e-06
M8 9 B2 8 VDD hvp L=3.0e-07 W=0.55e-06
M9 O 1 9 VDD hvp L=3.0e-07 W=0.55e-06
M10 10 1 O VDD hvp L=3.0e-07 W=0.55e-06
M11 11 B2 10 VDD hvp L=3.0e-07 W=0.55e-06
M12 VDD B3 11 VDD hvp L=3.0e-07 W=0.55e-06
M13 GND I1 1 GND hvn L=3.5e-07 W=0.4e-06
M14 O B2 GND GND hvn L=3.5e-07 W=0.4e-06
M15 GND B3 O GND hvn L=3.5e-07 W=0.4e-06
M16 O 1 GND GND hvn L=3.5e-07 W=0.4e-06
M17 GND 1 O GND hvn L=3.5e-07 W=0.4e-06
M18 O B2 GND GND hvn L=3.5e-07 W=0.4e-06
M19 GND B3 O GND hvn L=3.5e-07 W=0.4e-06
M20 O B3 GND GND hvn L=3.5e-07 W=0.4e-06
M21 GND B2 O GND hvn L=3.5e-07 W=0.4e-06
M22 O 1 GND GND hvn L=3.5e-07 W=0.4e-06
M23 GND 1 O GND hvn L=3.5e-07 W=0.4e-06
M24 O B2 GND GND hvn L=3.5e-07 W=0.4e-06
M25 GND B3 O GND hvn L=3.5e-07 W=0.4e-06
.ENDS AND3B2X4

.SUBCKT AND3X1 O I1 I2 I3
M0 VDD I1 1 VDD hvp L=3.0e-07 W=1e-06
M1 1 I2 VDD VDD hvp L=3.0e-07 W=1e-06
M2 VDD I3 1 VDD hvp L=3.0e-07 W=1e-06
M3 O 1 VDD VDD hvp L=3.0e-07 W=1e-06
M4 4 I1 1 GND hvn L=3.5e-07 W=0.65e-06
M5 5 I2 4 GND hvn L=3.5e-07 W=0.65e-06
M6 GND I3 5 GND hvn L=3.5e-07 W=0.65e-06
M7 O 1 GND GND hvn L=3.5e-07 W=0.65e-06
.ENDS AND3X1

.SUBCKT AND3X2 O I1 I2 I3
M0 VDD I1 1 VDD hvp L=3.0e-07 W=1e-06
M1 1 I2 VDD VDD hvp L=3.0e-07 W=1e-06
M2 VDD I3 1 VDD hvp L=3.0e-07 W=1e-06
M3 O 1 VDD VDD hvp L=3.0e-07 W=1e-06
M4 VDD 1 O VDD hvp L=3.0e-07 W=1e-06
M5 4 I1 1 GND hvn L=3.5e-07 W=0.65e-06
M6 5 I2 4 GND hvn L=3.5e-07 W=0.65e-06
M7 GND I3 5 GND hvn L=3.5e-07 W=0.65e-06
M8 O 1 GND GND hvn L=3.5e-07 W=0.65e-06
M9 GND 1 O GND hvn L=3.5e-07 W=0.65e-06
.ENDS AND3X2

.SUBCKT AND3X3 O I1 I2 I3
M0 VDD I1 1 VDD hvp L=3.0e-07 W=1e-06
M1 1 I2 VDD VDD hvp L=3.0e-07 W=1e-06
M2 VDD I3 1 VDD hvp L=3.0e-07 W=1e-06
M3 O 1 VDD VDD hvp L=3.0e-07 W=1e-06
M4 VDD 1 O VDD hvp L=3.0e-07 W=1e-06
M5 O 1 VDD VDD hvp L=3.0e-07 W=1e-06
M6 4 I1 1 GND hvn L=3.5e-07 W=0.65e-06
M7 5 I2 4 GND hvn L=3.5e-07 W=0.65e-06
M8 GND I3 5 GND hvn L=3.5e-07 W=0.65e-06
M9 O 1 GND GND hvn L=3.5e-07 W=0.65e-06
M10 GND 1 O GND hvn L=3.5e-07 W=0.65e-06
M11 O 1 GND GND hvn L=3.5e-07 W=0.65e-06
.ENDS AND3X3

.SUBCKT AND3X4 O I1 I2 I3
M0 VDD I1 1 VDD hvp L=3.0e-07 W=1e-06
M1 1 I2 VDD VDD hvp L=3.0e-07 W=1e-06
M2 VDD I3 1 VDD hvp L=3.0e-07 W=1e-06
M3 O 1 VDD VDD hvp L=3.0e-07 W=1e-06
M4 VDD 1 O VDD hvp L=3.0e-07 W=1e-06
M5 O 1 VDD VDD hvp L=3.0e-07 W=1e-06
M6 VDD 1 O VDD hvp L=3.0e-07 W=1e-06
M7 4 I1 1 GND hvn L=3.5e-07 W=0.65e-06
M8 5 I2 4 GND hvn L=3.5e-07 W=0.65e-06
M9 GND I3 5 GND hvn L=3.5e-07 W=0.65e-06
M10 O 1 GND GND hvn L=3.5e-07 W=0.65e-06
M11 GND 1 O GND hvn L=3.5e-07 W=0.65e-06
M12 O 1 GND GND hvn L=3.5e-07 W=0.65e-06
M13 GND 1 O GND hvn L=3.5e-07 W=0.65e-06
.ENDS AND3X4

.SUBCKT AND3X6 O I1 I2 I3
M0 VDD I1 1 VDD hvp L=3.0e-07 W=1e-06
M1 1 I2 VDD VDD hvp L=3.0e-07 W=1e-06
M2 VDD I3 1 VDD hvp L=3.0e-07 W=1e-06
M3 O 1 VDD VDD hvp L=3.0e-07 W=1e-06
M4 VDD 1 O VDD hvp L=3.0e-07 W=1e-06
M5 O 1 VDD VDD hvp L=3.0e-07 W=1e-06
M6 VDD 1 O VDD hvp L=3.0e-07 W=1e-06
M7 O 1 VDD VDD hvp L=3.0e-07 W=1e-06
M8 VDD 1 O VDD hvp L=3.0e-07 W=1e-06
M9 4 I1 1 GND hvn L=3.5e-07 W=0.65e-06
M10 5 I2 4 GND hvn L=3.5e-07 W=0.65e-06
M11 GND I3 5 GND hvn L=3.5e-07 W=0.65e-06
M12 O 1 GND GND hvn L=3.5e-07 W=0.65e-06
M13 GND 1 O GND hvn L=3.5e-07 W=0.65e-06
M14 O 1 GND GND hvn L=3.5e-07 W=0.65e-06
M15 GND 1 O GND hvn L=3.5e-07 W=0.65e-06
M16 O 1 GND GND hvn L=3.5e-07 W=0.65e-06
M17 GND 1 O GND hvn L=3.5e-07 W=0.65e-06
.ENDS AND3X6

.SUBCKT AND4X1 O I1 I2 I3 I4
M0 2 I1 VDD VDD hvp L=3.0e-07 W=0.75e-06
M1 VDD I2 2 VDD hvp L=3.0e-07 W=0.75e-06
M2 2 I3 VDD VDD hvp L=3.0e-07 W=0.75e-06
M3 VDD I4 2 VDD hvp L=3.0e-07 W=0.75e-06
M4 O 2 VDD VDD hvp L=3.0e-07 W=1e-06
M5 4 I1 2 GND hvn L=3.5e-07 W=0.65e-06
M6 5 I2 4 GND hvn L=3.5e-07 W=0.65e-06
M7 6 I3 5 GND hvn L=3.5e-07 W=0.65e-06
M8 GND I4 6 GND hvn L=3.5e-07 W=0.65e-06
M9 O 2 GND GND hvn L=3.5e-07 W=0.65e-06
.ENDS AND4X1

.SUBCKT AND4X2 O I1 I2 I3 I4
M0 2 I1 VDD VDD hvp L=3.0e-07 W=0.75e-06
M1 VDD I2 2 VDD hvp L=3.0e-07 W=0.75e-06
M2 2 I3 VDD VDD hvp L=3.0e-07 W=0.75e-06
M3 VDD I4 2 VDD hvp L=3.0e-07 W=0.75e-06
M4 O 2 VDD VDD hvp L=3.0e-07 W=1e-06
M5 VDD 2 O VDD hvp L=3.0e-07 W=1e-06
M6 4 I1 2 GND hvn L=3.5e-07 W=0.65e-06
M7 5 I2 4 GND hvn L=3.5e-07 W=0.65e-06
M8 6 I3 5 GND hvn L=3.5e-07 W=0.65e-06
M9 GND I4 6 GND hvn L=3.5e-07 W=0.65e-06
M10 O 2 GND GND hvn L=3.5e-07 W=0.65e-06
M11 GND 2 O GND hvn L=3.5e-07 W=0.65e-06
.ENDS AND4X2

.SUBCKT AND4X4 O I1 I2 I3 I4
M0 2 I1 VDD VDD hvp L=3.0e-07 W=0.75e-06
M1 VDD I2 2 VDD hvp L=3.0e-07 W=0.75e-06
M2 2 I3 VDD VDD hvp L=3.0e-07 W=0.75e-06
M3 VDD I4 2 VDD hvp L=3.0e-07 W=0.75e-06
M4 O 2 VDD VDD hvp L=3.0e-07 W=1e-06
M5 VDD 2 O VDD hvp L=3.0e-07 W=1e-06
M6 O 2 VDD VDD hvp L=3.0e-07 W=1e-06
M7 VDD 2 O VDD hvp L=3.0e-07 W=1e-06
M8 4 I1 2 GND hvn L=3.5e-07 W=0.65e-06
M9 5 I2 4 GND hvn L=3.5e-07 W=0.65e-06
M10 6 I3 5 GND hvn L=3.5e-07 W=0.65e-06
M11 GND I4 6 GND hvn L=3.5e-07 W=0.65e-06
M12 O 2 GND GND hvn L=3.5e-07 W=0.65e-06
M13 GND 2 O GND hvn L=3.5e-07 W=0.65e-06
M14 O 2 GND GND hvn L=3.5e-07 W=0.65e-06
M15 GND 2 O GND hvn L=3.5e-07 W=0.65e-06
.ENDS AND4X4

.SUBCKT ANTENNAX1 ANT
D0 GND ANT nppw33 PJ=1.8e-06 area=0.2025p
.ENDS ANTENNAX1

.SUBCKT ANTENNAX2 ANT
D0 GND ANT nppw33 PJ=2.33e-06 area=0.33655p
.ENDS ANTENNAX2

.SUBCKT ANTENNA2X1 ANT
D0 GND ANT nppw33  PJ=1.8e-06 area=0.2025p
D1 ANT VDD ppnw33  PJ=2.258e-06 area=0.30555p
.ENDS ANTENNA2X1

.SUBCKT AO112X1 O A1 B1 C1 C2
M0 2 A1 1 VDD hvp L=3.0e-07 W=1e-06
M1 3 B1 2 VDD hvp L=3.0e-07 W=1e-06
M2 3 C1 VDD VDD hvp L=3.0e-07 W=1e-06
M3 VDD C2 3 VDD hvp L=3.0e-07 W=1e-06
M4 O 1 VDD VDD hvp L=3.0e-07 W=1e-06
M5 GND A1 1 GND hvn L=3.5e-07 W=0.65e-06
M6 1 B1 GND GND hvn L=3.5e-07 W=0.65e-06
M7 7 C1 1 GND hvn L=3.5e-07 W=0.65e-06
M8 GND C2 7 GND hvn L=3.5e-07 W=0.65e-06
M9 O 1 GND GND hvn L=3.5e-07 W=0.65e-06
.ENDS AO112X1

.SUBCKT AO112X2 O A1 B1 C1 C2
M0 2 A1 1 VDD hvp L=3.0e-07 W=1e-06
M1 3 B1 2 VDD hvp L=3.0e-07 W=1e-06
M2 3 C1 VDD VDD hvp L=3.0e-07 W=1e-06
M3 VDD C2 3 VDD hvp L=3.0e-07 W=1e-06
M4 O 1 VDD VDD hvp L=3.0e-07 W=1e-06
M5 VDD 1 O VDD hvp L=3.0e-07 W=1e-06
M6 GND A1 1 GND hvn L=3.5e-07 W=0.65e-06
M7 1 B1 GND GND hvn L=3.5e-07 W=0.65e-06
M8 7 C1 1 GND hvn L=3.5e-07 W=0.65e-06
M9 GND C2 7 GND hvn L=3.5e-07 W=0.65e-06
M10 O 1 GND GND hvn L=3.5e-07 W=0.65e-06
M11 GND 1 O GND hvn L=3.5e-07 W=0.65e-06
.ENDS AO112X2

.SUBCKT AO112X4 O A1 B1 C1 C2
M0 2 A1 1 VDD hvp L=3.0e-07 W=1e-06
M1 3 B1 2 VDD hvp L=3.0e-07 W=1e-06
M2 3 C1 VDD VDD hvp L=3.0e-07 W=1e-06
M3 VDD C2 3 VDD hvp L=3.0e-07 W=1e-06
M4 O 1 VDD VDD hvp L=3.0e-07 W=1e-06
M5 VDD 1 O VDD hvp L=3.0e-07 W=1e-06
M6 O 1 VDD VDD hvp L=3.0e-07 W=1e-06
M7 VDD 1 O VDD hvp L=3.0e-07 W=1e-06
M8 GND A1 1 GND hvn L=3.5e-07 W=0.65e-06
M9 1 B1 GND GND hvn L=3.5e-07 W=0.65e-06
M10 7 C1 1 GND hvn L=3.5e-07 W=0.65e-06
M11 GND C2 7 GND hvn L=3.5e-07 W=0.65e-06
M12 O 1 GND GND hvn L=3.5e-07 W=0.65e-06
M13 GND 1 O GND hvn L=3.5e-07 W=0.65e-06
M14 O 1 GND GND hvn L=3.5e-07 W=0.65e-06
M15 GND 1 O GND hvn L=3.5e-07 W=0.65e-06
.ENDS AO112X4

.SUBCKT AO122X1 O A1 B1 B2 C1 C2
M0 2 B1 1 VDD hvp L=3.0e-07 W=1e-06
M1 1 B2 2 VDD hvp L=3.0e-07 W=1e-06
M2 3 A1 1 VDD hvp L=3.0e-07 W=1e-06
M3 2 C1 VDD VDD hvp L=3.0e-07 W=1e-06
M4 VDD C2 2 VDD hvp L=3.0e-07 W=1e-06
M5 O 3 VDD VDD hvp L=3.0e-07 W=1e-06
M6 6 B1 3 GND hvn L=3.5e-07 W=0.65e-06
M7 GND B2 6 GND hvn L=3.5e-07 W=0.65e-06
M8 3 A1 GND GND hvn L=3.5e-07 W=0.65e-06
M9 8 C1 3 GND hvn L=3.5e-07 W=0.65e-06
M10 GND C2 8 GND hvn L=3.5e-07 W=0.65e-06
M11 O 3 GND GND hvn L=3.5e-07 W=0.65e-06
.ENDS AO122X1

.SUBCKT AO122X2 O A1 B1 B2 C1 C2
M0 2 B1 1 VDD hvp L=3.0e-07 W=1e-06
M1 1 B2 2 VDD hvp L=3.0e-07 W=1e-06
M2 3 A1 1 VDD hvp L=3.0e-07 W=1e-06
M3 2 C1 VDD VDD hvp L=3.0e-07 W=1e-06
M4 VDD C2 2 VDD hvp L=3.0e-07 W=1e-06
M5 O 3 VDD VDD hvp L=3.0e-07 W=1e-06
M6 VDD 3 O VDD hvp L=3.0e-07 W=1e-06
M7 6 B1 3 GND hvn L=3.5e-07 W=0.65e-06
M8 GND B2 6 GND hvn L=3.5e-07 W=0.65e-06
M9 3 A1 GND GND hvn L=3.5e-07 W=0.65e-06
M10 8 C1 3 GND hvn L=3.5e-07 W=0.65e-06
M11 GND C2 8 GND hvn L=3.5e-07 W=0.65e-06
M12 O 3 GND GND hvn L=3.5e-07 W=0.65e-06
M13 GND 3 O GND hvn L=3.5e-07 W=0.65e-06
.ENDS AO122X2

.SUBCKT AO122X4 O A1 B1 B2 C1 C2
M0 2 B1 1 VDD hvp L=3.0e-07 W=1e-06
M1 1 B2 2 VDD hvp L=3.0e-07 W=1e-06
M2 3 A1 1 VDD hvp L=3.0e-07 W=1e-06
M3 2 C1 VDD VDD hvp L=3.0e-07 W=1e-06
M4 VDD C2 2 VDD hvp L=3.0e-07 W=1e-06
M5 O 3 VDD VDD hvp L=3.0e-07 W=1e-06
M6 VDD 3 O VDD hvp L=3.0e-07 W=1e-06
M7 O 3 VDD VDD hvp L=3.0e-07 W=1e-06
M8 VDD 3 O VDD hvp L=3.0e-07 W=1e-06
M9 6 B1 3 GND hvn L=3.5e-07 W=0.65e-06
M10 GND B2 6 GND hvn L=3.5e-07 W=0.65e-06
M11 3 A1 GND GND hvn L=3.5e-07 W=0.65e-06
M12 8 C1 3 GND hvn L=3.5e-07 W=0.65e-06
M13 GND C2 8 GND hvn L=3.5e-07 W=0.65e-06
M14 O 3 GND GND hvn L=3.5e-07 W=0.65e-06
M15 GND 3 O GND hvn L=3.5e-07 W=0.65e-06
M16 O 3 GND GND hvn L=3.5e-07 W=0.65e-06
M17 GND 3 O GND hvn L=3.5e-07 W=0.65e-06
.ENDS AO122X4

.SUBCKT AO12X1 O A1 B1 B2
M0 2 A1 1 VDD hvp L=3.0e-07 W=1e-06
M1 2 B1 VDD VDD hvp L=3.0e-07 W=1e-06
M2 VDD B2 2 VDD hvp L=3.0e-07 W=1e-06
M3 O 1 VDD VDD hvp L=3.0e-07 W=1e-06
M4 GND A1 1 GND hvn L=3.5e-07 W=0.65e-06
M5 6 B1 1 GND hvn L=3.5e-07 W=0.65e-06
M6 GND B2 6 GND hvn L=3.5e-07 W=0.65e-06
M7 O 1 GND GND hvn L=3.5e-07 W=0.65e-06
.ENDS AO12X1

.SUBCKT AO12X2 O A1 B1 B2
M0 2 A1 1 VDD hvp L=3.0e-07 W=1e-06
M1 2 B1 VDD VDD hvp L=3.0e-07 W=1e-06
M2 VDD B2 2 VDD hvp L=3.0e-07 W=1e-06
M3 O 1 VDD VDD hvp L=3.0e-07 W=1e-06
M4 VDD 1 O VDD hvp L=3.0e-07 W=1e-06
M5 GND A1 1 GND hvn L=3.5e-07 W=0.65e-06
M6 6 B1 1 GND hvn L=3.5e-07 W=0.65e-06
M7 GND B2 6 GND hvn L=3.5e-07 W=0.65e-06
M8 O 1 GND GND hvn L=3.5e-07 W=0.65e-06
M9 GND 1 O GND hvn L=3.5e-07 W=0.65e-06
.ENDS AO12X2

.SUBCKT AO12X4 O A1 B1 B2
M0 2 A1 1 VDD hvp L=3.0e-07 W=1e-06
M1 2 B1 VDD VDD hvp L=3.0e-07 W=1e-06
M2 VDD B2 2 VDD hvp L=3.0e-07 W=1e-06
M3 O 1 VDD VDD hvp L=3.0e-07 W=1e-06
M4 VDD 1 O VDD hvp L=3.0e-07 W=1e-06
M5 O 1 VDD VDD hvp L=3.0e-07 W=1e-06
M6 VDD 1 O VDD hvp L=3.0e-07 W=1e-06
M7 GND A1 1 GND hvn L=3.5e-07 W=0.65e-06
M8 6 B1 1 GND hvn L=3.5e-07 W=0.65e-06
M9 GND B2 6 GND hvn L=3.5e-07 W=0.65e-06
M10 O 1 GND GND hvn L=3.5e-07 W=0.65e-06
M11 GND 1 O GND hvn L=3.5e-07 W=0.65e-06
M12 O 1 GND GND hvn L=3.5e-07 W=0.65e-06
M13 GND 1 O GND hvn L=3.5e-07 W=0.65e-06
.ENDS AO12X4

.SUBCKT AO13X1 O A1 B1 B2 B3
M0 2 A1 1 VDD hvp L=3.0e-07 W=1e-06
M1 VDD B1 2 VDD hvp L=3.0e-07 W=1e-06
M2 2 B2 VDD VDD hvp L=3.0e-07 W=1e-06
M3 VDD B3 2 VDD hvp L=3.0e-07 W=1e-06
M4 O 1 VDD VDD hvp L=3.0e-07 W=1e-06
M5 1 A1 GND GND hvn L=3.5e-07 W=0.65e-06
M6 6 B1 1 GND hvn L=3.5e-07 W=0.65e-06
M7 7 B2 6 GND hvn L=3.5e-07 W=0.65e-06
M8 GND B3 7 GND hvn L=3.5e-07 W=0.65e-06
M9 O 1 GND GND hvn L=3.5e-07 W=0.65e-06
.ENDS AO13X1

.SUBCKT AO13X2 O A1 B1 B2 B3
M0 2 A1 1 VDD hvp L=3.0e-07 W=1e-06
M1 VDD B1 2 VDD hvp L=3.0e-07 W=1e-06
M2 2 B2 VDD VDD hvp L=3.0e-07 W=1e-06
M3 VDD B3 2 VDD hvp L=3.0e-07 W=1e-06
M4 O 1 VDD VDD hvp L=3.0e-07 W=1e-06
M5 VDD 1 O VDD hvp L=3.0e-07 W=1e-06
M6 1 A1 GND GND hvn L=3.5e-07 W=0.65e-06
M7 6 B1 1 GND hvn L=3.5e-07 W=0.65e-06
M8 7 B2 6 GND hvn L=3.5e-07 W=0.65e-06
M9 GND B3 7 GND hvn L=3.5e-07 W=0.65e-06
M10 O 1 GND GND hvn L=3.5e-07 W=0.65e-06
M11 GND 1 O GND hvn L=3.5e-07 W=0.65e-06
.ENDS AO13X2

.SUBCKT AO13X4 O A1 B1 B2 B3
M0 2 A1 1 VDD hvp L=3.0e-07 W=1e-06
M1 VDD B1 2 VDD hvp L=3.0e-07 W=1e-06
M2 2 B2 VDD VDD hvp L=3.0e-07 W=1e-06
M3 VDD B3 2 VDD hvp L=3.0e-07 W=1e-06
M4 O 1 VDD VDD hvp L=3.0e-07 W=1e-06
M5 VDD 1 O VDD hvp L=3.0e-07 W=1e-06
M6 O 1 VDD VDD hvp L=3.0e-07 W=1e-06
M7 VDD 1 O VDD hvp L=3.0e-07 W=1e-06
M8 1 A1 GND GND hvn L=3.5e-07 W=0.65e-06
M9 6 B1 1 GND hvn L=3.5e-07 W=0.65e-06
M10 7 B2 6 GND hvn L=3.5e-07 W=0.65e-06
M11 GND B3 7 GND hvn L=3.5e-07 W=0.65e-06
M12 O 1 GND GND hvn L=3.5e-07 W=0.65e-06
M13 GND 1 O GND hvn L=3.5e-07 W=0.65e-06
M14 O 1 GND GND hvn L=3.5e-07 W=0.65e-06
M15 GND 1 O GND hvn L=3.5e-07 W=0.65e-06
.ENDS AO13X4

.SUBCKT AO2222X1 O A1 A2 B1 B2 C1 C2 D1 D2
M0 2 A2 1 VDD hvp L=3.0e-07 W=0.88e-06
M1 1 A1 2 VDD hvp L=3.0e-07 W=0.88e-06
M2 1 B1 VDD VDD hvp L=3.0e-07 W=0.88e-06
M3 VDD B2 1 VDD hvp L=3.0e-07 W=0.88e-06
M4 O 2 VDD VDD hvp L=3.0e-07 W=0.88e-06
M5 VDD 6 O VDD hvp L=3.0e-07 W=0.88e-06
M6 5 D2 VDD VDD hvp L=3.0e-07 W=0.88e-06
M7 VDD D1 5 VDD hvp L=3.0e-07 W=0.88e-06
M8 5 C2 6 VDD hvp L=3.0e-07 W=0.88e-06
M9 6 C1 5 VDD hvp L=3.0e-07 W=0.88e-06
M10 8 A2 GND GND hvn L=3.5e-07 W=0.59e-06
M11 2 A1 8 GND hvn L=3.5e-07 W=0.59e-06
M12 9 B1 2 GND hvn L=3.5e-07 W=0.59e-06
M13 GND B2 9 GND hvn L=3.5e-07 W=0.59e-06
M14 10 2 O GND hvn L=3.5e-07 W=0.59e-06
M15 GND 6 10 GND hvn L=3.5e-07 W=0.59e-06
M16 11 D2 GND GND hvn L=3.5e-07 W=0.59e-06
M17 6 D1 11 GND hvn L=3.5e-07 W=0.59e-06
M18 12 C2 GND GND hvn L=3.5e-07 W=0.59e-06
M19 6 C1 12 GND hvn L=3.5e-07 W=0.59e-06
.ENDS AO2222X1

.SUBCKT AO2222X2 O A1 A2 B1 B2 C1 C2 D1 D2
M0 2 A2 1 VDD hvp L=3.0e-07 W=0.88e-06
M1 1 A1 2 VDD hvp L=3.0e-07 W=0.88e-06
M2 1 B1 VDD VDD hvp L=3.0e-07 W=0.88e-06
M3 VDD B2 1 VDD hvp L=3.0e-07 W=0.88e-06
M4 O 2 VDD VDD hvp L=3.0e-07 W=0.88e-06
M5 VDD 2 O VDD hvp L=3.0e-07 W=0.88e-06
M6 O 6 VDD VDD hvp L=3.0e-07 W=0.88e-06
M7 VDD 6 O VDD hvp L=3.0e-07 W=0.88e-06
M8 VDD D1 5 VDD hvp L=3.0e-07 W=0.88e-06
M9 5 D2 VDD VDD hvp L=3.0e-07 W=0.88e-06
M10 6 C2 5 VDD hvp L=3.0e-07 W=0.88e-06
M11 5 C1 6 VDD hvp L=3.0e-07 W=0.88e-06
M12 8 A2 GND GND hvn L=3.5e-07 W=0.59e-06
M13 2 A1 8 GND hvn L=3.5e-07 W=0.59e-06
M14 9 B1 2 GND hvn L=3.5e-07 W=0.59e-06
M15 GND B2 9 GND hvn L=3.5e-07 W=0.59e-06
M16 O 2 10 GND hvn L=3.5e-07 W=0.59e-06
M17 10 2 O GND hvn L=3.5e-07 W=0.59e-06
M18 GND 6 10 GND hvn L=3.5e-07 W=0.59e-06
M19 10 6 GND GND hvn L=3.5e-07 W=0.59e-06
M20 11 D1 6 GND hvn L=3.5e-07 W=0.59e-06
M21 GND D2 11 GND hvn L=3.5e-07 W=0.59e-06
M22 12 C2 GND GND hvn L=3.5e-07 W=0.59e-06
M23 6 C1 12 GND hvn L=3.5e-07 W=0.59e-06
.ENDS AO2222X2

.SUBCKT AO2222X4 O A1 A2 B1 B2 C1 C2 D1 D2
M0 2 A2 1 VDD hvp L=3.0e-07 W=0.88e-06
M1 1 A1 2 VDD hvp L=3.0e-07 W=0.88e-06
M2 1 B1 VDD VDD hvp L=3.0e-07 W=0.88e-06
M3 VDD B2 1 VDD hvp L=3.0e-07 W=0.88e-06
M4 O 2 VDD VDD hvp L=3.0e-07 W=0.88e-06
M5 VDD 2 O VDD hvp L=3.0e-07 W=0.88e-06
M6 O 2 VDD VDD hvp L=3.0e-07 W=0.88e-06
M7 VDD 2 O VDD hvp L=3.0e-07 W=0.88e-06
M8 O 6 VDD VDD hvp L=3.0e-07 W=0.88e-06
M9 VDD 6 O VDD hvp L=3.0e-07 W=0.88e-06
M10 O 6 VDD VDD hvp L=3.0e-07 W=0.88e-06
M11 VDD 6 O VDD hvp L=3.0e-07 W=0.88e-06
M12 VDD D1 5 VDD hvp L=3.0e-07 W=0.88e-06
M13 5 D2 VDD VDD hvp L=3.0e-07 W=0.88e-06
M14 6 C2 5 VDD hvp L=3.0e-07 W=0.88e-06
M15 5 C1 6 VDD hvp L=3.0e-07 W=0.88e-06
M16 8 A2 GND GND hvn L=3.5e-07 W=0.59e-06
M17 2 A1 8 GND hvn L=3.5e-07 W=0.59e-06
M18 9 B1 2 GND hvn L=3.5e-07 W=0.59e-06
M19 GND B2 9 GND hvn L=3.5e-07 W=0.59e-06
M20 O 2 10 GND hvn L=3.5e-07 W=0.59e-06
M21 10 2 O GND hvn L=3.5e-07 W=0.59e-06
M22 O 2 10 GND hvn L=3.5e-07 W=0.59e-06
M23 10 2 O GND hvn L=3.5e-07 W=0.59e-06
M24 GND 6 10 GND hvn L=3.5e-07 W=0.59e-06
M25 10 6 GND GND hvn L=3.5e-07 W=0.59e-06
M26 GND 6 10 GND hvn L=3.5e-07 W=0.59e-06
M27 10 6 GND GND hvn L=3.5e-07 W=0.59e-06
M28 11 D1 6 GND hvn L=3.5e-07 W=0.59e-06
M29 GND D2 11 GND hvn L=3.5e-07 W=0.59e-06
M30 12 C2 GND GND hvn L=3.5e-07 W=0.59e-06
M31 6 C1 12 GND hvn L=3.5e-07 W=0.59e-06
.ENDS AO2222X4

.SUBCKT AO222X1 O A1 A2 B1 B2 C1 C2
M0 2 A1 1 VDD hvp L=3.0e-07 W=1e-06
M1 1 A2 2 VDD hvp L=3.0e-07 W=1e-06
M2 3 B2 1 VDD hvp L=3.0e-07 W=1e-06
M3 1 B1 3 VDD hvp L=3.0e-07 W=1e-06
M4 3 C1 VDD VDD hvp L=3.0e-07 W=1e-06
M5 VDD C2 3 VDD hvp L=3.0e-07 W=1e-06
M6 O 2 VDD VDD hvp L=3.0e-07 W=1e-06
M7 6 A1 2 GND hvn L=3.5e-07 W=0.65e-06
M8 GND A2 6 GND hvn L=3.5e-07 W=0.65e-06
M9 8 B2 GND GND hvn L=3.5e-07 W=0.65e-06
M10 2 B1 8 GND hvn L=3.5e-07 W=0.65e-06
M11 9 C1 2 GND hvn L=3.5e-07 W=0.65e-06
M12 GND C2 9 GND hvn L=3.5e-07 W=0.65e-06
M13 O 2 GND GND hvn L=3.5e-07 W=0.65e-06
.ENDS AO222X1

.SUBCKT AO222X2 O A1 A2 B1 B2 C1 C2
M0 2 A1 1 VDD hvp L=3.0e-07 W=1e-06
M1 1 A2 2 VDD hvp L=3.0e-07 W=1e-06
M2 3 B2 1 VDD hvp L=3.0e-07 W=1e-06
M3 1 B1 3 VDD hvp L=3.0e-07 W=1e-06
M4 3 C1 VDD VDD hvp L=3.0e-07 W=1e-06
M5 VDD C2 3 VDD hvp L=3.0e-07 W=1e-06
M6 O 2 VDD VDD hvp L=3.0e-07 W=1e-06
M7 VDD 2 O VDD hvp L=3.0e-07 W=1e-06
M8 6 A1 2 GND hvn L=3.5e-07 W=0.65e-06
M9 GND A2 6 GND hvn L=3.5e-07 W=0.65e-06
M10 8 B2 GND GND hvn L=3.5e-07 W=0.65e-06
M11 2 B1 8 GND hvn L=3.5e-07 W=0.65e-06
M12 9 C1 2 GND hvn L=3.5e-07 W=0.65e-06
M13 GND C2 9 GND hvn L=3.5e-07 W=0.65e-06
M14 O 2 GND GND hvn L=3.5e-07 W=0.65e-06
M15 GND 2 O GND hvn L=3.5e-07 W=0.65e-06
.ENDS AO222X2

.SUBCKT AO222X4 O A1 A2 B1 B2 C1 C2
M0 2 A1 1 VDD hvp L=3.0e-07 W=1e-06
M1 1 A2 2 VDD hvp L=3.0e-07 W=1e-06
M2 3 B2 1 VDD hvp L=3.0e-07 W=1e-06
M3 1 B1 3 VDD hvp L=3.0e-07 W=1e-06
M4 3 C1 VDD VDD hvp L=3.0e-07 W=1e-06
M5 VDD C2 3 VDD hvp L=3.0e-07 W=1e-06
M6 O 2 VDD VDD hvp L=3.0e-07 W=1e-06
M7 VDD 2 O VDD hvp L=3.0e-07 W=1e-06
M8 O 2 VDD VDD hvp L=3.0e-07 W=1e-06
M9 VDD 2 O VDD hvp L=3.0e-07 W=1e-06
M10 6 A1 2 GND hvn L=3.5e-07 W=0.65e-06
M11 GND A2 6 GND hvn L=3.5e-07 W=0.65e-06
M12 8 B2 GND GND hvn L=3.5e-07 W=0.65e-06
M13 2 B1 8 GND hvn L=3.5e-07 W=0.65e-06
M14 9 C1 2 GND hvn L=3.5e-07 W=0.65e-06
M15 GND C2 9 GND hvn L=3.5e-07 W=0.65e-06
M16 O 2 GND GND hvn L=3.5e-07 W=0.65e-06
M17 GND 2 O GND hvn L=3.5e-07 W=0.65e-06
M18 O 2 GND GND hvn L=3.5e-07 W=0.65e-06
M19 GND 2 O GND hvn L=3.5e-07 W=0.65e-06
.ENDS AO222X4

.SUBCKT AO22X1 O A1 A2 B1 B2
M0 2 A1 1 VDD hvp L=3.0e-07 W=1e-06
M1 1 A2 2 VDD hvp L=3.0e-07 W=1e-06
M2 1 B1 VDD VDD hvp L=3.0e-07 W=1e-06
M3 VDD B2 1 VDD hvp L=3.0e-07 W=1e-06
M4 O 2 VDD VDD hvp L=3.0e-07 W=1e-06
M5 5 A1 2 GND hvn L=3.5e-07 W=0.65e-06
M6 GND A2 5 GND hvn L=3.5e-07 W=0.65e-06
M7 7 B1 2 GND hvn L=3.5e-07 W=0.65e-06
M8 GND B2 7 GND hvn L=3.5e-07 W=0.65e-06
M9 O 2 GND GND hvn L=3.5e-07 W=0.65e-06
.ENDS AO22X1

.SUBCKT AO22X2 O A1 A2 B1 B2
M0 2 A1 1 VDD hvp L=3.0e-07 W=1e-06
M1 1 A2 2 VDD hvp L=3.0e-07 W=1e-06
M2 1 B1 VDD VDD hvp L=3.0e-07 W=1e-06
M3 VDD B2 1 VDD hvp L=3.0e-07 W=1e-06
M4 O 2 VDD VDD hvp L=3.0e-07 W=1e-06
M5 VDD 2 O VDD hvp L=3.0e-07 W=1e-06
M6 5 A1 2 GND hvn L=3.5e-07 W=0.65e-06
M7 GND A2 5 GND hvn L=3.5e-07 W=0.65e-06
M8 7 B1 2 GND hvn L=3.5e-07 W=0.65e-06
M9 GND B2 7 GND hvn L=3.5e-07 W=0.65e-06
M10 O 2 GND GND hvn L=3.5e-07 W=0.65e-06
M11 GND 2 O GND hvn L=3.5e-07 W=0.65e-06
.ENDS AO22X2

.SUBCKT AO22X4 O A1 A2 B1 B2
M0 2 A1 1 VDD hvp L=3.0e-07 W=1e-06
M1 1 A2 2 VDD hvp L=3.0e-07 W=1e-06
M2 1 B1 VDD VDD hvp L=3.0e-07 W=1e-06
M3 VDD B2 1 VDD hvp L=3.0e-07 W=1e-06
M4 O 2 VDD VDD hvp L=3.0e-07 W=1e-06
M5 VDD 2 O VDD hvp L=3.0e-07 W=1e-06
M6 O 2 VDD VDD hvp L=3.0e-07 W=1e-06
M7 VDD 2 O VDD hvp L=3.0e-07 W=1e-06
M8 5 A1 2 GND hvn L=3.5e-07 W=0.65e-06
M9 GND A2 5 GND hvn L=3.5e-07 W=0.65e-06
M10 7 B1 2 GND hvn L=3.5e-07 W=0.65e-06
M11 GND B2 7 GND hvn L=3.5e-07 W=0.65e-06
M12 O 2 GND GND hvn L=3.5e-07 W=0.65e-06
M13 GND 2 O GND hvn L=3.5e-07 W=0.65e-06
M14 O 2 GND GND hvn L=3.5e-07 W=0.65e-06
M15 GND 2 O GND hvn L=3.5e-07 W=0.65e-06
.ENDS AO22X4

.SUBCKT AOI112X1 O A1 B1 C1 C2
M0 VDD C2 1 VDD hvp L=3.0e-07 W=0.9e-06
M1 1 C1 VDD VDD hvp L=3.0e-07 W=0.9e-06
M2 1 B1 3 VDD hvp L=3.0e-07 W=0.9e-06
M3 3 B1 1 VDD hvp L=3.0e-07 W=0.9e-06
M4 O A1 3 VDD hvp L=3.0e-07 W=0.9e-06
M5 3 A1 O VDD hvp L=3.0e-07 W=0.9e-06
M6 GND C2 5 GND hvn L=3.5e-07 W=0.6e-06
M7 5 C2 GND GND hvn L=3.5e-07 W=0.6e-06
M8 O C1 5 GND hvn L=3.5e-07 W=0.6e-06
M9 5 C1 O GND hvn L=3.5e-07 W=0.6e-06
M10 O B1 GND GND hvn L=3.5e-07 W=0.6e-06
M11 GND A1 O GND hvn L=3.5e-07 W=0.6e-06
.ENDS AOI112X1

.SUBCKT AOI112X2 O A1 B1 C1 C2
M0 2 A1 1 VDD hvp L=3.0e-07 W=1e-06
M1 3 B1 2 VDD hvp L=3.0e-07 W=1e-06
M2 VDD C2 3 VDD hvp L=3.0e-07 W=1e-06
M3 3 C1 VDD VDD hvp L=3.0e-07 W=1e-06
M4 VDD 1 5 VDD hvp L=3.0e-07 W=1e-06
M5 O 5 VDD VDD hvp L=3.0e-07 W=1e-06
M6 VDD 5 O VDD hvp L=3.0e-07 W=1e-06
M7 1 A1 GND GND hvn L=3.5e-07 W=0.65e-06
M8 GND B1 1 GND hvn L=3.5e-07 W=0.65e-06
M9 8 C2 GND GND hvn L=3.5e-07 W=0.65e-06
M10 1 C1 8 GND hvn L=3.5e-07 W=0.65e-06
M11 GND 1 5 GND hvn L=3.5e-07 W=0.65e-06
M12 O 5 GND GND hvn L=3.5e-07 W=0.65e-06
M13 GND 5 O GND hvn L=3.5e-07 W=0.65e-06
.ENDS AOI112X2

.SUBCKT AOI112X3 O A1 B1 C1 C2
M0 2 A1 1 VDD hvp L=3.0e-07 W=1e-06
M1 3 B1 2 VDD hvp L=3.0e-07 W=1e-06
M2 VDD C2 3 VDD hvp L=3.0e-07 W=1e-06
M3 3 C1 VDD VDD hvp L=3.0e-07 W=1e-06
M4 VDD 1 5 VDD hvp L=3.0e-07 W=1e-06
M5 O 5 VDD VDD hvp L=3.0e-07 W=1e-06
M6 VDD 5 O VDD hvp L=3.0e-07 W=1e-06
M7 O 5 VDD VDD hvp L=3.0e-07 W=1e-06
M8 1 A1 GND GND hvn L=3.5e-07 W=0.65e-06
M9 GND B1 1 GND hvn L=3.5e-07 W=0.65e-06
M10 8 C2 GND GND hvn L=3.5e-07 W=0.65e-06
M11 1 C1 8 GND hvn L=3.5e-07 W=0.65e-06
M12 GND 1 5 GND hvn L=3.5e-07 W=0.65e-06
M13 O 5 GND GND hvn L=3.5e-07 W=0.65e-06
M14 GND 5 O GND hvn L=3.5e-07 W=0.65e-06
M15 O 5 GND GND hvn L=3.5e-07 W=0.65e-06
.ENDS AOI112X3

.SUBCKT AOI112X4 O A1 B1 C1 C2
M0 2 A1 1 VDD hvp L=3.0e-07 W=1e-06
M1 3 B1 2 VDD hvp L=3.0e-07 W=1e-06
M2 VDD C2 3 VDD hvp L=3.0e-07 W=1e-06
M3 3 C1 VDD VDD hvp L=3.0e-07 W=1e-06
M4 VDD 1 5 VDD hvp L=3.0e-07 W=1e-06
M5 O 5 VDD VDD hvp L=3.0e-07 W=1e-06
M6 VDD 5 O VDD hvp L=3.0e-07 W=1e-06
M7 O 5 VDD VDD hvp L=3.0e-07 W=1e-06
M8 VDD 5 O VDD hvp L=3.0e-07 W=1e-06
M9 1 A1 GND GND hvn L=3.5e-07 W=0.65e-06
M10 GND B1 1 GND hvn L=3.5e-07 W=0.65e-06
M11 8 C2 GND GND hvn L=3.5e-07 W=0.65e-06
M12 1 C1 8 GND hvn L=3.5e-07 W=0.65e-06
M13 GND 1 5 GND hvn L=3.5e-07 W=0.65e-06
M14 O 5 GND GND hvn L=3.5e-07 W=0.65e-06
M15 GND 5 O GND hvn L=3.5e-07 W=0.65e-06
M16 O 5 GND GND hvn L=3.5e-07 W=0.65e-06
M17 GND 5 O GND hvn L=3.5e-07 W=0.65e-06
.ENDS AOI112X4

.SUBCKT AOI122X1 O A1 B1 B2 C1 C2
M0 2 A1 1 VDD hvp L=3.0e-07 W=1e-06
M1 3 B2 2 VDD hvp L=3.0e-07 W=1e-06
M2 2 B1 3 VDD hvp L=3.0e-07 W=1e-06
M3 3 C1 VDD VDD hvp L=3.0e-07 W=1e-06
M4 VDD C2 3 VDD hvp L=3.0e-07 W=1e-06
M5 5 1 VDD VDD hvp L=3.0e-07 W=1e-06
M6 O 5 VDD VDD hvp L=3.0e-07 W=1e-06
M7 GND A1 1 GND hvn L=3.5e-07 W=0.65e-06
M8 8 B2 GND GND hvn L=3.5e-07 W=0.65e-06
M9 1 B1 8 GND hvn L=3.5e-07 W=0.65e-06
M10 9 C1 1 GND hvn L=3.5e-07 W=0.65e-06
M11 GND C2 9 GND hvn L=3.5e-07 W=0.65e-06
M12 5 1 GND GND hvn L=3.5e-07 W=0.65e-06
M13 O 5 GND GND hvn L=3.5e-07 W=0.65e-06
.ENDS AOI122X1

.SUBCKT AOI122X2 O A1 B1 B2 C1 C2
M0 2 A1 1 VDD hvp L=3.0e-07 W=1e-06
M1 3 B2 2 VDD hvp L=3.0e-07 W=1e-06
M2 2 B1 3 VDD hvp L=3.0e-07 W=1e-06
M3 3 C1 VDD VDD hvp L=3.0e-07 W=1e-06
M4 VDD C2 3 VDD hvp L=3.0e-07 W=1e-06
M5 5 1 VDD VDD hvp L=3.0e-07 W=1e-06
M6 O 5 VDD VDD hvp L=3.0e-07 W=1e-06
M7 VDD 5 O VDD hvp L=3.0e-07 W=1e-06
M8 GND A1 1 GND hvn L=3.5e-07 W=0.65e-06
M9 8 B2 GND GND hvn L=3.5e-07 W=0.65e-06
M10 1 B1 8 GND hvn L=3.5e-07 W=0.65e-06
M11 9 C1 1 GND hvn L=3.5e-07 W=0.65e-06
M12 GND C2 9 GND hvn L=3.5e-07 W=0.65e-06
M13 5 1 GND GND hvn L=3.5e-07 W=0.65e-06
M14 O 5 GND GND hvn L=3.5e-07 W=0.65e-06
M15 GND 5 O GND hvn L=3.5e-07 W=0.65e-06
.ENDS AOI122X2

.SUBCKT AOI12B2X1 O A1 B1B B2B
M0 2 B1B 1 VDD hvp L=3.0e-07 W=0.9e-06
M1 VDD B2B 2 VDD hvp L=3.0e-07 W=0.9e-06
M2 4 1 VDD VDD hvp L=3.0e-07 W=0.9e-06
M3 O A1 4 VDD hvp L=3.0e-07 W=0.9e-06
M4 6 A1 O VDD hvp L=3.0e-07 W=0.9e-06
M5 VDD 1 6 VDD hvp L=3.0e-07 W=0.9e-06
M6 1 B1B GND GND hvn L=3.5e-07 W=0.6e-06
M7 GND B2B 1 GND hvn L=3.5e-07 W=0.6e-06
M8 O A1 GND GND hvn L=3.5e-07 W=0.6e-06
M9 GND 1 O GND hvn L=3.5e-07 W=0.6e-06
.ENDS AOI12B2X1

.SUBCKT AOI12B2X2 O A1 B1B B2B
M0 2 B1B 1 VDD hvp L=3.0e-07 W=0.9e-06
M1 VDD B2B 2 VDD hvp L=3.0e-07 W=0.9e-06
M2 4 1 VDD VDD hvp L=3.0e-07 W=0.9e-06
M3 O A1 4 VDD hvp L=3.0e-07 W=0.9e-06
M4 6 A1 O VDD hvp L=3.0e-07 W=0.9e-06
M5 VDD 1 6 VDD hvp L=3.0e-07 W=0.9e-06
M6 7 1 VDD VDD hvp L=3.0e-07 W=0.9e-06
M7 O A1 7 VDD hvp L=3.0e-07 W=0.9e-06
M8 8 A1 O VDD hvp L=3.0e-07 W=0.9e-06
M9 VDD 1 8 VDD hvp L=3.0e-07 W=0.9e-06
M10 1 B1B GND GND hvn L=3.5e-07 W=0.6e-06
M11 GND B2B 1 GND hvn L=3.5e-07 W=0.6e-06
M12 O A1 GND GND hvn L=3.5e-07 W=0.6e-06
M13 GND 1 O GND hvn L=3.5e-07 W=0.6e-06
M14 O 1 GND GND hvn L=3.5e-07 W=0.6e-06
M15 GND A1 O GND hvn L=3.5e-07 W=0.6e-06
.ENDS AOI12B2X2

.SUBCKT AOI12X1 O A1 B1 B2
M0 O A1 1 VDD hvp L=3.0e-07 W=1e-06
M1 1 A1 O VDD hvp L=3.0e-07 W=1e-06
M2 VDD B1 1 VDD hvp L=3.0e-07 W=1e-06
M3 1 B2 VDD VDD hvp L=3.0e-07 W=1e-06
M4 O A1 GND GND hvn L=3.5e-07 W=0.65e-06
M5 5 B1 O GND hvn L=3.5e-07 W=0.65e-06
M6 GND B2 5 GND hvn L=3.5e-07 W=0.65e-06
M7 6 B2 GND GND hvn L=3.5e-07 W=0.65e-06
M8 O B1 6 GND hvn L=3.5e-07 W=0.65e-06
.ENDS AOI12X1

.SUBCKT AOI12X2 O A1 B1 B2
M0 O A1 1 VDD hvp L=3.0e-07 W=0.9e-06
M1 1 A1 O VDD hvp L=3.0e-07 W=0.9e-06
M2 O A1 1 VDD hvp L=3.0e-07 W=0.9e-06
M3 1 A1 O VDD hvp L=3.0e-07 W=0.9e-06
M4 VDD B1 1 VDD hvp L=3.0e-07 W=0.9e-06
M5 1 B1 VDD VDD hvp L=3.0e-07 W=0.9e-06
M6 VDD B2 1 VDD hvp L=3.0e-07 W=0.9e-06
M7 1 B2 VDD VDD hvp L=3.0e-07 W=0.9e-06
M8 GND A1 O GND hvn L=3.5e-07 W=0.6e-06
M9 O A1 GND GND hvn L=3.5e-07 W=0.6e-06
M10 5 B1 O GND hvn L=3.5e-07 W=0.6e-06
M11 O B1 5 GND hvn L=3.5e-07 W=0.6e-06
M12 5 B1 O GND hvn L=3.5e-07 W=0.6e-06
M13 GND B2 5 GND hvn L=3.5e-07 W=0.6e-06
M14 5 B2 GND GND hvn L=3.5e-07 W=0.6e-06
M15 GND B2 5 GND hvn L=3.5e-07 W=0.6e-06
.ENDS AOI12X2

.SUBCKT AOI12X3 O A1 B1 B2
M0 VDD B1 1 VDD hvp L=3.0e-07 W=1e-06
M1 1 B2 VDD VDD hvp L=3.0e-07 W=1e-06
M2 3 A1 1 VDD hvp L=3.0e-07 W=1e-06
M3 VDD 3 4 VDD hvp L=3.0e-07 W=1e-06
M4 O 4 VDD VDD hvp L=3.0e-07 W=1e-06
M5 VDD 4 O VDD hvp L=3.0e-07 W=1e-06
M6 O 4 VDD VDD hvp L=3.0e-07 W=1e-06
M7 6 B1 3 GND hvn L=3.5e-07 W=0.65e-06
M8 GND B2 6 GND hvn L=3.5e-07 W=0.65e-06
M9 3 A1 GND GND hvn L=3.5e-07 W=0.65e-06
M10 GND 3 4 GND hvn L=3.5e-07 W=0.65e-06
M11 O 4 GND GND hvn L=3.5e-07 W=0.65e-06
M12 GND 4 O GND hvn L=3.5e-07 W=0.65e-06
M13 O 4 GND GND hvn L=3.5e-07 W=0.65e-06
.ENDS AOI12X3

.SUBCKT AOI12X4 O A1 B1 B2
M0 VDD B1 1 VDD hvp L=3.0e-07 W=1e-06
M1 1 B2 VDD VDD hvp L=3.0e-07 W=1e-06
M2 3 A1 1 VDD hvp L=3.0e-07 W=1e-06
M3 VDD 3 4 VDD hvp L=3.0e-07 W=1e-06
M4 O 4 VDD VDD hvp L=3.0e-07 W=1e-06
M5 VDD 4 O VDD hvp L=3.0e-07 W=1e-06
M6 O 4 VDD VDD hvp L=3.0e-07 W=1e-06
M7 VDD 4 O VDD hvp L=3.0e-07 W=1e-06
M8 6 B1 3 GND hvn L=3.5e-07 W=0.65e-06
M9 GND B2 6 GND hvn L=3.5e-07 W=0.65e-06
M10 3 A1 GND GND hvn L=3.5e-07 W=0.65e-06
M11 GND 3 4 GND hvn L=3.5e-07 W=0.65e-06
M12 O 4 GND GND hvn L=3.5e-07 W=0.65e-06
M13 GND 4 O GND hvn L=3.5e-07 W=0.65e-06
M14 O 4 GND GND hvn L=3.5e-07 W=0.65e-06
M15 GND 4 O GND hvn L=3.5e-07 W=0.65e-06
.ENDS AOI12X4

.SUBCKT AOI13X1 O A1 B1 B2 B3
M0 O A1 1 VDD hvp L=3.0e-07 W=0.9e-06
M1 1 A1 O VDD hvp L=3.0e-07 W=0.9e-06
M2 VDD B1 1 VDD hvp L=3.0e-07 W=0.9e-06
M3 1 B2 VDD VDD hvp L=3.0e-07 W=0.9e-06
M4 VDD B3 1 VDD hvp L=3.0e-07 W=0.9e-06
M5 O A1 GND GND hvn L=3.5e-07 W=0.6e-06
M6 O B1 5 GND hvn L=3.5e-07 W=0.6e-06
M7 5 B1 O GND hvn L=3.5e-07 W=0.6e-06
M8 6 B2 5 GND hvn L=3.5e-07 W=0.6e-06
M9 GND B3 6 GND hvn L=3.5e-07 W=0.6e-06
M10 7 B3 GND GND hvn L=3.5e-07 W=0.6e-06
M11 5 B2 7 GND hvn L=3.5e-07 W=0.6e-06
.ENDS AOI13X1

.SUBCKT AOI13X2 O A1 B1 B2 B3
M0 2 B3 VDD VDD hvp L=3.0e-07 W=0.9e-06
M1 VDD B3 2 VDD hvp L=3.0e-07 W=0.9e-06
M2 2 B2 VDD VDD hvp L=3.0e-07 W=0.9e-06
M3 VDD B2 2 VDD hvp L=3.0e-07 W=0.9e-06
M4 VDD B1 2 VDD hvp L=3.0e-07 W=0.9e-06
M5 2 B1 VDD VDD hvp L=3.0e-07 W=0.9e-06
M6 O A1 2 VDD hvp L=3.0e-07 W=0.9e-06
M7 2 A1 O VDD hvp L=3.0e-07 W=0.9e-06
M8 O A1 2 VDD hvp L=3.0e-07 W=0.9e-06
M9 2 A1 O VDD hvp L=3.0e-07 W=0.9e-06
M10 5 B3 GND GND hvn L=3.5e-07 W=0.6e-06
M11 GND B3 5 GND hvn L=3.5e-07 W=0.6e-06
M12 5 B3 GND GND hvn L=3.5e-07 W=0.6e-06
M13 6 B2 5 GND hvn L=3.5e-07 W=0.6e-06
M14 5 B2 6 GND hvn L=3.5e-07 W=0.6e-06
M15 6 B2 5 GND hvn L=3.5e-07 W=0.6e-06
M16 O B1 6 GND hvn L=3.5e-07 W=0.6e-06
M17 6 B1 O GND hvn L=3.5e-07 W=0.6e-06
M18 O B1 6 GND hvn L=3.5e-07 W=0.6e-06
M19 GND A1 O GND hvn L=3.5e-07 W=0.6e-06
M20 O A1 GND GND hvn L=3.5e-07 W=0.6e-06
.ENDS AOI13X2

.SUBCKT AOI13X3 O A1 B1 B2 B3
M0 2 B3 VDD VDD hvp L=3.0e-07 W=0.9e-06
M1 VDD B3 2 VDD hvp L=3.0e-07 W=0.9e-06
M2 2 B3 VDD VDD hvp L=3.0e-07 W=0.9e-06
M3 VDD B2 2 VDD hvp L=3.0e-07 W=0.9e-06
M4 2 B2 VDD VDD hvp L=3.0e-07 W=0.9e-06
M5 VDD B2 2 VDD hvp L=3.0e-07 W=0.9e-06
M6 2 B1 VDD VDD hvp L=3.0e-07 W=0.9e-06
M7 VDD B1 2 VDD hvp L=3.0e-07 W=0.9e-06
M8 2 B1 VDD VDD hvp L=3.0e-07 W=0.9e-06
M9 O A1 2 VDD hvp L=3.0e-07 W=0.9e-06
M10 2 A1 O VDD hvp L=3.0e-07 W=0.9e-06
M11 O A1 2 VDD hvp L=3.0e-07 W=0.9e-06
M12 2 A1 O VDD hvp L=3.0e-07 W=0.9e-06
M13 5 B3 GND GND hvn L=3.5e-07 W=0.6e-06
M14 GND B3 5 GND hvn L=3.5e-07 W=0.6e-06
M15 5 B3 GND GND hvn L=3.5e-07 W=0.6e-06
M16 6 B2 5 GND hvn L=3.5e-07 W=0.6e-06
M17 5 B2 6 GND hvn L=3.5e-07 W=0.6e-06
M18 6 B2 5 GND hvn L=3.5e-07 W=0.6e-06
M19 O B1 6 GND hvn L=3.5e-07 W=0.6e-06
M20 6 B1 O GND hvn L=3.5e-07 W=0.6e-06
M21 O B1 6 GND hvn L=3.5e-07 W=0.6e-06
M22 GND A1 O GND hvn L=3.5e-07 W=0.6e-06
M23 O A1 GND GND hvn L=3.5e-07 W=0.6e-06
.ENDS AOI13X3

.SUBCKT AOI13X4 O A1 B1 B2 B3
M0 2 A1 1 VDD hvp L=3.0e-07 W=1e-06
M1 VDD B1 2 VDD hvp L=3.0e-07 W=1e-06
M2 2 B2 VDD VDD hvp L=3.0e-07 W=1e-06
M3 VDD B3 2 VDD hvp L=3.0e-07 W=1e-06
M4 4 1 VDD VDD hvp L=3.0e-07 W=1e-06
M5 O 4 VDD VDD hvp L=3.0e-07 W=1e-06
M6 VDD 4 O VDD hvp L=3.0e-07 W=1e-06
M7 O 4 VDD VDD hvp L=3.0e-07 W=1e-06
M8 VDD 4 O VDD hvp L=3.0e-07 W=1e-06
M9 1 A1 GND GND hvn L=3.5e-07 W=0.65e-06
M10 7 B1 1 GND hvn L=3.5e-07 W=0.65e-06
M11 8 B2 7 GND hvn L=3.5e-07 W=0.65e-06
M12 GND B3 8 GND hvn L=3.5e-07 W=0.65e-06
M13 4 1 GND GND hvn L=3.5e-07 W=0.65e-06
M14 O 4 GND GND hvn L=3.5e-07 W=0.65e-06
M15 GND 4 O GND hvn L=3.5e-07 W=0.65e-06
M16 O 4 GND GND hvn L=3.5e-07 W=0.65e-06
M17 GND 4 O GND hvn L=3.5e-07 W=0.65e-06
.ENDS AOI13X4

.SUBCKT AOI21B1X1 O A1 A2 B1B
M0 2 B1B VDD VDD hvp L=3.0e-07 W=1e-06
M1 4 2 O VDD hvp L=3.0e-07 W=1e-06
M2 VDD A1 4 VDD hvp L=3.0e-07 W=1e-06
M3 4 A2 VDD VDD hvp L=3.0e-07 W=1e-06
M4 2 B1B GND GND hvn L=3.5e-07 W=0.65e-06
M5 O 2 GND GND hvn L=3.5e-07 W=0.65e-06
M6 6 A1 O GND hvn L=3.5e-07 W=0.65e-06
M7 GND A2 6 GND hvn L=3.5e-07 W=0.65e-06
.ENDS AOI21B1X1

.SUBCKT AOI21B1X2 O A1 A2 B1B
M0 2 B1B VDD VDD hvp L=3.0e-07 W=0.9e-06
M1 O 2 3 VDD hvp L=3.0e-07 W=0.9e-06
M2 3 2 O VDD hvp L=3.0e-07 W=0.9e-06
M3 VDD A2 3 VDD hvp L=3.0e-07 W=0.9e-06
M4 3 A1 VDD VDD hvp L=3.0e-07 W=0.9e-06
M5 VDD A1 3 VDD hvp L=3.0e-07 W=0.9e-06
M6 3 A2 VDD VDD hvp L=3.0e-07 W=0.9e-06
M7 2 B1B GND GND hvn L=3.5e-07 W=0.6e-06
M8 O 2 GND GND hvn L=3.5e-07 W=0.6e-06
M9 GND 2 O GND hvn L=3.5e-07 W=0.6e-06
M10 6 A2 GND GND hvn L=3.5e-07 W=0.6e-06
M11 O A1 6 GND hvn L=3.5e-07 W=0.6e-06
M12 7 A1 O GND hvn L=3.5e-07 W=0.6e-06
M13 GND A2 7 GND hvn L=3.5e-07 W=0.6e-06
.ENDS AOI21B1X2

.SUBCKT AOI21B1X3 O A1 A2 B1B
M0 2 B1B VDD VDD hvp L=3.0e-07 W=0.9e-06
M1 4 2 O VDD hvp L=3.0e-07 W=0.9e-06
M2 O 2 4 VDD hvp L=3.0e-07 W=0.9e-06
M3 4 2 O VDD hvp L=3.0e-07 W=0.9e-06
M4 VDD A2 4 VDD hvp L=3.0e-07 W=0.9e-06
M5 4 A1 VDD VDD hvp L=3.0e-07 W=0.9e-06
M6 VDD A1 4 VDD hvp L=3.0e-07 W=0.9e-06
M7 4 A2 VDD VDD hvp L=3.0e-07 W=0.9e-06
M8 VDD A1 4 VDD hvp L=3.0e-07 W=0.9e-06
M9 4 A1 VDD VDD hvp L=3.0e-07 W=0.9e-06
M10 2 B1B GND GND hvn L=3.5e-07 W=0.6e-06
M11 GND 2 O GND hvn L=3.5e-07 W=0.6e-06
M12 O 2 GND GND hvn L=3.5e-07 W=0.6e-06
M13 GND 2 O GND hvn L=3.5e-07 W=0.6e-06
M14 6 A2 GND GND hvn L=3.5e-07 W=0.6e-06
M15 O A1 6 GND hvn L=3.5e-07 W=0.6e-06
M16 7 A1 O GND hvn L=3.5e-07 W=0.6e-06
M17 GND A2 7 GND hvn L=3.5e-07 W=0.6e-06
M18 8 A2 GND GND hvn L=3.5e-07 W=0.6e-06
M19 O A1 8 GND hvn L=3.5e-07 W=0.6e-06
.ENDS AOI21B1X3

.SUBCKT AOI21B1X4 O A1 A2 B1B
M0 2 A1 VDD VDD hvp L=3.0e-07 W=1e-06
M1 VDD A2 2 VDD hvp L=3.0e-07 W=1e-06
M2 3 2 VDD VDD hvp L=3.0e-07 W=1e-06
M3 VDD B1B 3 VDD hvp L=3.0e-07 W=1e-06
M4 O 3 VDD VDD hvp L=3.0e-07 W=1e-06
M5 VDD 3 O VDD hvp L=3.0e-07 W=1e-06
M6 O 3 VDD VDD hvp L=3.0e-07 W=1e-06
M7 VDD 3 O VDD hvp L=3.0e-07 W=1e-06
M8 5 A1 2 GND hvn L=3.5e-07 W=0.65e-06
M9 GND A2 5 GND hvn L=3.5e-07 W=0.65e-06
M10 7 2 GND GND hvn L=3.5e-07 W=0.65e-06
M11 3 B1B 7 GND hvn L=3.5e-07 W=0.65e-06
M12 O 3 GND GND hvn L=3.5e-07 W=0.65e-06
M13 GND 3 O GND hvn L=3.5e-07 W=0.65e-06
M14 O 3 GND GND hvn L=3.5e-07 W=0.65e-06
M15 GND 3 O GND hvn L=3.5e-07 W=0.65e-06
.ENDS AOI21B1X4

.SUBCKT AOI2222X1 O A1 A2 B1 B2 C1 C2 D1 D2
M0 2 C2 1 VDD hvp L=3.0e-07 W=1e-06
M1 1 C1 2 VDD hvp L=3.0e-07 W=1e-06
M2 2 D1 VDD VDD hvp L=3.0e-07 W=1e-06
M3 VDD D2 2 VDD hvp L=3.0e-07 W=1e-06
M4 VDD 5 O VDD hvp L=3.0e-07 W=1e-06
M5 5 1 VDD VDD hvp L=3.0e-07 W=1e-06
M6 VDD 7 5 VDD hvp L=3.0e-07 W=1e-06
M7 6 B2 VDD VDD hvp L=3.0e-07 W=1e-06
M8 VDD B1 6 VDD hvp L=3.0e-07 W=1e-06
M9 7 A1 6 VDD hvp L=3.0e-07 W=1e-06
M10 6 A2 7 VDD hvp L=3.0e-07 W=1e-06
M11 9 C2 GND GND hvn L=3.5e-07 W=0.65e-06
M12 1 C1 9 GND hvn L=3.5e-07 W=0.65e-06
M13 10 D1 1 GND hvn L=3.5e-07 W=0.65e-06
M14 GND D2 10 GND hvn L=3.5e-07 W=0.65e-06
M15 GND 5 O GND hvn L=3.5e-07 W=0.65e-06
M16 11 1 GND GND hvn L=3.5e-07 W=0.65e-06
M17 5 7 11 GND hvn L=3.5e-07 W=0.65e-06
M18 12 B2 GND GND hvn L=3.5e-07 W=0.65e-06
M19 7 B1 12 GND hvn L=3.5e-07 W=0.65e-06
M20 13 A1 7 GND hvn L=3.5e-07 W=0.65e-06
M21 GND A2 13 GND hvn L=3.5e-07 W=0.65e-06
.ENDS AOI2222X1

.SUBCKT AOI2222X2 O A1 A2 B1 B2 C1 C2 D1 D2
M0 2 C2 1 VDD hvp L=3.0e-07 W=1e-06
M1 1 C1 2 VDD hvp L=3.0e-07 W=1e-06
M2 2 D1 VDD VDD hvp L=3.0e-07 W=1e-06
M3 VDD D2 2 VDD hvp L=3.0e-07 W=1e-06
M4 O 5 VDD VDD hvp L=3.0e-07 W=1e-06
M5 VDD 5 O VDD hvp L=3.0e-07 W=1e-06
M6 5 1 VDD VDD hvp L=3.0e-07 W=1e-06
M7 VDD 7 5 VDD hvp L=3.0e-07 W=1e-06
M8 6 B2 VDD VDD hvp L=3.0e-07 W=1e-06
M9 VDD B1 6 VDD hvp L=3.0e-07 W=1e-06
M10 7 A1 6 VDD hvp L=3.0e-07 W=1e-06
M11 6 A2 7 VDD hvp L=3.0e-07 W=1e-06
M12 9 C2 GND GND hvn L=3.5e-07 W=0.65e-06
M13 1 C1 9 GND hvn L=3.5e-07 W=0.65e-06
M14 10 D1 1 GND hvn L=3.5e-07 W=0.65e-06
M15 GND D2 10 GND hvn L=3.5e-07 W=0.65e-06
M16 O 5 GND GND hvn L=3.5e-07 W=0.65e-06
M17 GND 5 O GND hvn L=3.5e-07 W=0.65e-06
M18 11 1 GND GND hvn L=3.5e-07 W=0.65e-06
M19 5 7 11 GND hvn L=3.5e-07 W=0.65e-06
M20 12 B2 GND GND hvn L=3.5e-07 W=0.65e-06
M21 7 B1 12 GND hvn L=3.5e-07 W=0.65e-06
M22 13 A1 7 GND hvn L=3.5e-07 W=0.65e-06
M23 GND A2 13 GND hvn L=3.5e-07 W=0.65e-06
.ENDS AOI2222X2

.SUBCKT AOI222X1 O A1 A2 B1 B2 C1 C2
M0 2 A2 O VDD hvp L=3.0e-07 W=1e-06
M1 O A1 2 VDD hvp L=3.0e-07 W=1e-06
M2 2 B2 3 VDD hvp L=3.0e-07 W=1e-06
M3 3 B1 2 VDD hvp L=3.0e-07 W=1e-06
M4 VDD C1 3 VDD hvp L=3.0e-07 W=1e-06
M5 3 C2 VDD VDD hvp L=3.0e-07 W=1e-06
M6 6 A2 GND GND hvn L=3.5e-07 W=0.65e-06
M7 O A1 6 GND hvn L=3.5e-07 W=0.65e-06
M8 7 B2 GND GND hvn L=3.5e-07 W=0.65e-06
M9 O B1 7 GND hvn L=3.5e-07 W=0.65e-06
M10 8 C1 O GND hvn L=3.5e-07 W=0.65e-06
M11 GND C2 8 GND hvn L=3.5e-07 W=0.65e-06
.ENDS AOI222X1

.SUBCKT AOI222X2 O A1 A2 B1 B2 C1 C2
M0 O A2 1 VDD hvp L=3.0e-07 W=0.9e-06
M1 1 A2 O VDD hvp L=3.0e-07 W=0.9e-06
M2 O A2 1 VDD hvp L=3.0e-07 W=0.9e-06
M3 1 A1 O VDD hvp L=3.0e-07 W=0.9e-06
M4 O A1 1 VDD hvp L=3.0e-07 W=0.9e-06
M5 1 A1 O VDD hvp L=3.0e-07 W=0.9e-06
M6 3 B2 1 VDD hvp L=3.0e-07 W=0.9e-06
M7 1 B2 3 VDD hvp L=3.0e-07 W=0.9e-06
M8 3 B2 1 VDD hvp L=3.0e-07 W=0.9e-06
M9 1 B1 3 VDD hvp L=3.0e-07 W=0.9e-06
M10 3 B1 1 VDD hvp L=3.0e-07 W=0.9e-06
M11 1 B1 3 VDD hvp L=3.0e-07 W=0.9e-06
M12 3 C1 VDD VDD hvp L=3.0e-07 W=0.9e-06
M13 VDD C1 3 VDD hvp L=3.0e-07 W=0.9e-06
M14 3 C1 VDD VDD hvp L=3.0e-07 W=0.9e-06
M15 VDD C2 3 VDD hvp L=3.0e-07 W=0.9e-06
M16 3 C2 VDD VDD hvp L=3.0e-07 W=0.9e-06
M17 VDD C2 3 VDD hvp L=3.0e-07 W=0.9e-06
M18 GND A2 5 GND hvn L=3.5e-07 W=0.6e-06
M19 5 A2 GND GND hvn L=3.5e-07 W=0.6e-06
M20 O A1 5 GND hvn L=3.5e-07 W=0.6e-06
M21 5 A1 O GND hvn L=3.5e-07 W=0.6e-06
M22 GND B2 7 GND hvn L=3.5e-07 W=0.6e-06
M23 7 B2 GND GND hvn L=3.5e-07 W=0.6e-06
M24 O B1 7 GND hvn L=3.5e-07 W=0.6e-06
M25 7 B1 O GND hvn L=3.5e-07 W=0.6e-06
M26 O C1 8 GND hvn L=3.5e-07 W=0.6e-06
M27 8 C1 O GND hvn L=3.5e-07 W=0.6e-06
M28 GND C2 8 GND hvn L=3.5e-07 W=0.6e-06
M29 8 C2 GND GND hvn L=3.5e-07 W=0.6e-06
.ENDS AOI222X2

.SUBCKT AOI22B2X1 O A1 A2 B1B B2B
M0 VDD A2 1 VDD hvp L=3.0e-07 W=1e-06
M1 1 A1 VDD VDD hvp L=3.0e-07 W=1e-06
M2 O 4 1 VDD hvp L=3.0e-07 W=1e-06
M3 5 B1B 4 VDD hvp L=3.0e-07 W=1e-06
M4 VDD B2B 5 VDD hvp L=3.0e-07 W=1e-06
M5 7 A2 GND GND hvn L=3.5e-07 W=0.65e-06
M6 O A1 7 GND hvn L=3.5e-07 W=0.65e-06
M7 GND 4 O GND hvn L=3.5e-07 W=0.65e-06
M8 4 B1B GND GND hvn L=3.5e-07 W=0.65e-06
M9 GND B2B 4 GND hvn L=3.5e-07 W=0.65e-06
.ENDS AOI22B2X1

.SUBCKT AOI22B2X2 O A1 A2 B1B B2B
M0 VDD A2 1 VDD hvp L=3.0e-07 W=1e-06
M1 1 A1 VDD VDD hvp L=3.0e-07 W=1e-06
M2 VDD A1 1 VDD hvp L=3.0e-07 W=1e-06
M3 1 A2 VDD VDD hvp L=3.0e-07 W=1e-06
M4 O 4 1 VDD hvp L=3.0e-07 W=1e-06
M5 1 4 O VDD hvp L=3.0e-07 W=1e-06
M6 5 B1B 4 VDD hvp L=3.0e-07 W=1e-06
M7 VDD B2B 5 VDD hvp L=3.0e-07 W=1e-06
M8 7 A2 GND GND hvn L=3.5e-07 W=0.65e-06
M9 O A1 7 GND hvn L=3.5e-07 W=0.65e-06
M10 8 A1 O GND hvn L=3.5e-07 W=0.65e-06
M11 GND A2 8 GND hvn L=3.5e-07 W=0.65e-06
M12 O 4 GND GND hvn L=3.5e-07 W=0.65e-06
M13 GND 4 O GND hvn L=3.5e-07 W=0.65e-06
M14 4 B1B GND GND hvn L=3.5e-07 W=0.65e-06
M15 GND B2B 4 GND hvn L=3.5e-07 W=0.65e-06
.ENDS AOI22B2X2

.SUBCKT AOI22X1 O A1 A2 B1 B2
M0 VDD B2 1 VDD hvp L=3.0e-07 W=0.9e-06
M1 1 B2 VDD VDD hvp L=3.0e-07 W=0.9e-06
M2 VDD B1 1 VDD hvp L=3.0e-07 W=0.9e-06
M3 1 B1 VDD VDD hvp L=3.0e-07 W=0.9e-06
M4 1 A1 O VDD hvp L=3.0e-07 W=0.9e-06
M5 O A1 1 VDD hvp L=3.0e-07 W=0.9e-06
M6 1 A2 O VDD hvp L=3.0e-07 W=0.9e-06
M7 O A2 1 VDD hvp L=3.0e-07 W=0.9e-06
M8 GND B2 4 GND hvn L=3.5e-07 W=0.6e-06
M9 6 B2 GND GND hvn L=3.5e-07 W=0.6e-06
M10 O B1 6 GND hvn L=3.5e-07 W=0.6e-06
M11 4 B1 O GND hvn L=3.5e-07 W=0.6e-06
M12 O A1 7 GND hvn L=3.5e-07 W=0.6e-06
M13 8 A1 O GND hvn L=3.5e-07 W=0.6e-06
M14 GND A2 8 GND hvn L=3.5e-07 W=0.6e-06
M15 7 A2 GND GND hvn L=3.5e-07 W=0.6e-06
.ENDS AOI22X1

.SUBCKT AOI22X2 O A1 A2 B1 B2
M0 2 A2 1 VDD hvp L=3.0e-07 W=1e-06
M1 1 A1 2 VDD hvp L=3.0e-07 W=1e-06
M2 VDD B1 1 VDD hvp L=3.0e-07 W=1e-06
M3 1 B2 VDD VDD hvp L=3.0e-07 W=1e-06
M4 VDD 2 4 VDD hvp L=3.0e-07 W=1e-06
M5 O 4 VDD VDD hvp L=3.0e-07 W=1e-06
M6 VDD 4 O VDD hvp L=3.0e-07 W=1e-06
M7 7 A2 GND GND hvn L=3.5e-07 W=0.65e-06
M8 2 A1 7 GND hvn L=3.5e-07 W=0.65e-06
M9 8 B1 2 GND hvn L=3.5e-07 W=0.65e-06
M10 GND B2 8 GND hvn L=3.5e-07 W=0.65e-06
M11 GND 2 4 GND hvn L=3.5e-07 W=0.65e-06
M12 O 4 GND GND hvn L=3.5e-07 W=0.65e-06
M13 GND 4 O GND hvn L=3.5e-07 W=0.65e-06
.ENDS AOI22X2

.SUBCKT AOI22X3 O A1 A2 B1 B2
M0 2 A2 1 VDD hvp L=3.0e-07 W=1e-06
M1 1 A1 2 VDD hvp L=3.0e-07 W=1e-06
M2 VDD B1 1 VDD hvp L=3.0e-07 W=1e-06
M3 1 B2 VDD VDD hvp L=3.0e-07 W=1e-06
M4 VDD 2 4 VDD hvp L=3.0e-07 W=1e-06
M5 O 4 VDD VDD hvp L=3.0e-07 W=1e-06
M6 VDD 4 O VDD hvp L=3.0e-07 W=1e-06
M7 O 4 VDD VDD hvp L=3.0e-07 W=1e-06
M8 7 A2 GND GND hvn L=3.5e-07 W=0.65e-06
M9 2 A1 7 GND hvn L=3.5e-07 W=0.65e-06
M10 8 B1 2 GND hvn L=3.5e-07 W=0.65e-06
M11 GND B2 8 GND hvn L=3.5e-07 W=0.65e-06
M12 GND 2 4 GND hvn L=3.5e-07 W=0.65e-06
M13 O 4 GND GND hvn L=3.5e-07 W=0.65e-06
M14 GND 4 O GND hvn L=3.5e-07 W=0.65e-06
M15 O 4 GND GND hvn L=3.5e-07 W=0.65e-06
.ENDS AOI22X3

.SUBCKT AOI22X4 O A1 A2 B1 B2
M0 2 A2 1 VDD hvp L=3.0e-07 W=1e-06
M1 1 A1 2 VDD hvp L=3.0e-07 W=1e-06
M2 VDD B1 1 VDD hvp L=3.0e-07 W=1e-06
M3 1 B2 VDD VDD hvp L=3.0e-07 W=1e-06
M4 VDD 2 4 VDD hvp L=3.0e-07 W=1e-06
M5 O 4 VDD VDD hvp L=3.0e-07 W=1e-06
M6 VDD 4 O VDD hvp L=3.0e-07 W=1e-06
M7 O 4 VDD VDD hvp L=3.0e-07 W=1e-06
M8 VDD 4 O VDD hvp L=3.0e-07 W=1e-06
M9 7 A2 GND GND hvn L=3.5e-07 W=0.65e-06
M10 2 A1 7 GND hvn L=3.5e-07 W=0.65e-06
M11 8 B1 2 GND hvn L=3.5e-07 W=0.65e-06
M12 GND B2 8 GND hvn L=3.5e-07 W=0.65e-06
M13 GND 2 4 GND hvn L=3.5e-07 W=0.65e-06
M14 O 4 GND GND hvn L=3.5e-07 W=0.65e-06
M15 GND 4 O GND hvn L=3.5e-07 W=0.65e-06
M16 O 4 GND GND hvn L=3.5e-07 W=0.65e-06
M17 GND 4 O GND hvn L=3.5e-07 W=0.65e-06
.ENDS AOI22X4

.SUBCKT BUFX1 O I
M0 VDD I 1 VDD hvp L=3.0e-07 W=1e-06
M1 O 1 VDD VDD hvp L=3.0e-07 W=1e-06
M2 GND I 1 GND hvn L=3.5e-07 W=0.65e-06
M3 O 1 GND GND hvn L=3.5e-07 W=0.65e-06
.ENDS BUFX1

.SUBCKT BUFX10 O I
M0 VDD I 1 VDD hvp L=3.0e-07 W=1e-06
M1 1 I VDD VDD hvp L=3.0e-07 W=1e-06
M2 VDD I 1 VDD hvp L=3.0e-07 W=1e-06
M3 O 1 VDD VDD hvp L=3.0e-07 W=1e-06
M4 VDD 1 O VDD hvp L=3.0e-07 W=1e-06
M5 O 1 VDD VDD hvp L=3.0e-07 W=1e-06
M6 VDD 1 O VDD hvp L=3.0e-07 W=1e-06
M7 O 1 VDD VDD hvp L=3.0e-07 W=1e-06
M8 VDD 1 O VDD hvp L=3.0e-07 W=1e-06
M9 O 1 VDD VDD hvp L=3.0e-07 W=1e-06
M10 VDD 1 O VDD hvp L=3.0e-07 W=1e-06
M11 O 1 VDD VDD hvp L=3.0e-07 W=1e-06
M12 VDD 1 O VDD hvp L=3.0e-07 W=1e-06
M13 GND I 1 GND hvn L=3.5e-07 W=0.65e-06
M14 1 I GND GND hvn L=3.5e-07 W=0.65e-06
M15 GND I 1 GND hvn L=3.5e-07 W=0.65e-06
M16 O 1 GND GND hvn L=3.5e-07 W=0.65e-06
M17 GND 1 O GND hvn L=3.5e-07 W=0.65e-06
M18 O 1 GND GND hvn L=3.5e-07 W=0.65e-06
M19 GND 1 O GND hvn L=3.5e-07 W=0.65e-06
M20 O 1 GND GND hvn L=3.5e-07 W=0.65e-06
M21 GND 1 O GND hvn L=3.5e-07 W=0.65e-06
M22 O 1 GND GND hvn L=3.5e-07 W=0.65e-06
M23 GND 1 O GND hvn L=3.5e-07 W=0.65e-06
M24 O 1 GND GND hvn L=3.5e-07 W=0.65e-06
M25 GND 1 O GND hvn L=3.5e-07 W=0.65e-06
.ENDS BUFX10

.SUBCKT BUFX12 O I
M0 VDD I 1 VDD hvp L=3.0e-07 W=1e-06
M1 1 I VDD VDD hvp L=3.0e-07 W=1e-06
M2 VDD I 1 VDD hvp L=3.0e-07 W=1e-06
M3 O 1 VDD VDD hvp L=3.0e-07 W=1e-06
M4 VDD 1 O VDD hvp L=3.0e-07 W=1e-06
M5 O 1 VDD VDD hvp L=3.0e-07 W=1e-06
M6 VDD 1 O VDD hvp L=3.0e-07 W=1e-06
M7 O 1 VDD VDD hvp L=3.0e-07 W=1e-06
M8 VDD 1 O VDD hvp L=3.0e-07 W=1e-06
M9 O 1 VDD VDD hvp L=3.0e-07 W=1e-06
M10 VDD 1 O VDD hvp L=3.0e-07 W=1e-06
M11 O 1 VDD VDD hvp L=3.0e-07 W=1e-06
M12 VDD 1 O VDD hvp L=3.0e-07 W=1e-06
M13 O 1 VDD VDD hvp L=3.0e-07 W=1e-06
M14 VDD 1 O VDD hvp L=3.0e-07 W=1e-06
M15 GND I 1 GND hvn L=3.5e-07 W=0.65e-06
M16 1 I GND GND hvn L=3.5e-07 W=0.65e-06
M17 GND I 1 GND hvn L=3.5e-07 W=0.65e-06
M18 O 1 GND GND hvn L=3.5e-07 W=0.65e-06
M19 GND 1 O GND hvn L=3.5e-07 W=0.65e-06
M20 O 1 GND GND hvn L=3.5e-07 W=0.65e-06
M21 GND 1 O GND hvn L=3.5e-07 W=0.65e-06
M22 O 1 GND GND hvn L=3.5e-07 W=0.65e-06
M23 GND 1 O GND hvn L=3.5e-07 W=0.65e-06
M24 O 1 GND GND hvn L=3.5e-07 W=0.65e-06
M25 GND 1 O GND hvn L=3.5e-07 W=0.65e-06
M26 O 1 GND GND hvn L=3.5e-07 W=0.65e-06
M27 GND 1 O GND hvn L=3.5e-07 W=0.65e-06
M28 O 1 GND GND hvn L=3.5e-07 W=0.65e-06
M29 GND 1 O GND hvn L=3.5e-07 W=0.65e-06
.ENDS BUFX12

.SUBCKT BUFX16 O I
M0 VDD I 1 VDD hvp L=3.0e-07 W=1e-06
M1 1 I VDD VDD hvp L=3.0e-07 W=1e-06
M2 VDD I 1 VDD hvp L=3.0e-07 W=1e-06
M3 O 1 VDD VDD hvp L=3.0e-07 W=1e-06
M4 VDD 1 O VDD hvp L=3.0e-07 W=1e-06
M5 O 1 VDD VDD hvp L=3.0e-07 W=1e-06
M6 VDD 1 O VDD hvp L=3.0e-07 W=1e-06
M7 O 1 VDD VDD hvp L=3.0e-07 W=1e-06
M8 VDD 1 O VDD hvp L=3.0e-07 W=1e-06
M9 O 1 VDD VDD hvp L=3.0e-07 W=1e-06
M10 VDD 1 O VDD hvp L=3.0e-07 W=1e-06
M11 O 1 VDD VDD hvp L=3.0e-07 W=1e-06
M12 VDD 1 O VDD hvp L=3.0e-07 W=1e-06
M13 O 1 VDD VDD hvp L=3.0e-07 W=1e-06
M14 VDD 1 O VDD hvp L=3.0e-07 W=1e-06
M15 O 1 VDD VDD hvp L=3.0e-07 W=1e-06
M16 VDD 1 O VDD hvp L=3.0e-07 W=1e-06
M17 O 1 VDD VDD hvp L=3.0e-07 W=1e-06
M18 VDD 1 O VDD hvp L=3.0e-07 W=1e-06
M19 GND I 1 GND hvn L=3.5e-07 W=0.65e-06
M20 1 I GND GND hvn L=3.5e-07 W=0.65e-06
M21 GND I 1 GND hvn L=3.5e-07 W=0.65e-06
M22 O 1 GND GND hvn L=3.5e-07 W=0.65e-06
M23 GND 1 O GND hvn L=3.5e-07 W=0.65e-06
M24 O 1 GND GND hvn L=3.5e-07 W=0.65e-06
M25 GND 1 O GND hvn L=3.5e-07 W=0.65e-06
M26 O 1 GND GND hvn L=3.5e-07 W=0.65e-06
M27 GND 1 O GND hvn L=3.5e-07 W=0.65e-06
M28 O 1 GND GND hvn L=3.5e-07 W=0.65e-06
M29 GND 1 O GND hvn L=3.5e-07 W=0.65e-06
M30 O 1 GND GND hvn L=3.5e-07 W=0.65e-06
M31 GND 1 O GND hvn L=3.5e-07 W=0.65e-06
M32 O 1 GND GND hvn L=3.5e-07 W=0.65e-06
M33 GND 1 O GND hvn L=3.5e-07 W=0.65e-06
M34 O 1 GND GND hvn L=3.5e-07 W=0.65e-06
M35 GND 1 O GND hvn L=3.5e-07 W=0.65e-06
M36 O 1 GND GND hvn L=3.5e-07 W=0.65e-06
M37 GND 1 O GND hvn L=3.5e-07 W=0.65e-06
.ENDS BUFX16

.SUBCKT BUFX2 O I
M0 VDD I 1 VDD hvp L=3.0e-07 W=1e-06
M1 O 1 VDD VDD hvp L=3.0e-07 W=1e-06
M2 VDD 1 O VDD hvp L=3.0e-07 W=1e-06
M3 GND I 1 GND hvn L=3.5e-07 W=0.65e-06
M4 O 1 GND GND hvn L=3.5e-07 W=0.65e-06
M5 GND 1 O GND hvn L=3.5e-07 W=0.65e-06
.ENDS BUFX2

.SUBCKT BUFX20 O I
M0 VDD I 1 VDD hvp L=3.0e-07 W=1e-06
M1 1 I VDD VDD hvp L=3.0e-07 W=1e-06
M2 VDD I 1 VDD hvp L=3.0e-07 W=1e-06
M3 O 1 VDD VDD hvp L=3.0e-07 W=1e-06
M4 VDD 1 O VDD hvp L=3.0e-07 W=1e-06
M5 O 1 VDD VDD hvp L=3.0e-07 W=1e-06
M6 VDD 1 O VDD hvp L=3.0e-07 W=1e-06
M7 O 1 VDD VDD hvp L=3.0e-07 W=1e-06
M8 VDD 1 O VDD hvp L=3.0e-07 W=1e-06
M9 O 1 VDD VDD hvp L=3.0e-07 W=1e-06
M10 VDD 1 O VDD hvp L=3.0e-07 W=1e-06
M11 O 1 VDD VDD hvp L=3.0e-07 W=1e-06
M12 VDD 1 O VDD hvp L=3.0e-07 W=1e-06
M13 O 1 VDD VDD hvp L=3.0e-07 W=1e-06
M14 VDD 1 O VDD hvp L=3.0e-07 W=1e-06
M15 O 1 VDD VDD hvp L=3.0e-07 W=1e-06
M16 VDD 1 O VDD hvp L=3.0e-07 W=1e-06
M17 O 1 VDD VDD hvp L=3.0e-07 W=1e-06
M18 VDD 1 O VDD hvp L=3.0e-07 W=1e-06
M19 O 1 VDD VDD hvp L=3.0e-07 W=1e-06
M20 VDD 1 O VDD hvp L=3.0e-07 W=1e-06
M21 O 1 VDD VDD hvp L=3.0e-07 W=1e-06
M22 VDD 1 O VDD hvp L=3.0e-07 W=1e-06
M23 GND I 1 GND hvn L=3.5e-07 W=0.65e-06
M24 1 I GND GND hvn L=3.5e-07 W=0.65e-06
M25 GND I 1 GND hvn L=3.5e-07 W=0.65e-06
M26 O 1 GND GND hvn L=3.5e-07 W=0.65e-06
M27 GND 1 O GND hvn L=3.5e-07 W=0.65e-06
M28 O 1 GND GND hvn L=3.5e-07 W=0.65e-06
M29 GND 1 O GND hvn L=3.5e-07 W=0.65e-06
M30 O 1 GND GND hvn L=3.5e-07 W=0.65e-06
M31 GND 1 O GND hvn L=3.5e-07 W=0.65e-06
M32 O 1 GND GND hvn L=3.5e-07 W=0.65e-06
M33 GND 1 O GND hvn L=3.5e-07 W=0.65e-06
M34 O 1 GND GND hvn L=3.5e-07 W=0.65e-06
M35 GND 1 O GND hvn L=3.5e-07 W=0.65e-06
M36 O 1 GND GND hvn L=3.5e-07 W=0.65e-06
M37 GND 1 O GND hvn L=3.5e-07 W=0.65e-06
M38 O 1 GND GND hvn L=3.5e-07 W=0.65e-06
M39 GND 1 O GND hvn L=3.5e-07 W=0.65e-06
M40 O 1 GND GND hvn L=3.5e-07 W=0.65e-06
M41 GND 1 O GND hvn L=3.5e-07 W=0.65e-06
M42 O 1 GND GND hvn L=3.5e-07 W=0.65e-06
M43 GND 1 O GND hvn L=3.5e-07 W=0.65e-06
M44 O 1 GND GND hvn L=3.5e-07 W=0.65e-06
M45 GND 1 O GND hvn L=3.5e-07 W=0.65e-06
.ENDS BUFX20

.SUBCKT BUFX3 O I
M0 VDD I 1 VDD hvp L=3.0e-07 W=1e-06
M1 O 1 VDD VDD hvp L=3.0e-07 W=1e-06
M2 VDD 1 O VDD hvp L=3.0e-07 W=1e-06
M3 O 1 VDD VDD hvp L=3.0e-07 W=1e-06
M4 GND I 1 GND hvn L=3.5e-07 W=0.65e-06
M5 O 1 GND GND hvn L=3.5e-07 W=0.65e-06
M6 GND 1 O GND hvn L=3.5e-07 W=0.65e-06
M7 O 1 GND GND hvn L=3.5e-07 W=0.65e-06
.ENDS BUFX3

.SUBCKT BUFX4 O I
M0 VDD I 1 VDD hvp L=3.0e-07 W=1e-06
M1 O 1 VDD VDD hvp L=3.0e-07 W=1e-06
M2 VDD 1 O VDD hvp L=3.0e-07 W=1e-06
M3 O 1 VDD VDD hvp L=3.0e-07 W=1e-06
M4 VDD 1 O VDD hvp L=3.0e-07 W=1e-06
M5 GND I 1 GND hvn L=3.5e-07 W=0.65e-06
M6 O 1 GND GND hvn L=3.5e-07 W=0.65e-06
M7 GND 1 O GND hvn L=3.5e-07 W=0.65e-06
M8 O 1 GND GND hvn L=3.5e-07 W=0.65e-06
M9 GND 1 O GND hvn L=3.5e-07 W=0.65e-06
.ENDS BUFX4

.SUBCKT BUFX5 O I
M0 VDD I 1 VDD hvp L=3.0e-07 W=1e-06
M1 O 1 VDD VDD hvp L=3.0e-07 W=1e-06
M2 VDD 1 O VDD hvp L=3.0e-07 W=1e-06
M3 O 1 VDD VDD hvp L=3.0e-07 W=1e-06
M4 VDD 1 O VDD hvp L=3.0e-07 W=1e-06
M5 O 1 VDD VDD hvp L=3.0e-07 W=1e-06
M6 GND I 1 GND hvn L=3.5e-07 W=0.65e-06
M7 O 1 GND GND hvn L=3.5e-07 W=0.65e-06
M8 GND 1 O GND hvn L=3.5e-07 W=0.65e-06
M9 O 1 GND GND hvn L=3.5e-07 W=0.65e-06
M10 GND 1 O GND hvn L=3.5e-07 W=0.65e-06
M11 O 1 GND GND hvn L=3.5e-07 W=0.65e-06
.ENDS BUFX5

.SUBCKT BUFX6 O I
M0 VDD I 1 VDD hvp L=3.0e-07 W=1e-06
M1 O 1 VDD VDD hvp L=3.0e-07 W=1e-06
M2 VDD 1 O VDD hvp L=3.0e-07 W=1e-06
M3 O 1 VDD VDD hvp L=3.0e-07 W=1e-06
M4 VDD 1 O VDD hvp L=3.0e-07 W=1e-06
M5 O 1 VDD VDD hvp L=3.0e-07 W=1e-06
M6 VDD 1 O VDD hvp L=3.0e-07 W=1e-06
M7 GND I 1 GND hvn L=3.5e-07 W=0.65e-06
M8 O 1 GND GND hvn L=3.5e-07 W=0.65e-06
M9 GND 1 O GND hvn L=3.5e-07 W=0.65e-06
M10 O 1 GND GND hvn L=3.5e-07 W=0.65e-06
M11 GND 1 O GND hvn L=3.5e-07 W=0.65e-06
M12 O 1 GND GND hvn L=3.5e-07 W=0.65e-06
M13 GND 1 O GND hvn L=3.5e-07 W=0.65e-06
.ENDS BUFX6

.SUBCKT BUFX8 O I
M0 2 I VDD VDD hvp L=3.0e-07 W=1e-06
M1 VDD I 2 VDD hvp L=3.0e-07 W=1e-06
M2 O 2 VDD VDD hvp L=3.0e-07 W=1e-06
M3 VDD 2 O VDD hvp L=3.0e-07 W=1e-06
M4 O 2 VDD VDD hvp L=3.0e-07 W=1e-06
M5 VDD 2 O VDD hvp L=3.0e-07 W=1e-06
M6 O 2 VDD VDD hvp L=3.0e-07 W=1e-06
M7 VDD 2 O VDD hvp L=3.0e-07 W=1e-06
M8 O 2 VDD VDD hvp L=3.0e-07 W=1e-06
M9 VDD 2 O VDD hvp L=3.0e-07 W=1e-06
M10 2 I GND GND hvn L=3.5e-07 W=0.65e-06
M11 GND I 2 GND hvn L=3.5e-07 W=0.65e-06
M12 O 2 GND GND hvn L=3.5e-07 W=0.65e-06
M13 GND 2 O GND hvn L=3.5e-07 W=0.65e-06
M14 O 2 GND GND hvn L=3.5e-07 W=0.65e-06
M15 GND 2 O GND hvn L=3.5e-07 W=0.65e-06
M16 O 2 GND GND hvn L=3.5e-07 W=0.65e-06
M17 GND 2 O GND hvn L=3.5e-07 W=0.65e-06
M18 O 2 GND GND hvn L=3.5e-07 W=0.65e-06
M19 GND 2 O GND hvn L=3.5e-07 W=0.65e-06
.ENDS BUFX8

.SUBCKT BUSHOLDX1 IO
M0 VDD IO 1 VDD hvp L=3.0e-07 W=1e-06
M1 IO 1 VDD VDD hvp L=1.9e-06 W=1e-06
M2 GND IO 1 GND hvn L=3.5e-07 W=0.5e-06
M3 IO 1 GND GND hvn L=1.9e-06 W=0.5e-06
.ENDS BUSHOLDX1

.SUBCKT CLKAND2X1 O I1 I2
M0 2 I1 VDD VDD hvp L=3.0e-07 W=1e-06
M1 VDD I2 2 VDD hvp L=3.0e-07 W=1e-06
M2 O 2 VDD VDD hvp L=3.0e-07 W=1e-06
M3 4 I1 2 GND hvn L=3.5e-07 W=0.65e-06
M4 GND I2 4 GND hvn L=3.5e-07 W=0.65e-06
M5 O 2 GND GND hvn L=3.5e-07 W=0.45e-06
.ENDS CLKAND2X1

.SUBCKT CLKAND2X2 O I1 I2
M0 2 I1 VDD VDD hvp L=3.0e-07 W=1e-06
M1 VDD I2 2 VDD hvp L=3.0e-07 W=1e-06
M2 O 2 VDD VDD hvp L=3.0e-07 W=1e-06
M3 VDD 2 O VDD hvp L=3.0e-07 W=1e-06
M4 4 I1 2 GND hvn L=3.5e-07 W=0.65e-06
M5 GND I2 4 GND hvn L=3.5e-07 W=0.65e-06
M6 O 2 GND GND hvn L=3.5e-07 W=0.45e-06
M7 GND 2 O GND hvn L=3.5e-07 W=0.45e-06
.ENDS CLKAND2X2

.SUBCKT CLKAND2X4 O I1 I2
M0 2 I1 VDD VDD hvp L=3.0e-07 W=1e-06
M1 VDD I2 2 VDD hvp L=3.0e-07 W=1e-06
M2 O 2 VDD VDD hvp L=3.0e-07 W=1e-06
M3 VDD 2 O VDD hvp L=3.0e-07 W=1e-06
M4 O 2 VDD VDD hvp L=3.0e-07 W=1e-06
M5 VDD 2 O VDD hvp L=3.0e-07 W=1e-06
M6 4 I1 2 GND hvn L=3.5e-07 W=0.65e-06
M7 GND I2 4 GND hvn L=3.5e-07 W=0.65e-06
M8 O 2 GND GND hvn L=3.5e-07 W=0.45e-06
M9 GND 2 O GND hvn L=3.5e-07 W=0.45e-06
M10 O 2 GND GND hvn L=3.5e-07 W=0.45e-06
M11 GND 2 O GND hvn L=3.5e-07 W=0.45e-06
.ENDS CLKAND2X4

.SUBCKT CLKBUFX1 O I
M0 VDD I 1 VDD hvp L=3.0e-07 W=1e-06
M1 O 1 VDD VDD hvp L=3.0e-07 W=1e-06
M2 GND I 1 GND hvn L=3.5e-07 W=0.5e-06
M3 O 1 GND GND hvn L=3.5e-07 W=0.5e-06
.ENDS CLKBUFX1

.SUBCKT CLKBUFX10 O I
M0 2 I VDD VDD hvp L=3.0e-07 W=1e-06
M1 VDD I 2 VDD hvp L=3.0e-07 W=1e-06
M2 2 I VDD VDD hvp L=3.0e-07 W=1e-06
M3 VDD I 2 VDD hvp L=3.0e-07 W=1e-06
M4 O 2 VDD VDD hvp L=3.0e-07 W=1e-06
M5 VDD 2 O VDD hvp L=3.0e-07 W=1e-06
M6 O 2 VDD VDD hvp L=3.0e-07 W=1e-06
M7 VDD 2 O VDD hvp L=3.0e-07 W=1e-06
M8 O 2 VDD VDD hvp L=3.0e-07 W=1e-06
M9 VDD 2 O VDD hvp L=3.0e-07 W=1e-06
M10 O 2 VDD VDD hvp L=3.0e-07 W=1e-06
M11 VDD 2 O VDD hvp L=3.0e-07 W=1e-06
M12 O 2 VDD VDD hvp L=3.0e-07 W=1e-06
M13 VDD 2 O VDD hvp L=3.0e-07 W=1e-06
M16 2 I GND GND hvn L=3.5e-07 W=0.5e-06
M17 GND I 2 GND hvn L=3.5e-07 W=0.5e-06
M18 2 I GND GND hvn L=3.5e-07 W=0.5e-06
M19 GND I 2 GND hvn L=3.5e-07 W=0.5e-06
M20 O 2 GND GND hvn L=3.5e-07 W=0.5e-06
M21 GND 2 O GND hvn L=3.5e-07 W=0.5e-06
M22 O 2 GND GND hvn L=3.5e-07 W=0.5e-06
M23 GND 2 O GND hvn L=3.5e-07 W=0.5e-06
M24 O 2 GND GND hvn L=3.5e-07 W=0.5e-06
M25 GND 2 O GND hvn L=3.5e-07 W=0.5e-06
M26 O 2 GND GND hvn L=3.5e-07 W=0.5e-06
M27 GND 2 O GND hvn L=3.5e-07 W=0.5e-06
M28 O 2 GND GND hvn L=3.5e-07 W=0.5e-06
M29 GND 2 O GND hvn L=3.5e-07 W=0.5e-06
.ENDS CLKBUFX10

.SUBCKT CLKBUFX12 O I
M0 2 I VDD VDD hvp L=3.0e-07 W=1e-06
M1 VDD I 2 VDD hvp L=3.0e-07 W=1e-06
M2 2 I VDD VDD hvp L=3.0e-07 W=1e-06
M3 VDD I 2 VDD hvp L=3.0e-07 W=1e-06
M4 O 2 VDD VDD hvp L=3.0e-07 W=1e-06
M5 VDD 2 O VDD hvp L=3.0e-07 W=1e-06
M6 O 2 VDD VDD hvp L=3.0e-07 W=1e-06
M7 VDD 2 O VDD hvp L=3.0e-07 W=1e-06
M8 O 2 VDD VDD hvp L=3.0e-07 W=1e-06
M9 VDD 2 O VDD hvp L=3.0e-07 W=1e-06
M10 O 2 VDD VDD hvp L=3.0e-07 W=1e-06
M11 VDD 2 O VDD hvp L=3.0e-07 W=1e-06
M12 O 2 VDD VDD hvp L=3.0e-07 W=1e-06
M13 VDD 2 O VDD hvp L=3.0e-07 W=1e-06
M14 O 2 VDD VDD hvp L=3.0e-07 W=1e-06
M15 VDD 2 O VDD hvp L=3.0e-07 W=1e-06
M16 2 I GND GND hvn L=3.5e-07 W=0.5e-06
M17 GND I 2 GND hvn L=3.5e-07 W=0.5e-06
M18 2 I GND GND hvn L=3.5e-07 W=0.5e-06
M19 GND I 2 GND hvn L=3.5e-07 W=0.5e-06
M20 O 2 GND GND hvn L=3.5e-07 W=0.5e-06
M21 GND 2 O GND hvn L=3.5e-07 W=0.5e-06
M22 O 2 GND GND hvn L=3.5e-07 W=0.5e-06
M23 GND 2 O GND hvn L=3.5e-07 W=0.5e-06
M24 O 2 GND GND hvn L=3.5e-07 W=0.5e-06
M25 GND 2 O GND hvn L=3.5e-07 W=0.5e-06
M26 O 2 GND GND hvn L=3.5e-07 W=0.5e-06
M27 GND 2 O GND hvn L=3.5e-07 W=0.5e-06
M28 O 2 GND GND hvn L=3.5e-07 W=0.5e-06
M29 GND 2 O GND hvn L=3.5e-07 W=0.5e-06
M30 O 2 GND GND hvn L=3.5e-07 W=0.5e-06
M31 GND 2 O GND hvn L=3.5e-07 W=0.5e-06
.ENDS CLKBUFX12

.SUBCKT CLKBUFX16 O I
M0 2 I VDD VDD hvp L=3.0e-07 W=1e-06
M1 VDD I 2 VDD hvp L=3.0e-07 W=1e-06
M2 2 I VDD VDD hvp L=3.0e-07 W=1e-06
M3 VDD I 2 VDD hvp L=3.0e-07 W=1e-06
M4 O 2 VDD VDD hvp L=3.0e-07 W=1e-06
M5 VDD 2 O VDD hvp L=3.0e-07 W=1e-06
M6 O 2 VDD VDD hvp L=3.0e-07 W=1e-06
M7 VDD 2 O VDD hvp L=3.0e-07 W=1e-06
M8 O 2 VDD VDD hvp L=3.0e-07 W=1e-06
M9 VDD 2 O VDD hvp L=3.0e-07 W=1e-06
M10 O 2 VDD VDD hvp L=3.0e-07 W=1e-06
M11 VDD 2 O VDD hvp L=3.0e-07 W=1e-06
M12 O 2 VDD VDD hvp L=3.0e-07 W=1e-06
M13 VDD 2 O VDD hvp L=3.0e-07 W=1e-06
M14 O 2 VDD VDD hvp L=3.0e-07 W=1e-06
M15 VDD 2 O VDD hvp L=3.0e-07 W=1e-06
M16 O 2 VDD VDD hvp L=3.0e-07 W=1e-06
M17 VDD 2 O VDD hvp L=3.0e-07 W=1e-06
M18 O 2 VDD VDD hvp L=3.0e-07 W=1e-06
M19 VDD 2 O VDD hvp L=3.0e-07 W=1e-06
M20 2 I GND GND hvn L=3.5e-07 W=0.5e-06
M21 GND I 2 GND hvn L=3.5e-07 W=0.5e-06
M22 2 I GND GND hvn L=3.5e-07 W=0.5e-06
M23 GND I 2 GND hvn L=3.5e-07 W=0.5e-06
M24 O 2 GND GND hvn L=3.5e-07 W=0.5e-06
M25 GND 2 O GND hvn L=3.5e-07 W=0.5e-06
M26 O 2 GND GND hvn L=3.5e-07 W=0.5e-06
M27 GND 2 O GND hvn L=3.5e-07 W=0.5e-06
M28 O 2 GND GND hvn L=3.5e-07 W=0.5e-06
M29 GND 2 O GND hvn L=3.5e-07 W=0.5e-06
M30 O 2 GND GND hvn L=3.5e-07 W=0.5e-06
M31 GND 2 O GND hvn L=3.5e-07 W=0.5e-06
M32 O 2 GND GND hvn L=3.5e-07 W=0.5e-06
M33 GND 2 O GND hvn L=3.5e-07 W=0.5e-06
M34 O 2 GND GND hvn L=3.5e-07 W=0.5e-06
M35 GND 2 O GND hvn L=3.5e-07 W=0.5e-06
M36 O 2 GND GND hvn L=3.5e-07 W=0.5e-06
M37 GND 2 O GND hvn L=3.5e-07 W=0.5e-06
M38 O 2 GND GND hvn L=3.5e-07 W=0.5e-06
M39 GND 2 O GND hvn L=3.5e-07 W=0.5e-06
.ENDS CLKBUFX16

.SUBCKT CLKBUFX2 O I
M0 VDD I 1 VDD hvp L=3.0e-07 W=1e-06
M1 O 1 VDD VDD hvp L=3.0e-07 W=1e-06
M2 VDD 1 O VDD hvp L=3.0e-07 W=1e-06
M3 GND I 1 GND hvn L=3.5e-07 W=0.5e-06
M4 O 1 GND GND hvn L=3.5e-07 W=0.5e-06
M5 GND 1 O GND hvn L=3.5e-07 W=0.5e-06
.ENDS CLKBUFX2

.SUBCKT CLKBUFX20 O I
M0 2 I VDD VDD hvp L=3.0e-07 W=1e-06
M1 VDD I 2 VDD hvp L=3.0e-07 W=1e-06
M2 2 I VDD VDD hvp L=3.0e-07 W=1e-06
M3 VDD I 2 VDD hvp L=3.0e-07 W=1e-06
M4 2 I VDD VDD hvp L=3.0e-07 W=1e-06
M5 VDD I 2 VDD hvp L=3.0e-07 W=1e-06
M6 O 2 VDD VDD hvp L=3.0e-07 W=1e-06
M7 VDD 2 O VDD hvp L=3.0e-07 W=1e-06
M8 O 2 VDD VDD hvp L=3.0e-07 W=1e-06
M9 VDD 2 O VDD hvp L=3.0e-07 W=1e-06
M10 O 2 VDD VDD hvp L=3.0e-07 W=1e-06
M11 VDD 2 O VDD hvp L=3.0e-07 W=1e-06
M12 O 2 VDD VDD hvp L=3.0e-07 W=1e-06
M13 VDD 2 O VDD hvp L=3.0e-07 W=1e-06
M14 O 2 VDD VDD hvp L=3.0e-07 W=1e-06
M15 VDD 2 O VDD hvp L=3.0e-07 W=1e-06
M16 O 2 VDD VDD hvp L=3.0e-07 W=1e-06
M17 VDD 2 O VDD hvp L=3.0e-07 W=1e-06
M18 O 2 VDD VDD hvp L=3.0e-07 W=1e-06
M19 VDD 2 O VDD hvp L=3.0e-07 W=1e-06
M20 O 2 VDD VDD hvp L=3.0e-07 W=1e-06
M21 VDD 2 O VDD hvp L=3.0e-07 W=1e-06
M22 O 2 VDD VDD hvp L=3.0e-07 W=1e-06
M23 VDD 2 O VDD hvp L=3.0e-07 W=1e-06
M24 O 2 VDD VDD hvp L=3.0e-07 W=1e-06
M25 VDD 2 O VDD hvp L=3.0e-07 W=1e-06
M26 2 I GND GND hvn L=3.5e-07 W=0.5e-06
M27 GND I 2 GND hvn L=3.5e-07 W=0.5e-06
M28 2 I GND GND hvn L=3.5e-07 W=0.5e-06
M29 GND I 2 GND hvn L=3.5e-07 W=0.5e-06
M30 2 I GND GND hvn L=3.5e-07 W=0.5e-06
M31 GND I 2 GND hvn L=3.5e-07 W=0.5e-06
M32 O 2 GND GND hvn L=3.5e-07 W=0.5e-06
M33 GND 2 O GND hvn L=3.5e-07 W=0.5e-06
M34 O 2 GND GND hvn L=3.5e-07 W=0.5e-06
M35 GND 2 O GND hvn L=3.5e-07 W=0.5e-06
M36 O 2 GND GND hvn L=3.5e-07 W=0.5e-06
M37 GND 2 O GND hvn L=3.5e-07 W=0.5e-06
M38 O 2 GND GND hvn L=3.5e-07 W=0.5e-06
M39 GND 2 O GND hvn L=3.5e-07 W=0.5e-06
M40 O 2 GND GND hvn L=3.5e-07 W=0.5e-06
M41 GND 2 O GND hvn L=3.5e-07 W=0.5e-06
M42 O 2 GND GND hvn L=3.5e-07 W=0.5e-06
M43 GND 2 O GND hvn L=3.5e-07 W=0.5e-06
M44 O 2 GND GND hvn L=3.5e-07 W=0.5e-06
M45 GND 2 O GND hvn L=3.5e-07 W=0.5e-06
M46 O 2 GND GND hvn L=3.5e-07 W=0.5e-06
M47 GND 2 O GND hvn L=3.5e-07 W=0.5e-06
M48 O 2 GND GND hvn L=3.5e-07 W=0.5e-06
M49 GND 2 O GND hvn L=3.5e-07 W=0.5e-06
M50 O 2 GND GND hvn L=3.5e-07 W=0.5e-06
M51 GND 2 O GND hvn L=3.5e-07 W=0.5e-06
.ENDS CLKBUFX20

.SUBCKT CLKBUFX3 O I
M0 VDD I 1 VDD hvp L=3.0e-07 W=1e-06
M1 O 1 VDD VDD hvp L=3.0e-07 W=1e-06
M2 VDD 1 O VDD hvp L=3.0e-07 W=1e-06
M3 O 1 VDD VDD hvp L=3.0e-07 W=1e-06
M4 GND I 1 GND hvn L=3.5e-07 W=0.5e-06
M5 O 1 GND GND hvn L=3.5e-07 W=0.5e-06
M6 GND 1 O GND hvn L=3.5e-07 W=0.5e-06
M7 O 1 GND GND hvn L=3.5e-07 W=0.5e-06
.ENDS CLKBUFX3

.SUBCKT CLKBUFX4 O I
M0 VDD I 1 VDD hvp L=3.0e-07 W=1e-06
M1 O 1 VDD VDD hvp L=3.0e-07 W=1e-06
M2 VDD 1 O VDD hvp L=3.0e-07 W=1e-06
M3 O 1 VDD VDD hvp L=3.0e-07 W=1e-06
M4 VDD 1 O VDD hvp L=3.0e-07 W=1e-06
M5 GND I 1 GND hvn L=3.5e-07 W=0.5e-06
M6 O 1 GND GND hvn L=3.5e-07 W=0.5e-06
M7 GND 1 O GND hvn L=3.5e-07 W=0.5e-06
M8 O 1 GND GND hvn L=3.5e-07 W=0.5e-06
M9 GND 1 O GND hvn L=3.5e-07 W=0.5e-06
.ENDS CLKBUFX4

.SUBCKT CLKBUFX5 O I
M0 2 I VDD VDD hvp L=3.0e-07 W=1e-06
M1 VDD I 2 VDD hvp L=3.0e-07 W=1e-06
M2 O 2 VDD VDD hvp L=3.0e-07 W=1e-06
M3 VDD 2 O VDD hvp L=3.0e-07 W=1e-06
M4 O 2 VDD VDD hvp L=3.0e-07 W=1e-06
M5 VDD 2 O VDD hvp L=3.0e-07 W=1e-06
M6 O 2 VDD VDD hvp L=3.0e-07 W=1e-06
M8 2 I GND GND hvn L=3.5e-07 W=0.5e-06
M9 GND I 2 GND hvn L=3.5e-07 W=0.5e-06
M10 O 2 GND GND hvn L=3.5e-07 W=0.5e-06
M11 GND 2 O GND hvn L=3.5e-07 W=0.5e-06
M12 O 2 GND GND hvn L=3.5e-07 W=0.5e-06
M13 GND 2 O GND hvn L=3.5e-07 W=0.5e-06
M14 O 2 GND GND hvn L=3.5e-07 W=0.5e-06
.ENDS CLKBUFX5

.SUBCKT CLKBUFX6 O I
M0 2 I VDD VDD hvp L=3.0e-07 W=1e-06
M1 VDD I 2 VDD hvp L=3.0e-07 W=1e-06
M2 O 2 VDD VDD hvp L=3.0e-07 W=1e-06
M3 VDD 2 O VDD hvp L=3.0e-07 W=1e-06
M4 O 2 VDD VDD hvp L=3.0e-07 W=1e-06
M5 VDD 2 O VDD hvp L=3.0e-07 W=1e-06
M6 O 2 VDD VDD hvp L=3.0e-07 W=1e-06
M7 VDD 2 O VDD hvp L=3.0e-07 W=1e-06
M8 2 I GND GND hvn L=3.5e-07 W=0.5e-06
M9 GND I 2 GND hvn L=3.5e-07 W=0.5e-06
M10 O 2 GND GND hvn L=3.5e-07 W=0.5e-06
M11 GND 2 O GND hvn L=3.5e-07 W=0.5e-06
M12 O 2 GND GND hvn L=3.5e-07 W=0.5e-06
M13 GND 2 O GND hvn L=3.5e-07 W=0.5e-06
M14 O 2 GND GND hvn L=3.5e-07 W=0.5e-06
M15 GND 2 O GND hvn L=3.5e-07 W=0.5e-06
.ENDS CLKBUFX6

.SUBCKT CLKBUFX8 O I
M0 2 I VDD VDD hvp L=3.0e-07 W=1e-06
M1 VDD I 2 VDD hvp L=3.0e-07 W=1e-06
M2 O 2 VDD VDD hvp L=3.0e-07 W=1e-06
M3 VDD 2 O VDD hvp L=3.0e-07 W=1e-06
M4 O 2 VDD VDD hvp L=3.0e-07 W=1e-06
M5 VDD 2 O VDD hvp L=3.0e-07 W=1e-06
M6 O 2 VDD VDD hvp L=3.0e-07 W=1e-06
M7 VDD 2 O VDD hvp L=3.0e-07 W=1e-06
M8 O 2 VDD VDD hvp L=3.0e-07 W=1e-06
M9 VDD 2 O VDD hvp L=3.0e-07 W=1e-06
M10 2 I GND GND hvn L=3.5e-07 W=0.5e-06
M11 GND I 2 GND hvn L=3.5e-07 W=0.5e-06
M12 O 2 GND GND hvn L=3.5e-07 W=0.5e-06
M13 GND 2 O GND hvn L=3.5e-07 W=0.5e-06
M14 O 2 GND GND hvn L=3.5e-07 W=0.5e-06
M15 GND 2 O GND hvn L=3.5e-07 W=0.5e-06
M16 O 2 GND GND hvn L=3.5e-07 W=0.5e-06
M17 GND 2 O GND hvn L=3.5e-07 W=0.5e-06
M18 O 2 GND GND hvn L=3.5e-07 W=0.5e-06
M19 GND 2 O GND hvn L=3.5e-07 W=0.5e-06
.ENDS CLKBUFX8

.SUBCKT CLKINVX1 O I
M0 O I VDD VDD hvp L=3.0e-07 W=1e-06
M1 O I GND GND hvn L=3.5e-07 W=0.55e-06
.ENDS CLKINVX1

.SUBCKT CLKINVX10 O I
M0 O I VDD VDD hvp L=3.0e-07 W=1e-06
M1 VDD I O VDD hvp L=3.0e-07 W=1e-06
M2 O I VDD VDD hvp L=3.0e-07 W=1e-06
M3 VDD I O VDD hvp L=3.0e-07 W=1e-06
M4 O I VDD VDD hvp L=3.0e-07 W=1e-06
M5 VDD I O VDD hvp L=3.0e-07 W=1e-06
M6 O I VDD VDD hvp L=3.0e-07 W=1e-06
M7 VDD I O VDD hvp L=3.0e-07 W=1e-06
M8 O I VDD VDD hvp L=3.0e-07 W=1e-06
M9 VDD I O VDD hvp L=3.0e-07 W=1e-06
M12 O I GND GND hvn L=3.5e-07 W=0.55e-06
M13 GND I O GND hvn L=3.5e-07 W=0.55e-06
M14 O I GND GND hvn L=3.5e-07 W=0.55e-06
M15 GND I O GND hvn L=3.5e-07 W=0.55e-06
M16 O I GND GND hvn L=3.5e-07 W=0.55e-06
M17 GND I O GND hvn L=3.5e-07 W=0.55e-06
M18 O I GND GND hvn L=3.5e-07 W=0.55e-06
M19 GND I O GND hvn L=3.5e-07 W=0.55e-06
M20 O I GND GND hvn L=3.5e-07 W=0.55e-06
M21 GND I O GND hvn L=3.5e-07 W=0.55e-06
.ENDS CLKINVX10

.SUBCKT CLKINVX12 O I
M0 O I VDD VDD hvp L=3.0e-07 W=1e-06
M1 VDD I O VDD hvp L=3.0e-07 W=1e-06
M2 O I VDD VDD hvp L=3.0e-07 W=1e-06
M3 VDD I O VDD hvp L=3.0e-07 W=1e-06
M4 O I VDD VDD hvp L=3.0e-07 W=1e-06
M5 VDD I O VDD hvp L=3.0e-07 W=1e-06
M6 O I VDD VDD hvp L=3.0e-07 W=1e-06
M7 VDD I O VDD hvp L=3.0e-07 W=1e-06
M8 O I VDD VDD hvp L=3.0e-07 W=1e-06
M9 VDD I O VDD hvp L=3.0e-07 W=1e-06
M10 O I VDD VDD hvp L=3.0e-07 W=1e-06
M11 VDD I O VDD hvp L=3.0e-07 W=1e-06
M12 O I GND GND hvn L=3.5e-07 W=0.55e-06
M13 GND I O GND hvn L=3.5e-07 W=0.55e-06
M14 O I GND GND hvn L=3.5e-07 W=0.55e-06
M15 GND I O GND hvn L=3.5e-07 W=0.55e-06
M16 O I GND GND hvn L=3.5e-07 W=0.55e-06
M17 GND I O GND hvn L=3.5e-07 W=0.55e-06
M18 O I GND GND hvn L=3.5e-07 W=0.55e-06
M19 GND I O GND hvn L=3.5e-07 W=0.55e-06
M20 O I GND GND hvn L=3.5e-07 W=0.55e-06
M21 GND I O GND hvn L=3.5e-07 W=0.55e-06
M22 O I GND GND hvn L=3.5e-07 W=0.55e-06
M23 GND I O GND hvn L=3.5e-07 W=0.55e-06
.ENDS CLKINVX12

.SUBCKT CLKINVX16 O I
M0 O I VDD VDD hvp L=3.0e-07 W=1e-06
M1 VDD I O VDD hvp L=3.0e-07 W=1e-06
M2 O I VDD VDD hvp L=3.0e-07 W=1e-06
M3 VDD I O VDD hvp L=3.0e-07 W=1e-06
M4 O I VDD VDD hvp L=3.0e-07 W=1e-06
M5 VDD I O VDD hvp L=3.0e-07 W=1e-06
M6 O I VDD VDD hvp L=3.0e-07 W=1e-06
M7 VDD I O VDD hvp L=3.0e-07 W=1e-06
M8 O I VDD VDD hvp L=3.0e-07 W=1e-06
M9 VDD I O VDD hvp L=3.0e-07 W=1e-06
M10 O I VDD VDD hvp L=3.0e-07 W=1e-06
M11 VDD I O VDD hvp L=3.0e-07 W=1e-06
M12 O I VDD VDD hvp L=3.0e-07 W=1e-06
M13 VDD I O VDD hvp L=3.0e-07 W=1e-06
M14 O I VDD VDD hvp L=3.0e-07 W=1e-06
M15 VDD I O VDD hvp L=3.0e-07 W=1e-06
M16 O I GND GND hvn L=3.5e-07 W=0.55e-06
M17 GND I O GND hvn L=3.5e-07 W=0.55e-06
M18 O I GND GND hvn L=3.5e-07 W=0.55e-06
M19 GND I O GND hvn L=3.5e-07 W=0.55e-06
M20 O I GND GND hvn L=3.5e-07 W=0.55e-06
M21 GND I O GND hvn L=3.5e-07 W=0.55e-06
M22 O I GND GND hvn L=3.5e-07 W=0.55e-06
M23 GND I O GND hvn L=3.5e-07 W=0.55e-06
M24 O I GND GND hvn L=3.5e-07 W=0.55e-06
M25 GND I O GND hvn L=3.5e-07 W=0.55e-06
M26 O I GND GND hvn L=3.5e-07 W=0.55e-06
M27 GND I O GND hvn L=3.5e-07 W=0.55e-06
M28 O I GND GND hvn L=3.5e-07 W=0.55e-06
M29 GND I O GND hvn L=3.5e-07 W=0.55e-06
M30 O I GND GND hvn L=3.5e-07 W=0.55e-06
M31 GND I O GND hvn L=3.5e-07 W=0.55e-06
.ENDS CLKINVX16

.SUBCKT CLKINVX2 O I
M0 O I VDD VDD hvp L=3.0e-07 W=1e-06
M1 VDD I O VDD hvp L=3.0e-07 W=1e-06
M2 O I GND GND hvn L=3.5e-07 W=0.55e-06
M3 GND I O GND hvn L=3.5e-07 W=0.55e-06
.ENDS CLKINVX2

.SUBCKT CLKINVX20 O I
M0 O I VDD VDD hvp L=3.0e-07 W=1e-06
M1 VDD I O VDD hvp L=3.0e-07 W=1e-06
M2 O I VDD VDD hvp L=3.0e-07 W=1e-06
M3 VDD I O VDD hvp L=3.0e-07 W=1e-06
M4 O I VDD VDD hvp L=3.0e-07 W=1e-06
M5 VDD I O VDD hvp L=3.0e-07 W=1e-06
M6 O I VDD VDD hvp L=3.0e-07 W=1e-06
M7 VDD I O VDD hvp L=3.0e-07 W=1e-06
M8 O I VDD VDD hvp L=3.0e-07 W=1e-06
M9 VDD I O VDD hvp L=3.0e-07 W=1e-06
M10 O I VDD VDD hvp L=3.0e-07 W=1e-06
M11 VDD I O VDD hvp L=3.0e-07 W=1e-06
M12 O I VDD VDD hvp L=3.0e-07 W=1e-06
M13 VDD I O VDD hvp L=3.0e-07 W=1e-06
M14 O I VDD VDD hvp L=3.0e-07 W=1e-06
M15 VDD I O VDD hvp L=3.0e-07 W=1e-06
M16 O I VDD VDD hvp L=3.0e-07 W=1e-06
M17 VDD I O VDD hvp L=3.0e-07 W=1e-06
M18 O I VDD VDD hvp L=3.0e-07 W=1e-06
M19 VDD I O VDD hvp L=3.0e-07 W=1e-06
M20 O I GND GND hvn L=3.5e-07 W=0.55e-06
M21 GND I O GND hvn L=3.5e-07 W=0.55e-06
M22 O I GND GND hvn L=3.5e-07 W=0.55e-06
M23 GND I O GND hvn L=3.5e-07 W=0.55e-06
M24 O I GND GND hvn L=3.5e-07 W=0.55e-06
M25 GND I O GND hvn L=3.5e-07 W=0.55e-06
M26 O I GND GND hvn L=3.5e-07 W=0.55e-06
M27 GND I O GND hvn L=3.5e-07 W=0.55e-06
M28 O I GND GND hvn L=3.5e-07 W=0.55e-06
M29 GND I O GND hvn L=3.5e-07 W=0.55e-06
M30 O I GND GND hvn L=3.5e-07 W=0.55e-06
M31 GND I O GND hvn L=3.5e-07 W=0.55e-06
M32 O I GND GND hvn L=3.5e-07 W=0.55e-06
M33 GND I O GND hvn L=3.5e-07 W=0.55e-06
M34 O I GND GND hvn L=3.5e-07 W=0.55e-06
M35 GND I O GND hvn L=3.5e-07 W=0.55e-06
M36 O I GND GND hvn L=3.5e-07 W=0.55e-06
M37 GND I O GND hvn L=3.5e-07 W=0.55e-06
M38 O I GND GND hvn L=3.5e-07 W=0.55e-06
M39 GND I O GND hvn L=3.5e-07 W=0.55e-06
.ENDS CLKINVX20

.SUBCKT CLKINVX3 O I
M0 O I VDD VDD hvp L=3.0e-07 W=1e-06
M1 VDD I O VDD hvp L=3.0e-07 W=1e-06
M2 O I VDD VDD hvp L=3.0e-07 W=1e-06
M3 O I GND GND hvn L=3.5e-07 W=0.55e-06
M4 GND I O GND hvn L=3.5e-07 W=0.55e-06
M5 O I GND GND hvn L=3.5e-07 W=0.55e-06
.ENDS CLKINVX3

.SUBCKT CLKINVX4 O I
M0 O I VDD VDD hvp L=3.0e-07 W=1e-06
M1 VDD I O VDD hvp L=3.0e-07 W=1e-06
M2 O I VDD VDD hvp L=3.0e-07 W=1e-06
M3 VDD I O VDD hvp L=3.0e-07 W=1e-06
M4 O I GND GND hvn L=3.5e-07 W=0.55e-06
M5 GND I O GND hvn L=3.5e-07 W=0.55e-06
M6 O I GND GND hvn L=3.5e-07 W=0.55e-06
M7 GND I O GND hvn L=3.5e-07 W=0.55e-06
.ENDS CLKINVX4

.SUBCKT CLKINVX5 O I
M0 O I VDD VDD hvp L=3.0e-07 W=1e-06
M1 VDD I O VDD hvp L=3.0e-07 W=1e-06
M2 O I VDD VDD hvp L=3.0e-07 W=1e-06
M3 VDD I O VDD hvp L=3.0e-07 W=1e-06
M4 O I VDD VDD hvp L=3.0e-07 W=1e-06
M6 O I GND GND hvn L=3.5e-07 W=0.55e-06
M7 GND I O GND hvn L=3.5e-07 W=0.55e-06
M8 O I GND GND hvn L=3.5e-07 W=0.55e-06
M9 GND I O GND hvn L=3.5e-07 W=0.55e-06
M10 O I GND GND hvn L=3.5e-07 W=0.55e-06
.ENDS CLKINVX5

.SUBCKT CLKINVX6 O I
M0 O I VDD VDD hvp L=3.0e-07 W=1e-06
M1 VDD I O VDD hvp L=3.0e-07 W=1e-06
M2 O I VDD VDD hvp L=3.0e-07 W=1e-06
M3 VDD I O VDD hvp L=3.0e-07 W=1e-06
M4 O I VDD VDD hvp L=3.0e-07 W=1e-06
M5 VDD I O VDD hvp L=3.0e-07 W=1e-06
M6 O I GND GND hvn L=3.5e-07 W=0.55e-06
M7 GND I O GND hvn L=3.5e-07 W=0.55e-06
M8 O I GND GND hvn L=3.5e-07 W=0.55e-06
M9 GND I O GND hvn L=3.5e-07 W=0.55e-06
M10 O I GND GND hvn L=3.5e-07 W=0.55e-06
M11 GND I O GND hvn L=3.5e-07 W=0.55e-06
.ENDS CLKINVX6

.SUBCKT CLKINVX8 O I
M0 O I VDD VDD hvp L=3.0e-07 W=1e-06
M1 VDD I O VDD hvp L=3.0e-07 W=1e-06
M2 O I VDD VDD hvp L=3.0e-07 W=1e-06
M3 VDD I O VDD hvp L=3.0e-07 W=1e-06
M4 O I VDD VDD hvp L=3.0e-07 W=1e-06
M5 VDD I O VDD hvp L=3.0e-07 W=1e-06
M6 O I VDD VDD hvp L=3.0e-07 W=1e-06
M7 VDD I O VDD hvp L=3.0e-07 W=1e-06
M8 O I GND GND hvn L=3.5e-07 W=0.55e-06
M9 GND I O GND hvn L=3.5e-07 W=0.55e-06
M10 O I GND GND hvn L=3.5e-07 W=0.55e-06
M11 GND I O GND hvn L=3.5e-07 W=0.55e-06
M12 O I GND GND hvn L=3.5e-07 W=0.55e-06
M13 GND I O GND hvn L=3.5e-07 W=0.55e-06
M14 O I GND GND hvn L=3.5e-07 W=0.55e-06
M15 GND I O GND hvn L=3.5e-07 W=0.55e-06
.ENDS CLKINVX8

.SUBCKT CLKMUX2X1 O I0 I1 S
M0 VDD S 1 VDD hvp L=3.0e-07 W=0.3e-06
M1 3 I0 VDD VDD hvp L=3.0e-07 W=1e-06
M2 4 S 3 VDD hvp L=3.0e-07 W=0.6e-06
M3 5 1 4 VDD hvp L=3.0e-07 W=0.6e-06
M4 VDD I1 5 VDD hvp L=3.0e-07 W=1e-06
M5 O 4 VDD VDD hvp L=3.0e-07 W=1e-06
M6 GND S 1 GND hvn L=3.5e-07 W=0.3e-06
M7 8 I0 GND GND hvn L=3.5e-07 W=0.65e-06
M8 4 1 8 GND hvn L=3.5e-07 W=0.4e-06
M9 9 S 4 GND hvn L=3.5e-07 W=0.4e-06
M10 GND I1 9 GND hvn L=3.5e-07 W=0.65e-06
M11 O 4 GND GND hvn L=3.5e-07 W=0.65e-06
.ENDS CLKMUX2X1

.SUBCKT CLKMUX2X2 O I0 I1 S
M0 VDD S 1 VDD hvp L=3.0e-07 W=0.3e-06
M1 3 I0 VDD VDD hvp L=3.0e-07 W=1e-06
M2 4 S 3 VDD hvp L=3.0e-07 W=0.6e-06
M3 5 1 4 VDD hvp L=3.0e-07 W=0.6e-06
M4 VDD I1 5 VDD hvp L=3.0e-07 W=1e-06
M5 O 4 VDD VDD hvp L=3.0e-07 W=1e-06
M6 VDD 4 O VDD hvp L=3.0e-07 W=1e-06
M7 GND S 1 GND hvn L=3.5e-07 W=0.3e-06
M8 8 I0 GND GND hvn L=3.5e-07 W=0.65e-06
M9 4 1 8 GND hvn L=3.5e-07 W=0.4e-06
M10 9 S 4 GND hvn L=3.5e-07 W=0.4e-06
M11 GND I1 9 GND hvn L=3.5e-07 W=0.65e-06
M12 O 4 GND GND hvn L=3.5e-07 W=0.65e-06
M13 GND 4 O GND hvn L=3.5e-07 W=0.65e-06
.ENDS CLKMUX2X2

.SUBCKT CLKMUX2X4 O I0 I1 S
M0 VDD S 1 VDD hvp L=3.0e-07 W=0.3e-06
M1 3 I0 VDD VDD hvp L=3.0e-07 W=1e-06
M2 4 S 3 VDD hvp L=3.0e-07 W=0.6e-06
M3 5 1 4 VDD hvp L=3.0e-07 W=0.6e-06
M4 VDD I1 5 VDD hvp L=3.0e-07 W=1e-06
M5 O 4 VDD VDD hvp L=3.0e-07 W=1e-06
M6 VDD 4 O VDD hvp L=3.0e-07 W=1e-06
M7 O 4 VDD VDD hvp L=3.0e-07 W=1e-06
M8 VDD 4 O VDD hvp L=3.0e-07 W=1e-06
M9 GND S 1 GND hvn L=3.5e-07 W=0.3e-06
M10 8 I0 GND GND hvn L=3.5e-07 W=0.65e-06
M11 4 1 8 GND hvn L=3.5e-07 W=0.4e-06
M12 9 S 4 GND hvn L=3.5e-07 W=0.4e-06
M13 GND I1 9 GND hvn L=3.5e-07 W=0.65e-06
M14 O 4 GND GND hvn L=3.5e-07 W=0.65e-06
M15 GND 4 O GND hvn L=3.5e-07 W=0.65e-06
M16 O 4 GND GND hvn L=3.5e-07 W=0.65e-06
M17 GND 4 O GND hvn L=3.5e-07 W=0.65e-06
.ENDS CLKMUX2X4

.SUBCKT CLKNAND2X1 O I1 I2
M0 O I2 VDD VDD hvp L=3.0e-07 W=1e-06
M1 VDD I1 O VDD hvp L=3.0e-07 W=1e-06
M2 4 I2 GND GND hvn L=3.5e-07 W=0.65e-06
M3 O I1 4 GND hvn L=3.5e-07 W=0.65e-06
.ENDS CLKNAND2X1

.SUBCKT CLKNAND2X2 O I1 I2
M0 O I2 VDD VDD hvp L=3.0e-07 W=1e-06
M1 VDD I1 O VDD hvp L=3.0e-07 W=1e-06
M2 O I1 VDD VDD hvp L=3.0e-07 W=1e-06
M3 VDD I2 O VDD hvp L=3.0e-07 W=1e-06
M4 4 I2 GND GND hvn L=3.5e-07 W=0.65e-06
M5 O I1 4 GND hvn L=3.5e-07 W=0.65e-06
M6 5 I1 O GND hvn L=3.5e-07 W=0.65e-06
M7 GND I2 5 GND hvn L=3.5e-07 W=0.65e-06
.ENDS CLKNAND2X2

.SUBCKT CLKNAND2X4 O I1 I2
M0 O I2 VDD VDD hvp L=3.0e-07 W=0.9e-06
M1 VDD I1 O VDD hvp L=3.0e-07 W=0.9e-06
M2 O I1 VDD VDD hvp L=3.0e-07 W=0.9e-06
M3 VDD I2 O VDD hvp L=3.0e-07 W=0.9e-06
M4 O I2 VDD VDD hvp L=3.0e-07 W=0.9e-06
M5 VDD I1 O VDD hvp L=3.0e-07 W=0.9e-06
M6 O I1 VDD VDD hvp L=3.0e-07 W=0.9e-06
M7 VDD I2 O VDD hvp L=3.0e-07 W=0.9e-06
M8 4 I2 GND GND hvn L=3.5e-07 W=0.6e-06
M9 O I1 4 GND hvn L=3.5e-07 W=0.6e-06
M10 5 I1 O GND hvn L=3.5e-07 W=0.6e-06
M11 GND I2 5 GND hvn L=3.5e-07 W=0.6e-06
M12 6 I2 GND GND hvn L=3.5e-07 W=0.6e-06
M13 O I1 6 GND hvn L=3.5e-07 W=0.6e-06
M14 7 I1 O GND hvn L=3.5e-07 W=0.6e-06
M15 GND I2 7 GND hvn L=3.5e-07 W=0.6e-06
.ENDS CLKNAND2X4

.SUBCKT CLKNOR2X1 O I1 I2
M0 2 I2 VDD VDD hvp L=3.0e-07 W=0.9e-06
M1 O I1 2 VDD hvp L=3.0e-07 W=0.9e-06
M2 4 I1 O VDD hvp L=3.0e-07 W=0.9e-06
M3 VDD I2 4 VDD hvp L=3.0e-07 W=0.9e-06
M4 GND I2 O GND hvn L=3.5e-07 W=0.6e-06
M5 O I1 GND GND hvn L=3.5e-07 W=0.6e-06
.ENDS CLKNOR2X1

.SUBCKT CLKNOR2X2 O I1 I2
M0 2 I2 VDD VDD hvp L=3.0e-07 W=0.9e-06
M1 O I1 2 VDD hvp L=3.0e-07 W=0.9e-06
M2 4 I1 O VDD hvp L=3.0e-07 W=0.9e-06
M3 VDD I2 4 VDD hvp L=3.0e-07 W=0.9e-06
M4 5 I2 VDD VDD hvp L=3.0e-07 W=0.9e-06
M5 O I1 5 VDD hvp L=3.0e-07 W=0.9e-06
M6 6 I1 O VDD hvp L=3.0e-07 W=0.9e-06
M7 VDD I2 6 VDD hvp L=3.0e-07 W=0.9e-06
M8 GND I2 O GND hvn L=3.5e-07 W=0.6e-06
M9 O I1 GND GND hvn L=3.5e-07 W=0.6e-06
M10 GND I2 O GND hvn L=3.5e-07 W=0.6e-06
M11 O I1 GND GND hvn L=3.5e-07 W=0.6e-06
.ENDS CLKNOR2X2

.SUBCKT CLKNOR2X4 O I1 I2
M0 2 I2 VDD VDD hvp L=3.0e-07 W=0.9e-06
M1 O I1 2 VDD hvp L=3.0e-07 W=0.9e-06
M2 4 I1 O VDD hvp L=3.0e-07 W=0.9e-06
M3 VDD I2 4 VDD hvp L=3.0e-07 W=0.9e-06
M4 5 I2 VDD VDD hvp L=3.0e-07 W=0.9e-06
M5 O I1 5 VDD hvp L=3.0e-07 W=0.9e-06
M6 6 I1 O VDD hvp L=3.0e-07 W=0.9e-06
M7 VDD I2 6 VDD hvp L=3.0e-07 W=0.9e-06
M8 7 I2 VDD VDD hvp L=3.0e-07 W=0.9e-06
M9 O I1 7 VDD hvp L=3.0e-07 W=0.9e-06
M10 8 I1 O VDD hvp L=3.0e-07 W=0.9e-06
M11 VDD I2 8 VDD hvp L=3.0e-07 W=0.9e-06
M12 9 I2 VDD VDD hvp L=3.0e-07 W=0.9e-06
M13 O I1 9 VDD hvp L=3.0e-07 W=0.9e-06
M14 10 I1 O VDD hvp L=3.0e-07 W=0.9e-06
M15 VDD I2 10 VDD hvp L=3.0e-07 W=0.9e-06
M16 GND I2 O GND hvn L=3.5e-07 W=0.6e-06
M17 O I1 GND GND hvn L=3.5e-07 W=0.6e-06
M18 GND I2 O GND hvn L=3.5e-07 W=0.6e-06
M19 O I1 GND GND hvn L=3.5e-07 W=0.6e-06
M20 GND I2 O GND hvn L=3.5e-07 W=0.3e-06
M21 O I1 GND GND hvn L=3.5e-07 W=0.6e-06
M22 GND I2 O GND hvn L=3.5e-07 W=0.6e-06
M23 O I1 GND GND hvn L=3.5e-07 W=0.6e-06
.ENDS CLKNOR2X4

.SUBCKT CLKOR2X1 O I1 I2
M0 2 I1 1 VDD hvp L=3.0e-07 W=1e-06
M1 VDD I2 2 VDD hvp L=3.0e-07 W=1e-06
M2 O 1 VDD VDD hvp L=3.0e-07 W=1e-06
M3 1 I1 GND GND hvn L=3.5e-07 W=0.65e-06
M4 GND I2 1 GND hvn L=3.5e-07 W=0.65e-06
M5 O 1 GND GND hvn L=3.5e-07 W=0.65e-06
.ENDS CLKOR2X1

.SUBCKT CLKOR2X2 O I1 I2
M0 2 I1 1 VDD hvp L=3.0e-07 W=1e-06
M1 VDD I2 2 VDD hvp L=3.0e-07 W=1e-06
M2 O 1 VDD VDD hvp L=3.0e-07 W=1e-06
M3 VDD 1 O VDD hvp L=3.0e-07 W=1e-06
M4 1 I1 GND GND hvn L=3.5e-07 W=0.65e-06
M5 GND I2 1 GND hvn L=3.5e-07 W=0.65e-06
M6 O 1 GND GND hvn L=3.5e-07 W=0.65e-06
M7 GND 1 O GND hvn L=3.5e-07 W=0.65e-06
.ENDS CLKOR2X2

.SUBCKT CLKOR2X4 O I1 I2
M0 2 I1 1 VDD hvp L=3.0e-07 W=1e-06
M1 VDD I2 2 VDD hvp L=3.0e-07 W=1e-06
M2 O 1 VDD VDD hvp L=3.0e-07 W=1e-06
M3 VDD 1 O VDD hvp L=3.0e-07 W=1e-06
M4 O 1 VDD VDD hvp L=3.0e-07 W=1e-06
M5 VDD 1 O VDD hvp L=3.0e-07 W=1e-06
M6 1 I1 GND GND hvn L=3.5e-07 W=0.65e-06
M7 GND I2 1 GND hvn L=3.5e-07 W=0.65e-06
M8 O 1 GND GND hvn L=3.5e-07 W=0.65e-06
M9 GND 1 O GND hvn L=3.5e-07 W=0.65e-06
M10 O 1 GND GND hvn L=3.5e-07 W=0.65e-06
M11 GND 1 O GND hvn L=3.5e-07 W=0.65e-06
.ENDS CLKOR2X4

.SUBCKT CLKXNOR2X1 O I1 I2
M0 VDD I1 1 VDD hvp L=3.0e-07 W=1e-06
M1 3 1 VDD VDD hvp L=3.0e-07 W=1e-06
M2 4 I2 3 VDD hvp L=3.0e-07 W=0.43e-06
M3 1 5 4 VDD hvp L=3.0e-07 W=0.43e-06
M4 VDD I2 5 VDD hvp L=3.0e-07 W=0.79e-06
M5 O 4 VDD VDD hvp L=3.0e-07 W=0.79e-06
M6 GND I1 1 GND hvn L=3.5e-07 W=0.65e-06
M7 3 1 GND GND hvn L=3.5e-07 W=0.65e-06
M8 4 5 3 GND hvn L=3.5e-07 W=0.35e-06
M9 1 I2 4 GND hvn L=3.5e-07 W=0.35e-06
M10 GND I2 5 GND hvn L=3.5e-07 W=0.45e-06
M11 O 4 GND GND hvn L=3.5e-07 W=0.65e-06
.ENDS CLKXNOR2X1

.SUBCKT CLKXNOR2X2 O I1 I2
M0 VDD I1 1 VDD hvp L=3.0e-07 W=1e-06
M1 3 1 VDD VDD hvp L=3.0e-07 W=1e-06
M2 4 I2 3 VDD hvp L=3.0e-07 W=0.43e-06
M3 1 5 4 VDD hvp L=3.0e-07 W=0.43e-06
M4 VDD I2 5 VDD hvp L=3.0e-07 W=0.79e-06
M5 O 4 VDD VDD hvp L=3.0e-07 W=0.79e-06
M6 VDD 4 O VDD hvp L=3.0e-07 W=0.79e-06
M7 GND I1 1 GND hvn L=3.5e-07 W=0.65e-06
M8 3 1 GND GND hvn L=3.5e-07 W=0.65e-06
M9 4 5 3 GND hvn L=3.5e-07 W=0.35e-06
M10 1 I2 4 GND hvn L=3.5e-07 W=0.35e-06
M11 GND I2 5 GND hvn L=3.5e-07 W=0.45e-06
M12 O 4 GND GND hvn L=3.5e-07 W=0.65e-06
M13 GND 4 O GND hvn L=3.5e-07 W=0.65e-06
.ENDS CLKXNOR2X2

.SUBCKT CLKXNOR2X4 O I1 I2
M0 VDD I1 1 VDD hvp L=3.0e-07 W=1e-06
M1 3 1 VDD VDD hvp L=3.0e-07 W=1e-06
M2 4 I2 3 VDD hvp L=3.0e-07 W=0.43e-06
M3 1 5 4 VDD hvp L=3.0e-07 W=0.43e-06
M4 VDD I2 5 VDD hvp L=3.0e-07 W=0.79e-06
M5 O 4 VDD VDD hvp L=3.0e-07 W=0.79e-06
M6 VDD 4 O VDD hvp L=3.0e-07 W=0.79e-06
M7 O 4 VDD VDD hvp L=3.0e-07 W=0.79e-06
M8 VDD 4 O VDD hvp L=3.0e-07 W=0.79e-06
M9 GND I1 1 GND hvn L=3.5e-07 W=0.65e-06
M10 3 1 GND GND hvn L=3.5e-07 W=0.65e-06
M11 4 5 3 GND hvn L=3.5e-07 W=0.35e-06
M12 1 I2 4 GND hvn L=3.5e-07 W=0.35e-06
M13 GND I2 5 GND hvn L=3.5e-07 W=0.45e-06
M14 O 4 GND GND hvn L=3.5e-07 W=0.65e-06
M15 GND 4 O GND hvn L=3.5e-07 W=0.65e-06
M16 O 4 GND GND hvn L=3.5e-07 W=0.65e-06
M17 GND 4 O GND hvn L=3.5e-07 W=0.65e-06
.ENDS CLKXNOR2X4

.SUBCKT CLKXOR2X1 O I1 I2
M0 VDD I1 1 VDD hvp L=3.0e-07 W=0.95e-06
M1 3 1 VDD VDD hvp L=3.0e-07 W=0.95e-06
M2 4 5 3 VDD hvp L=3.0e-07 W=0.43e-06
M3 1 I2 4 VDD hvp L=3.0e-07 W=0.43e-06
M4 VDD I2 5 VDD hvp L=3.0e-07 W=0.79e-06
M5 O 4 VDD VDD hvp L=3.0e-07 W=0.79e-06
M6 GND I1 1 GND hvn L=3.5e-07 W=0.65e-06
M7 3 1 GND GND hvn L=3.5e-07 W=0.65e-06
M8 4 I2 3 GND hvn L=3.5e-07 W=0.35e-06
M9 1 5 4 GND hvn L=3.5e-07 W=0.35e-06
M10 GND I2 5 GND hvn L=3.5e-07 W=0.45e-06
M11 O 4 GND GND hvn L=3.5e-07 W=0.65e-06
.ENDS CLKXOR2X1

.SUBCKT CLKXOR2X2 O I1 I2
M0 VDD I1 1 VDD hvp L=3.0e-07 W=0.95e-06
M1 3 1 VDD VDD hvp L=3.0e-07 W=0.95e-06
M2 4 5 3 VDD hvp L=3.0e-07 W=0.43e-06
M3 1 I2 4 VDD hvp L=3.0e-07 W=0.43e-06
M4 VDD I2 5 VDD hvp L=3.0e-07 W=0.79e-06
M5 O 4 VDD VDD hvp L=3.0e-07 W=0.79e-06
M6 VDD 4 O VDD hvp L=3.0e-07 W=0.79e-06
M7 GND I1 1 GND hvn L=3.5e-07 W=0.65e-06
M8 3 1 GND GND hvn L=3.5e-07 W=0.65e-06
M9 4 I2 3 GND hvn L=3.5e-07 W=0.35e-06
M10 1 5 4 GND hvn L=3.5e-07 W=0.35e-06
M11 GND I2 5 GND hvn L=3.5e-07 W=0.45e-06
M12 O 4 GND GND hvn L=3.5e-07 W=0.65e-06
M13 GND 4 O GND hvn L=3.5e-07 W=0.65e-06
.ENDS CLKXOR2X2

.SUBCKT CLKXOR2X4 O I1 I2
M0 VDD I1 1 VDD hvp L=3.0e-07 W=0.95e-06
M1 3 1 VDD VDD hvp L=3.0e-07 W=0.95e-06
M2 4 5 3 VDD hvp L=3.0e-07 W=0.43e-06
M3 1 I2 4 VDD hvp L=3.0e-07 W=0.43e-06
M4 VDD I2 5 VDD hvp L=3.0e-07 W=0.79e-06
M5 O 4 VDD VDD hvp L=3.0e-07 W=0.79e-06
M6 VDD 4 O VDD hvp L=3.0e-07 W=0.79e-06
M7 O 4 VDD VDD hvp L=3.0e-07 W=0.79e-06
M8 VDD 4 O VDD hvp L=3.0e-07 W=0.79e-06
M9 GND I1 1 GND hvn L=3.5e-07 W=0.65e-06
M10 3 1 GND GND hvn L=3.5e-07 W=0.65e-06
M11 4 I2 3 GND hvn L=3.5e-07 W=0.35e-06
M12 1 5 4 GND hvn L=3.5e-07 W=0.35e-06
M13 GND I2 5 GND hvn L=3.5e-07 W=0.45e-06
M14 O 4 GND GND hvn L=3.5e-07 W=0.65e-06
M15 GND 4 O GND hvn L=3.5e-07 W=0.65e-06
M16 O 4 GND GND hvn L=3.5e-07 W=0.65e-06
M17 GND 4 O GND hvn L=3.5e-07 W=0.65e-06
.ENDS CLKXOR2X4

.SUBCKT DELAY0N1X2 O I
M0 VDD I 1 VDD hvp L=3.0e-07 W=1e-06
M1 O 1 VDD VDD hvp L=3.0e-07 W=1e-06
M2 VDD 1 O VDD hvp L=3.0e-07 W=1e-06
M3 GND I 1 GND hvn L=3.5e-07 W=0.65e-06
M4 O 1 GND GND hvn L=3.5e-07 W=0.65e-06
M5 GND 1 O GND hvn L=3.5e-07 W=0.65e-06
.ENDS DELAY0N1X2

.SUBCKT DELAY0N2X2 O I
M0 VDD I 1 VDD hvp L=3.0e-07 W=1e-06
M1 VDD 1 3 VDD hvp L=4e-07 W=1e-06
M2 4 3 VDD VDD hvp L=4e-07 W=1e-06
M3 O 4 VDD VDD hvp L=3.0e-07 W=1e-06
M4 VDD 4 O VDD hvp L=3.0e-07 W=1e-06
M5 GND I 1 GND hvn L=3.5e-07 W=0.65e-06
M6 GND 1 3 GND hvn L=4e-07 W=0.65e-06
M7 4 3 GND GND hvn L=4e-07 W=0.65e-06
M8 O 4 GND GND hvn L=3.5e-07 W=0.65e-06
M9 GND 4 O GND hvn L=3.5e-07 W=0.65e-06
.ENDS DELAY0N2X2

.SUBCKT DELAY1NX2 O I
M0 VDD I 1 VDD hvp L=3.0e-07 W=1e-06
M1 VDD 1 3 VDD hvp L=4e-07 W=1e-06
M2 4 3 VDD VDD hvp L=8e-07 W=0.6e-06
M3 VDD 4 5 VDD hvp L=8e-07 W=0.6e-06
M4 6 5 VDD VDD hvp L=4e-07 W=1e-06
M5 O 6 VDD VDD hvp L=3.0e-07 W=1e-06
M6 VDD 6 O VDD hvp L=3.0e-07 W=1e-06
M7 GND I 1 GND hvn L=3.5e-07 W=0.65e-06
M8 GND 1 3 GND hvn L=4e-07 W=0.65e-06
M9 4 3 GND GND hvn L=8e-07 W=0.4e-06
M10 GND 4 5 GND hvn L=8e-07 W=0.4e-06
M11 6 5 GND GND hvn L=4e-07 W=0.65e-06
M12 O 6 GND GND hvn L=3.5e-07 W=0.65e-06
M13 GND 6 O GND hvn L=3.5e-07 W=0.65e-06
.ENDS DELAY1NX2

.SUBCKT DELAY2NX2 O I
M0 VDD I 1 VDD hvp L=3.0e-07 W=1e-06
M1 VDD 1 3 VDD hvp L=4e-07 W=1e-06
M2 4 3 VDD VDD hvp L=8e-07 W=0.6e-06
M3 VDD 4 5 VDD hvp L=8e-07 W=0.6e-06
M4 6 5 VDD VDD hvp L=8e-07 W=0.6e-06
M5 VDD 6 7 VDD hvp L=8e-07 W=0.6e-06
M6 8 7 VDD VDD hvp L=4e-07 W=1e-06
M7 O 8 VDD VDD hvp L=3.0e-07 W=1e-06
M8 VDD 8 O VDD hvp L=3.0e-07 W=1e-06
M9 GND I 1 GND hvn L=3.5e-07 W=0.65e-06
M10 GND 1 3 GND hvn L=4e-07 W=0.65e-06
M11 4 3 GND GND hvn L=8e-07 W=0.4e-06
M12 GND 4 5 GND hvn L=8e-07 W=0.4e-06
M13 6 5 GND GND hvn L=8e-07 W=0.4e-06
M14 GND 6 7 GND hvn L=8e-07 W=0.4e-06
M15 8 7 GND GND hvn L=4e-07 W=0.65e-06
M16 O 8 GND GND hvn L=3.5e-07 W=0.65e-06
M17 GND 8 O GND hvn L=3.5e-07 W=0.65e-06
.ENDS DELAY2NX2

.SUBCKT DELAY3NX2 O I
M0 VDD I 1 VDD hvp L=3.0e-07 W=1e-06
M1 3 1 VDD VDD hvp L=4e-07 W=1e-06
M2 VDD 3 4 VDD hvp L=8e-07 W=0.6e-06
M3 5 4 VDD VDD hvp L=8e-07 W=0.6e-06
M4 VDD 5 6 VDD hvp L=8e-07 W=0.6e-06
M5 7 6 VDD VDD hvp L=8e-07 W=0.6e-06
M6 VDD 7 8 VDD hvp L=8e-07 W=0.6e-06
M7 9 8 VDD VDD hvp L=8e-07 W=0.6e-06
M8 VDD 9 10 VDD hvp L=4e-07 W=1e-06
M9 O 10 VDD VDD hvp L=3.0e-07 W=1e-06
M10 VDD 10 O VDD hvp L=3.0e-07 W=1e-06
M11 GND I 1 GND hvn L=3.5e-07 W=0.65e-06
M12 3 1 GND GND hvn L=4e-07 W=0.65e-06
M13 GND 3 4 GND hvn L=8e-07 W=0.4e-06
M14 5 4 GND GND hvn L=8e-07 W=0.4e-06
M15 GND 5 6 GND hvn L=8e-07 W=0.4e-06
M16 7 6 GND GND hvn L=8e-07 W=0.4e-06
M17 GND 7 8 GND hvn L=8e-07 W=0.4e-06
M18 9 8 GND GND hvn L=8e-07 W=0.4e-06
M19 GND 9 10 GND hvn L=4e-07 W=0.65e-06
M20 O 10 GND GND hvn L=3.5e-07 W=0.65e-06
M21 GND 10 O GND hvn L=3.5e-07 W=0.65e-06
.ENDS DELAY3NX2

.SUBCKT DFFCKBQX1 Q D CKB
M0 VDD D 1 VDD hvp L=3.0e-07 W=1e-06
M1 3 CKB VDD VDD hvp L=3.0e-07 W=0.6e-06
M2 4 3 VDD VDD hvp L=3.0e-07 W=0.3e-06
M3 5 3 1 VDD hvp L=3.0e-07 W=0.6e-06
M4 6 4 5 VDD hvp L=3.0e-07 W=0.4e-06
M5 VDD 7 6 VDD hvp L=3.0e-07 W=0.4e-06
M6 7 5 VDD VDD hvp L=3.0e-07 W=0.5e-06
M7 8 4 7 VDD hvp L=3.0e-07 W=0.5e-06
M8 9 3 8 VDD hvp L=3.0e-07 W=0.3e-06
M9 VDD 10 9 VDD hvp L=3.0e-07 W=0.3e-06
M10 VDD 8 10 VDD hvp L=3.0e-07 W=1e-06
M11 Q 10 VDD VDD hvp L=3.0e-07 W=1e-06
M12 1 D GND GND hvn L=3.5e-07 W=0.65e-06
M13 GND CKB 3 GND hvn L=3.5e-07 W=0.3e-06
M14 4 3 GND GND hvn L=3.5e-07 W=0.6e-06
M15 5 4 1 GND hvn L=3.5e-07 W=0.6e-06
M16 13 3 5 GND hvn L=3.5e-07 W=0.3e-06
M17 GND 7 13 GND hvn L=3.5e-07 W=0.3e-06
M18 7 5 GND GND hvn L=3.5e-07 W=0.3e-06
M19 8 3 7 GND hvn L=3.5e-07 W=0.3e-06
M20 14 4 8 GND hvn L=3.5e-07 W=0.3e-06
M21 GND 10 14 GND hvn L=3.5e-07 W=0.3e-06
M22 GND 8 10 GND hvn L=3.5e-07 W=0.65e-06
M23 Q 10 GND GND hvn L=3.5e-07 W=0.65e-06
.ENDS DFFCKBQX1

.SUBCKT DFFCKBQX2 Q D CKB
M0 VDD D 1 VDD hvp L=3.0e-07 W=1e-06
M1 3 CKB VDD VDD hvp L=3.0e-07 W=0.6e-06
M2 4 3 VDD VDD hvp L=3.0e-07 W=0.3e-06
M3 5 3 1 VDD hvp L=3.0e-07 W=0.6e-06
M4 6 4 5 VDD hvp L=3.0e-07 W=0.4e-06
M5 VDD 7 6 VDD hvp L=3.0e-07 W=0.4e-06
M6 7 5 VDD VDD hvp L=3.0e-07 W=0.5e-06
M7 8 4 7 VDD hvp L=3.0e-07 W=0.5e-06
M8 9 3 8 VDD hvp L=3.0e-07 W=0.3e-06
M9 VDD 10 9 VDD hvp L=3.0e-07 W=0.3e-06
M10 VDD 8 10 VDD hvp L=3.0e-07 W=1e-06
M11 Q 10 VDD VDD hvp L=3.0e-07 W=1e-06
M12 VDD 10 Q VDD hvp L=3.0e-07 W=1e-06
M13 1 D GND GND hvn L=3.5e-07 W=0.65e-06
M14 GND CKB 3 GND hvn L=3.5e-07 W=0.3e-06
M15 4 3 GND GND hvn L=3.5e-07 W=0.6e-06
M16 5 4 1 GND hvn L=3.5e-07 W=0.6e-06
M17 13 3 5 GND hvn L=3.5e-07 W=0.3e-06
M18 GND 7 13 GND hvn L=3.5e-07 W=0.3e-06
M19 7 5 GND GND hvn L=3.5e-07 W=0.3e-06
M20 8 3 7 GND hvn L=3.5e-07 W=0.3e-06
M21 14 4 8 GND hvn L=3.5e-07 W=0.3e-06
M22 GND 10 14 GND hvn L=3.5e-07 W=0.3e-06
M23 GND 8 10 GND hvn L=3.5e-07 W=0.65e-06
M24 Q 10 GND GND hvn L=3.5e-07 W=0.65e-06
M25 GND 10 Q GND hvn L=3.5e-07 W=0.65e-06
.ENDS DFFCKBQX2

.SUBCKT DFFCKBQX4 Q D CKB
M0 VDD D 1 VDD hvp L=3.0e-07 W=1e-06
M1 3 CKB VDD VDD hvp L=3.0e-07 W=0.6e-06
M2 4 3 VDD VDD hvp L=3.0e-07 W=0.3e-06
M3 5 3 1 VDD hvp L=3.0e-07 W=0.6e-06
M4 6 4 5 VDD hvp L=3.0e-07 W=0.4e-06
M5 VDD 7 6 VDD hvp L=3.0e-07 W=0.4e-06
M6 7 5 VDD VDD hvp L=3.0e-07 W=0.5e-06
M7 8 4 7 VDD hvp L=3.0e-07 W=0.5e-06
M8 9 3 8 VDD hvp L=3.0e-07 W=0.3e-06
M9 VDD 10 9 VDD hvp L=3.0e-07 W=0.3e-06
M10 VDD 8 10 VDD hvp L=3.0e-07 W=1e-06
M11 Q 10 VDD VDD hvp L=3.0e-07 W=1e-06
M12 VDD 10 Q VDD hvp L=3.0e-07 W=1e-06
M13 Q 10 VDD VDD hvp L=3.0e-07 W=1e-06
M14 VDD 10 Q VDD hvp L=3.0e-07 W=1e-06
M15 1 D GND GND hvn L=3.5e-07 W=0.65e-06
M16 GND CKB 3 GND hvn L=3.5e-07 W=0.3e-06
M17 4 3 GND GND hvn L=3.5e-07 W=0.6e-06
M18 5 4 1 GND hvn L=3.5e-07 W=0.6e-06
M19 13 3 5 GND hvn L=3.5e-07 W=0.3e-06
M20 GND 7 13 GND hvn L=3.5e-07 W=0.3e-06
M21 7 5 GND GND hvn L=3.5e-07 W=0.3e-06
M22 8 3 7 GND hvn L=3.5e-07 W=0.3e-06
M23 14 4 8 GND hvn L=3.5e-07 W=0.3e-06
M24 GND 10 14 GND hvn L=3.5e-07 W=0.3e-06
M25 GND 8 10 GND hvn L=3.5e-07 W=0.65e-06
M26 Q 10 GND GND hvn L=3.5e-07 W=0.65e-06
M27 GND 10 Q GND hvn L=3.5e-07 W=0.65e-06
M28 Q 10 GND GND hvn L=3.5e-07 W=0.65e-06
M29 GND 10 Q GND hvn L=3.5e-07 W=0.65e-06
.ENDS DFFCKBQX4

.SUBCKT DFFCKBRBQBX1 QB D RB CKB
M0 VDD D 1 VDD hvp L=3.0e-07 W=1e-06
M1 3 CKB VDD VDD hvp L=3.0e-07 W=0.3e-06
M2 4 3 VDD VDD hvp L=3.0e-07 W=0.3e-06
M3 5 3 1 VDD hvp L=3.0e-07 W=0.47e-06
M4 6 CKB 5 VDD hvp L=3.0e-07 W=0.47e-06
M5 VDD RB 6 VDD hvp L=3.0e-07 W=0.47e-06
M6 6 7 VDD VDD hvp L=3.0e-07 W=0.28e-06
M7 7 5 VDD VDD hvp L=3.0e-07 W=0.47e-06
M8 8 4 7 VDD hvp L=3.0e-07 W=0.47e-06
M9 9 3 8 VDD hvp L=3.0e-07 W=0.3e-06
M10 VDD 10 9 VDD hvp L=3.0e-07 W=0.3e-06
M11 10 RB VDD VDD hvp L=3.0e-07 W=0.3e-06
M12 VDD 8 10 VDD hvp L=3.0e-07 W=0.3e-06
M13 QB 8 VDD VDD hvp L=3.0e-07 W=1e-06
M14 1 D GND GND hvn L=3.5e-07 W=0.65e-06
M15 GND CKB 3 GND hvn L=3.5e-07 W=0.3e-06
M16 4 3 GND GND hvn L=3.5e-07 W=0.3e-06
M17 5 CKB 1 GND hvn L=3.5e-07 W=0.28e-06
M18 6 3 5 GND hvn L=3.5e-07 W=0.3e-06
M19 13 RB 6 GND hvn L=3.5e-07 W=0.28e-06
M20 GND 7 13 GND hvn L=3.5e-07 W=0.28e-06
M21 7 5 GND GND hvn L=3.5e-07 W=0.28e-06
M22 8 3 7 GND hvn L=3.5e-07 W=0.3e-06
M23 14 4 8 GND hvn L=3.5e-07 W=0.3e-06
M24 GND 10 14 GND hvn L=3.5e-07 W=0.3e-06
M25 15 RB GND GND hvn L=3.5e-07 W=0.3e-06
M26 10 8 15 GND hvn L=3.5e-07 W=0.3e-06
M27 QB 8 GND GND hvn L=3.5e-07 W=0.65e-06
.ENDS DFFCKBRBQBX1

.SUBCKT DFFCKBRBQBX2 QB D RB CKB
M0 VDD D 1 VDD hvp L=3.0e-07 W=1e-06
M1 3 CKB VDD VDD hvp L=3.0e-07 W=0.3e-06
M2 4 3 VDD VDD hvp L=3.0e-07 W=0.3e-06
M3 5 3 1 VDD hvp L=3.0e-07 W=0.47e-06
M4 6 CKB 5 VDD hvp L=3.0e-07 W=0.47e-06
M5 VDD RB 6 VDD hvp L=3.0e-07 W=0.47e-06
M6 6 7 VDD VDD hvp L=3.0e-07 W=0.28e-06
M7 7 5 VDD VDD hvp L=3.0e-07 W=0.47e-06
M8 8 4 7 VDD hvp L=3.0e-07 W=0.47e-06
M9 9 3 8 VDD hvp L=3.0e-07 W=0.3e-06
M10 VDD 10 9 VDD hvp L=3.0e-07 W=0.3e-06
M11 10 RB VDD VDD hvp L=3.0e-07 W=0.3e-06
M12 VDD 8 10 VDD hvp L=3.0e-07 W=0.3e-06
M13 QB 8 VDD VDD hvp L=3.0e-07 W=1e-06
M14 VDD 8 QB VDD hvp L=3.0e-07 W=1e-06
M15 1 D GND GND hvn L=3.5e-07 W=0.65e-06
M16 GND CKB 3 GND hvn L=3.5e-07 W=0.3e-06
M17 4 3 GND GND hvn L=3.5e-07 W=0.3e-06
M18 5 CKB 1 GND hvn L=3.5e-07 W=0.28e-06
M19 6 3 5 GND hvn L=3.5e-07 W=0.3e-06
M20 13 RB 6 GND hvn L=3.5e-07 W=0.28e-06
M21 GND 7 13 GND hvn L=3.5e-07 W=0.28e-06
M22 7 5 GND GND hvn L=3.5e-07 W=0.28e-06
M23 8 3 7 GND hvn L=3.5e-07 W=0.3e-06
M24 14 4 8 GND hvn L=3.5e-07 W=0.3e-06
M25 GND 10 14 GND hvn L=3.5e-07 W=0.3e-06
M26 15 RB GND GND hvn L=3.5e-07 W=0.3e-06
M27 10 8 15 GND hvn L=3.5e-07 W=0.3e-06
M28 QB 8 GND GND hvn L=3.5e-07 W=0.65e-06
M29 GND 8 QB GND hvn L=3.5e-07 W=0.65e-06
.ENDS DFFCKBRBQBX2

.SUBCKT DFFCKBRBQBX4 QB D RB CKB
M0 VDD D 1 VDD hvp L=3.0e-07 W=1e-06
M1 3 CKB VDD VDD hvp L=3.0e-07 W=0.3e-06
M2 4 3 VDD VDD hvp L=3.0e-07 W=0.3e-06
M3 5 3 1 VDD hvp L=3.0e-07 W=0.47e-06
M4 6 CKB 5 VDD hvp L=3.0e-07 W=0.47e-06
M5 VDD RB 6 VDD hvp L=3.0e-07 W=0.47e-06
M6 6 7 VDD VDD hvp L=3.0e-07 W=0.28e-06
M7 7 5 VDD VDD hvp L=3.0e-07 W=0.47e-06
M8 8 4 7 VDD hvp L=3.0e-07 W=0.47e-06
M9 9 3 8 VDD hvp L=3.0e-07 W=0.3e-06
M10 VDD 10 9 VDD hvp L=3.0e-07 W=0.3e-06
M11 10 RB VDD VDD hvp L=3.0e-07 W=0.3e-06
M12 VDD 8 10 VDD hvp L=3.0e-07 W=0.3e-06
M13 QB 8 VDD VDD hvp L=3.0e-07 W=1e-06
M14 VDD 8 QB VDD hvp L=3.0e-07 W=1e-06
M15 QB 8 VDD VDD hvp L=3.0e-07 W=1e-06
M16 VDD 8 QB VDD hvp L=3.0e-07 W=1e-06
M17 1 D GND GND hvn L=3.5e-07 W=0.65e-06
M18 GND CKB 3 GND hvn L=3.5e-07 W=0.3e-06
M19 4 3 GND GND hvn L=3.5e-07 W=0.3e-06
M20 5 CKB 1 GND hvn L=3.5e-07 W=0.28e-06
M21 6 3 5 GND hvn L=3.5e-07 W=0.3e-06
M22 13 RB 6 GND hvn L=3.5e-07 W=0.28e-06
M23 GND 7 13 GND hvn L=3.5e-07 W=0.28e-06
M24 7 5 GND GND hvn L=3.5e-07 W=0.28e-06
M25 8 3 7 GND hvn L=3.5e-07 W=0.3e-06
M26 14 4 8 GND hvn L=3.5e-07 W=0.3e-06
M27 GND 10 14 GND hvn L=3.5e-07 W=0.3e-06
M28 15 RB GND GND hvn L=3.5e-07 W=0.3e-06
M29 10 8 15 GND hvn L=3.5e-07 W=0.3e-06
M30 QB 8 GND GND hvn L=3.5e-07 W=0.65e-06
M31 GND 8 QB GND hvn L=3.5e-07 W=0.65e-06
M32 QB 8 GND GND hvn L=3.5e-07 W=0.65e-06
M33 GND 8 QB GND hvn L=3.5e-07 W=0.65e-06
.ENDS DFFCKBRBQBX4

.SUBCKT DFFCKBRBQX1 Q D RB CKB
M0 VDD D 1 VDD hvp L=3.0e-07 W=1e-06
M1 3 CKB VDD VDD hvp L=3.0e-07 W=0.6e-06
M2 4 3 VDD VDD hvp L=3.0e-07 W=0.3e-06
M3 5 3 1 VDD hvp L=3.0e-07 W=0.5e-06
M4 6 4 5 VDD hvp L=3.0e-07 W=0.3e-06
M5 VDD RB 6 VDD hvp L=3.0e-07 W=0.3e-06
M6 6 7 VDD VDD hvp L=3.0e-07 W=0.3e-06
M7 7 5 VDD VDD hvp L=3.0e-07 W=0.47e-06
M8 8 4 7 VDD hvp L=3.0e-07 W=0.47e-06
M9 9 3 8 VDD hvp L=3.0e-07 W=0.3e-06
M10 VDD 10 9 VDD hvp L=3.0e-07 W=0.3e-06
M11 10 RB VDD VDD hvp L=3.0e-07 W=0.8e-06
M12 VDD 8 10 VDD hvp L=3.0e-07 W=0.89e-06
M13 Q 10 VDD VDD hvp L=3.0e-07 W=1e-06
M14 1 D GND GND hvn L=3.5e-07 W=0.65e-06
M15 GND CKB 3 GND hvn L=3.5e-07 W=0.3e-06
M16 4 3 GND GND hvn L=3.5e-07 W=0.6e-06
M17 5 4 1 GND hvn L=3.5e-07 W=0.5e-06
M18 6 3 5 GND hvn L=3.5e-07 W=0.3e-06
M19 13 RB 6 GND hvn L=3.5e-07 W=0.3e-06
M20 GND 7 13 GND hvn L=3.5e-07 W=0.3e-06
M21 7 5 GND GND hvn L=3.5e-07 W=0.28e-06
M22 8 3 7 GND hvn L=3.5e-07 W=0.3e-06
M23 14 4 8 GND hvn L=3.5e-07 W=0.3e-06
M24 GND 10 14 GND hvn L=3.5e-07 W=0.3e-06
M25 15 RB GND GND hvn L=3.5e-07 W=0.49e-06
M26 10 8 15 GND hvn L=3.5e-07 W=0.49e-06
M27 Q 10 GND GND hvn L=3.5e-07 W=0.65e-06
.ENDS DFFCKBRBQX1

.SUBCKT DFFCKBRBQX2 Q D RB CKB
M0 VDD D 1 VDD hvp L=3.0e-07 W=1e-06
M1 3 CKB VDD VDD hvp L=3.0e-07 W=0.6e-06
M2 4 3 VDD VDD hvp L=3.0e-07 W=0.3e-06
M3 5 3 1 VDD hvp L=3.0e-07 W=0.5e-06
M4 6 4 5 VDD hvp L=3.0e-07 W=0.3e-06
M5 VDD RB 6 VDD hvp L=3.0e-07 W=0.3e-06
M6 6 7 VDD VDD hvp L=3.0e-07 W=0.3e-06
M7 7 5 VDD VDD hvp L=3.0e-07 W=0.47e-06
M8 8 4 7 VDD hvp L=3.0e-07 W=0.47e-06
M9 9 3 8 VDD hvp L=3.0e-07 W=0.3e-06
M10 VDD 10 9 VDD hvp L=3.0e-07 W=0.3e-06
M11 10 RB VDD VDD hvp L=3.0e-07 W=0.8e-06
M12 VDD 8 10 VDD hvp L=3.0e-07 W=0.89e-06
M13 Q 10 VDD VDD hvp L=3.0e-07 W=1e-06
M14 VDD 10 Q VDD hvp L=3.0e-07 W=1e-06
M15 1 D GND GND hvn L=3.5e-07 W=0.65e-06
M16 GND CKB 3 GND hvn L=3.5e-07 W=0.3e-06
M17 4 3 GND GND hvn L=3.5e-07 W=0.6e-06
M18 5 4 1 GND hvn L=3.5e-07 W=0.5e-06
M19 6 3 5 GND hvn L=3.5e-07 W=0.3e-06
M20 13 RB 6 GND hvn L=3.5e-07 W=0.3e-06
M21 GND 7 13 GND hvn L=3.5e-07 W=0.3e-06
M22 7 5 GND GND hvn L=3.5e-07 W=0.28e-06
M23 8 3 7 GND hvn L=3.5e-07 W=0.3e-06
M24 14 4 8 GND hvn L=3.5e-07 W=0.3e-06
M25 GND 10 14 GND hvn L=3.5e-07 W=0.3e-06
M26 15 RB GND GND hvn L=3.5e-07 W=0.49e-06
M27 10 8 15 GND hvn L=3.5e-07 W=0.49e-06
M28 Q 10 GND GND hvn L=3.5e-07 W=0.65e-06
M29 GND 10 Q GND hvn L=3.5e-07 W=0.65e-06
.ENDS DFFCKBRBQX2

.SUBCKT DFFCKBRBQX4 Q D RB CKB
M0 VDD D 1 VDD hvp L=3.0e-07 W=1e-06
M1 3 CKB VDD VDD hvp L=3.0e-07 W=0.6e-06
M2 4 3 VDD VDD hvp L=3.0e-07 W=0.3e-06
M3 5 3 1 VDD hvp L=3.0e-07 W=0.5e-06
M4 6 4 5 VDD hvp L=3.0e-07 W=0.3e-06
M5 VDD RB 6 VDD hvp L=3.0e-07 W=0.3e-06
M6 6 7 VDD VDD hvp L=3.0e-07 W=0.3e-06
M7 7 5 VDD VDD hvp L=3.0e-07 W=0.47e-06
M8 8 4 7 VDD hvp L=3.0e-07 W=0.47e-06
M9 9 3 8 VDD hvp L=3.0e-07 W=0.3e-06
M10 VDD 10 9 VDD hvp L=3.0e-07 W=0.3e-06
M11 10 RB VDD VDD hvp L=3.0e-07 W=0.8e-06
M12 VDD 8 10 VDD hvp L=3.0e-07 W=0.89e-06
M13 Q 10 VDD VDD hvp L=3.0e-07 W=1e-06
M14 VDD 10 Q VDD hvp L=3.0e-07 W=1e-06
M15 Q 10 VDD VDD hvp L=3.0e-07 W=1e-06
M16 VDD 10 Q VDD hvp L=3.0e-07 W=1e-06
M17 1 D GND GND hvn L=3.5e-07 W=0.65e-06
M18 GND CKB 3 GND hvn L=3.5e-07 W=0.3e-06
M19 4 3 GND GND hvn L=3.5e-07 W=0.6e-06
M20 5 4 1 GND hvn L=3.5e-07 W=0.5e-06
M21 6 3 5 GND hvn L=3.5e-07 W=0.3e-06
M22 13 RB 6 GND hvn L=3.5e-07 W=0.3e-06
M23 GND 7 13 GND hvn L=3.5e-07 W=0.3e-06
M24 7 5 GND GND hvn L=3.5e-07 W=0.28e-06
M25 8 3 7 GND hvn L=3.5e-07 W=0.3e-06
M26 14 4 8 GND hvn L=3.5e-07 W=0.3e-06
M27 GND 10 14 GND hvn L=3.5e-07 W=0.3e-06
M28 15 RB GND GND hvn L=3.5e-07 W=0.49e-06
M29 10 8 15 GND hvn L=3.5e-07 W=0.49e-06
M30 Q 10 GND GND hvn L=3.5e-07 W=0.65e-06
M31 GND 10 Q GND hvn L=3.5e-07 W=0.65e-06
M32 Q 10 GND GND hvn L=3.5e-07 W=0.65e-06
M33 GND 10 Q GND hvn L=3.5e-07 W=0.65e-06
.ENDS DFFCKBRBQX4

.SUBCKT DFFCKBRSBQX1 Q D RB SB CKB
M0 VDD D 1 VDD hvp L=3.0e-07 W=1e-06
M1 3 CKB VDD VDD hvp L=3.0e-07 W=0.6e-06
M2 4 3 VDD VDD hvp L=3.0e-07 W=0.3e-06
M3 5 3 1 VDD hvp L=3.0e-07 W=0.6e-06
M4 6 4 5 VDD hvp L=3.0e-07 W=0.28e-06
M5 VDD RB 6 VDD hvp L=3.0e-07 W=0.3e-06
M6 6 7 VDD VDD hvp L=3.0e-07 W=0.3e-06
M7 VDD 5 7 VDD hvp L=3.0e-07 W=0.42e-06
M8 7 SB VDD VDD hvp L=3.0e-07 W=0.39e-06
M9 8 4 7 VDD hvp L=3.0e-07 W=0.35e-06
M10 9 3 8 VDD hvp L=3.0e-07 W=0.35e-06
M11 VDD SB 9 VDD hvp L=3.0e-07 W=0.33e-06
M12 VDD 10 9 VDD hvp L=3.0e-07 W=0.28e-06
M13 10 RB VDD VDD hvp L=3.0e-07 W=0.5e-06
M14 VDD 8 10 VDD hvp L=3.0e-07 W=0.5e-06
M15 Q 10 VDD VDD hvp L=3.0e-07 W=1e-06
M16 1 D GND GND hvn L=3.5e-07 W=0.65e-06
M17 GND CKB 3 GND hvn L=3.5e-07 W=0.3e-06
M18 4 3 GND GND hvn L=3.5e-07 W=0.6e-06
M19 5 4 1 GND hvn L=3.5e-07 W=0.51e-06
M20 6 3 5 GND hvn L=3.5e-07 W=0.3e-06
M21 13 RB 6 GND hvn L=3.5e-07 W=0.3e-06
M22 GND 7 13 GND hvn L=3.5e-07 W=0.3e-06
M23 14 5 GND GND hvn L=3.5e-07 W=0.28e-06
M24 7 SB 14 GND hvn L=3.5e-07 W=0.28e-06
M25 8 3 7 GND hvn L=3.5e-07 W=0.28e-06
M26 9 4 8 GND hvn L=3.5e-07 W=0.3e-06
M27 15 SB 9 GND hvn L=3.5e-07 W=0.28e-06
M28 GND 10 15 GND hvn L=3.5e-07 W=0.28e-06
M29 16 RB GND GND hvn L=3.5e-07 W=0.3e-06
M30 10 8 16 GND hvn L=3.5e-07 W=0.3e-06
M31 Q 10 GND GND hvn L=3.5e-07 W=0.65e-06
.ENDS DFFCKBRSBQX1

.SUBCKT DFFCKBRSBQX2 Q D RB SB CKB
M0 VDD D 1 VDD hvp L=3.0e-07 W=1e-06
M1 3 CKB VDD VDD hvp L=3.0e-07 W=0.6e-06
M2 4 3 VDD VDD hvp L=3.0e-07 W=0.3e-06
M3 5 3 1 VDD hvp L=3.0e-07 W=0.6e-06
M4 6 4 5 VDD hvp L=3.0e-07 W=0.28e-06
M5 VDD RB 6 VDD hvp L=3.0e-07 W=0.3e-06
M6 6 7 VDD VDD hvp L=3.0e-07 W=0.3e-06
M7 VDD 5 7 VDD hvp L=3.0e-07 W=0.42e-06
M8 7 SB VDD VDD hvp L=3.0e-07 W=0.39e-06
M9 8 4 7 VDD hvp L=3.0e-07 W=0.35e-06
M10 9 3 8 VDD hvp L=3.0e-07 W=0.35e-06
M11 VDD SB 9 VDD hvp L=3.0e-07 W=0.33e-06
M12 VDD 10 9 VDD hvp L=3.0e-07 W=0.28e-06
M13 10 RB VDD VDD hvp L=3.0e-07 W=0.5e-06
M14 VDD 8 10 VDD hvp L=3.0e-07 W=0.5e-06
M15 Q 10 VDD VDD hvp L=3.0e-07 W=1e-06
M16 VDD 10 Q VDD hvp L=3.0e-07 W=1e-06
M17 1 D GND GND hvn L=3.5e-07 W=0.65e-06
M18 GND CKB 3 GND hvn L=3.5e-07 W=0.3e-06
M19 4 3 GND GND hvn L=3.5e-07 W=0.6e-06
M20 5 4 1 GND hvn L=3.5e-07 W=0.51e-06
M21 6 3 5 GND hvn L=3.5e-07 W=0.3e-06
M22 13 RB 6 GND hvn L=3.5e-07 W=0.3e-06
M23 GND 7 13 GND hvn L=3.5e-07 W=0.3e-06
M24 14 5 GND GND hvn L=3.5e-07 W=0.28e-06
M25 7 SB 14 GND hvn L=3.5e-07 W=0.28e-06
M26 8 3 7 GND hvn L=3.5e-07 W=0.28e-06
M27 9 4 8 GND hvn L=3.5e-07 W=0.3e-06
M28 15 SB 9 GND hvn L=3.5e-07 W=0.28e-06
M29 GND 10 15 GND hvn L=3.5e-07 W=0.28e-06
M30 16 RB GND GND hvn L=3.5e-07 W=0.3e-06
M31 10 8 16 GND hvn L=3.5e-07 W=0.3e-06
M32 Q 10 GND GND hvn L=3.5e-07 W=0.65e-06
M33 GND 10 Q GND hvn L=3.5e-07 W=0.65e-06
.ENDS DFFCKBRSBQX2

.SUBCKT DFFCKBRSBQX4 Q D RB SB CKB
M0 VDD D 1 VDD hvp L=3.0e-07 W=1e-06
M1 3 CKB VDD VDD hvp L=3.0e-07 W=0.6e-06
M2 4 3 VDD VDD hvp L=3.0e-07 W=0.3e-06
M3 5 3 1 VDD hvp L=3.0e-07 W=0.6e-06
M4 6 4 5 VDD hvp L=3.0e-07 W=0.28e-06
M5 VDD RB 6 VDD hvp L=3.0e-07 W=0.3e-06
M6 6 7 VDD VDD hvp L=3.0e-07 W=0.3e-06
M7 VDD 5 7 VDD hvp L=3.0e-07 W=0.42e-06
M8 7 SB VDD VDD hvp L=3.0e-07 W=0.39e-06
M9 8 4 7 VDD hvp L=3.0e-07 W=0.35e-06
M10 9 3 8 VDD hvp L=3.0e-07 W=0.35e-06
M11 VDD SB 9 VDD hvp L=3.0e-07 W=0.33e-06
M12 VDD 10 9 VDD hvp L=3.0e-07 W=0.28e-06
M13 10 RB VDD VDD hvp L=3.0e-07 W=0.5e-06
M14 VDD 8 10 VDD hvp L=3.0e-07 W=0.5e-06
M15 Q 10 VDD VDD hvp L=3.0e-07 W=1e-06
M16 VDD 10 Q VDD hvp L=3.0e-07 W=1e-06
M17 Q 10 VDD VDD hvp L=3.0e-07 W=1e-06
M18 VDD 10 Q VDD hvp L=3.0e-07 W=1e-06
M19 1 D GND GND hvn L=3.5e-07 W=0.65e-06
M20 GND CKB 3 GND hvn L=3.5e-07 W=0.3e-06
M21 4 3 GND GND hvn L=3.5e-07 W=0.6e-06
M22 5 4 1 GND hvn L=3.5e-07 W=0.51e-06
M23 6 3 5 GND hvn L=3.5e-07 W=0.3e-06
M24 13 RB 6 GND hvn L=3.5e-07 W=0.3e-06
M25 GND 7 13 GND hvn L=3.5e-07 W=0.3e-06
M26 14 5 GND GND hvn L=3.5e-07 W=0.28e-06
M27 7 SB 14 GND hvn L=3.5e-07 W=0.28e-06
M28 8 3 7 GND hvn L=3.5e-07 W=0.28e-06
M29 9 4 8 GND hvn L=3.5e-07 W=0.3e-06
M30 15 SB 9 GND hvn L=3.5e-07 W=0.28e-06
M31 GND 10 15 GND hvn L=3.5e-07 W=0.28e-06
M32 16 RB GND GND hvn L=3.5e-07 W=0.3e-06
M33 10 8 16 GND hvn L=3.5e-07 W=0.3e-06
M34 Q 10 GND GND hvn L=3.5e-07 W=0.65e-06
M35 GND 10 Q GND hvn L=3.5e-07 W=0.65e-06
M36 Q 10 GND GND hvn L=3.5e-07 W=0.65e-06
M37 GND 10 Q GND hvn L=3.5e-07 W=0.65e-06
.ENDS DFFCKBRSBQX4

.SUBCKT DFFCNLDQBX1 QB CN D LD CK
M0 2 3 VDD VDD hvp L=3.0e-07 W=0.75e-06
M1 VDD CN 2 VDD hvp L=3.0e-07 W=0.75e-06
M2 3 4 VDD VDD hvp L=3.0e-07 W=0.75e-06
M3 5 D 4 VDD hvp L=3.0e-07 W=0.8e-06
M4 VDD 6 5 VDD hvp L=3.0e-07 W=0.8e-06
M5 6 LD VDD VDD hvp L=3.0e-07 W=0.8e-06
M6 7 LD VDD VDD hvp L=3.0e-07 W=0.8e-06
M7 4 14 7 VDD hvp L=3.0e-07 W=0.8e-06
M8 VDD CK 8 VDD hvp L=3.0e-07 W=0.3e-06
M9 9 8 VDD VDD hvp L=3.0e-07 W=0.7e-06
M10 10 9 2 VDD hvp L=3.0e-07 W=0.5e-06
M11 11 8 10 VDD hvp L=3.0e-07 W=0.3e-06
M12 VDD 12 11 VDD hvp L=3.0e-07 W=0.3e-06
M13 12 10 VDD VDD hvp L=3.0e-07 W=0.4e-06
M14 13 8 12 VDD hvp L=3.0e-07 W=0.7e-06
M15 14 9 13 VDD hvp L=3.0e-07 W=0.28e-06
M16 VDD 15 14 VDD hvp L=3.0e-07 W=0.28e-06
M17 VDD 13 15 VDD hvp L=3.0e-07 W=0.3e-06
M18 QB 13 VDD VDD hvp L=3.0e-07 W=1e-06
M19 17 3 2 GND hvn L=3.5e-07 W=0.65e-06
M20 GND CN 17 GND hvn L=3.5e-07 W=0.65e-06
M21 3 4 GND GND hvn L=3.5e-07 W=0.65e-06
M22 19 D 4 GND hvn L=3.5e-07 W=0.65e-06
M23 GND LD 19 GND hvn L=3.5e-07 W=0.65e-06
M24 6 LD GND GND hvn L=3.5e-07 W=0.3e-06
M25 20 6 GND GND hvn L=3.5e-07 W=0.65e-06
M26 4 14 20 GND hvn L=3.5e-07 W=0.65e-06
M27 GND CK 8 GND hvn L=3.5e-07 W=0.6e-06
M28 9 8 GND GND hvn L=3.5e-07 W=0.3e-06
M29 10 8 2 GND hvn L=3.5e-07 W=0.6e-06
M30 21 9 10 GND hvn L=3.5e-07 W=0.28e-06
M31 GND 12 21 GND hvn L=3.5e-07 W=0.28e-06
M32 12 10 GND GND hvn L=3.5e-07 W=0.28e-06
M33 13 9 12 GND hvn L=3.5e-07 W=0.56e-06
M34 14 8 13 GND hvn L=3.5e-07 W=0.3e-06
M35 GND 15 14 GND hvn L=3.5e-07 W=0.3e-06
M36 GND 13 15 GND hvn L=3.5e-07 W=0.3e-06
M37 QB 13 GND GND hvn L=3.5e-07 W=0.65e-06
.ENDS DFFCNLDQBX1

.SUBCKT DFFCNLDQBX2 QB CN D LD CK
M0 2 3 VDD VDD hvp L=3.0e-07 W=0.75e-06
M1 VDD CN 2 VDD hvp L=3.0e-07 W=0.75e-06
M2 3 4 VDD VDD hvp L=3.0e-07 W=0.75e-06
M3 5 D 4 VDD hvp L=3.0e-07 W=0.8e-06
M4 VDD 6 5 VDD hvp L=3.0e-07 W=0.8e-06
M5 6 LD VDD VDD hvp L=3.0e-07 W=0.8e-06
M6 7 LD VDD VDD hvp L=3.0e-07 W=0.8e-06
M7 4 14 7 VDD hvp L=3.0e-07 W=0.8e-06
M8 VDD CK 8 VDD hvp L=3.0e-07 W=0.3e-06
M9 9 8 VDD VDD hvp L=3.0e-07 W=0.7e-06
M10 10 9 2 VDD hvp L=3.0e-07 W=0.5e-06
M11 11 8 10 VDD hvp L=3.0e-07 W=0.3e-06
M12 VDD 12 11 VDD hvp L=3.0e-07 W=0.3e-06
M13 12 10 VDD VDD hvp L=3.0e-07 W=0.4e-06
M14 13 8 12 VDD hvp L=3.0e-07 W=0.7e-06
M15 14 9 13 VDD hvp L=3.0e-07 W=0.28e-06
M16 VDD 15 14 VDD hvp L=3.0e-07 W=0.28e-06
M17 VDD 13 15 VDD hvp L=3.0e-07 W=0.3e-06
M18 QB 13 VDD VDD hvp L=3.0e-07 W=1e-06
M19 VDD 13 QB VDD hvp L=3.0e-07 W=1e-06
M20 17 3 2 GND hvn L=3.5e-07 W=0.65e-06
M21 GND CN 17 GND hvn L=3.5e-07 W=0.65e-06
M22 3 4 GND GND hvn L=3.5e-07 W=0.65e-06
M23 19 D 4 GND hvn L=3.5e-07 W=0.65e-06
M24 GND LD 19 GND hvn L=3.5e-07 W=0.65e-06
M25 6 LD GND GND hvn L=3.5e-07 W=0.3e-06
M26 20 6 GND GND hvn L=3.5e-07 W=0.65e-06
M27 4 14 20 GND hvn L=3.5e-07 W=0.65e-06
M28 GND CK 8 GND hvn L=3.5e-07 W=0.6e-06
M29 9 8 GND GND hvn L=3.5e-07 W=0.3e-06
M30 10 8 2 GND hvn L=3.5e-07 W=0.6e-06
M31 21 9 10 GND hvn L=3.5e-07 W=0.28e-06
M32 GND 12 21 GND hvn L=3.5e-07 W=0.28e-06
M33 12 10 GND GND hvn L=3.5e-07 W=0.28e-06
M34 13 9 12 GND hvn L=3.5e-07 W=0.56e-06
M35 14 8 13 GND hvn L=3.5e-07 W=0.3e-06
M36 GND 15 14 GND hvn L=3.5e-07 W=0.3e-06
M37 GND 13 15 GND hvn L=3.5e-07 W=0.3e-06
M38 QB 13 GND GND hvn L=3.5e-07 W=0.65e-06
M39 GND 13 QB GND hvn L=3.5e-07 W=0.65e-06
.ENDS DFFCNLDQBX2

.SUBCKT DFFCNLDQBX4 QB CN D LD CK
M0 2 3 VDD VDD hvp L=3.0e-07 W=0.75e-06
M1 VDD CN 2 VDD hvp L=3.0e-07 W=0.75e-06
M2 3 4 VDD VDD hvp L=3.0e-07 W=0.75e-06
M3 5 D 4 VDD hvp L=3.0e-07 W=0.8e-06
M4 VDD 6 5 VDD hvp L=3.0e-07 W=0.8e-06
M5 6 LD VDD VDD hvp L=3.0e-07 W=0.8e-06
M6 7 LD VDD VDD hvp L=3.0e-07 W=0.8e-06
M7 4 14 7 VDD hvp L=3.0e-07 W=0.8e-06
M8 VDD CK 8 VDD hvp L=3.0e-07 W=0.3e-06
M9 9 8 VDD VDD hvp L=3.0e-07 W=0.7e-06
M10 10 9 2 VDD hvp L=3.0e-07 W=0.5e-06
M11 11 8 10 VDD hvp L=3.0e-07 W=0.3e-06
M12 VDD 12 11 VDD hvp L=3.0e-07 W=0.3e-06
M13 12 10 VDD VDD hvp L=3.0e-07 W=0.4e-06
M14 13 8 12 VDD hvp L=3.0e-07 W=0.7e-06
M15 14 9 13 VDD hvp L=3.0e-07 W=0.28e-06
M16 VDD 15 14 VDD hvp L=3.0e-07 W=0.28e-06
M17 VDD 13 15 VDD hvp L=3.0e-07 W=0.3e-06
M18 QB 13 VDD VDD hvp L=3.0e-07 W=1e-06
M19 VDD 13 QB VDD hvp L=3.0e-07 W=1e-06
M20 QB 13 VDD VDD hvp L=3.0e-07 W=1e-06
M21 VDD 13 QB VDD hvp L=3.0e-07 W=1e-06
M22 17 3 2 GND hvn L=3.5e-07 W=0.65e-06
M23 GND CN 17 GND hvn L=3.5e-07 W=0.65e-06
M24 3 4 GND GND hvn L=3.5e-07 W=0.65e-06
M25 19 D 4 GND hvn L=3.5e-07 W=0.65e-06
M26 GND LD 19 GND hvn L=3.5e-07 W=0.65e-06
M27 6 LD GND GND hvn L=3.5e-07 W=0.3e-06
M28 20 6 GND GND hvn L=3.5e-07 W=0.65e-06
M29 4 14 20 GND hvn L=3.5e-07 W=0.65e-06
M30 GND CK 8 GND hvn L=3.5e-07 W=0.6e-06
M31 9 8 GND GND hvn L=3.5e-07 W=0.3e-06
M32 10 8 2 GND hvn L=3.5e-07 W=0.6e-06
M33 21 9 10 GND hvn L=3.5e-07 W=0.28e-06
M34 GND 12 21 GND hvn L=3.5e-07 W=0.28e-06
M35 12 10 GND GND hvn L=3.5e-07 W=0.28e-06
M36 13 9 12 GND hvn L=3.5e-07 W=0.56e-06
M37 14 8 13 GND hvn L=3.5e-07 W=0.3e-06
M38 GND 15 14 GND hvn L=3.5e-07 W=0.3e-06
M39 GND 13 15 GND hvn L=3.5e-07 W=0.3e-06
M40 QB 13 GND GND hvn L=3.5e-07 W=0.65e-06
M41 GND 13 QB GND hvn L=3.5e-07 W=0.65e-06
M42 QB 13 GND GND hvn L=3.5e-07 W=0.65e-06
M43 GND 13 QB GND hvn L=3.5e-07 W=0.65e-06
.ENDS DFFCNLDQBX4

.SUBCKT DFFCNLDQX1 Q CN D LD CK
M0 2 3 VDD VDD hvp L=3.0e-07 W=0.75e-06
M1 VDD CN 2 VDD hvp L=3.0e-07 W=0.75e-06
M2 3 4 VDD VDD hvp L=3.0e-07 W=0.75e-06
M3 5 D 4 VDD hvp L=3.0e-07 W=0.8e-06
M4 VDD 6 5 VDD hvp L=3.0e-07 W=0.8e-06
M5 6 LD VDD VDD hvp L=3.0e-07 W=0.8e-06
M6 7 LD VDD VDD hvp L=3.0e-07 W=0.8e-06
M7 4 14 7 VDD hvp L=3.0e-07 W=0.8e-06
M8 VDD CK 8 VDD hvp L=3.0e-07 W=0.3e-06
M9 9 8 VDD VDD hvp L=3.0e-07 W=0.7e-06
M10 10 9 2 VDD hvp L=3.0e-07 W=0.5e-06
M11 11 8 10 VDD hvp L=3.0e-07 W=0.3e-06
M12 VDD 12 11 VDD hvp L=3.0e-07 W=0.3e-06
M13 12 10 VDD VDD hvp L=3.0e-07 W=0.4e-06
M14 13 8 12 VDD hvp L=3.0e-07 W=0.7e-06
M15 14 9 13 VDD hvp L=3.0e-07 W=0.28e-06
M16 VDD 15 14 VDD hvp L=3.0e-07 W=0.28e-06
M17 VDD 13 15 VDD hvp L=3.0e-07 W=0.8e-06
M18 Q 15 VDD VDD hvp L=3.0e-07 W=1e-06
M19 17 3 2 GND hvn L=3.5e-07 W=0.65e-06
M20 GND CN 17 GND hvn L=3.5e-07 W=0.65e-06
M21 3 4 GND GND hvn L=3.5e-07 W=0.65e-06
M22 19 D 4 GND hvn L=3.5e-07 W=0.65e-06
M23 GND LD 19 GND hvn L=3.5e-07 W=0.65e-06
M24 6 LD GND GND hvn L=3.5e-07 W=0.3e-06
M25 20 6 GND GND hvn L=3.5e-07 W=0.65e-06
M26 4 14 20 GND hvn L=3.5e-07 W=0.65e-06
M27 GND CK 8 GND hvn L=3.5e-07 W=0.6e-06
M28 9 8 GND GND hvn L=3.5e-07 W=0.3e-06
M29 10 8 2 GND hvn L=3.5e-07 W=0.6e-06
M30 21 9 10 GND hvn L=3.5e-07 W=0.28e-06
M31 GND 12 21 GND hvn L=3.5e-07 W=0.28e-06
M32 12 10 GND GND hvn L=3.5e-07 W=0.28e-06
M33 13 9 12 GND hvn L=3.5e-07 W=0.56e-06
M34 14 8 13 GND hvn L=3.5e-07 W=0.3e-06
M35 GND 15 14 GND hvn L=3.5e-07 W=0.3e-06
M36 GND 13 15 GND hvn L=3.5e-07 W=0.5e-06
M37 Q 15 GND GND hvn L=3.5e-07 W=0.65e-06
.ENDS DFFCNLDQX1

.SUBCKT DFFCNLDQX2 Q CN D LD CK
M0 2 3 VDD VDD hvp L=3.0e-07 W=0.75e-06
M1 VDD CN 2 VDD hvp L=3.0e-07 W=0.75e-06
M2 3 4 VDD VDD hvp L=3.0e-07 W=0.75e-06
M3 5 D 4 VDD hvp L=3.0e-07 W=0.8e-06
M4 VDD 6 5 VDD hvp L=3.0e-07 W=0.8e-06
M5 6 LD VDD VDD hvp L=3.0e-07 W=0.8e-06
M6 7 LD VDD VDD hvp L=3.0e-07 W=0.8e-06
M7 4 14 7 VDD hvp L=3.0e-07 W=0.8e-06
M8 VDD CK 8 VDD hvp L=3.0e-07 W=0.3e-06
M9 9 8 VDD VDD hvp L=3.0e-07 W=0.7e-06
M10 10 9 2 VDD hvp L=3.0e-07 W=0.5e-06
M11 11 8 10 VDD hvp L=3.0e-07 W=0.3e-06
M12 VDD 12 11 VDD hvp L=3.0e-07 W=0.3e-06
M13 12 10 VDD VDD hvp L=3.0e-07 W=0.4e-06
M14 13 8 12 VDD hvp L=3.0e-07 W=0.7e-06
M15 14 9 13 VDD hvp L=3.0e-07 W=0.28e-06
M16 VDD 15 14 VDD hvp L=3.0e-07 W=0.28e-06
M17 VDD 13 15 VDD hvp L=3.0e-07 W=0.8e-06
M18 Q 15 VDD VDD hvp L=3.0e-07 W=1e-06
M19 VDD 15 Q VDD hvp L=3.0e-07 W=1e-06
M20 17 3 2 GND hvn L=3.5e-07 W=0.65e-06
M21 GND CN 17 GND hvn L=3.5e-07 W=0.65e-06
M22 3 4 GND GND hvn L=3.5e-07 W=0.65e-06
M23 19 D 4 GND hvn L=3.5e-07 W=0.65e-06
M24 GND LD 19 GND hvn L=3.5e-07 W=0.65e-06
M25 6 LD GND GND hvn L=3.5e-07 W=0.3e-06
M26 20 6 GND GND hvn L=3.5e-07 W=0.65e-06
M27 4 14 20 GND hvn L=3.5e-07 W=0.65e-06
M28 GND CK 8 GND hvn L=3.5e-07 W=0.6e-06
M29 9 8 GND GND hvn L=3.5e-07 W=0.3e-06
M30 10 8 2 GND hvn L=3.5e-07 W=0.6e-06
M31 21 9 10 GND hvn L=3.5e-07 W=0.28e-06
M32 GND 12 21 GND hvn L=3.5e-07 W=0.28e-06
M33 12 10 GND GND hvn L=3.5e-07 W=0.28e-06
M34 13 9 12 GND hvn L=3.5e-07 W=0.56e-06
M35 14 8 13 GND hvn L=3.5e-07 W=0.3e-06
M36 GND 15 14 GND hvn L=3.5e-07 W=0.3e-06
M37 GND 13 15 GND hvn L=3.5e-07 W=0.5e-06
M38 Q 15 GND GND hvn L=3.5e-07 W=0.65e-06
M39 GND 15 Q GND hvn L=3.5e-07 W=0.65e-06
.ENDS DFFCNLDQX2

.SUBCKT DFFCNLDQX4 Q CN D LD CK
M0 2 3 VDD VDD hvp L=3.0e-07 W=0.75e-06
M1 VDD CN 2 VDD hvp L=3.0e-07 W=0.75e-06
M2 3 4 VDD VDD hvp L=3.0e-07 W=0.75e-06
M3 5 D 4 VDD hvp L=3.0e-07 W=0.8e-06
M4 VDD 6 5 VDD hvp L=3.0e-07 W=0.8e-06
M5 6 LD VDD VDD hvp L=3.0e-07 W=0.8e-06
M6 7 LD VDD VDD hvp L=3.0e-07 W=0.8e-06
M7 4 14 7 VDD hvp L=3.0e-07 W=0.8e-06
M8 VDD CK 8 VDD hvp L=3.0e-07 W=0.3e-06
M9 9 8 VDD VDD hvp L=3.0e-07 W=0.7e-06
M10 10 9 2 VDD hvp L=3.0e-07 W=0.5e-06
M11 11 8 10 VDD hvp L=3.0e-07 W=0.3e-06
M12 VDD 12 11 VDD hvp L=3.0e-07 W=0.3e-06
M13 12 10 VDD VDD hvp L=3.0e-07 W=0.4e-06
M14 13 8 12 VDD hvp L=3.0e-07 W=0.7e-06
M15 14 9 13 VDD hvp L=3.0e-07 W=0.28e-06
M16 VDD 15 14 VDD hvp L=3.0e-07 W=0.28e-06
M17 VDD 13 15 VDD hvp L=3.0e-07 W=0.8e-06
M18 Q 15 VDD VDD hvp L=3.0e-07 W=1e-06
M19 VDD 15 Q VDD hvp L=3.0e-07 W=1e-06
M20 Q 15 VDD VDD hvp L=3.0e-07 W=1e-06
M21 VDD 15 Q VDD hvp L=3.0e-07 W=1e-06
M22 17 3 2 GND hvn L=3.5e-07 W=0.65e-06
M23 GND CN 17 GND hvn L=3.5e-07 W=0.65e-06
M24 3 4 GND GND hvn L=3.5e-07 W=0.65e-06
M25 19 D 4 GND hvn L=3.5e-07 W=0.65e-06
M26 GND LD 19 GND hvn L=3.5e-07 W=0.65e-06
M27 6 LD GND GND hvn L=3.5e-07 W=0.3e-06
M28 20 6 GND GND hvn L=3.5e-07 W=0.65e-06
M29 4 14 20 GND hvn L=3.5e-07 W=0.65e-06
M30 GND CK 8 GND hvn L=3.5e-07 W=0.6e-06
M31 9 8 GND GND hvn L=3.5e-07 W=0.3e-06
M32 10 8 2 GND hvn L=3.5e-07 W=0.6e-06
M33 21 9 10 GND hvn L=3.5e-07 W=0.28e-06
M34 GND 12 21 GND hvn L=3.5e-07 W=0.28e-06
M35 12 10 GND GND hvn L=3.5e-07 W=0.28e-06
M36 13 9 12 GND hvn L=3.5e-07 W=0.56e-06
M37 14 8 13 GND hvn L=3.5e-07 W=0.3e-06
M38 GND 15 14 GND hvn L=3.5e-07 W=0.3e-06
M39 GND 13 15 GND hvn L=3.5e-07 W=0.5e-06
M40 Q 15 GND GND hvn L=3.5e-07 W=0.65e-06
M41 GND 15 Q GND hvn L=3.5e-07 W=0.65e-06
M42 Q 15 GND GND hvn L=3.5e-07 W=0.65e-06
M43 GND 15 Q GND hvn L=3.5e-07 W=0.65e-06
.ENDS DFFCNLDQX4

.SUBCKT DFFCNQBX1 QB CN D CK
M0 2 D VDD VDD hvp L=3.0e-07 W=0.6e-06
M1 VDD CN 2 VDD hvp L=3.0e-07 W=0.6e-06
M2 VDD CK 3 VDD hvp L=3.0e-07 W=0.35e-06
M3 4 3 VDD VDD hvp L=3.0e-07 W=0.9e-06
M4 5 4 2 VDD hvp L=3.0e-07 W=0.54e-06
M5 6 3 5 VDD hvp L=3.0e-07 W=0.3e-06
M6 VDD 7 6 VDD hvp L=3.0e-07 W=0.3e-06
M7 7 5 VDD VDD hvp L=3.0e-07 W=0.5e-06
M8 8 3 7 VDD hvp L=3.0e-07 W=0.5e-06
M9 9 4 8 VDD hvp L=3.0e-07 W=0.3e-06
M10 VDD 10 9 VDD hvp L=3.0e-07 W=0.3e-06
M11 10 8 VDD VDD hvp L=3.0e-07 W=0.3e-06
M12 QB 8 VDD VDD hvp L=3.0e-07 W=1e-06
M13 12 D 2 GND hvn L=3.5e-07 W=0.35e-06
M14 GND CN 12 GND hvn L=3.5e-07 W=0.35e-06
M15 GND CK 3 GND hvn L=3.5e-07 W=0.6e-06
M16 4 3 GND GND hvn L=3.5e-07 W=0.3e-06
M17 5 3 2 GND hvn L=3.5e-07 W=0.35e-06
M18 14 4 5 GND hvn L=3.5e-07 W=0.28e-06
M19 GND 7 14 GND hvn L=3.5e-07 W=0.3e-06
M20 7 5 GND GND hvn L=3.5e-07 W=0.3e-06
M21 8 4 7 GND hvn L=3.5e-07 W=0.3e-06
M22 15 3 8 GND hvn L=3.5e-07 W=0.3e-06
M23 GND 10 15 GND hvn L=3.5e-07 W=0.3e-06
M24 10 8 GND GND hvn L=3.5e-07 W=0.3e-06
M25 QB 8 GND GND hvn L=3.5e-07 W=0.65e-06
.ENDS DFFCNQBX1

.SUBCKT DFFCNQBX2 QB CN D CK
M0 2 D VDD VDD hvp L=3.0e-07 W=0.6e-06
M1 VDD CN 2 VDD hvp L=3.0e-07 W=0.6e-06
M2 VDD CK 3 VDD hvp L=3.0e-07 W=0.35e-06
M3 4 3 VDD VDD hvp L=3.0e-07 W=0.9e-06
M4 5 4 2 VDD hvp L=3.0e-07 W=0.54e-06
M5 6 3 5 VDD hvp L=3.0e-07 W=0.3e-06
M6 VDD 7 6 VDD hvp L=3.0e-07 W=0.3e-06
M7 7 5 VDD VDD hvp L=3.0e-07 W=0.5e-06
M8 8 3 7 VDD hvp L=3.0e-07 W=0.5e-06
M9 9 4 8 VDD hvp L=3.0e-07 W=0.3e-06
M10 VDD 10 9 VDD hvp L=3.0e-07 W=0.3e-06
M11 10 8 VDD VDD hvp L=3.0e-07 W=0.3e-06
M12 QB 8 VDD VDD hvp L=3.0e-07 W=1e-06
M13 VDD 8 QB VDD hvp L=3.0e-07 W=1e-06
M14 12 D 2 GND hvn L=3.5e-07 W=0.35e-06
M15 GND CN 12 GND hvn L=3.5e-07 W=0.35e-06
M16 GND CK 3 GND hvn L=3.5e-07 W=0.6e-06
M17 4 3 GND GND hvn L=3.5e-07 W=0.3e-06
M18 5 3 2 GND hvn L=3.5e-07 W=0.35e-06
M19 14 4 5 GND hvn L=3.5e-07 W=0.28e-06
M20 GND 7 14 GND hvn L=3.5e-07 W=0.3e-06
M21 7 5 GND GND hvn L=3.5e-07 W=0.3e-06
M22 8 4 7 GND hvn L=3.5e-07 W=0.3e-06
M23 15 3 8 GND hvn L=3.5e-07 W=0.3e-06
M24 GND 10 15 GND hvn L=3.5e-07 W=0.3e-06
M25 10 8 GND GND hvn L=3.5e-07 W=0.3e-06
M26 QB 8 GND GND hvn L=3.5e-07 W=0.65e-06
M27 GND 8 QB GND hvn L=3.5e-07 W=0.65e-06
.ENDS DFFCNQBX2

.SUBCKT DFFCNQBX4 QB CN D CK
M0 2 D VDD VDD hvp L=3.0e-07 W=0.6e-06
M1 VDD CN 2 VDD hvp L=3.0e-07 W=0.6e-06
M2 VDD CK 3 VDD hvp L=3.0e-07 W=0.35e-06
M3 4 3 VDD VDD hvp L=3.0e-07 W=0.9e-06
M4 5 4 2 VDD hvp L=3.0e-07 W=0.54e-06
M5 6 3 5 VDD hvp L=3.0e-07 W=0.3e-06
M6 VDD 7 6 VDD hvp L=3.0e-07 W=0.3e-06
M7 7 5 VDD VDD hvp L=3.0e-07 W=0.5e-06
M8 8 3 7 VDD hvp L=3.0e-07 W=0.5e-06
M9 9 4 8 VDD hvp L=3.0e-07 W=0.3e-06
M10 VDD 10 9 VDD hvp L=3.0e-07 W=0.3e-06
M11 10 8 VDD VDD hvp L=3.0e-07 W=0.3e-06
M12 QB 8 VDD VDD hvp L=3.0e-07 W=1e-06
M13 VDD 8 QB VDD hvp L=3.0e-07 W=1e-06
M14 QB 8 VDD VDD hvp L=3.0e-07 W=1e-06
M15 VDD 8 QB VDD hvp L=3.0e-07 W=1e-06
M16 12 D 2 GND hvn L=3.5e-07 W=0.35e-06
M17 GND CN 12 GND hvn L=3.5e-07 W=0.35e-06
M18 GND CK 3 GND hvn L=3.5e-07 W=0.6e-06
M19 4 3 GND GND hvn L=3.5e-07 W=0.3e-06
M20 5 3 2 GND hvn L=3.5e-07 W=0.35e-06
M21 14 4 5 GND hvn L=3.5e-07 W=0.28e-06
M22 GND 7 14 GND hvn L=3.5e-07 W=0.3e-06
M23 7 5 GND GND hvn L=3.5e-07 W=0.3e-06
M24 8 4 7 GND hvn L=3.5e-07 W=0.3e-06
M25 15 3 8 GND hvn L=3.5e-07 W=0.3e-06
M26 GND 10 15 GND hvn L=3.5e-07 W=0.3e-06
M27 10 8 GND GND hvn L=3.5e-07 W=0.3e-06
M28 QB 8 GND GND hvn L=3.5e-07 W=0.65e-06
M29 GND 8 QB GND hvn L=3.5e-07 W=0.65e-06
M30 QB 8 GND GND hvn L=3.5e-07 W=0.65e-06
M31 GND 8 QB GND hvn L=3.5e-07 W=0.65e-06
.ENDS DFFCNQBX4

.SUBCKT DFFCNQX1 Q CN D CK
M0 2 D VDD VDD hvp L=3.0e-07 W=0.6e-06
M1 VDD CN 2 VDD hvp L=3.0e-07 W=0.6e-06
M2 VDD CK 3 VDD hvp L=3.0e-07 W=0.35e-06
M3 4 3 VDD VDD hvp L=3.0e-07 W=0.9e-06
M4 5 4 2 VDD hvp L=3.0e-07 W=0.54e-06
M5 6 3 5 VDD hvp L=3.0e-07 W=0.3e-06
M6 VDD 7 6 VDD hvp L=3.0e-07 W=0.3e-06
M7 7 5 VDD VDD hvp L=3.0e-07 W=0.5e-06
M8 8 3 7 VDD hvp L=3.0e-07 W=0.5e-06
M9 9 4 8 VDD hvp L=3.0e-07 W=0.3e-06
M10 VDD 10 9 VDD hvp L=3.0e-07 W=0.3e-06
M11 VDD 8 10 VDD hvp L=3.0e-07 W=0.6e-06
M12 Q 10 VDD VDD hvp L=3.0e-07 W=1e-06
M13 12 D 2 GND hvn L=3.5e-07 W=0.35e-06
M14 GND CN 12 GND hvn L=3.5e-07 W=0.35e-06
M15 GND CK 3 GND hvn L=3.5e-07 W=0.6e-06
M16 4 3 GND GND hvn L=3.5e-07 W=0.3e-06
M17 5 3 2 GND hvn L=3.5e-07 W=0.35e-06
M18 14 4 5 GND hvn L=3.5e-07 W=0.28e-06
M19 GND 7 14 GND hvn L=3.5e-07 W=0.3e-06
M20 7 5 GND GND hvn L=3.5e-07 W=0.3e-06
M21 8 4 7 GND hvn L=3.5e-07 W=0.3e-06
M22 15 3 8 GND hvn L=3.5e-07 W=0.3e-06
M23 GND 10 15 GND hvn L=3.5e-07 W=0.3e-06
M24 GND 8 10 GND hvn L=3.5e-07 W=0.4e-06
M25 Q 10 GND GND hvn L=3.5e-07 W=0.65e-06
.ENDS DFFCNQX1

.SUBCKT DFFCNQX2 Q CN D CK
M0 2 D VDD VDD hvp L=3.0e-07 W=0.6e-06
M1 VDD CN 2 VDD hvp L=3.0e-07 W=0.6e-06
M2 VDD CK 3 VDD hvp L=3.0e-07 W=0.35e-06
M3 4 3 VDD VDD hvp L=3.0e-07 W=0.9e-06
M4 5 4 2 VDD hvp L=3.0e-07 W=0.54e-06
M5 6 3 5 VDD hvp L=3.0e-07 W=0.3e-06
M6 VDD 7 6 VDD hvp L=3.0e-07 W=0.3e-06
M7 7 5 VDD VDD hvp L=3.0e-07 W=0.5e-06
M8 8 3 7 VDD hvp L=3.0e-07 W=0.5e-06
M9 9 4 8 VDD hvp L=3.0e-07 W=0.3e-06
M10 VDD 10 9 VDD hvp L=3.0e-07 W=0.3e-06
M11 VDD 8 10 VDD hvp L=3.0e-07 W=0.6e-06
M12 Q 10 VDD VDD hvp L=3.0e-07 W=1e-06
M13 VDD 10 Q VDD hvp L=3.0e-07 W=1e-06
M14 12 D 2 GND hvn L=3.5e-07 W=0.35e-06
M15 GND CN 12 GND hvn L=3.5e-07 W=0.35e-06
M16 GND CK 3 GND hvn L=3.5e-07 W=0.6e-06
M17 4 3 GND GND hvn L=3.5e-07 W=0.3e-06
M18 5 3 2 GND hvn L=3.5e-07 W=0.35e-06
M19 14 4 5 GND hvn L=3.5e-07 W=0.28e-06
M20 GND 7 14 GND hvn L=3.5e-07 W=0.3e-06
M21 7 5 GND GND hvn L=3.5e-07 W=0.3e-06
M22 8 4 7 GND hvn L=3.5e-07 W=0.3e-06
M23 15 3 8 GND hvn L=3.5e-07 W=0.3e-06
M24 GND 10 15 GND hvn L=3.5e-07 W=0.3e-06
M25 GND 8 10 GND hvn L=3.5e-07 W=0.4e-06
M26 Q 10 GND GND hvn L=3.5e-07 W=0.65e-06
M27 GND 10 Q GND hvn L=3.5e-07 W=0.65e-06
.ENDS DFFCNQX2

.SUBCKT DFFCNQX4 Q CN D CK
M0 2 D VDD VDD hvp L=3.0e-07 W=0.6e-06
M1 VDD CN 2 VDD hvp L=3.0e-07 W=0.6e-06
M2 VDD CK 3 VDD hvp L=3.0e-07 W=0.35e-06
M3 4 3 VDD VDD hvp L=3.0e-07 W=0.9e-06
M4 5 4 2 VDD hvp L=3.0e-07 W=0.54e-06
M5 6 3 5 VDD hvp L=3.0e-07 W=0.3e-06
M6 VDD 7 6 VDD hvp L=3.0e-07 W=0.3e-06
M7 7 5 VDD VDD hvp L=3.0e-07 W=0.5e-06
M8 8 3 7 VDD hvp L=3.0e-07 W=0.5e-06
M9 9 4 8 VDD hvp L=3.0e-07 W=0.3e-06
M10 VDD 10 9 VDD hvp L=3.0e-07 W=0.3e-06
M11 VDD 8 10 VDD hvp L=3.0e-07 W=0.6e-06
M12 Q 10 VDD VDD hvp L=3.0e-07 W=1e-06
M13 VDD 10 Q VDD hvp L=3.0e-07 W=1e-06
M14 Q 10 VDD VDD hvp L=3.0e-07 W=1e-06
M15 VDD 10 Q VDD hvp L=3.0e-07 W=1e-06
M16 12 D 2 GND hvn L=3.5e-07 W=0.35e-06
M17 GND CN 12 GND hvn L=3.5e-07 W=0.35e-06
M18 GND CK 3 GND hvn L=3.5e-07 W=0.6e-06
M19 4 3 GND GND hvn L=3.5e-07 W=0.3e-06
M20 5 3 2 GND hvn L=3.5e-07 W=0.35e-06
M21 14 4 5 GND hvn L=3.5e-07 W=0.28e-06
M22 GND 7 14 GND hvn L=3.5e-07 W=0.3e-06
M23 7 5 GND GND hvn L=3.5e-07 W=0.3e-06
M24 8 4 7 GND hvn L=3.5e-07 W=0.3e-06
M25 15 3 8 GND hvn L=3.5e-07 W=0.3e-06
M26 GND 10 15 GND hvn L=3.5e-07 W=0.3e-06
M27 GND 8 10 GND hvn L=3.5e-07 W=0.4e-06
M28 Q 10 GND GND hvn L=3.5e-07 W=0.65e-06
M29 GND 10 Q GND hvn L=3.5e-07 W=0.65e-06
M30 Q 10 GND GND hvn L=3.5e-07 W=0.65e-06
M31 GND 10 Q GND hvn L=3.5e-07 W=0.65e-06
.ENDS DFFCNQX4

.SUBCKT DFFQBX1 QB D CK
M0 VDD D 1 VDD hvp L=3.0e-07 W=1e-06
M1 3 CK VDD VDD hvp L=3.0e-07 W=0.3e-06
M2 4 3 VDD VDD hvp L=3.0e-07 W=0.6e-06
M3 5 4 1 VDD hvp L=3.0e-07 W=0.6e-06
M4 6 3 5 VDD hvp L=3.0e-07 W=0.35e-06
M5 VDD 7 6 VDD hvp L=3.0e-07 W=0.35e-06
M6 7 5 VDD VDD hvp L=3.0e-07 W=0.4e-06
M7 8 3 7 VDD hvp L=3.0e-07 W=0.4e-06
M8 9 4 8 VDD hvp L=3.0e-07 W=0.3e-06
M9 VDD 10 9 VDD hvp L=3.0e-07 W=0.3e-06
M10 10 8 VDD VDD hvp L=3.0e-07 W=0.3e-06
M11 QB 8 VDD VDD hvp L=3.0e-07 W=1e-06
M12 1 D GND GND hvn L=3.5e-07 W=0.65e-06
M13 GND CK 3 GND hvn L=3.5e-07 W=0.6e-06
M14 4 3 GND GND hvn L=3.5e-07 W=0.3e-06
M15 5 3 1 GND hvn L=3.5e-07 W=0.6e-06
M16 13 4 5 GND hvn L=3.5e-07 W=0.3e-06
M17 GND 7 13 GND hvn L=3.5e-07 W=0.3e-06
M18 7 5 GND GND hvn L=3.5e-07 W=0.32e-06
M19 8 4 7 GND hvn L=3.5e-07 W=0.4e-06
M20 14 3 8 GND hvn L=3.5e-07 W=0.3e-06
M21 GND 10 14 GND hvn L=3.5e-07 W=0.3e-06
M22 10 8 GND GND hvn L=3.5e-07 W=0.3e-06
M23 QB 8 GND GND hvn L=3.5e-07 W=0.65e-06
.ENDS DFFQBX1

.SUBCKT DFFQBX2 QB D CK
M0 VDD D 1 VDD hvp L=3.0e-07 W=1e-06
M1 3 CK VDD VDD hvp L=3.0e-07 W=0.3e-06
M2 4 3 VDD VDD hvp L=3.0e-07 W=0.6e-06
M3 5 4 1 VDD hvp L=3.0e-07 W=0.6e-06
M4 6 3 5 VDD hvp L=3.0e-07 W=0.35e-06
M5 VDD 7 6 VDD hvp L=3.0e-07 W=0.35e-06
M6 7 5 VDD VDD hvp L=3.0e-07 W=0.4e-06
M7 8 3 7 VDD hvp L=3.0e-07 W=0.4e-06
M8 9 4 8 VDD hvp L=3.0e-07 W=0.3e-06
M9 VDD 10 9 VDD hvp L=3.0e-07 W=0.3e-06
M10 10 8 VDD VDD hvp L=3.0e-07 W=0.3e-06
M11 QB 8 VDD VDD hvp L=3.0e-07 W=1e-06
M12 VDD 8 QB VDD hvp L=3.0e-07 W=1e-06
M13 1 D GND GND hvn L=3.5e-07 W=0.65e-06
M14 GND CK 3 GND hvn L=3.5e-07 W=0.6e-06
M15 4 3 GND GND hvn L=3.5e-07 W=0.3e-06
M16 5 3 1 GND hvn L=3.5e-07 W=0.6e-06
M17 13 4 5 GND hvn L=3.5e-07 W=0.3e-06
M18 GND 7 13 GND hvn L=3.5e-07 W=0.3e-06
M19 7 5 GND GND hvn L=3.5e-07 W=0.32e-06
M20 8 4 7 GND hvn L=3.5e-07 W=0.4e-06
M21 14 3 8 GND hvn L=3.5e-07 W=0.3e-06
M22 GND 10 14 GND hvn L=3.5e-07 W=0.3e-06
M23 10 8 GND GND hvn L=3.5e-07 W=0.3e-06
M24 QB 8 GND GND hvn L=3.5e-07 W=0.65e-06
M25 GND 8 QB GND hvn L=3.5e-07 W=0.65e-06
.ENDS DFFQBX2

.SUBCKT DFFQBX4 QB D CK
M0 VDD D 1 VDD hvp L=3.0e-07 W=1e-06
M1 3 CK VDD VDD hvp L=3.0e-07 W=0.3e-06
M2 4 3 VDD VDD hvp L=3.0e-07 W=0.6e-06
M3 5 4 1 VDD hvp L=3.0e-07 W=0.6e-06
M4 6 3 5 VDD hvp L=3.0e-07 W=0.35e-06
M5 VDD 7 6 VDD hvp L=3.0e-07 W=0.35e-06
M6 7 5 VDD VDD hvp L=3.0e-07 W=0.4e-06
M7 8 3 7 VDD hvp L=3.0e-07 W=0.4e-06
M8 9 4 8 VDD hvp L=3.0e-07 W=0.3e-06
M9 VDD 10 9 VDD hvp L=3.0e-07 W=0.3e-06
M10 10 8 VDD VDD hvp L=3.0e-07 W=0.3e-06
M11 QB 8 VDD VDD hvp L=3.0e-07 W=1e-06
M12 VDD 8 QB VDD hvp L=3.0e-07 W=1e-06
M13 QB 8 VDD VDD hvp L=3.0e-07 W=1e-06
M14 VDD 8 QB VDD hvp L=3.0e-07 W=1e-06
M15 1 D GND GND hvn L=3.5e-07 W=0.65e-06
M16 GND CK 3 GND hvn L=3.5e-07 W=0.6e-06
M17 4 3 GND GND hvn L=3.5e-07 W=0.3e-06
M18 5 3 1 GND hvn L=3.5e-07 W=0.6e-06
M19 13 4 5 GND hvn L=3.5e-07 W=0.3e-06
M20 GND 7 13 GND hvn L=3.5e-07 W=0.3e-06
M21 7 5 GND GND hvn L=3.5e-07 W=0.32e-06
M22 8 4 7 GND hvn L=3.5e-07 W=0.4e-06
M23 14 3 8 GND hvn L=3.5e-07 W=0.3e-06
M24 GND 10 14 GND hvn L=3.5e-07 W=0.3e-06
M25 10 8 GND GND hvn L=3.5e-07 W=0.3e-06
M26 QB 8 GND GND hvn L=3.5e-07 W=0.65e-06
M27 GND 8 QB GND hvn L=3.5e-07 W=0.65e-06
M28 QB 8 GND GND hvn L=3.5e-07 W=0.65e-06
M29 GND 8 QB GND hvn L=3.5e-07 W=0.65e-06
.ENDS DFFQBX4

.SUBCKT DFFQBX6 QB D CK
M0 VDD D 1 VDD hvp L=3.0e-07 W=1e-06
M1 3 CK VDD VDD hvp L=3.0e-07 W=0.3e-06
M2 4 3 VDD VDD hvp L=3.0e-07 W=0.6e-06
M3 5 4 1 VDD hvp L=3.0e-07 W=0.6e-06
M4 6 3 5 VDD hvp L=3.0e-07 W=0.35e-06
M5 VDD 7 6 VDD hvp L=3.0e-07 W=0.35e-06
M6 7 5 VDD VDD hvp L=3.0e-07 W=0.4e-06
M7 8 3 7 VDD hvp L=3.0e-07 W=0.4e-06
M8 9 4 8 VDD hvp L=3.0e-07 W=0.3e-06
M9 VDD 10 9 VDD hvp L=3.0e-07 W=0.3e-06
M10 10 8 VDD VDD hvp L=3.0e-07 W=0.3e-06
M11 QB 8 VDD VDD hvp L=3.0e-07 W=1e-06
M12 VDD 8 QB VDD hvp L=3.0e-07 W=1e-06
M13 QB 8 VDD VDD hvp L=3.0e-07 W=1e-06
M14 VDD 8 QB VDD hvp L=3.0e-07 W=1e-06
M15 QB 8 VDD VDD hvp L=3.0e-07 W=1e-06
M16 VDD 8 QB VDD hvp L=3.0e-07 W=1e-06
M17 1 D GND GND hvn L=3.5e-07 W=0.65e-06
M18 GND CK 3 GND hvn L=3.5e-07 W=0.6e-06
M19 4 3 GND GND hvn L=3.5e-07 W=0.3e-06
M20 5 3 1 GND hvn L=3.5e-07 W=0.6e-06
M21 13 4 5 GND hvn L=3.5e-07 W=0.3e-06
M22 GND 7 13 GND hvn L=3.5e-07 W=0.3e-06
M23 7 5 GND GND hvn L=3.5e-07 W=0.32e-06
M24 8 4 7 GND hvn L=3.5e-07 W=0.4e-06
M25 14 3 8 GND hvn L=3.5e-07 W=0.3e-06
M26 GND 10 14 GND hvn L=3.5e-07 W=0.3e-06
M27 10 8 GND GND hvn L=3.5e-07 W=0.3e-06
M28 QB 8 GND GND hvn L=3.5e-07 W=0.65e-06
M29 GND 8 QB GND hvn L=3.5e-07 W=0.65e-06
M30 QB 8 GND GND hvn L=3.5e-07 W=0.65e-06
M31 GND 8 QB GND hvn L=3.5e-07 W=0.65e-06
M32 QB 8 GND GND hvn L=3.5e-07 W=0.65e-06
M33 GND 8 QB GND hvn L=3.5e-07 W=0.65e-06
.ENDS DFFQBX6

.SUBCKT DFFQX1 Q D CK
M0 VDD D 1 VDD hvp L=3.0e-07 W=1e-06
M1 3 CK VDD VDD hvp L=3.0e-07 W=0.3e-06
M2 4 3 VDD VDD hvp L=3.0e-07 W=0.6e-06
M3 5 4 1 VDD hvp L=3.0e-07 W=0.6e-06
M4 6 3 5 VDD hvp L=3.0e-07 W=0.35e-06
M5 VDD 7 6 VDD hvp L=3.0e-07 W=0.35e-06
M6 7 5 VDD VDD hvp L=3.0e-07 W=0.4e-06
M7 8 3 7 VDD hvp L=3.0e-07 W=0.4e-06
M8 9 4 8 VDD hvp L=3.0e-07 W=0.3e-06
M9 VDD 10 9 VDD hvp L=3.0e-07 W=0.3e-06
M10 VDD 8 10 VDD hvp L=3.0e-07 W=1e-06
M11 Q 10 VDD VDD hvp L=3.0e-07 W=1e-06
M12 1 D GND GND hvn L=3.5e-07 W=0.65e-06
M13 GND CK 3 GND hvn L=3.5e-07 W=0.6e-06
M14 4 3 GND GND hvn L=3.5e-07 W=0.3e-06
M15 5 3 1 GND hvn L=3.5e-07 W=0.6e-06
M16 13 4 5 GND hvn L=3.5e-07 W=0.3e-06
M17 GND 7 13 GND hvn L=3.5e-07 W=0.3e-06
M18 7 5 GND GND hvn L=3.5e-07 W=0.32e-06
M19 8 4 7 GND hvn L=3.5e-07 W=0.4e-06
M20 14 3 8 GND hvn L=3.5e-07 W=0.3e-06
M21 GND 10 14 GND hvn L=3.5e-07 W=0.3e-06
M22 GND 8 10 GND hvn L=3.5e-07 W=0.65e-06
M23 Q 10 GND GND hvn L=3.5e-07 W=0.65e-06
.ENDS DFFQX1

.SUBCKT DFFQX2 Q D CK
M0 VDD D 1 VDD hvp L=3.0e-07 W=1e-06
M1 3 CK VDD VDD hvp L=3.0e-07 W=0.3e-06
M2 4 3 VDD VDD hvp L=3.0e-07 W=0.6e-06
M3 5 4 1 VDD hvp L=3.0e-07 W=0.6e-06
M4 6 3 5 VDD hvp L=3.0e-07 W=0.35e-06
M5 VDD 7 6 VDD hvp L=3.0e-07 W=0.35e-06
M6 7 5 VDD VDD hvp L=3.0e-07 W=0.4e-06
M7 8 3 7 VDD hvp L=3.0e-07 W=0.4e-06
M8 9 4 8 VDD hvp L=3.0e-07 W=0.3e-06
M9 VDD 10 9 VDD hvp L=3.0e-07 W=0.3e-06
M10 VDD 8 10 VDD hvp L=3.0e-07 W=1e-06
M11 Q 10 VDD VDD hvp L=3.0e-07 W=1e-06
M12 VDD 10 Q VDD hvp L=3.0e-07 W=1e-06
M13 1 D GND GND hvn L=3.5e-07 W=0.65e-06
M14 GND CK 3 GND hvn L=3.5e-07 W=0.6e-06
M15 4 3 GND GND hvn L=3.5e-07 W=0.3e-06
M16 5 3 1 GND hvn L=3.5e-07 W=0.6e-06
M17 13 4 5 GND hvn L=3.5e-07 W=0.3e-06
M18 GND 7 13 GND hvn L=3.5e-07 W=0.3e-06
M19 7 5 GND GND hvn L=3.5e-07 W=0.32e-06
M20 8 4 7 GND hvn L=3.5e-07 W=0.4e-06
M21 14 3 8 GND hvn L=3.5e-07 W=0.3e-06
M22 GND 10 14 GND hvn L=3.5e-07 W=0.3e-06
M23 GND 8 10 GND hvn L=3.5e-07 W=0.65e-06
M24 Q 10 GND GND hvn L=3.5e-07 W=0.65e-06
M25 GND 10 Q GND hvn L=3.5e-07 W=0.65e-06
.ENDS DFFQX2

.SUBCKT DFFQX4 Q D CK
M0 VDD D 1 VDD hvp L=3.0e-07 W=1e-06
M1 3 CK VDD VDD hvp L=3.0e-07 W=0.3e-06
M2 4 3 VDD VDD hvp L=3.0e-07 W=0.6e-06
M3 5 4 1 VDD hvp L=3.0e-07 W=0.6e-06
M4 6 3 5 VDD hvp L=3.0e-07 W=0.35e-06
M5 VDD 7 6 VDD hvp L=3.0e-07 W=0.35e-06
M6 7 5 VDD VDD hvp L=3.0e-07 W=0.4e-06
M7 8 3 7 VDD hvp L=3.0e-07 W=0.4e-06
M8 9 4 8 VDD hvp L=3.0e-07 W=0.3e-06
M9 VDD 10 9 VDD hvp L=3.0e-07 W=0.3e-06
M10 VDD 8 10 VDD hvp L=3.0e-07 W=1e-06
M11 Q 10 VDD VDD hvp L=3.0e-07 W=1e-06
M12 VDD 10 Q VDD hvp L=3.0e-07 W=1e-06
M13 Q 10 VDD VDD hvp L=3.0e-07 W=1e-06
M14 VDD 10 Q VDD hvp L=3.0e-07 W=1e-06
M15 1 D GND GND hvn L=3.5e-07 W=0.65e-06
M16 GND CK 3 GND hvn L=3.5e-07 W=0.6e-06
M17 4 3 GND GND hvn L=3.5e-07 W=0.3e-06
M18 5 3 1 GND hvn L=3.5e-07 W=0.6e-06
M19 13 4 5 GND hvn L=3.5e-07 W=0.3e-06
M20 GND 7 13 GND hvn L=3.5e-07 W=0.3e-06
M21 7 5 GND GND hvn L=3.5e-07 W=0.32e-06
M22 8 4 7 GND hvn L=3.5e-07 W=0.4e-06
M23 14 3 8 GND hvn L=3.5e-07 W=0.3e-06
M24 GND 10 14 GND hvn L=3.5e-07 W=0.3e-06
M25 GND 8 10 GND hvn L=3.5e-07 W=0.65e-06
M26 Q 10 GND GND hvn L=3.5e-07 W=0.65e-06
M27 GND 10 Q GND hvn L=3.5e-07 W=0.65e-06
M28 Q 10 GND GND hvn L=3.5e-07 W=0.65e-06
M29 GND 10 Q GND hvn L=3.5e-07 W=0.65e-06
.ENDS DFFQX4

.SUBCKT DFFQX6 Q D CK
M0 VDD D 1 VDD hvp L=3.0e-07 W=1e-06
M1 3 CK VDD VDD hvp L=3.0e-07 W=0.3e-06
M2 4 3 VDD VDD hvp L=3.0e-07 W=0.6e-06
M3 5 4 1 VDD hvp L=3.0e-07 W=0.6e-06
M4 6 3 5 VDD hvp L=3.0e-07 W=0.35e-06
M5 VDD 7 6 VDD hvp L=3.0e-07 W=0.35e-06
M6 7 5 VDD VDD hvp L=3.0e-07 W=0.4e-06
M7 8 3 7 VDD hvp L=3.0e-07 W=0.4e-06
M8 9 4 8 VDD hvp L=3.0e-07 W=0.3e-06
M9 VDD 10 9 VDD hvp L=3.0e-07 W=0.3e-06
M10 VDD 8 10 VDD hvp L=3.0e-07 W=1e-06
M11 Q 10 VDD VDD hvp L=3.0e-07 W=1e-06
M12 VDD 10 Q VDD hvp L=3.0e-07 W=1e-06
M13 Q 10 VDD VDD hvp L=3.0e-07 W=1e-06
M14 VDD 10 Q VDD hvp L=3.0e-07 W=1e-06
M15 Q 10 VDD VDD hvp L=3.0e-07 W=1e-06
M16 VDD 10 Q VDD hvp L=3.0e-07 W=1e-06
M17 1 D GND GND hvn L=3.5e-07 W=0.65e-06
M18 GND CK 3 GND hvn L=3.5e-07 W=0.6e-06
M19 4 3 GND GND hvn L=3.5e-07 W=0.3e-06
M20 5 3 1 GND hvn L=3.5e-07 W=0.6e-06
M21 13 4 5 GND hvn L=3.5e-07 W=0.3e-06
M22 GND 7 13 GND hvn L=3.5e-07 W=0.3e-06
M23 7 5 GND GND hvn L=3.5e-07 W=0.32e-06
M24 8 4 7 GND hvn L=3.5e-07 W=0.4e-06
M25 14 3 8 GND hvn L=3.5e-07 W=0.3e-06
M26 GND 10 14 GND hvn L=3.5e-07 W=0.3e-06
M27 GND 8 10 GND hvn L=3.5e-07 W=0.65e-06
M28 Q 10 GND GND hvn L=3.5e-07 W=0.65e-06
M29 GND 10 Q GND hvn L=3.5e-07 W=0.65e-06
M30 Q 10 GND GND hvn L=3.5e-07 W=0.65e-06
M31 GND 10 Q GND hvn L=3.5e-07 W=0.65e-06
M32 Q 10 GND GND hvn L=3.5e-07 W=0.65e-06
M33 GND 10 Q GND hvn L=3.5e-07 W=0.65e-06
.ENDS DFFQX6

.SUBCKT DFFHQBX1 QB D CK
M0 VDD D 3 VDD hvp L=3.0e-07 W=0.55e-06
M1 14 CK VDD VDD hvp L=3.0e-07 W=0.6e-06
M2 8 6 14 VDD hvp L=3.0e-07 W=0.6e-06
M3 VDD CK 4 VDD hvp L=3.0e-07 W=0.28e-06
M4 6 4 VDD VDD hvp L=3.0e-07 W=0.56e-06
M5 15 6 VDD VDD hvp L=3.0e-07 W=0.55e-06
M6 5 3 15 VDD hvp L=3.0e-07 W=0.55e-06
M7 16 8 5 VDD hvp L=3.0e-07 W=0.3e-06
M8 VDD 7 16 VDD hvp L=3.0e-07 W=0.3e-06
M9 7 5 VDD VDD hvp L=3.0e-07 W=0.75e-06
M10 9 8 7 VDD hvp L=3.0e-07 W=0.65e-06
M11 17 6 9 VDD hvp L=3.0e-07 W=0.28e-06
M12 VDD 10 17 VDD hvp L=3.0e-07 W=0.28e-06
M13 10 9 VDD VDD hvp L=3.0e-07 W=0.3e-06
M14 QB 10 VDD VDD hvp L=3.0e-07 W=1e-06
M15 GND D 3 GND hvn L=3.5e-07 W=0.28e-06
M16 8 CK GND GND hvn L=3.5e-07 W=0.28e-06
M17 GND CK 4 GND hvn L=3.5e-07 W=0.28e-06
M18 6 4 GND GND hvn L=3.5e-07 W=0.28e-06
M19 18 8 GND GND hvn L=3.5e-07 W=0.3e-06
M20 5 3 18 GND hvn L=3.5e-07 W=0.3e-06
M21 19 6 5 GND hvn L=3.5e-07 W=0.28e-06
M22 GND 7 19 GND hvn L=3.5e-07 W=0.28e-06
M23 7 5 GND GND hvn L=3.5e-07 W=0.35e-06
M24 9 6 7 GND hvn L=3.5e-07 W=0.4e-06
M25 20 8 9 GND hvn L=3.5e-07 W=0.28e-06
M26 GND 10 20 GND hvn L=3.5e-07 W=0.28e-06
M27 10 9 GND GND hvn L=3.5e-07 W=0.28e-06
M28 QB 10 GND GND hvn L=3.5e-07 W=0.65e-06
.ENDS DFFHQBX1

.SUBCKT DFFHQBX2 QB D CK
M0 VDD D 3 VDD hvp L=3.0e-07 W=0.55e-06
M1 14 CK VDD VDD hvp L=3.0e-07 W=0.6e-06
M2 8 6 14 VDD hvp L=3.0e-07 W=0.6e-06
M3 VDD CK 4 VDD hvp L=3.0e-07 W=0.28e-06
M4 6 4 VDD VDD hvp L=3.0e-07 W=0.56e-06
M5 15 6 VDD VDD hvp L=3.0e-07 W=0.55e-06
M6 5 3 15 VDD hvp L=3.0e-07 W=0.55e-06
M7 16 8 5 VDD hvp L=3.0e-07 W=0.3e-06
M8 VDD 7 16 VDD hvp L=3.0e-07 W=0.3e-06
M9 7 5 VDD VDD hvp L=3.0e-07 W=0.75e-06
M10 9 8 7 VDD hvp L=3.0e-07 W=0.65e-06
M11 17 6 9 VDD hvp L=3.0e-07 W=0.28e-06
M12 VDD 10 17 VDD hvp L=3.0e-07 W=0.28e-06
M13 10 9 VDD VDD hvp L=3.0e-07 W=0.3e-06
M14 QB 10 VDD VDD hvp L=3.0e-07 W=1e-06
M15 VDD 10 QB VDD hvp L=3.0e-07 W=1e-06
M16 GND D 3 GND hvn L=3.5e-07 W=0.28e-06
M17 8 CK GND GND hvn L=3.5e-07 W=0.28e-06
M18 GND CK 4 GND hvn L=3.5e-07 W=0.28e-06
M19 6 4 GND GND hvn L=3.5e-07 W=0.28e-06
M20 18 8 GND GND hvn L=3.5e-07 W=0.3e-06
M21 5 3 18 GND hvn L=3.5e-07 W=0.3e-06
M22 19 6 5 GND hvn L=3.5e-07 W=0.28e-06
M23 GND 7 19 GND hvn L=3.5e-07 W=0.28e-06
M24 7 5 GND GND hvn L=3.5e-07 W=0.35e-06
M25 9 6 7 GND hvn L=3.5e-07 W=0.4e-06
M26 20 8 9 GND hvn L=3.5e-07 W=0.28e-06
M27 GND 10 20 GND hvn L=3.5e-07 W=0.28e-06
M28 10 9 GND GND hvn L=3.5e-07 W=0.28e-06
M29 QB 10 GND GND hvn L=3.5e-07 W=0.65e-06
M30 GND 10 QB GND hvn L=3.5e-07 W=0.65e-06
.ENDS DFFHQBX2

.SUBCKT DFFHQBX4 QB D CK
M0 VDD D 3 VDD hvp L=3.0e-07 W=0.55e-06
M1 14 CK VDD VDD hvp L=3.0e-07 W=0.6e-06
M2 8 6 14 VDD hvp L=3.0e-07 W=0.6e-06
M3 VDD CK 4 VDD hvp L=3.0e-07 W=0.28e-06
M4 6 4 VDD VDD hvp L=3.0e-07 W=0.56e-06
M5 15 6 VDD VDD hvp L=3.0e-07 W=0.55e-06
M6 5 3 15 VDD hvp L=3.0e-07 W=0.55e-06
M7 16 8 5 VDD hvp L=3.0e-07 W=0.3e-06
M8 VDD 7 16 VDD hvp L=3.0e-07 W=0.3e-06
M9 7 5 VDD VDD hvp L=3.0e-07 W=0.75e-06
M10 9 8 7 VDD hvp L=3.0e-07 W=0.65e-06
M11 17 6 9 VDD hvp L=3.0e-07 W=0.28e-06
M12 VDD 10 17 VDD hvp L=3.0e-07 W=0.28e-06
M13 10 9 VDD VDD hvp L=3.0e-07 W=0.3e-06
M14 QB 10 VDD VDD hvp L=3.0e-07 W=1e-06
M15 VDD 10 QB VDD hvp L=3.0e-07 W=1e-06
M16 QB 10 VDD VDD hvp L=3.0e-07 W=1e-06
M17 VDD 10 QB VDD hvp L=3.0e-07 W=1e-06
M18 GND D 3 GND hvn L=3.5e-07 W=0.28e-06
M19 8 CK GND GND hvn L=3.5e-07 W=0.28e-06
M20 GND CK 4 GND hvn L=3.5e-07 W=0.28e-06
M21 6 4 GND GND hvn L=3.5e-07 W=0.28e-06
M22 18 8 GND GND hvn L=3.5e-07 W=0.3e-06
M23 5 3 18 GND hvn L=3.5e-07 W=0.3e-06
M24 19 6 5 GND hvn L=3.5e-07 W=0.28e-06
M25 GND 7 19 GND hvn L=3.5e-07 W=0.28e-06
M26 7 5 GND GND hvn L=3.5e-07 W=0.35e-06
M27 9 6 7 GND hvn L=3.5e-07 W=0.4e-06
M28 20 8 9 GND hvn L=3.5e-07 W=0.28e-06
M29 GND 10 20 GND hvn L=3.5e-07 W=0.28e-06
M30 10 9 GND GND hvn L=3.5e-07 W=0.28e-06
M31 QB 10 GND GND hvn L=3.5e-07 W=0.65e-06
M32 GND 10 QB GND hvn L=3.5e-07 W=0.65e-06
M33 QB 10 GND GND hvn L=3.5e-07 W=0.65e-06
M34 GND 10 QB GND hvn L=3.5e-07 W=0.65e-06
.ENDS DFFHQBX4

.SUBCKT DFFHQBX6 QB D CK
M0 VDD D 3 VDD hvp L=3.0e-07 W=0.55e-06
M1 14 CK VDD VDD hvp L=3.0e-07 W=0.6e-06
M2 8 6 14 VDD hvp L=3.0e-07 W=0.6e-06
M3 VDD CK 4 VDD hvp L=3.0e-07 W=0.28e-06
M4 6 4 VDD VDD hvp L=3.0e-07 W=0.56e-06
M5 15 6 VDD VDD hvp L=3.0e-07 W=0.55e-06
M6 5 3 15 VDD hvp L=3.0e-07 W=0.55e-06
M7 16 8 5 VDD hvp L=3.0e-07 W=0.3e-06
M8 VDD 7 16 VDD hvp L=3.0e-07 W=0.3e-06
M9 7 5 VDD VDD hvp L=3.0e-07 W=0.75e-06
M10 9 8 7 VDD hvp L=3.0e-07 W=0.65e-06
M11 17 6 9 VDD hvp L=3.0e-07 W=0.28e-06
M12 VDD 10 17 VDD hvp L=3.0e-07 W=0.28e-06
M13 10 9 VDD VDD hvp L=3.0e-07 W=0.3e-06
M14 QB 10 VDD VDD hvp L=3.0e-07 W=1e-06
M15 VDD 10 QB VDD hvp L=3.0e-07 W=1e-06
M16 QB 10 VDD VDD hvp L=3.0e-07 W=1e-06
M17 VDD 10 QB VDD hvp L=3.0e-07 W=1e-06
M18 QB 10 VDD VDD hvp L=3.0e-07 W=1e-06
M19 VDD 10 QB VDD hvp L=3.0e-07 W=1e-06
M20 GND D 3 GND hvn L=3.5e-07 W=0.28e-06
M21 8 CK GND GND hvn L=3.5e-07 W=0.28e-06
M22 GND CK 4 GND hvn L=3.5e-07 W=0.28e-06
M23 6 4 GND GND hvn L=3.5e-07 W=0.28e-06
M24 18 8 GND GND hvn L=3.5e-07 W=0.3e-06
M25 5 3 18 GND hvn L=3.5e-07 W=0.3e-06
M26 19 6 5 GND hvn L=3.5e-07 W=0.28e-06
M27 GND 7 19 GND hvn L=3.5e-07 W=0.28e-06
M28 7 5 GND GND hvn L=3.5e-07 W=0.35e-06
M29 9 6 7 GND hvn L=3.5e-07 W=0.4e-06
M30 20 8 9 GND hvn L=3.5e-07 W=0.28e-06
M31 GND 10 20 GND hvn L=3.5e-07 W=0.28e-06
M32 10 9 GND GND hvn L=3.5e-07 W=0.28e-06
M33 QB 10 GND GND hvn L=3.5e-07 W=0.65e-06
M34 GND 10 QB GND hvn L=3.5e-07 W=0.65e-06
M35 QB 10 GND GND hvn L=3.5e-07 W=0.65e-06
M36 GND 10 QB GND hvn L=3.5e-07 W=0.65e-06
M37 QB 10 GND GND hvn L=3.5e-07 W=0.65e-06
M38 GND 10 QB GND hvn L=3.5e-07 W=0.65e-06
.ENDS DFFHQBX6

.SUBCKT DFFHQX1 Q D CK
M0 VDD D 3 VDD hvp L=3.0e-07 W=0.55e-06
M1 14 CK VDD VDD hvp L=3.0e-07 W=0.6e-06
M2 8 6 14 VDD hvp L=3.0e-07 W=0.6e-06
M3 VDD CK 4 VDD hvp L=3.0e-07 W=0.28e-06
M4 6 4 VDD VDD hvp L=3.0e-07 W=0.56e-06
M5 15 6 VDD VDD hvp L=3.0e-07 W=0.55e-06
M6 5 3 15 VDD hvp L=3.0e-07 W=0.55e-06
M7 16 8 5 VDD hvp L=3.0e-07 W=0.3e-06
M8 VDD 7 16 VDD hvp L=3.0e-07 W=0.3e-06
M9 7 5 VDD VDD hvp L=3.0e-07 W=0.75e-06
M10 10 8 7 VDD hvp L=3.0e-07 W=0.65e-06
M11 17 6 10 VDD hvp L=3.0e-07 W=0.28e-06
M12 VDD 9 17 VDD hvp L=3.0e-07 W=0.28e-06
M13 VDD 10 9 VDD hvp L=3.0e-07 W=0.3e-06
M14 Q 10 VDD VDD hvp L=3.0e-07 W=1e-06
M15 GND D 3 GND hvn L=3.5e-07 W=0.28e-06
M16 8 CK GND GND hvn L=3.5e-07 W=0.28e-06
M17 GND CK 4 GND hvn L=3.5e-07 W=0.28e-06
M18 6 4 GND GND hvn L=3.5e-07 W=0.28e-06
M19 18 8 GND GND hvn L=3.5e-07 W=0.3e-06
M20 5 3 18 GND hvn L=3.5e-07 W=0.3e-06
M21 19 6 5 GND hvn L=3.5e-07 W=0.28e-06
M22 GND 7 19 GND hvn L=3.5e-07 W=0.28e-06
M23 7 5 GND GND hvn L=3.5e-07 W=0.35e-06
M24 10 6 7 GND hvn L=3.5e-07 W=0.4e-06
M25 20 8 10 GND hvn L=3.5e-07 W=0.28e-06
M26 GND 9 20 GND hvn L=3.5e-07 W=0.28e-06
M27 GND 10 9 GND hvn L=3.5e-07 W=0.28e-06
M28 Q 10 GND GND hvn L=3.5e-07 W=0.65e-06
.ENDS DFFHQX1

.SUBCKT DFFHQX2 Q D CK
M0 VDD D 3 VDD hvp L=3.0e-07 W=0.55e-06
M1 14 CK VDD VDD hvp L=3.0e-07 W=0.6e-06
M2 8 6 14 VDD hvp L=3.0e-07 W=0.6e-06
M3 VDD CK 4 VDD hvp L=3.0e-07 W=0.28e-06
M4 6 4 VDD VDD hvp L=3.0e-07 W=0.56e-06
M5 15 6 VDD VDD hvp L=3.0e-07 W=0.55e-06
M6 5 3 15 VDD hvp L=3.0e-07 W=0.55e-06
M7 16 8 5 VDD hvp L=3.0e-07 W=0.3e-06
M8 VDD 7 16 VDD hvp L=3.0e-07 W=0.3e-06
M9 7 5 VDD VDD hvp L=3.0e-07 W=0.75e-06
M10 10 8 7 VDD hvp L=3.0e-07 W=0.65e-06
M11 17 6 10 VDD hvp L=3.0e-07 W=0.28e-06
M12 VDD 9 17 VDD hvp L=3.0e-07 W=0.28e-06
M13 VDD 10 9 VDD hvp L=3.0e-07 W=0.3e-06
M14 Q 10 VDD VDD hvp L=3.0e-07 W=1e-06
M15 VDD 10 Q VDD hvp L=3.0e-07 W=1e-06
M16 GND D 3 GND hvn L=3.5e-07 W=0.28e-06
M17 8 CK GND GND hvn L=3.5e-07 W=0.28e-06
M18 GND CK 4 GND hvn L=3.5e-07 W=0.28e-06
M19 6 4 GND GND hvn L=3.5e-07 W=0.28e-06
M20 18 8 GND GND hvn L=3.5e-07 W=0.3e-06
M21 5 3 18 GND hvn L=3.5e-07 W=0.3e-06
M22 19 6 5 GND hvn L=3.5e-07 W=0.28e-06
M23 GND 7 19 GND hvn L=3.5e-07 W=0.28e-06
M24 7 5 GND GND hvn L=3.5e-07 W=0.35e-06
M25 10 6 7 GND hvn L=3.5e-07 W=0.4e-06
M26 20 8 10 GND hvn L=3.5e-07 W=0.28e-06
M27 GND 9 20 GND hvn L=3.5e-07 W=0.28e-06
M28 GND 10 9 GND hvn L=3.5e-07 W=0.28e-06
M29 Q 10 GND GND hvn L=3.5e-07 W=0.65e-06
M30 GND 10 Q GND hvn L=3.5e-07 W=0.65e-06
.ENDS DFFHQX2

.SUBCKT DFFHQX4 Q D CK
M0 VDD D 3 VDD hvp L=3.0e-07 W=0.55e-06
M1 14 CK VDD VDD hvp L=3.0e-07 W=0.6e-06
M2 8 6 14 VDD hvp L=3.0e-07 W=0.6e-06
M3 VDD CK 4 VDD hvp L=3.0e-07 W=0.28e-06
M4 6 4 VDD VDD hvp L=3.0e-07 W=0.56e-06
M5 15 6 VDD VDD hvp L=3.0e-07 W=0.55e-06
M6 5 3 15 VDD hvp L=3.0e-07 W=0.55e-06
M7 16 8 5 VDD hvp L=3.0e-07 W=0.3e-06
M8 VDD 7 16 VDD hvp L=3.0e-07 W=0.3e-06
M9 7 5 VDD VDD hvp L=3.0e-07 W=0.75e-06
M10 10 8 7 VDD hvp L=3.0e-07 W=0.65e-06
M11 17 6 10 VDD hvp L=3.0e-07 W=0.28e-06
M12 VDD 9 17 VDD hvp L=3.0e-07 W=0.28e-06
M13 VDD 10 9 VDD hvp L=3.0e-07 W=0.3e-06
M14 Q 10 VDD VDD hvp L=3.0e-07 W=1e-06
M15 VDD 10 Q VDD hvp L=3.0e-07 W=1e-06
M16 Q 10 VDD VDD hvp L=3.0e-07 W=1e-06
M17 VDD 10 Q VDD hvp L=3.0e-07 W=1e-06
M18 GND D 3 GND hvn L=3.5e-07 W=0.28e-06
M19 8 CK GND GND hvn L=3.5e-07 W=0.28e-06
M20 GND CK 4 GND hvn L=3.5e-07 W=0.28e-06
M21 6 4 GND GND hvn L=3.5e-07 W=0.28e-06
M22 18 8 GND GND hvn L=3.5e-07 W=0.3e-06
M23 5 3 18 GND hvn L=3.5e-07 W=0.3e-06
M24 19 6 5 GND hvn L=3.5e-07 W=0.28e-06
M25 GND 7 19 GND hvn L=3.5e-07 W=0.28e-06
M26 7 5 GND GND hvn L=3.5e-07 W=0.35e-06
M27 10 6 7 GND hvn L=3.5e-07 W=0.4e-06
M28 20 8 10 GND hvn L=3.5e-07 W=0.28e-06
M29 GND 9 20 GND hvn L=3.5e-07 W=0.28e-06
M30 GND 10 9 GND hvn L=3.5e-07 W=0.28e-06
M31 Q 10 GND GND hvn L=3.5e-07 W=0.65e-06
M32 GND 10 Q GND hvn L=3.5e-07 W=0.65e-06
M33 Q 10 GND GND hvn L=3.5e-07 W=0.65e-06
M34 GND 10 Q GND hvn L=3.5e-07 W=0.65e-06
.ENDS DFFHQX4

.SUBCKT DFFHQX6 Q D CK
M0 VDD D 3 VDD hvp L=3.0e-07 W=0.55e-06
M1 14 CK VDD VDD hvp L=3.0e-07 W=0.6e-06
M2 8 6 14 VDD hvp L=3.0e-07 W=0.6e-06
M3 VDD CK 4 VDD hvp L=3.0e-07 W=0.28e-06
M4 6 4 VDD VDD hvp L=3.0e-07 W=0.56e-06
M5 15 6 VDD VDD hvp L=3.0e-07 W=0.55e-06
M6 5 3 15 VDD hvp L=3.0e-07 W=0.55e-06
M7 16 8 5 VDD hvp L=3.0e-07 W=0.3e-06
M8 VDD 7 16 VDD hvp L=3.0e-07 W=0.3e-06
M9 7 5 VDD VDD hvp L=3.0e-07 W=0.75e-06
M10 10 8 7 VDD hvp L=3.0e-07 W=0.65e-06
M11 17 6 10 VDD hvp L=3.0e-07 W=0.28e-06
M12 VDD 9 17 VDD hvp L=3.0e-07 W=0.28e-06
M13 VDD 10 9 VDD hvp L=3.0e-07 W=0.3e-06
M14 Q 10 VDD VDD hvp L=3.0e-07 W=1e-06
M15 VDD 10 Q VDD hvp L=3.0e-07 W=1e-06
M16 Q 10 VDD VDD hvp L=3.0e-07 W=1e-06
M17 VDD 10 Q VDD hvp L=3.0e-07 W=1e-06
M18 Q 10 VDD VDD hvp L=3.0e-07 W=1e-06
M19 VDD 10 Q VDD hvp L=3.0e-07 W=1e-06
M20 GND D 3 GND hvn L=3.5e-07 W=0.28e-06
M21 8 CK GND GND hvn L=3.5e-07 W=0.28e-06
M22 GND CK 4 GND hvn L=3.5e-07 W=0.28e-06
M23 6 4 GND GND hvn L=3.5e-07 W=0.28e-06
M24 18 8 GND GND hvn L=3.5e-07 W=0.3e-06
M25 5 3 18 GND hvn L=3.5e-07 W=0.3e-06
M26 19 6 5 GND hvn L=3.5e-07 W=0.28e-06
M27 GND 7 19 GND hvn L=3.5e-07 W=0.28e-06
M28 7 5 GND GND hvn L=3.5e-07 W=0.35e-06
M29 10 6 7 GND hvn L=3.5e-07 W=0.4e-06
M30 20 8 10 GND hvn L=3.5e-07 W=0.28e-06
M31 GND 9 20 GND hvn L=3.5e-07 W=0.28e-06
M32 GND 10 9 GND hvn L=3.5e-07 W=0.28e-06
M33 Q 10 GND GND hvn L=3.5e-07 W=0.65e-06
M34 GND 10 Q GND hvn L=3.5e-07 W=0.65e-06
M35 Q 10 GND GND hvn L=3.5e-07 W=0.65e-06
M36 GND 10 Q GND hvn L=3.5e-07 W=0.65e-06
M37 Q 10 GND GND hvn L=3.5e-07 W=0.65e-06
M38 GND 10 Q GND hvn L=3.5e-07 W=0.65e-06
.ENDS DFFHQX6

.SUBCKT DFFRBQBX1 QB D RB CK
M0 VDD D 1 VDD hvp L=3.0e-07 W=1e-06
M1 3 CK VDD VDD hvp L=3.0e-07 W=0.3e-06
M2 4 3 VDD VDD hvp L=3.0e-07 W=0.6e-06
M3 5 4 1 VDD hvp L=3.0e-07 W=0.6e-06
M4 6 3 5 VDD hvp L=3.0e-07 W=0.6e-06
M5 VDD RB 6 VDD hvp L=3.0e-07 W=0.6e-06
M6 6 7 VDD VDD hvp L=3.0e-07 W=0.3e-06
M7 7 5 VDD VDD hvp L=3.0e-07 W=0.47e-06
M8 8 3 7 VDD hvp L=3.0e-07 W=0.3e-06
M9 9 4 8 VDD hvp L=3.0e-07 W=0.3e-06
M10 VDD 10 9 VDD hvp L=3.0e-07 W=0.3e-06
M11 10 RB VDD VDD hvp L=3.0e-07 W=0.3e-06
M12 VDD 8 10 VDD hvp L=3.0e-07 W=0.3e-06
M13 QB 8 VDD VDD hvp L=3.0e-07 W=1e-06
M14 GND D 1 GND hvn L=3.5e-07 W=0.65e-06
M15 GND CK 3 GND hvn L=3.5e-07 W=0.6e-06
M16 4 3 GND GND hvn L=3.5e-07 W=0.3e-06
M17 5 3 1 GND hvn L=3.5e-07 W=0.3e-06
M18 6 4 5 GND hvn L=3.5e-07 W=0.6e-06
M19 13 RB 6 GND hvn L=3.5e-07 W=0.3e-06
M20 GND 7 13 GND hvn L=3.5e-07 W=0.3e-06
M21 7 5 GND GND hvn L=3.5e-07 W=0.28e-06
M22 8 4 7 GND hvn L=3.5e-07 W=0.3e-06
M23 14 3 8 GND hvn L=3.5e-07 W=0.3e-06
M24 GND 10 14 GND hvn L=3.5e-07 W=0.3e-06
M25 15 RB GND GND hvn L=3.5e-07 W=0.3e-06
M26 10 8 15 GND hvn L=3.5e-07 W=0.3e-06
M27 QB 8 GND GND hvn L=3.5e-07 W=0.65e-06
.ENDS DFFRBQBX1

.SUBCKT DFFRBQBX2 QB D RB CK
M0 VDD D 1 VDD hvp L=3.0e-07 W=1e-06
M1 3 CK VDD VDD hvp L=3.0e-07 W=0.3e-06
M2 4 3 VDD VDD hvp L=3.0e-07 W=0.6e-06
M3 5 4 1 VDD hvp L=3.0e-07 W=0.6e-06
M4 6 3 5 VDD hvp L=3.0e-07 W=0.6e-06
M5 VDD RB 6 VDD hvp L=3.0e-07 W=0.6e-06
M6 6 7 VDD VDD hvp L=3.0e-07 W=0.3e-06
M7 7 5 VDD VDD hvp L=3.0e-07 W=0.47e-06
M8 8 3 7 VDD hvp L=3.0e-07 W=0.3e-06
M9 9 4 8 VDD hvp L=3.0e-07 W=0.3e-06
M10 VDD 10 9 VDD hvp L=3.0e-07 W=0.3e-06
M11 10 RB VDD VDD hvp L=3.0e-07 W=0.3e-06
M12 VDD 8 10 VDD hvp L=3.0e-07 W=0.3e-06
M13 QB 8 VDD VDD hvp L=3.0e-07 W=1e-06
M14 VDD 8 QB VDD hvp L=3.0e-07 W=1e-06
M15 GND D 1 GND hvn L=3.5e-07 W=0.65e-06
M16 GND CK 3 GND hvn L=3.5e-07 W=0.6e-06
M17 4 3 GND GND hvn L=3.5e-07 W=0.3e-06
M18 5 3 1 GND hvn L=3.5e-07 W=0.3e-06
M19 6 4 5 GND hvn L=3.5e-07 W=0.6e-06
M20 13 RB 6 GND hvn L=3.5e-07 W=0.3e-06
M21 GND 7 13 GND hvn L=3.5e-07 W=0.3e-06
M22 7 5 GND GND hvn L=3.5e-07 W=0.28e-06
M23 8 4 7 GND hvn L=3.5e-07 W=0.3e-06
M24 14 3 8 GND hvn L=3.5e-07 W=0.3e-06
M25 GND 10 14 GND hvn L=3.5e-07 W=0.3e-06
M26 15 RB GND GND hvn L=3.5e-07 W=0.3e-06
M27 10 8 15 GND hvn L=3.5e-07 W=0.3e-06
M28 QB 8 GND GND hvn L=3.5e-07 W=0.65e-06
M29 GND 8 QB GND hvn L=3.5e-07 W=0.65e-06
.ENDS DFFRBQBX2

.SUBCKT DFFRBQBX4 QB D RB CK
M0 VDD D 1 VDD hvp L=3.0e-07 W=1e-06
M1 3 CK VDD VDD hvp L=3.0e-07 W=0.3e-06
M2 4 3 VDD VDD hvp L=3.0e-07 W=0.6e-06
M3 5 4 1 VDD hvp L=3.0e-07 W=0.6e-06
M4 6 3 5 VDD hvp L=3.0e-07 W=0.6e-06
M5 VDD RB 6 VDD hvp L=3.0e-07 W=0.6e-06
M6 6 7 VDD VDD hvp L=3.0e-07 W=0.3e-06
M7 7 5 VDD VDD hvp L=3.0e-07 W=0.47e-06
M8 8 3 7 VDD hvp L=3.0e-07 W=0.3e-06
M9 9 4 8 VDD hvp L=3.0e-07 W=0.3e-06
M10 VDD 10 9 VDD hvp L=3.0e-07 W=0.3e-06
M11 10 RB VDD VDD hvp L=3.0e-07 W=0.3e-06
M12 VDD 8 10 VDD hvp L=3.0e-07 W=0.3e-06
M13 QB 8 VDD VDD hvp L=3.0e-07 W=1e-06
M14 VDD 8 QB VDD hvp L=3.0e-07 W=1e-06
M15 QB 8 VDD VDD hvp L=3.0e-07 W=1e-06
M16 VDD 8 QB VDD hvp L=3.0e-07 W=1e-06
M17 GND D 1 GND hvn L=3.5e-07 W=0.65e-06
M18 GND CK 3 GND hvn L=3.5e-07 W=0.6e-06
M19 4 3 GND GND hvn L=3.5e-07 W=0.3e-06
M20 5 3 1 GND hvn L=3.5e-07 W=0.3e-06
M21 6 4 5 GND hvn L=3.5e-07 W=0.6e-06
M22 13 RB 6 GND hvn L=3.5e-07 W=0.3e-06
M23 GND 7 13 GND hvn L=3.5e-07 W=0.3e-06
M24 7 5 GND GND hvn L=3.5e-07 W=0.28e-06
M25 8 4 7 GND hvn L=3.5e-07 W=0.3e-06
M26 14 3 8 GND hvn L=3.5e-07 W=0.3e-06
M27 GND 10 14 GND hvn L=3.5e-07 W=0.3e-06
M28 15 RB GND GND hvn L=3.5e-07 W=0.3e-06
M29 10 8 15 GND hvn L=3.5e-07 W=0.3e-06
M30 QB 8 GND GND hvn L=3.5e-07 W=0.65e-06
M31 GND 8 QB GND hvn L=3.5e-07 W=0.65e-06
M32 QB 8 GND GND hvn L=3.5e-07 W=0.65e-06
M33 GND 8 QB GND hvn L=3.5e-07 W=0.65e-06
.ENDS DFFRBQBX4

.SUBCKT DFFRBQBX6 QB D RB CK
M0 VDD D 1 VDD hvp L=3.0e-07 W=1e-06
M1 3 CK VDD VDD hvp L=3.0e-07 W=0.3e-06
M2 4 3 VDD VDD hvp L=3.0e-07 W=0.6e-06
M3 5 4 1 VDD hvp L=3.0e-07 W=0.6e-06
M4 6 3 5 VDD hvp L=3.0e-07 W=0.6e-06
M5 VDD RB 6 VDD hvp L=3.0e-07 W=0.6e-06
M6 6 7 VDD VDD hvp L=3.0e-07 W=0.3e-06
M7 7 5 VDD VDD hvp L=3.0e-07 W=0.47e-06
M8 8 3 7 VDD hvp L=3.0e-07 W=0.3e-06
M9 9 4 8 VDD hvp L=3.0e-07 W=0.3e-06
M10 VDD 10 9 VDD hvp L=3.0e-07 W=0.3e-06
M11 10 RB VDD VDD hvp L=3.0e-07 W=0.3e-06
M12 VDD 8 10 VDD hvp L=3.0e-07 W=0.3e-06
M13 QB 8 VDD VDD hvp L=3.0e-07 W=1e-06
M14 VDD 8 QB VDD hvp L=3.0e-07 W=1e-06
M15 QB 8 VDD VDD hvp L=3.0e-07 W=1e-06
M16 VDD 8 QB VDD hvp L=3.0e-07 W=1e-06
M17 QB 8 VDD VDD hvp L=3.0e-07 W=1e-06
M18 VDD 8 QB VDD hvp L=3.0e-07 W=1e-06
M19 GND D 1 GND hvn L=3.5e-07 W=0.65e-06
M20 GND CK 3 GND hvn L=3.5e-07 W=0.6e-06
M21 4 3 GND GND hvn L=3.5e-07 W=0.3e-06
M22 5 3 1 GND hvn L=3.5e-07 W=0.3e-06
M23 6 4 5 GND hvn L=3.5e-07 W=0.6e-06
M24 13 RB 6 GND hvn L=3.5e-07 W=0.3e-06
M25 GND 7 13 GND hvn L=3.5e-07 W=0.3e-06
M26 7 5 GND GND hvn L=3.5e-07 W=0.28e-06
M27 8 4 7 GND hvn L=3.5e-07 W=0.3e-06
M28 14 3 8 GND hvn L=3.5e-07 W=0.3e-06
M29 GND 10 14 GND hvn L=3.5e-07 W=0.3e-06
M30 15 RB GND GND hvn L=3.5e-07 W=0.3e-06
M31 10 8 15 GND hvn L=3.5e-07 W=0.3e-06
M32 QB 8 GND GND hvn L=3.5e-07 W=0.65e-06
M33 GND 8 QB GND hvn L=3.5e-07 W=0.65e-06
M34 QB 8 GND GND hvn L=3.5e-07 W=0.65e-06
M35 GND 8 QB GND hvn L=3.5e-07 W=0.65e-06
M36 QB 8 GND GND hvn L=3.5e-07 W=0.65e-06
M37 GND 8 QB GND hvn L=3.5e-07 W=0.65e-06
.ENDS DFFRBQBX6

.SUBCKT DFFRBQX1 Q D RB CK
M0 VDD D 1 VDD hvp L=3.0e-07 W=1e-06
M1 3 CK VDD VDD hvp L=3.0e-07 W=0.3e-06
M2 4 3 VDD VDD hvp L=3.0e-07 W=0.6e-06
M3 5 4 1 VDD hvp L=3.0e-07 W=0.5e-06
M4 6 3 5 VDD hvp L=3.0e-07 W=0.3e-06
M5 VDD RB 6 VDD hvp L=3.0e-07 W=0.3e-06
M6 6 7 VDD VDD hvp L=3.0e-07 W=0.3e-06
M7 7 5 VDD VDD hvp L=3.0e-07 W=0.47e-06
M8 8 3 7 VDD hvp L=3.0e-07 W=0.47e-06
M9 9 4 8 VDD hvp L=3.0e-07 W=0.3e-06
M10 VDD 10 9 VDD hvp L=3.0e-07 W=0.3e-06
M11 10 RB VDD VDD hvp L=3.0e-07 W=0.8e-06
M12 VDD 8 10 VDD hvp L=3.0e-07 W=0.89e-06
M13 Q 10 VDD VDD hvp L=3.0e-07 W=1e-06
M14 GND D 1 GND hvn L=3.5e-07 W=0.65e-06
M15 GND CK 3 GND hvn L=3.5e-07 W=0.6e-06
M16 4 3 GND GND hvn L=3.5e-07 W=0.3e-06
M17 5 3 1 GND hvn L=3.5e-07 W=0.5e-06
M18 6 4 5 GND hvn L=3.5e-07 W=0.3e-06
M19 13 RB 6 GND hvn L=3.5e-07 W=0.3e-06
M20 GND 7 13 GND hvn L=3.5e-07 W=0.3e-06
M21 7 5 GND GND hvn L=3.5e-07 W=0.28e-06
M22 8 4 7 GND hvn L=3.5e-07 W=0.3e-06
M23 14 3 8 GND hvn L=3.5e-07 W=0.3e-06
M24 GND 10 14 GND hvn L=3.5e-07 W=0.3e-06
M25 15 RB GND GND hvn L=3.5e-07 W=0.49e-06
M26 10 8 15 GND hvn L=3.5e-07 W=0.49e-06
M27 Q 10 GND GND hvn L=3.5e-07 W=0.65e-06
.ENDS DFFRBQX1

.SUBCKT DFFRBQX2 Q D RB CK
M0 VDD D 1 VDD hvp L=3.0e-07 W=1e-06
M1 3 CK VDD VDD hvp L=3.0e-07 W=0.3e-06
M2 4 3 VDD VDD hvp L=3.0e-07 W=0.6e-06
M3 5 4 1 VDD hvp L=3.0e-07 W=0.5e-06
M4 6 3 5 VDD hvp L=3.0e-07 W=0.3e-06
M5 VDD RB 6 VDD hvp L=3.0e-07 W=0.3e-06
M6 6 7 VDD VDD hvp L=3.0e-07 W=0.3e-06
M7 7 5 VDD VDD hvp L=3.0e-07 W=0.47e-06
M8 8 3 7 VDD hvp L=3.0e-07 W=0.47e-06
M9 9 4 8 VDD hvp L=3.0e-07 W=0.3e-06
M10 VDD 10 9 VDD hvp L=3.0e-07 W=0.3e-06
M11 10 RB VDD VDD hvp L=3.0e-07 W=0.8e-06
M12 VDD 8 10 VDD hvp L=3.0e-07 W=0.89e-06
M13 Q 10 VDD VDD hvp L=3.0e-07 W=1e-06
M14 VDD 10 Q VDD hvp L=3.0e-07 W=1e-06
M15 GND D 1 GND hvn L=3.5e-07 W=0.65e-06
M16 GND CK 3 GND hvn L=3.5e-07 W=0.6e-06
M17 4 3 GND GND hvn L=3.5e-07 W=0.3e-06
M18 5 3 1 GND hvn L=3.5e-07 W=0.5e-06
M19 6 4 5 GND hvn L=3.5e-07 W=0.3e-06
M20 13 RB 6 GND hvn L=3.5e-07 W=0.3e-06
M21 GND 7 13 GND hvn L=3.5e-07 W=0.3e-06
M22 7 5 GND GND hvn L=3.5e-07 W=0.28e-06
M23 8 4 7 GND hvn L=3.5e-07 W=0.3e-06
M24 14 3 8 GND hvn L=3.5e-07 W=0.3e-06
M25 GND 10 14 GND hvn L=3.5e-07 W=0.3e-06
M26 15 RB GND GND hvn L=3.5e-07 W=0.49e-06
M27 10 8 15 GND hvn L=3.5e-07 W=0.49e-06
M28 Q 10 GND GND hvn L=3.5e-07 W=0.65e-06
M29 GND 10 Q GND hvn L=3.5e-07 W=0.65e-06
.ENDS DFFRBQX2

.SUBCKT DFFRBQX4 Q D RB CK
M0 VDD D 1 VDD hvp L=3.0e-07 W=1e-06
M1 3 CK VDD VDD hvp L=3.0e-07 W=0.3e-06
M2 4 3 VDD VDD hvp L=3.0e-07 W=0.6e-06
M3 5 4 1 VDD hvp L=3.0e-07 W=0.5e-06
M4 6 3 5 VDD hvp L=3.0e-07 W=0.3e-06
M5 VDD RB 6 VDD hvp L=3.0e-07 W=0.3e-06
M6 6 7 VDD VDD hvp L=3.0e-07 W=0.3e-06
M7 7 5 VDD VDD hvp L=3.0e-07 W=0.47e-06
M8 8 3 7 VDD hvp L=3.0e-07 W=0.47e-06
M9 9 4 8 VDD hvp L=3.0e-07 W=0.3e-06
M10 VDD 10 9 VDD hvp L=3.0e-07 W=0.3e-06
M11 10 RB VDD VDD hvp L=3.0e-07 W=0.8e-06
M12 VDD 8 10 VDD hvp L=3.0e-07 W=0.89e-06
M13 Q 10 VDD VDD hvp L=3.0e-07 W=1e-06
M14 VDD 10 Q VDD hvp L=3.0e-07 W=1e-06
M15 Q 10 VDD VDD hvp L=3.0e-07 W=1e-06
M16 VDD 10 Q VDD hvp L=3.0e-07 W=1e-06
M17 GND D 1 GND hvn L=3.5e-07 W=0.65e-06
M18 GND CK 3 GND hvn L=3.5e-07 W=0.6e-06
M19 4 3 GND GND hvn L=3.5e-07 W=0.3e-06
M20 5 3 1 GND hvn L=3.5e-07 W=0.5e-06
M21 6 4 5 GND hvn L=3.5e-07 W=0.3e-06
M22 13 RB 6 GND hvn L=3.5e-07 W=0.3e-06
M23 GND 7 13 GND hvn L=3.5e-07 W=0.3e-06
M24 7 5 GND GND hvn L=3.5e-07 W=0.28e-06
M25 8 4 7 GND hvn L=3.5e-07 W=0.3e-06
M26 14 3 8 GND hvn L=3.5e-07 W=0.3e-06
M27 GND 10 14 GND hvn L=3.5e-07 W=0.3e-06
M28 15 RB GND GND hvn L=3.5e-07 W=0.49e-06
M29 10 8 15 GND hvn L=3.5e-07 W=0.49e-06
M30 Q 10 GND GND hvn L=3.5e-07 W=0.65e-06
M31 GND 10 Q GND hvn L=3.5e-07 W=0.65e-06
M32 Q 10 GND GND hvn L=3.5e-07 W=0.65e-06
M33 GND 10 Q GND hvn L=3.5e-07 W=0.65e-06
.ENDS DFFRBQX4

.SUBCKT DFFRBQX6 Q D RB CK
M0 VDD D 1 VDD hvp L=3.0e-07 W=1e-06
M1 3 CK VDD VDD hvp L=3.0e-07 W=0.3e-06
M2 4 3 VDD VDD hvp L=3.0e-07 W=0.6e-06
M3 5 4 1 VDD hvp L=3.0e-07 W=0.5e-06
M4 6 3 5 VDD hvp L=3.0e-07 W=0.3e-06
M5 VDD RB 6 VDD hvp L=3.0e-07 W=0.3e-06
M6 6 7 VDD VDD hvp L=3.0e-07 W=0.3e-06
M7 7 5 VDD VDD hvp L=3.0e-07 W=0.47e-06
M8 8 3 7 VDD hvp L=3.0e-07 W=0.47e-06
M9 9 4 8 VDD hvp L=3.0e-07 W=0.3e-06
M10 VDD 10 9 VDD hvp L=3.0e-07 W=0.3e-06
M11 10 RB VDD VDD hvp L=3.0e-07 W=0.8e-06
M12 VDD 8 10 VDD hvp L=3.0e-07 W=0.89e-06
M13 Q 10 VDD VDD hvp L=3.0e-07 W=1e-06
M14 VDD 10 Q VDD hvp L=3.0e-07 W=1e-06
M15 Q 10 VDD VDD hvp L=3.0e-07 W=1e-06
M16 VDD 10 Q VDD hvp L=3.0e-07 W=1e-06
M17 Q 10 VDD VDD hvp L=3.0e-07 W=1e-06
M18 VDD 10 Q VDD hvp L=3.0e-07 W=1e-06
M19 GND D 1 GND hvn L=3.5e-07 W=0.65e-06
M20 GND CK 3 GND hvn L=3.5e-07 W=0.6e-06
M21 4 3 GND GND hvn L=3.5e-07 W=0.3e-06
M22 5 3 1 GND hvn L=3.5e-07 W=0.5e-06
M23 6 4 5 GND hvn L=3.5e-07 W=0.3e-06
M24 13 RB 6 GND hvn L=3.5e-07 W=0.3e-06
M25 GND 7 13 GND hvn L=3.5e-07 W=0.3e-06
M26 7 5 GND GND hvn L=3.5e-07 W=0.28e-06
M27 8 4 7 GND hvn L=3.5e-07 W=0.3e-06
M28 14 3 8 GND hvn L=3.5e-07 W=0.3e-06
M29 GND 10 14 GND hvn L=3.5e-07 W=0.3e-06
M30 15 RB GND GND hvn L=3.5e-07 W=0.49e-06
M31 10 8 15 GND hvn L=3.5e-07 W=0.49e-06
M32 Q 10 GND GND hvn L=3.5e-07 W=0.65e-06
M33 GND 10 Q GND hvn L=3.5e-07 W=0.65e-06
M34 Q 10 GND GND hvn L=3.5e-07 W=0.65e-06
M35 GND 10 Q GND hvn L=3.5e-07 W=0.65e-06
M36 Q 10 GND GND hvn L=3.5e-07 W=0.65e-06
M37 GND 10 Q GND hvn L=3.5e-07 W=0.65e-06
.ENDS DFFRBQX6

.SUBCKT DFFRSBQBX1 QB D RB SB CK
M0 VDD D 1 VDD hvp L=3.0e-07 W=1e-06
M1 3 CK VDD VDD hvp L=3.0e-07 W=0.3e-06
M2 4 3 VDD VDD hvp L=3.0e-07 W=0.3e-06
M3 5 4 1 VDD hvp L=3.0e-07 W=0.6e-06
M4 6 3 5 VDD hvp L=3.0e-07 W=0.4e-06
M5 VDD RB 6 VDD hvp L=3.0e-07 W=0.6e-06
M6 6 7 VDD VDD hvp L=3.0e-07 W=0.3e-06
M7 VDD 5 7 VDD hvp L=3.0e-07 W=0.4e-06
M8 7 SB VDD VDD hvp L=3.0e-07 W=0.4e-06
M9 8 3 7 VDD hvp L=3.0e-07 W=0.4e-06
M10 9 4 8 VDD hvp L=3.0e-07 W=0.3e-06
M11 VDD SB 9 VDD hvp L=3.0e-07 W=0.3e-06
M12 VDD 10 9 VDD hvp L=3.0e-07 W=0.3e-06
M13 10 RB VDD VDD hvp L=3.0e-07 W=0.3e-06
M14 VDD 8 10 VDD hvp L=3.0e-07 W=0.3e-06
M15 QB 8 VDD VDD hvp L=3.0e-07 W=1e-06
M16 GND D 1 GND hvn L=3.5e-07 W=0.65e-06
M17 GND CK 3 GND hvn L=3.5e-07 W=0.3e-06
M18 4 3 GND GND hvn L=3.5e-07 W=0.3e-06
M19 5 3 1 GND hvn L=3.5e-07 W=0.3e-06
M20 6 4 5 GND hvn L=3.5e-07 W=0.3e-06
M21 13 RB 6 GND hvn L=3.5e-07 W=0.3e-06
M22 GND 7 13 GND hvn L=3.5e-07 W=0.3e-06
M23 14 5 GND GND hvn L=3.5e-07 W=0.28e-06
M24 7 SB 14 GND hvn L=3.5e-07 W=0.28e-06
M25 8 4 7 GND hvn L=3.5e-07 W=0.28e-06
M26 9 3 8 GND hvn L=3.5e-07 W=0.28e-06
M27 15 SB 9 GND hvn L=3.5e-07 W=0.3e-06
M28 GND 10 15 GND hvn L=3.5e-07 W=0.3e-06
M29 16 RB GND GND hvn L=3.5e-07 W=0.3e-06
M30 10 8 16 GND hvn L=3.5e-07 W=0.3e-06
M31 QB 8 GND GND hvn L=3.5e-07 W=0.65e-06
.ENDS DFFRSBQBX1

.SUBCKT DFFRSBQBX2 QB D RB SB CK
M0 VDD D 1 VDD hvp L=3.0e-07 W=1e-06
M1 3 CK VDD VDD hvp L=3.0e-07 W=0.3e-06
M2 4 3 VDD VDD hvp L=3.0e-07 W=0.3e-06
M3 5 4 1 VDD hvp L=3.0e-07 W=0.6e-06
M4 6 3 5 VDD hvp L=3.0e-07 W=0.4e-06
M5 VDD RB 6 VDD hvp L=3.0e-07 W=0.6e-06
M6 6 7 VDD VDD hvp L=3.0e-07 W=0.3e-06
M7 VDD 5 7 VDD hvp L=3.0e-07 W=0.4e-06
M8 7 SB VDD VDD hvp L=3.0e-07 W=0.4e-06
M9 8 3 7 VDD hvp L=3.0e-07 W=0.4e-06
M10 9 4 8 VDD hvp L=3.0e-07 W=0.3e-06
M11 VDD SB 9 VDD hvp L=3.0e-07 W=0.3e-06
M12 VDD 10 9 VDD hvp L=3.0e-07 W=0.3e-06
M13 10 RB VDD VDD hvp L=3.0e-07 W=0.3e-06
M14 VDD 8 10 VDD hvp L=3.0e-07 W=0.3e-06
M15 QB 8 VDD VDD hvp L=3.0e-07 W=1e-06
M16 VDD 8 QB VDD hvp L=3.0e-07 W=1e-06
M17 GND D 1 GND hvn L=3.5e-07 W=0.65e-06
M18 GND CK 3 GND hvn L=3.5e-07 W=0.3e-06
M19 4 3 GND GND hvn L=3.5e-07 W=0.3e-06
M20 5 3 1 GND hvn L=3.5e-07 W=0.3e-06
M21 6 4 5 GND hvn L=3.5e-07 W=0.3e-06
M22 13 RB 6 GND hvn L=3.5e-07 W=0.3e-06
M23 GND 7 13 GND hvn L=3.5e-07 W=0.3e-06
M24 14 5 GND GND hvn L=3.5e-07 W=0.28e-06
M25 7 SB 14 GND hvn L=3.5e-07 W=0.28e-06
M26 8 4 7 GND hvn L=3.5e-07 W=0.28e-06
M27 9 3 8 GND hvn L=3.5e-07 W=0.28e-06
M28 15 SB 9 GND hvn L=3.5e-07 W=0.3e-06
M29 GND 10 15 GND hvn L=3.5e-07 W=0.3e-06
M30 16 RB GND GND hvn L=3.5e-07 W=0.3e-06
M31 10 8 16 GND hvn L=3.5e-07 W=0.3e-06
M32 QB 8 GND GND hvn L=3.5e-07 W=0.65e-06
M33 GND 8 QB GND hvn L=3.5e-07 W=0.65e-06
.ENDS DFFRSBQBX2

.SUBCKT DFFRSBQBX4 QB D RB SB CK
M0 VDD D 1 VDD hvp L=3.0e-07 W=1e-06
M1 3 CK VDD VDD hvp L=3.0e-07 W=0.3e-06
M2 4 3 VDD VDD hvp L=3.0e-07 W=0.3e-06
M3 5 4 1 VDD hvp L=3.0e-07 W=0.6e-06
M4 6 3 5 VDD hvp L=3.0e-07 W=0.4e-06
M5 VDD RB 6 VDD hvp L=3.0e-07 W=0.6e-06
M6 6 7 VDD VDD hvp L=3.0e-07 W=0.3e-06
M7 VDD 5 7 VDD hvp L=3.0e-07 W=0.4e-06
M8 7 SB VDD VDD hvp L=3.0e-07 W=0.4e-06
M9 8 3 7 VDD hvp L=3.0e-07 W=0.4e-06
M10 9 4 8 VDD hvp L=3.0e-07 W=0.3e-06
M11 VDD SB 9 VDD hvp L=3.0e-07 W=0.3e-06
M12 VDD 10 9 VDD hvp L=3.0e-07 W=0.3e-06
M13 10 RB VDD VDD hvp L=3.0e-07 W=0.3e-06
M14 VDD 8 10 VDD hvp L=3.0e-07 W=0.3e-06
M15 QB 8 VDD VDD hvp L=3.0e-07 W=1e-06
M16 VDD 8 QB VDD hvp L=3.0e-07 W=1e-06
M17 QB 8 VDD VDD hvp L=3.0e-07 W=1e-06
M18 VDD 8 QB VDD hvp L=3.0e-07 W=1e-06
M19 GND D 1 GND hvn L=3.5e-07 W=0.65e-06
M20 GND CK 3 GND hvn L=3.5e-07 W=0.3e-06
M21 4 3 GND GND hvn L=3.5e-07 W=0.3e-06
M22 5 3 1 GND hvn L=3.5e-07 W=0.3e-06
M23 6 4 5 GND hvn L=3.5e-07 W=0.3e-06
M24 13 RB 6 GND hvn L=3.5e-07 W=0.3e-06
M25 GND 7 13 GND hvn L=3.5e-07 W=0.3e-06
M26 14 5 GND GND hvn L=3.5e-07 W=0.28e-06
M27 7 SB 14 GND hvn L=3.5e-07 W=0.28e-06
M28 8 4 7 GND hvn L=3.5e-07 W=0.28e-06
M29 9 3 8 GND hvn L=3.5e-07 W=0.28e-06
M30 15 SB 9 GND hvn L=3.5e-07 W=0.3e-06
M31 GND 10 15 GND hvn L=3.5e-07 W=0.3e-06
M32 16 RB GND GND hvn L=3.5e-07 W=0.3e-06
M33 10 8 16 GND hvn L=3.5e-07 W=0.3e-06
M34 QB 8 GND GND hvn L=3.5e-07 W=0.65e-06
M35 GND 8 QB GND hvn L=3.5e-07 W=0.65e-06
M36 QB 8 GND GND hvn L=3.5e-07 W=0.65e-06
M37 GND 8 QB GND hvn L=3.5e-07 W=0.65e-06
.ENDS DFFRSBQBX4

.SUBCKT DFFRSBQX1 Q D RB SB CK
M0 VDD D 1 VDD hvp L=3.0e-07 W=1e-06
M1 3 CK VDD VDD hvp L=3.0e-07 W=0.3e-06
M2 4 3 VDD VDD hvp L=3.0e-07 W=0.6e-06
M3 5 4 1 VDD hvp L=3.0e-07 W=0.45e-06
M4 6 3 5 VDD hvp L=3.0e-07 W=0.3e-06
M5 VDD RB 6 VDD hvp L=3.0e-07 W=0.3e-06
M6 6 7 VDD VDD hvp L=3.0e-07 W=0.3e-06
M7 VDD 5 7 VDD hvp L=3.0e-07 W=0.36e-06
M8 7 SB VDD VDD hvp L=3.0e-07 W=0.36e-06
M9 8 3 7 VDD hvp L=3.0e-07 W=0.4e-06
M10 9 4 8 VDD hvp L=3.0e-07 W=0.3e-06
M11 VDD SB 9 VDD hvp L=3.0e-07 W=0.3e-06
M12 VDD 10 9 VDD hvp L=3.0e-07 W=0.28e-06
M13 10 RB VDD VDD hvp L=3.0e-07 W=0.5e-06
M14 VDD 8 10 VDD hvp L=3.0e-07 W=0.5e-06
M15 Q 10 VDD VDD hvp L=3.0e-07 W=1e-06
M16 GND D 1 GND hvn L=3.5e-07 W=0.65e-06
M17 GND CK 3 GND hvn L=3.5e-07 W=0.6e-06
M18 4 3 GND GND hvn L=3.5e-07 W=0.3e-06
M19 5 3 1 GND hvn L=3.5e-07 W=0.45e-06
M20 6 4 5 GND hvn L=3.5e-07 W=0.3e-06
M21 13 RB 6 GND hvn L=3.5e-07 W=0.3e-06
M22 GND 7 13 GND hvn L=3.5e-07 W=0.3e-06
M23 14 5 GND GND hvn L=3.5e-07 W=0.28e-06
M24 7 SB 14 GND hvn L=3.5e-07 W=0.28e-06
M25 8 4 7 GND hvn L=3.5e-07 W=0.28e-06
M26 9 3 8 GND hvn L=3.5e-07 W=0.28e-06
M27 15 SB 9 GND hvn L=3.5e-07 W=0.3e-06
M28 GND 10 15 GND hvn L=3.5e-07 W=0.28e-06
M29 16 RB GND GND hvn L=3.5e-07 W=0.3e-06
M30 10 8 16 GND hvn L=3.5e-07 W=0.3e-06
M31 Q 10 GND GND hvn L=3.5e-07 W=0.65e-06
.ENDS DFFRSBQX1

.SUBCKT DFFRSBQX2 Q D RB SB CK
M0 VDD D 1 VDD hvp L=3.0e-07 W=1e-06
M1 3 CK VDD VDD hvp L=3.0e-07 W=0.3e-06
M2 4 3 VDD VDD hvp L=3.0e-07 W=0.6e-06
M3 5 4 1 VDD hvp L=3.0e-07 W=0.45e-06
M4 6 3 5 VDD hvp L=3.0e-07 W=0.3e-06
M5 VDD RB 6 VDD hvp L=3.0e-07 W=0.3e-06
M6 6 7 VDD VDD hvp L=3.0e-07 W=0.3e-06
M7 VDD 5 7 VDD hvp L=3.0e-07 W=0.36e-06
M8 7 SB VDD VDD hvp L=3.0e-07 W=0.36e-06
M9 8 3 7 VDD hvp L=3.0e-07 W=0.4e-06
M10 9 4 8 VDD hvp L=3.0e-07 W=0.3e-06
M11 VDD SB 9 VDD hvp L=3.0e-07 W=0.3e-06
M12 VDD 10 9 VDD hvp L=3.0e-07 W=0.28e-06
M13 10 RB VDD VDD hvp L=3.0e-07 W=0.5e-06
M14 VDD 8 10 VDD hvp L=3.0e-07 W=0.5e-06
M15 Q 10 VDD VDD hvp L=3.0e-07 W=1e-06
M16 VDD 10 Q VDD hvp L=3.0e-07 W=1e-06
M17 GND D 1 GND hvn L=3.5e-07 W=0.65e-06
M18 GND CK 3 GND hvn L=3.5e-07 W=0.6e-06
M19 4 3 GND GND hvn L=3.5e-07 W=0.3e-06
M20 5 3 1 GND hvn L=3.5e-07 W=0.45e-06
M21 6 4 5 GND hvn L=3.5e-07 W=0.3e-06
M22 13 RB 6 GND hvn L=3.5e-07 W=0.3e-06
M23 GND 7 13 GND hvn L=3.5e-07 W=0.3e-06
M24 14 5 GND GND hvn L=3.5e-07 W=0.28e-06
M25 7 SB 14 GND hvn L=3.5e-07 W=0.28e-06
M26 8 4 7 GND hvn L=3.5e-07 W=0.28e-06
M27 9 3 8 GND hvn L=3.5e-07 W=0.28e-06
M28 15 SB 9 GND hvn L=3.5e-07 W=0.3e-06
M29 GND 10 15 GND hvn L=3.5e-07 W=0.28e-06
M30 16 RB GND GND hvn L=3.5e-07 W=0.3e-06
M31 10 8 16 GND hvn L=3.5e-07 W=0.3e-06
M32 Q 10 GND GND hvn L=3.5e-07 W=0.65e-06
M33 GND 10 Q GND hvn L=3.5e-07 W=0.65e-06
.ENDS DFFRSBQX2

.SUBCKT DFFRSBQX4 Q D RB SB CK
M0 VDD D 1 VDD hvp L=3.0e-07 W=1e-06
M1 3 CK VDD VDD hvp L=3.0e-07 W=0.3e-06
M2 4 3 VDD VDD hvp L=3.0e-07 W=0.6e-06
M3 5 4 1 VDD hvp L=3.0e-07 W=0.45e-06
M4 6 3 5 VDD hvp L=3.0e-07 W=0.3e-06
M5 VDD RB 6 VDD hvp L=3.0e-07 W=0.3e-06
M6 6 7 VDD VDD hvp L=3.0e-07 W=0.3e-06
M7 VDD 5 7 VDD hvp L=3.0e-07 W=0.36e-06
M8 7 SB VDD VDD hvp L=3.0e-07 W=0.36e-06
M9 8 3 7 VDD hvp L=3.0e-07 W=0.4e-06
M10 9 4 8 VDD hvp L=3.0e-07 W=0.3e-06
M11 VDD SB 9 VDD hvp L=3.0e-07 W=0.3e-06
M12 VDD 10 9 VDD hvp L=3.0e-07 W=0.28e-06
M13 10 RB VDD VDD hvp L=3.0e-07 W=0.5e-06
M14 VDD 8 10 VDD hvp L=3.0e-07 W=0.5e-06
M15 Q 10 VDD VDD hvp L=3.0e-07 W=1e-06
M16 VDD 10 Q VDD hvp L=3.0e-07 W=1e-06
M17 Q 10 VDD VDD hvp L=3.0e-07 W=1e-06
M18 VDD 10 Q VDD hvp L=3.0e-07 W=1e-06
M19 GND D 1 GND hvn L=3.5e-07 W=0.65e-06
M20 GND CK 3 GND hvn L=3.5e-07 W=0.6e-06
M21 4 3 GND GND hvn L=3.5e-07 W=0.3e-06
M22 5 3 1 GND hvn L=3.5e-07 W=0.45e-06
M23 6 4 5 GND hvn L=3.5e-07 W=0.3e-06
M24 13 RB 6 GND hvn L=3.5e-07 W=0.3e-06
M25 GND 7 13 GND hvn L=3.5e-07 W=0.3e-06
M26 14 5 GND GND hvn L=3.5e-07 W=0.28e-06
M27 7 SB 14 GND hvn L=3.5e-07 W=0.28e-06
M28 8 4 7 GND hvn L=3.5e-07 W=0.28e-06
M29 9 3 8 GND hvn L=3.5e-07 W=0.28e-06
M30 15 SB 9 GND hvn L=3.5e-07 W=0.3e-06
M31 GND 10 15 GND hvn L=3.5e-07 W=0.28e-06
M32 16 RB GND GND hvn L=3.5e-07 W=0.3e-06
M33 10 8 16 GND hvn L=3.5e-07 W=0.3e-06
M34 Q 10 GND GND hvn L=3.5e-07 W=0.65e-06
M35 GND 10 Q GND hvn L=3.5e-07 W=0.65e-06
M36 Q 10 GND GND hvn L=3.5e-07 W=0.65e-06
M37 GND 10 Q GND hvn L=3.5e-07 W=0.65e-06
.ENDS DFFRSBQX4

.SUBCKT DFFSBQBX1 QB D SB CK
M0 VDD D 1 VDD hvp L=3.0e-07 W=1e-06
M1 3 CK VDD VDD hvp L=3.0e-07 W=0.3e-06
M2 4 3 VDD VDD hvp L=3.0e-07 W=0.6e-06
M3 5 4 1 VDD hvp L=3.0e-07 W=0.6e-06
M4 6 3 5 VDD hvp L=3.0e-07 W=0.3e-06
M5 VDD 7 6 VDD hvp L=3.0e-07 W=0.3e-06
M6 VDD 5 7 VDD hvp L=3.0e-07 W=0.6e-06
M7 7 SB VDD VDD hvp L=3.0e-07 W=0.42e-06
M8 8 3 7 VDD hvp L=3.0e-07 W=0.42e-06
M9 9 4 8 VDD hvp L=3.0e-07 W=0.3e-06
M10 VDD SB 9 VDD hvp L=3.0e-07 W=0.3e-06
M11 VDD 10 9 VDD hvp L=3.0e-07 W=0.3e-06
M12 VDD 8 10 VDD hvp L=3.0e-07 W=0.3e-06
M13 QB 8 VDD VDD hvp L=3.0e-07 W=1e-06
M14 GND D 1 GND hvn L=3.5e-07 W=0.65e-06
M15 GND CK 3 GND hvn L=3.5e-07 W=0.6e-06
M16 4 3 GND GND hvn L=3.5e-07 W=0.3e-06
M17 5 3 1 GND hvn L=3.5e-07 W=0.6e-06
M18 13 4 5 GND hvn L=3.5e-07 W=0.3e-06
M19 GND 7 13 GND hvn L=3.5e-07 W=0.3e-06
M20 14 5 GND GND hvn L=3.5e-07 W=0.3e-06
M21 7 SB 14 GND hvn L=3.5e-07 W=0.28e-06
M22 8 4 7 GND hvn L=3.5e-07 W=0.28e-06
M23 9 3 8 GND hvn L=3.5e-07 W=0.3e-06
M24 15 SB 9 GND hvn L=3.5e-07 W=0.3e-06
M25 GND 10 15 GND hvn L=3.5e-07 W=0.3e-06
M26 GND 8 10 GND hvn L=3.5e-07 W=0.3e-06
M27 QB 8 GND GND hvn L=3.5e-07 W=0.65e-06
.ENDS DFFSBQBX1

.SUBCKT DFFSBQBX2 QB D SB CK
M0 VDD D 1 VDD hvp L=3.0e-07 W=1e-06
M1 3 CK VDD VDD hvp L=3.0e-07 W=0.3e-06
M2 4 3 VDD VDD hvp L=3.0e-07 W=0.6e-06
M3 5 4 1 VDD hvp L=3.0e-07 W=0.6e-06
M4 6 3 5 VDD hvp L=3.0e-07 W=0.3e-06
M5 VDD 7 6 VDD hvp L=3.0e-07 W=0.3e-06
M6 VDD 5 7 VDD hvp L=3.0e-07 W=0.6e-06
M7 7 SB VDD VDD hvp L=3.0e-07 W=0.42e-06
M8 8 3 7 VDD hvp L=3.0e-07 W=0.42e-06
M9 9 4 8 VDD hvp L=3.0e-07 W=0.3e-06
M10 VDD SB 9 VDD hvp L=3.0e-07 W=0.3e-06
M11 VDD 10 9 VDD hvp L=3.0e-07 W=0.3e-06
M12 VDD 8 10 VDD hvp L=3.0e-07 W=0.3e-06
M13 QB 8 VDD VDD hvp L=3.0e-07 W=1e-06
M14 VDD 8 QB VDD hvp L=3.0e-07 W=1e-06
M15 GND D 1 GND hvn L=3.5e-07 W=0.65e-06
M16 GND CK 3 GND hvn L=3.5e-07 W=0.6e-06
M17 4 3 GND GND hvn L=3.5e-07 W=0.3e-06
M18 5 3 1 GND hvn L=3.5e-07 W=0.6e-06
M19 13 4 5 GND hvn L=3.5e-07 W=0.3e-06
M20 GND 7 13 GND hvn L=3.5e-07 W=0.3e-06
M21 14 5 GND GND hvn L=3.5e-07 W=0.3e-06
M22 7 SB 14 GND hvn L=3.5e-07 W=0.28e-06
M23 8 4 7 GND hvn L=3.5e-07 W=0.28e-06
M24 9 3 8 GND hvn L=3.5e-07 W=0.3e-06
M25 15 SB 9 GND hvn L=3.5e-07 W=0.3e-06
M26 GND 10 15 GND hvn L=3.5e-07 W=0.3e-06
M27 GND 8 10 GND hvn L=3.5e-07 W=0.3e-06
M28 QB 8 GND GND hvn L=3.5e-07 W=0.65e-06
M29 GND 8 QB GND hvn L=3.5e-07 W=0.65e-06
.ENDS DFFSBQBX2

.SUBCKT DFFSBQBX4 QB D SB CK
M0 VDD D 1 VDD hvp L=3.0e-07 W=1e-06
M1 3 CK VDD VDD hvp L=3.0e-07 W=0.3e-06
M2 4 3 VDD VDD hvp L=3.0e-07 W=0.6e-06
M3 5 4 1 VDD hvp L=3.0e-07 W=0.6e-06
M4 6 3 5 VDD hvp L=3.0e-07 W=0.3e-06
M5 VDD 7 6 VDD hvp L=3.0e-07 W=0.3e-06
M6 VDD 5 7 VDD hvp L=3.0e-07 W=0.6e-06
M7 7 SB VDD VDD hvp L=3.0e-07 W=0.42e-06
M8 8 3 7 VDD hvp L=3.0e-07 W=0.42e-06
M9 9 4 8 VDD hvp L=3.0e-07 W=0.3e-06
M10 VDD SB 9 VDD hvp L=3.0e-07 W=0.3e-06
M11 VDD 10 9 VDD hvp L=3.0e-07 W=0.3e-06
M12 VDD 8 10 VDD hvp L=3.0e-07 W=0.3e-06
M13 QB 8 VDD VDD hvp L=3.0e-07 W=1e-06
M14 VDD 8 QB VDD hvp L=3.0e-07 W=1e-06
M15 QB 8 VDD VDD hvp L=3.0e-07 W=1e-06
M16 VDD 8 QB VDD hvp L=3.0e-07 W=1e-06
M17 GND D 1 GND hvn L=3.5e-07 W=0.65e-06
M18 GND CK 3 GND hvn L=3.5e-07 W=0.6e-06
M19 4 3 GND GND hvn L=3.5e-07 W=0.3e-06
M20 5 3 1 GND hvn L=3.5e-07 W=0.6e-06
M21 13 4 5 GND hvn L=3.5e-07 W=0.3e-06
M22 GND 7 13 GND hvn L=3.5e-07 W=0.3e-06
M23 14 5 GND GND hvn L=3.5e-07 W=0.3e-06
M24 7 SB 14 GND hvn L=3.5e-07 W=0.28e-06
M25 8 4 7 GND hvn L=3.5e-07 W=0.28e-06
M26 9 3 8 GND hvn L=3.5e-07 W=0.3e-06
M27 15 SB 9 GND hvn L=3.5e-07 W=0.3e-06
M28 GND 10 15 GND hvn L=3.5e-07 W=0.3e-06
M29 GND 8 10 GND hvn L=3.5e-07 W=0.3e-06
M30 QB 8 GND GND hvn L=3.5e-07 W=0.65e-06
M31 GND 8 QB GND hvn L=3.5e-07 W=0.65e-06
M32 QB 8 GND GND hvn L=3.5e-07 W=0.65e-06
M33 GND 8 QB GND hvn L=3.5e-07 W=0.65e-06
.ENDS DFFSBQBX4

.SUBCKT DFFSBQX1 Q D SB CK
M0 VDD D 1 VDD hvp L=3.0e-07 W=1e-06
M1 3 CK VDD VDD hvp L=3.0e-07 W=0.3e-06
M2 4 3 VDD VDD hvp L=3.0e-07 W=0.6e-06
M3 5 4 1 VDD hvp L=3.0e-07 W=0.6e-06
M4 6 3 5 VDD hvp L=3.0e-07 W=0.3e-06
M5 VDD 7 6 VDD hvp L=3.0e-07 W=0.3e-06
M6 VDD 5 7 VDD hvp L=3.0e-07 W=0.6e-06
M7 7 SB VDD VDD hvp L=3.0e-07 W=0.42e-06
M8 8 3 7 VDD hvp L=3.0e-07 W=0.42e-06
M9 9 4 8 VDD hvp L=3.0e-07 W=0.3e-06
M10 VDD SB 9 VDD hvp L=3.0e-07 W=0.3e-06
M11 VDD 10 9 VDD hvp L=3.0e-07 W=0.3e-06
M12 VDD 8 10 VDD hvp L=3.0e-07 W=0.7e-06
M13 Q 10 VDD VDD hvp L=3.0e-07 W=1e-06
M14 GND D 1 GND hvn L=3.5e-07 W=0.65e-06
M15 GND CK 3 GND hvn L=3.5e-07 W=0.6e-06
M16 4 3 GND GND hvn L=3.5e-07 W=0.3e-06
M17 5 3 1 GND hvn L=3.5e-07 W=0.6e-06
M18 13 4 5 GND hvn L=3.5e-07 W=0.3e-06
M19 GND 7 13 GND hvn L=3.5e-07 W=0.3e-06
M20 14 5 GND GND hvn L=3.5e-07 W=0.3e-06
M21 7 SB 14 GND hvn L=3.5e-07 W=0.28e-06
M22 8 4 7 GND hvn L=3.5e-07 W=0.28e-06
M23 9 3 8 GND hvn L=3.5e-07 W=0.3e-06
M24 15 SB 9 GND hvn L=3.5e-07 W=0.3e-06
M25 GND 10 15 GND hvn L=3.5e-07 W=0.3e-06
M26 GND 8 10 GND hvn L=3.5e-07 W=0.6e-06
M27 Q 10 GND GND hvn L=3.5e-07 W=0.65e-06
.ENDS DFFSBQX1

.SUBCKT DFFSBQX2 Q D SB CK
M0 VDD D 1 VDD hvp L=3.0e-07 W=1e-06
M1 3 CK VDD VDD hvp L=3.0e-07 W=0.3e-06
M2 4 3 VDD VDD hvp L=3.0e-07 W=0.6e-06
M3 5 4 1 VDD hvp L=3.0e-07 W=0.6e-06
M4 6 3 5 VDD hvp L=3.0e-07 W=0.3e-06
M5 VDD 7 6 VDD hvp L=3.0e-07 W=0.3e-06
M6 VDD 5 7 VDD hvp L=3.0e-07 W=0.6e-06
M7 7 SB VDD VDD hvp L=3.0e-07 W=0.42e-06
M8 8 3 7 VDD hvp L=3.0e-07 W=0.42e-06
M9 9 4 8 VDD hvp L=3.0e-07 W=0.3e-06
M10 VDD SB 9 VDD hvp L=3.0e-07 W=0.3e-06
M11 VDD 10 9 VDD hvp L=3.0e-07 W=0.3e-06
M12 VDD 8 10 VDD hvp L=3.0e-07 W=0.7e-06
M13 Q 10 VDD VDD hvp L=3.0e-07 W=1e-06
M14 VDD 10 Q VDD hvp L=3.0e-07 W=1e-06
M15 GND D 1 GND hvn L=3.5e-07 W=0.65e-06
M16 GND CK 3 GND hvn L=3.5e-07 W=0.6e-06
M17 4 3 GND GND hvn L=3.5e-07 W=0.3e-06
M18 5 3 1 GND hvn L=3.5e-07 W=0.6e-06
M19 13 4 5 GND hvn L=3.5e-07 W=0.3e-06
M20 GND 7 13 GND hvn L=3.5e-07 W=0.3e-06
M21 14 5 GND GND hvn L=3.5e-07 W=0.3e-06
M22 7 SB 14 GND hvn L=3.5e-07 W=0.28e-06
M23 8 4 7 GND hvn L=3.5e-07 W=0.28e-06
M24 9 3 8 GND hvn L=3.5e-07 W=0.3e-06
M25 15 SB 9 GND hvn L=3.5e-07 W=0.3e-06
M26 GND 10 15 GND hvn L=3.5e-07 W=0.3e-06
M27 GND 8 10 GND hvn L=3.5e-07 W=0.6e-06
M28 Q 10 GND GND hvn L=3.5e-07 W=0.65e-06
M29 GND 10 Q GND hvn L=3.5e-07 W=0.65e-06
.ENDS DFFSBQX2

.SUBCKT DFFSBQX4 Q D SB CK
M0 VDD D 1 VDD hvp L=3.0e-07 W=1e-06
M1 3 CK VDD VDD hvp L=3.0e-07 W=0.3e-06
M2 4 3 VDD VDD hvp L=3.0e-07 W=0.6e-06
M3 5 4 1 VDD hvp L=3.0e-07 W=0.6e-06
M4 6 3 5 VDD hvp L=3.0e-07 W=0.3e-06
M5 VDD 7 6 VDD hvp L=3.0e-07 W=0.3e-06
M6 VDD 5 7 VDD hvp L=3.0e-07 W=0.6e-06
M7 7 SB VDD VDD hvp L=3.0e-07 W=0.42e-06
M8 8 3 7 VDD hvp L=3.0e-07 W=0.42e-06
M9 9 4 8 VDD hvp L=3.0e-07 W=0.3e-06
M10 VDD SB 9 VDD hvp L=3.0e-07 W=0.3e-06
M11 VDD 10 9 VDD hvp L=3.0e-07 W=0.3e-06
M12 VDD 8 10 VDD hvp L=3.0e-07 W=0.7e-06
M13 Q 10 VDD VDD hvp L=3.0e-07 W=1e-06
M14 VDD 10 Q VDD hvp L=3.0e-07 W=1e-06
M15 Q 10 VDD VDD hvp L=3.0e-07 W=1e-06
M16 VDD 10 Q VDD hvp L=3.0e-07 W=1e-06
M17 GND D 1 GND hvn L=3.5e-07 W=0.65e-06
M18 GND CK 3 GND hvn L=3.5e-07 W=0.6e-06
M19 4 3 GND GND hvn L=3.5e-07 W=0.3e-06
M20 5 3 1 GND hvn L=3.5e-07 W=0.6e-06
M21 13 4 5 GND hvn L=3.5e-07 W=0.3e-06
M22 GND 7 13 GND hvn L=3.5e-07 W=0.3e-06
M23 14 5 GND GND hvn L=3.5e-07 W=0.3e-06
M24 7 SB 14 GND hvn L=3.5e-07 W=0.28e-06
M25 8 4 7 GND hvn L=3.5e-07 W=0.28e-06
M26 9 3 8 GND hvn L=3.5e-07 W=0.3e-06
M27 15 SB 9 GND hvn L=3.5e-07 W=0.3e-06
M28 GND 10 15 GND hvn L=3.5e-07 W=0.3e-06
M29 GND 8 10 GND hvn L=3.5e-07 W=0.6e-06
M30 Q 10 GND GND hvn L=3.5e-07 W=0.65e-06
M31 GND 10 Q GND hvn L=3.5e-07 W=0.65e-06
M32 Q 10 GND GND hvn L=3.5e-07 W=0.65e-06
M33 GND 10 Q GND hvn L=3.5e-07 W=0.65e-06
.ENDS DFFSBQX4

.SUBCKT DLATCHQX1 Q D CL
M0 VDD D 1 VDD hvp L=3.0e-07 W=1e-06
M1 3 CL VDD VDD hvp L=3.0e-07 W=0.3e-06
M2 4 3 VDD VDD hvp L=3.0e-07 W=0.6e-06
M3 5 3 1 VDD hvp L=3.0e-07 W=0.6e-06
M4 6 4 5 VDD hvp L=3.0e-07 W=0.3e-06
M5 VDD 7 6 VDD hvp L=3.0e-07 W=0.3e-06
M6 7 5 VDD VDD hvp L=3.0e-07 W=0.3e-06
M7 Q 5 VDD VDD hvp L=3.0e-07 W=1e-06
M8 GND D 1 GND hvn L=3.5e-07 W=0.65e-06
M9 GND CL 3 GND hvn L=3.5e-07 W=0.6e-06
M10 4 3 GND GND hvn L=3.5e-07 W=0.3e-06
M11 5 4 1 GND hvn L=3.5e-07 W=0.6e-06
M12 10 3 5 GND hvn L=3.5e-07 W=0.3e-06
M13 GND 7 10 GND hvn L=3.5e-07 W=0.3e-06
M14 7 5 GND GND hvn L=3.5e-07 W=0.3e-06
M15 Q 5 GND GND hvn L=3.5e-07 W=0.65e-06
.ENDS DLATCHQX1

.SUBCKT DLATCHQX2 Q D CL
M0 VDD D 1 VDD hvp L=3.0e-07 W=1e-06
M1 3 CL VDD VDD hvp L=3.0e-07 W=0.3e-06
M2 4 3 VDD VDD hvp L=3.0e-07 W=0.6e-06
M3 5 3 1 VDD hvp L=3.0e-07 W=0.6e-06
M4 6 4 5 VDD hvp L=3.0e-07 W=0.3e-06
M5 VDD 7 6 VDD hvp L=3.0e-07 W=0.3e-06
M6 7 5 VDD VDD hvp L=3.0e-07 W=0.3e-06
M7 Q 5 VDD VDD hvp L=3.0e-07 W=1e-06
M8 VDD 5 Q VDD hvp L=3.0e-07 W=1e-06
M9 GND D 1 GND hvn L=3.5e-07 W=0.65e-06
M10 GND CL 3 GND hvn L=3.5e-07 W=0.6e-06
M11 4 3 GND GND hvn L=3.5e-07 W=0.3e-06
M12 5 4 1 GND hvn L=3.5e-07 W=0.6e-06
M13 10 3 5 GND hvn L=3.5e-07 W=0.3e-06
M14 GND 7 10 GND hvn L=3.5e-07 W=0.3e-06
M15 7 5 GND GND hvn L=3.5e-07 W=0.3e-06
M16 Q 5 GND GND hvn L=3.5e-07 W=0.65e-06
M17 GND 5 Q GND hvn L=3.5e-07 W=0.65e-06
.ENDS DLATCHQX2

.SUBCKT DLATCHQX4 Q D CL
M0 VDD D 1 VDD hvp L=3.0e-07 W=1e-06
M1 3 CL VDD VDD hvp L=3.0e-07 W=0.3e-06
M2 4 3 VDD VDD hvp L=3.0e-07 W=0.6e-06
M3 5 3 1 VDD hvp L=3.0e-07 W=0.6e-06
M4 6 4 5 VDD hvp L=3.0e-07 W=0.3e-06
M5 VDD 7 6 VDD hvp L=3.0e-07 W=0.3e-06
M6 7 5 VDD VDD hvp L=3.0e-07 W=0.3e-06
M7 Q 5 VDD VDD hvp L=3.0e-07 W=1e-06
M8 VDD 5 Q VDD hvp L=3.0e-07 W=1e-06
M9 Q 5 VDD VDD hvp L=3.0e-07 W=1e-06
M10 VDD 5 Q VDD hvp L=3.0e-07 W=1e-06
M11 GND D 1 GND hvn L=3.5e-07 W=0.65e-06
M12 GND CL 3 GND hvn L=3.5e-07 W=0.6e-06
M13 4 3 GND GND hvn L=3.5e-07 W=0.3e-06
M14 5 4 1 GND hvn L=3.5e-07 W=0.6e-06
M15 10 3 5 GND hvn L=3.5e-07 W=0.3e-06
M16 GND 7 10 GND hvn L=3.5e-07 W=0.3e-06
M17 7 5 GND GND hvn L=3.5e-07 W=0.3e-06
M18 Q 5 GND GND hvn L=3.5e-07 W=0.65e-06
M19 GND 5 Q GND hvn L=3.5e-07 W=0.65e-06
M20 Q 5 GND GND hvn L=3.5e-07 W=0.65e-06
M21 GND 5 Q GND hvn L=3.5e-07 W=0.65e-06
.ENDS DLATCHQX4

.SUBCKT DLATCHRBQX1 Q D RB CL
M0 VDD D 1 VDD hvp L=3.0e-07 W=0.44e-06
M1 3 RB VDD VDD hvp L=3.0e-07 W=0.49e-06
M2 VDD CL 4 VDD hvp L=3.0e-07 W=0.3e-06
M3 5 4 VDD VDD hvp L=3.0e-07 W=0.6e-06
M4 3 4 1 VDD hvp L=3.0e-07 W=0.8e-06
M5 6 5 3 VDD hvp L=3.0e-07 W=0.3e-06
M6 VDD 7 6 VDD hvp L=4.5e-07 W=0.3e-06
M7 7 3 VDD VDD hvp L=3.0e-07 W=0.3e-06
M8 Q 3 VDD VDD hvp L=3.0e-07 W=1e-06
M9 9 D 1 GND hvn L=3.5e-07 W=0.28e-06
M10 GND RB 9 GND hvn L=3.5e-07 W=0.28e-06
M11 GND CL 4 GND hvn L=3.5e-07 W=0.65e-06
M12 5 4 GND GND hvn L=3.5e-07 W=0.3e-06
M13 3 5 1 GND hvn L=3.5e-07 W=0.35e-06
M14 11 4 3 GND hvn L=3.5e-07 W=0.3e-06
M15 GND 7 11 GND hvn L=4.5e-07 W=0.3e-06
M16 7 3 GND GND hvn L=3.5e-07 W=0.3e-06
M17 Q 3 GND GND hvn L=3.5e-07 W=0.65e-06
.ENDS DLATCHRBQX1

.SUBCKT DLATCHRBQX2 Q D RB CL
M0 VDD D 1 VDD hvp L=3.0e-07 W=0.44e-06
M1 3 RB VDD VDD hvp L=3.0e-07 W=0.49e-06
M2 VDD CL 4 VDD hvp L=3.0e-07 W=0.3e-06
M3 5 4 VDD VDD hvp L=3.0e-07 W=0.6e-06
M4 3 4 1 VDD hvp L=3.0e-07 W=0.8e-06
M5 6 5 3 VDD hvp L=3.0e-07 W=0.3e-06
M6 VDD 7 6 VDD hvp L=4.5e-07 W=0.3e-06
M7 7 3 VDD VDD hvp L=3.0e-07 W=0.3e-06
M8 Q 3 VDD VDD hvp L=3.0e-07 W=1e-06
M9 VDD 3 Q VDD hvp L=3.0e-07 W=1e-06
M10 9 D 1 GND hvn L=3.5e-07 W=0.28e-06
M11 GND RB 9 GND hvn L=3.5e-07 W=0.28e-06
M12 GND CL 4 GND hvn L=3.5e-07 W=0.65e-06
M13 5 4 GND GND hvn L=3.5e-07 W=0.3e-06
M14 3 5 1 GND hvn L=3.5e-07 W=0.35e-06
M15 11 4 3 GND hvn L=3.5e-07 W=0.3e-06
M16 GND 7 11 GND hvn L=4.5e-07 W=0.3e-06
M17 7 3 GND GND hvn L=3.5e-07 W=0.3e-06
M18 Q 3 GND GND hvn L=3.5e-07 W=0.65e-06
M19 GND 3 Q GND hvn L=3.5e-07 W=0.65e-06
.ENDS DLATCHRBQX2

.SUBCKT DLATCHRBQX4 Q D RB CL
M0 VDD D 1 VDD hvp L=3.0e-07 W=0.44e-06
M1 3 RB VDD VDD hvp L=3.0e-07 W=0.49e-06
M2 VDD CL 4 VDD hvp L=3.0e-07 W=0.3e-06
M3 5 4 VDD VDD hvp L=3.0e-07 W=0.6e-06
M4 3 4 1 VDD hvp L=3.0e-07 W=0.8e-06
M5 6 5 3 VDD hvp L=3.0e-07 W=0.3e-06
M6 VDD 7 6 VDD hvp L=4.5e-07 W=0.3e-06
M7 7 3 VDD VDD hvp L=3.0e-07 W=0.3e-06
M8 Q 3 VDD VDD hvp L=3.0e-07 W=1e-06
M9 VDD 3 Q VDD hvp L=3.0e-07 W=1e-06
M10 Q 3 VDD VDD hvp L=3.0e-07 W=1e-06
M11 VDD 3 Q VDD hvp L=3.0e-07 W=1e-06
M12 9 D 1 GND hvn L=3.5e-07 W=0.28e-06
M13 GND RB 9 GND hvn L=3.5e-07 W=0.28e-06
M14 GND CL 4 GND hvn L=3.5e-07 W=0.65e-06
M15 5 4 GND GND hvn L=3.5e-07 W=0.3e-06
M16 3 5 1 GND hvn L=3.5e-07 W=0.35e-06
M17 11 4 3 GND hvn L=3.5e-07 W=0.3e-06
M18 GND 7 11 GND hvn L=4.5e-07 W=0.3e-06
M19 7 3 GND GND hvn L=3.5e-07 W=0.3e-06
M20 Q 3 GND GND hvn L=3.5e-07 W=0.65e-06
M21 GND 3 Q GND hvn L=3.5e-07 W=0.65e-06
M22 Q 3 GND GND hvn L=3.5e-07 W=0.65e-06
M23 GND 3 Q GND hvn L=3.5e-07 W=0.65e-06
.ENDS DLATCHRBQX4

.SUBCKT DLATCHRBX1 Q QB D RB CL
M0 VDD D 1 VDD hvp L=3.0e-07 W=0.44e-06
M1 3 RB VDD VDD hvp L=3.0e-07 W=0.49e-06
M2 VDD CL 4 VDD hvp L=3.0e-07 W=0.3e-06
M3 5 4 VDD VDD hvp L=3.0e-07 W=0.6e-06
M4 3 4 1 VDD hvp L=3.0e-07 W=0.8e-06
M5 6 5 3 VDD hvp L=3.0e-07 W=0.3e-06
M6 VDD 7 6 VDD hvp L=4.5e-07 W=0.3e-06
M7 7 3 VDD VDD hvp L=3.0e-07 W=0.3e-06
M8 VDD 3 Q VDD hvp L=3.0e-07 W=1e-06
M9 QB 7 VDD VDD hvp L=3.0e-07 W=1e-06
M10 10 D 1 GND hvn L=3.5e-07 W=0.28e-06
M11 GND RB 10 GND hvn L=3.5e-07 W=0.28e-06
M12 GND CL 4 GND hvn L=3.5e-07 W=0.65e-06
M13 5 4 GND GND hvn L=3.5e-07 W=0.3e-06
M14 3 5 1 GND hvn L=3.5e-07 W=0.35e-06
M15 12 4 3 GND hvn L=3.5e-07 W=0.3e-06
M16 GND 7 12 GND hvn L=4.5e-07 W=0.3e-06
M17 7 3 GND GND hvn L=3.5e-07 W=0.3e-06
M18 GND 3 Q GND hvn L=3.5e-07 W=0.65e-06
M19 QB 7 GND GND hvn L=3.5e-07 W=0.65e-06
.ENDS DLATCHRBX1

.SUBCKT DLATCHRBX2 Q QB D RB CL
M0 VDD D 1 VDD hvp L=3.0e-07 W=0.44e-06
M1 3 RB VDD VDD hvp L=3.0e-07 W=0.49e-06
M2 VDD CL 4 VDD hvp L=3.0e-07 W=0.3e-06
M3 5 4 VDD VDD hvp L=3.0e-07 W=0.6e-06
M4 3 4 1 VDD hvp L=3.0e-07 W=0.8e-06
M5 6 5 3 VDD hvp L=3.0e-07 W=0.3e-06
M6 VDD 7 6 VDD hvp L=4.5e-07 W=0.3e-06
M7 7 3 VDD VDD hvp L=3.0e-07 W=0.3e-06
M8 Q 3 VDD VDD hvp L=3.0e-07 W=1e-06
M9 VDD 3 Q VDD hvp L=3.0e-07 W=1e-06
M10 QB 7 VDD VDD hvp L=3.0e-07 W=1e-06
M11 VDD 7 QB VDD hvp L=3.0e-07 W=1e-06
M12 10 D 1 GND hvn L=3.5e-07 W=0.28e-06
M13 GND RB 10 GND hvn L=3.5e-07 W=0.28e-06
M14 GND CL 4 GND hvn L=3.5e-07 W=0.65e-06
M15 5 4 GND GND hvn L=3.5e-07 W=0.3e-06
M16 3 5 1 GND hvn L=3.5e-07 W=0.35e-06
M17 12 4 3 GND hvn L=3.5e-07 W=0.3e-06
M18 GND 7 12 GND hvn L=4.5e-07 W=0.3e-06
M19 7 3 GND GND hvn L=3.5e-07 W=0.3e-06
M20 Q 3 GND GND hvn L=3.5e-07 W=0.65e-06
M21 GND 3 Q GND hvn L=3.5e-07 W=0.65e-06
M22 QB 7 GND GND hvn L=3.5e-07 W=0.65e-06
M23 GND 7 QB GND hvn L=3.5e-07 W=0.65e-06
.ENDS DLATCHRBX2

.SUBCKT DLATCHRBX4 Q QB D RB CL
M0 VDD D 1 VDD hvp L=3.0e-07 W=0.44e-06
M1 3 RB VDD VDD hvp L=3.0e-07 W=0.49e-06
M2 VDD CL 4 VDD hvp L=3.0e-07 W=0.3e-06
M3 5 4 VDD VDD hvp L=3.0e-07 W=0.6e-06
M4 3 4 1 VDD hvp L=3.0e-07 W=0.8e-06
M5 6 5 3 VDD hvp L=3.0e-07 W=0.3e-06
M6 VDD 7 6 VDD hvp L=4.5e-07 W=0.3e-06
M7 7 3 VDD VDD hvp L=3.0e-07 W=0.3e-06
M8 Q 3 VDD VDD hvp L=3.0e-07 W=1e-06
M9 VDD 3 Q VDD hvp L=3.0e-07 W=1e-06
M10 Q 3 VDD VDD hvp L=3.0e-07 W=1e-06
M11 VDD 3 Q VDD hvp L=3.0e-07 W=1e-06
M12 QB 7 VDD VDD hvp L=3.0e-07 W=1e-06
M13 VDD 7 QB VDD hvp L=3.0e-07 W=1e-06
M14 QB 7 VDD VDD hvp L=3.0e-07 W=1e-06
M15 VDD 7 QB VDD hvp L=3.0e-07 W=1e-06
M16 10 D 1 GND hvn L=3.5e-07 W=0.28e-06
M17 GND RB 10 GND hvn L=3.5e-07 W=0.28e-06
M18 GND CL 4 GND hvn L=3.5e-07 W=0.65e-06
M19 5 4 GND GND hvn L=3.5e-07 W=0.3e-06
M20 3 5 1 GND hvn L=3.5e-07 W=0.35e-06
M21 12 4 3 GND hvn L=3.5e-07 W=0.3e-06
M22 GND 7 12 GND hvn L=4.5e-07 W=0.3e-06
M23 7 3 GND GND hvn L=3.5e-07 W=0.3e-06
M24 Q 3 GND GND hvn L=3.5e-07 W=0.65e-06
M25 GND 3 Q GND hvn L=3.5e-07 W=0.65e-06
M26 Q 3 GND GND hvn L=3.5e-07 W=0.65e-06
M27 GND 3 Q GND hvn L=3.5e-07 W=0.65e-06
M28 QB 7 GND GND hvn L=3.5e-07 W=0.65e-06
M29 GND 7 QB GND hvn L=3.5e-07 W=0.65e-06
M30 QB 7 GND GND hvn L=3.5e-07 W=0.65e-06
M31 GND 7 QB GND hvn L=3.5e-07 W=0.65e-06
.ENDS DLATCHRBX4

.SUBCKT DLATCHSTQX1 Q D ST CL
M0 2 D 1 VDD hvp L=3.0e-07 W=0.44e-06
M1 VDD ST 2 VDD hvp L=3.0e-07 W=0.44e-06
M2 VDD CL 4 VDD hvp L=3.0e-07 W=0.3e-06
M3 5 4 VDD VDD hvp L=3.0e-07 W=0.65e-06
M4 6 4 1 VDD hvp L=3.0e-07 W=0.8e-06
M5 7 5 6 VDD hvp L=3.0e-07 W=0.3e-06
M6 VDD 8 7 VDD hvp L=4.5e-07 W=0.3e-06
M7 8 6 VDD VDD hvp L=3.0e-07 W=0.3e-06
M8 Q 6 VDD VDD hvp L=3.0e-07 W=1e-06
M9 GND D 1 GND hvn L=3.5e-07 W=0.28e-06
M10 6 ST GND GND hvn L=3.5e-07 W=0.28e-06
M11 GND CL 4 GND hvn L=3.5e-07 W=0.65e-06
M12 5 4 GND GND hvn L=3.5e-07 W=0.3e-06
M13 6 5 1 GND hvn L=3.5e-07 W=0.35e-06
M14 11 4 6 GND hvn L=3.5e-07 W=0.3e-06
M15 GND 8 11 GND hvn L=4.5e-07 W=0.3e-06
M16 8 6 GND GND hvn L=3.5e-07 W=0.3e-06
M17 Q 6 GND GND hvn L=3.5e-07 W=0.65e-06
.ENDS DLATCHSTQX1

.SUBCKT DLATCHSTQX2 Q D ST CL
M0 2 D 1 VDD hvp L=3.0e-07 W=0.44e-06
M1 VDD ST 2 VDD hvp L=3.0e-07 W=0.44e-06
M2 VDD CL 4 VDD hvp L=3.0e-07 W=0.3e-06
M3 5 4 VDD VDD hvp L=3.0e-07 W=0.65e-06
M4 6 4 1 VDD hvp L=3.0e-07 W=0.8e-06
M5 7 5 6 VDD hvp L=3.0e-07 W=0.3e-06
M6 VDD 8 7 VDD hvp L=4.5e-07 W=0.3e-06
M7 8 6 VDD VDD hvp L=3.0e-07 W=0.3e-06
M8 Q 6 VDD VDD hvp L=3.0e-07 W=1e-06
M9 VDD 6 Q VDD hvp L=3.0e-07 W=1e-06
M10 GND D 1 GND hvn L=3.5e-07 W=0.28e-06
M11 6 ST GND GND hvn L=3.5e-07 W=0.28e-06
M12 GND CL 4 GND hvn L=3.5e-07 W=0.65e-06
M13 5 4 GND GND hvn L=3.5e-07 W=0.3e-06
M14 6 5 1 GND hvn L=3.5e-07 W=0.35e-06
M15 11 4 6 GND hvn L=3.5e-07 W=0.3e-06
M16 GND 8 11 GND hvn L=4.5e-07 W=0.3e-06
M17 8 6 GND GND hvn L=3.5e-07 W=0.3e-06
M18 Q 6 GND GND hvn L=3.5e-07 W=0.65e-06
M19 GND 6 Q GND hvn L=3.5e-07 W=0.65e-06
.ENDS DLATCHSTQX2

.SUBCKT DLATCHSTQX4 Q D ST CL
M0 2 D 1 VDD hvp L=3.0e-07 W=0.44e-06
M1 VDD ST 2 VDD hvp L=3.0e-07 W=0.44e-06
M2 VDD CL 4 VDD hvp L=3.0e-07 W=0.3e-06
M3 5 4 VDD VDD hvp L=3.0e-07 W=0.65e-06
M4 6 4 1 VDD hvp L=3.0e-07 W=0.8e-06
M5 7 5 6 VDD hvp L=3.0e-07 W=0.3e-06
M6 VDD 8 7 VDD hvp L=4.5e-07 W=0.3e-06
M7 8 6 VDD VDD hvp L=3.0e-07 W=0.3e-06
M8 Q 6 VDD VDD hvp L=3.0e-07 W=1e-06
M9 VDD 6 Q VDD hvp L=3.0e-07 W=1e-06
M10 Q 6 VDD VDD hvp L=3.0e-07 W=1e-06
M11 VDD 6 Q VDD hvp L=3.0e-07 W=1e-06
M12 GND D 1 GND hvn L=3.5e-07 W=0.28e-06
M13 6 ST GND GND hvn L=3.5e-07 W=0.28e-06
M14 GND CL 4 GND hvn L=3.5e-07 W=0.65e-06
M15 5 4 GND GND hvn L=3.5e-07 W=0.3e-06
M16 6 5 1 GND hvn L=3.5e-07 W=0.35e-06
M17 11 4 6 GND hvn L=3.5e-07 W=0.3e-06
M18 GND 8 11 GND hvn L=4.5e-07 W=0.3e-06
M19 8 6 GND GND hvn L=3.5e-07 W=0.3e-06
M20 Q 6 GND GND hvn L=3.5e-07 W=0.65e-06
M21 GND 6 Q GND hvn L=3.5e-07 W=0.65e-06
M22 Q 6 GND GND hvn L=3.5e-07 W=0.65e-06
M23 GND 6 Q GND hvn L=3.5e-07 W=0.65e-06
.ENDS DLATCHSTQX4

.SUBCKT DLATCHSTX1 Q QB D ST CL
M0 2 D 1 VDD hvp L=3.0e-07 W=0.44e-06
M1 VDD ST 2 VDD hvp L=3.0e-07 W=0.44e-06
M2 VDD CL 4 VDD hvp L=3.0e-07 W=0.3e-06
M3 5 4 VDD VDD hvp L=3.0e-07 W=0.65e-06
M4 6 4 1 VDD hvp L=3.0e-07 W=0.8e-06
M5 7 5 6 VDD hvp L=3.0e-07 W=0.3e-06
M6 VDD 8 7 VDD hvp L=4.5e-07 W=0.3e-06
M7 8 6 VDD VDD hvp L=3.0e-07 W=0.3e-06
M8 VDD 6 Q VDD hvp L=3.0e-07 W=1e-06
M9 QB 8 VDD VDD hvp L=3.0e-07 W=1e-06
M10 GND D 1 GND hvn L=3.5e-07 W=0.28e-06
M11 6 ST GND GND hvn L=3.5e-07 W=0.28e-06
M12 GND CL 4 GND hvn L=3.5e-07 W=0.65e-06
M13 5 4 GND GND hvn L=3.5e-07 W=0.3e-06
M14 6 5 1 GND hvn L=3.5e-07 W=0.35e-06
M15 12 4 6 GND hvn L=3.5e-07 W=0.3e-06
M16 GND 8 12 GND hvn L=4.5e-07 W=0.3e-06
M17 8 6 GND GND hvn L=3.5e-07 W=0.3e-06
M18 GND 6 Q GND hvn L=3.5e-07 W=0.65e-06
M19 QB 8 GND GND hvn L=3.5e-07 W=0.65e-06
.ENDS DLATCHSTX1

.SUBCKT DLATCHSTX2 Q QB D ST CL
M0 2 D 1 VDD hvp L=3.0e-07 W=0.44e-06
M1 VDD ST 2 VDD hvp L=3.0e-07 W=0.44e-06
M2 VDD CL 4 VDD hvp L=3.0e-07 W=0.3e-06
M3 5 4 VDD VDD hvp L=3.0e-07 W=0.65e-06
M4 6 4 1 VDD hvp L=3.0e-07 W=0.8e-06
M5 7 5 6 VDD hvp L=3.0e-07 W=0.3e-06
M6 VDD 8 7 VDD hvp L=4.5e-07 W=0.3e-06
M7 8 6 VDD VDD hvp L=3.0e-07 W=0.3e-06
M8 Q 6 VDD VDD hvp L=3.0e-07 W=1e-06
M9 VDD 6 Q VDD hvp L=3.0e-07 W=1e-06
M10 QB 8 VDD VDD hvp L=3.0e-07 W=1e-06
M11 VDD 8 QB VDD hvp L=3.0e-07 W=1e-06
M12 GND D 1 GND hvn L=3.5e-07 W=0.28e-06
M13 6 ST GND GND hvn L=3.5e-07 W=0.28e-06
M14 GND CL 4 GND hvn L=3.5e-07 W=0.65e-06
M15 5 4 GND GND hvn L=3.5e-07 W=0.3e-06
M16 6 5 1 GND hvn L=3.5e-07 W=0.35e-06
M17 12 4 6 GND hvn L=3.5e-07 W=0.3e-06
M18 GND 8 12 GND hvn L=4.5e-07 W=0.3e-06
M19 8 6 GND GND hvn L=3.5e-07 W=0.3e-06
M20 Q 6 GND GND hvn L=3.5e-07 W=0.65e-06
M21 GND 6 Q GND hvn L=3.5e-07 W=0.65e-06
M22 QB 8 GND GND hvn L=3.5e-07 W=0.65e-06
M23 GND 8 QB GND hvn L=3.5e-07 W=0.65e-06
.ENDS DLATCHSTX2

.SUBCKT DLATCHSTX4 Q QB D ST CL
M0 2 D 1 VDD hvp L=3.0e-07 W=0.44e-06
M1 VDD ST 2 VDD hvp L=3.0e-07 W=0.44e-06
M2 VDD CL 4 VDD hvp L=3.0e-07 W=0.3e-06
M3 5 4 VDD VDD hvp L=3.0e-07 W=0.65e-06
M4 6 4 1 VDD hvp L=3.0e-07 W=0.8e-06
M5 7 5 6 VDD hvp L=3.0e-07 W=0.3e-06
M6 VDD 8 7 VDD hvp L=4.5e-07 W=0.3e-06
M7 8 6 VDD VDD hvp L=3.0e-07 W=0.3e-06
M8 Q 6 VDD VDD hvp L=3.0e-07 W=1e-06
M9 VDD 6 Q VDD hvp L=3.0e-07 W=1e-06
M10 Q 6 VDD VDD hvp L=3.0e-07 W=1e-06
M11 VDD 6 Q VDD hvp L=3.0e-07 W=1e-06
M12 QB 8 VDD VDD hvp L=3.0e-07 W=1e-06
M13 VDD 8 QB VDD hvp L=3.0e-07 W=1e-06
M14 QB 8 VDD VDD hvp L=3.0e-07 W=1e-06
M15 VDD 8 QB VDD hvp L=3.0e-07 W=1e-06
M16 GND D 1 GND hvn L=3.5e-07 W=0.28e-06
M17 6 ST GND GND hvn L=3.5e-07 W=0.28e-06
M18 GND CL 4 GND hvn L=3.5e-07 W=0.65e-06
M19 5 4 GND GND hvn L=3.5e-07 W=0.3e-06
M20 6 5 1 GND hvn L=3.5e-07 W=0.35e-06
M21 12 4 6 GND hvn L=3.5e-07 W=0.3e-06
M22 GND 8 12 GND hvn L=4.5e-07 W=0.3e-06
M23 8 6 GND GND hvn L=3.5e-07 W=0.3e-06
M24 Q 6 GND GND hvn L=3.5e-07 W=0.65e-06
M25 GND 6 Q GND hvn L=3.5e-07 W=0.65e-06
M26 Q 6 GND GND hvn L=3.5e-07 W=0.65e-06
M27 GND 6 Q GND hvn L=3.5e-07 W=0.65e-06
M28 QB 8 GND GND hvn L=3.5e-07 W=0.65e-06
M29 GND 8 QB GND hvn L=3.5e-07 W=0.65e-06
M30 QB 8 GND GND hvn L=3.5e-07 W=0.65e-06
M31 GND 8 QB GND hvn L=3.5e-07 W=0.65e-06
.ENDS DLATCHSTX4

.SUBCKT DLATCHX1 Q QB D CL
M0 VDD D 1 VDD hvp L=3.0e-07 W=1e-06
M1 3 CL VDD VDD hvp L=3.0e-07 W=0.3e-06
M2 4 3 VDD VDD hvp L=3.0e-07 W=0.6e-06
M3 5 3 1 VDD hvp L=3.0e-07 W=0.8e-06
M4 6 4 5 VDD hvp L=3.0e-07 W=0.3e-06
M5 VDD 7 6 VDD hvp L=3.0e-07 W=0.3e-06
M6 7 5 VDD VDD hvp L=3.0e-07 W=1e-06
M7 VDD 5 Q VDD hvp L=3.0e-07 W=1e-06
M8 QB 7 VDD VDD hvp L=3.0e-07 W=1e-06
M9 GND D 1 GND hvn L=3.5e-07 W=0.65e-06
M10 GND CL 3 GND hvn L=3.5e-07 W=0.6e-06
M11 4 3 GND GND hvn L=3.5e-07 W=0.3e-06
M12 5 4 1 GND hvn L=3.5e-07 W=0.4e-06
M13 11 3 5 GND hvn L=3.5e-07 W=0.4e-06
M14 GND 7 11 GND hvn L=3.5e-07 W=0.4e-06
M15 7 5 GND GND hvn L=3.5e-07 W=0.65e-06
M16 GND 5 Q GND hvn L=3.5e-07 W=0.65e-06
M17 QB 7 GND GND hvn L=3.5e-07 W=0.65e-06
.ENDS DLATCHX1

.SUBCKT DLATCHX2 Q QB D CL
M0 VDD D 1 VDD hvp L=3.0e-07 W=1e-06
M1 3 CL VDD VDD hvp L=3.0e-07 W=0.3e-06
M2 4 3 VDD VDD hvp L=3.0e-07 W=0.6e-06
M3 5 3 1 VDD hvp L=3.0e-07 W=0.8e-06
M4 6 4 5 VDD hvp L=3.0e-07 W=0.3e-06
M5 VDD 7 6 VDD hvp L=3.0e-07 W=0.3e-06
M6 7 5 VDD VDD hvp L=3.0e-07 W=1e-06
M7 Q 5 VDD VDD hvp L=3.0e-07 W=1e-06
M8 VDD 5 Q VDD hvp L=3.0e-07 W=1e-06
M9 QB 7 VDD VDD hvp L=3.0e-07 W=1e-06
M10 VDD 7 QB VDD hvp L=3.0e-07 W=1e-06
M11 GND D 1 GND hvn L=3.5e-07 W=0.65e-06
M12 GND CL 3 GND hvn L=3.5e-07 W=0.6e-06
M13 4 3 GND GND hvn L=3.5e-07 W=0.3e-06
M14 5 4 1 GND hvn L=3.5e-07 W=0.4e-06
M15 11 3 5 GND hvn L=3.5e-07 W=0.4e-06
M16 GND 7 11 GND hvn L=3.5e-07 W=0.4e-06
M17 7 5 GND GND hvn L=3.5e-07 W=0.65e-06
M18 Q 5 GND GND hvn L=3.5e-07 W=0.65e-06
M19 GND 5 Q GND hvn L=3.5e-07 W=0.65e-06
M20 QB 7 GND GND hvn L=3.5e-07 W=0.65e-06
M21 GND 7 QB GND hvn L=3.5e-07 W=0.65e-06
.ENDS DLATCHX2

.SUBCKT DLATCHX4 Q QB D CL
M0 VDD D 1 VDD hvp L=3.0e-07 W=1e-06
M1 3 CL VDD VDD hvp L=3.0e-07 W=0.3e-06
M2 4 3 VDD VDD hvp L=3.0e-07 W=0.6e-06
M3 5 3 1 VDD hvp L=3.0e-07 W=0.8e-06
M4 6 4 5 VDD hvp L=3.0e-07 W=0.3e-06
M5 VDD 7 6 VDD hvp L=3.0e-07 W=0.3e-06
M6 7 5 VDD VDD hvp L=3.0e-07 W=1e-06
M7 Q 5 VDD VDD hvp L=3.0e-07 W=1e-06
M8 VDD 5 Q VDD hvp L=3.0e-07 W=1e-06
M9 Q 5 VDD VDD hvp L=3.0e-07 W=1e-06
M10 VDD 5 Q VDD hvp L=3.0e-07 W=1e-06
M11 QB 7 VDD VDD hvp L=3.0e-07 W=1e-06
M12 VDD 7 QB VDD hvp L=3.0e-07 W=1e-06
M13 QB 7 VDD VDD hvp L=3.0e-07 W=1e-06
M14 VDD 7 QB VDD hvp L=3.0e-07 W=1e-06
M15 GND D 1 GND hvn L=3.5e-07 W=0.65e-06
M16 GND CL 3 GND hvn L=3.5e-07 W=0.6e-06
M17 4 3 GND GND hvn L=3.5e-07 W=0.3e-06
M18 5 4 1 GND hvn L=3.5e-07 W=0.4e-06
M19 11 3 5 GND hvn L=3.5e-07 W=0.4e-06
M20 GND 7 11 GND hvn L=3.5e-07 W=0.4e-06
M21 7 5 GND GND hvn L=3.5e-07 W=0.65e-06
M22 Q 5 GND GND hvn L=3.5e-07 W=0.65e-06
M23 GND 5 Q GND hvn L=3.5e-07 W=0.65e-06
M24 Q 5 GND GND hvn L=3.5e-07 W=0.65e-06
M25 GND 5 Q GND hvn L=3.5e-07 W=0.65e-06
M26 QB 7 GND GND hvn L=3.5e-07 W=0.65e-06
M27 GND 7 QB GND hvn L=3.5e-07 W=0.65e-06
M28 QB 7 GND GND hvn L=3.5e-07 W=0.65e-06
M29 GND 7 QB GND hvn L=3.5e-07 W=0.65e-06
.ENDS DLATCHX4

.SUBCKT FAX1 CO S CI I1 I2
M0 VDD 5 S VDD hvp L=3.0e-07 W=0.94e-06
M1 3 I1 VDD VDD hvp L=3.0e-07 W=0.48e-06
M2 4 I2 3 VDD hvp L=3.0e-07 W=0.48e-06
M3 5 CI 4 VDD hvp L=3.0e-07 W=0.48e-06
M4 6 7 5 VDD hvp L=3.0e-07 W=0.48e-06
M5 VDD I1 6 VDD hvp L=3.0e-07 W=0.48e-06
M6 6 I2 VDD VDD hvp L=3.0e-07 W=0.48e-06
M7 VDD CI 6 VDD hvp L=3.0e-07 W=0.48e-06
M8 8 CI 7 VDD hvp L=3.0e-07 W=0.48e-06
M9 VDD I1 8 VDD hvp L=3.0e-07 W=0.48e-06
M10 8 I2 VDD VDD hvp L=3.0e-07 W=0.48e-06
M11 9 I1 7 VDD hvp L=3.0e-07 W=0.48e-06
M12 VDD I2 9 VDD hvp L=3.0e-07 W=0.48e-06
M13 CO 7 VDD VDD hvp L=3.0e-07 W=0.94e-06
M14 GND 5 S GND hvn L=3.5e-07 W=0.61e-06
M15 12 I1 GND GND hvn L=3.5e-07 W=0.34e-06
M16 13 I2 12 GND hvn L=3.5e-07 W=0.34e-06
M17 5 CI 13 GND hvn L=3.5e-07 W=0.34e-06
M18 14 7 5 GND hvn L=3.5e-07 W=0.34e-06
M19 GND I1 14 GND hvn L=3.5e-07 W=0.34e-06
M20 14 I2 GND GND hvn L=3.5e-07 W=0.34e-06
M21 GND CI 14 GND hvn L=3.5e-07 W=0.34e-06
M22 15 CI 7 GND hvn L=3.5e-07 W=0.34e-06
M23 GND I1 15 GND hvn L=3.5e-07 W=0.34e-06
M24 15 I2 GND GND hvn L=3.5e-07 W=0.34e-06
M25 16 I1 7 GND hvn L=3.5e-07 W=0.34e-06
M26 GND I2 16 GND hvn L=3.5e-07 W=0.34e-06
M27 CO 7 GND GND hvn L=3.5e-07 W=0.61e-06
.ENDS FAX1

.SUBCKT FAX2 CO S CI I1 I2
M0 S 5 VDD VDD hvp L=3.0e-07 W=0.94e-06
M1 VDD 5 S VDD hvp L=3.0e-07 W=0.94e-06
M2 3 I1 VDD VDD hvp L=3.0e-07 W=0.48e-06
M3 4 I2 3 VDD hvp L=3.0e-07 W=0.48e-06
M4 5 CI 4 VDD hvp L=3.0e-07 W=0.48e-06
M5 6 7 5 VDD hvp L=3.0e-07 W=0.48e-06
M6 VDD I1 6 VDD hvp L=3.0e-07 W=0.48e-06
M7 6 I2 VDD VDD hvp L=3.0e-07 W=0.48e-06
M8 VDD CI 6 VDD hvp L=3.0e-07 W=0.48e-06
M9 8 CI 7 VDD hvp L=3.0e-07 W=0.48e-06
M10 VDD I1 8 VDD hvp L=3.0e-07 W=0.48e-06
M11 8 I2 VDD VDD hvp L=3.0e-07 W=0.48e-06
M12 9 I1 7 VDD hvp L=3.0e-07 W=0.5e-06
M13 VDD I2 9 VDD hvp L=3.0e-07 W=0.5e-06
M14 CO 7 VDD VDD hvp L=3.0e-07 W=0.94e-06
M15 VDD 7 CO VDD hvp L=3.0e-07 W=0.94e-06
M16 S 5 GND GND hvn L=3.5e-07 W=0.61e-06
M17 GND 5 S GND hvn L=3.5e-07 W=0.61e-06
M18 12 I1 GND GND hvn L=3.5e-07 W=0.34e-06
M19 13 I2 12 GND hvn L=3.5e-07 W=0.34e-06
M20 5 CI 13 GND hvn L=3.5e-07 W=0.34e-06
M21 14 7 5 GND hvn L=3.5e-07 W=0.34e-06
M22 GND I1 14 GND hvn L=3.5e-07 W=0.34e-06
M23 14 I2 GND GND hvn L=3.5e-07 W=0.34e-06
M24 GND CI 14 GND hvn L=3.5e-07 W=0.34e-06
M25 15 CI 7 GND hvn L=3.5e-07 W=0.34e-06
M26 GND I1 15 GND hvn L=3.5e-07 W=0.34e-06
M27 15 I2 GND GND hvn L=3.5e-07 W=0.34e-06
M28 16 I1 7 GND hvn L=3.5e-07 W=0.35e-06
M29 GND I2 16 GND hvn L=3.5e-07 W=0.35e-06
M30 CO 7 GND GND hvn L=3.5e-07 W=0.61e-06
M31 GND 7 CO GND hvn L=3.5e-07 W=0.61e-06
.ENDS FAX2

.SUBCKT FAX4 CO S CI I1 I2
M0 S 5 VDD VDD hvp L=3.0e-07 W=0.94e-06
M1 VDD 5 S VDD hvp L=3.0e-07 W=0.94e-06
M2 S 5 VDD VDD hvp L=3.0e-07 W=0.94e-06
M3 VDD 5 S VDD hvp L=3.0e-07 W=0.94e-06
M4 3 I1 VDD VDD hvp L=3.0e-07 W=0.48e-06
M5 4 I2 3 VDD hvp L=3.0e-07 W=0.48e-06
M6 5 CI 4 VDD hvp L=3.0e-07 W=0.48e-06
M7 6 7 5 VDD hvp L=3.0e-07 W=0.48e-06
M8 VDD I1 6 VDD hvp L=3.0e-07 W=0.48e-06
M9 6 I2 VDD VDD hvp L=3.0e-07 W=0.48e-06
M10 VDD CI 6 VDD hvp L=3.0e-07 W=0.48e-06
M11 8 CI 7 VDD hvp L=3.0e-07 W=0.48e-06
M12 VDD I1 8 VDD hvp L=3.0e-07 W=0.48e-06
M13 8 I2 VDD VDD hvp L=3.0e-07 W=0.48e-06
M14 9 I1 7 VDD hvp L=3.0e-07 W=0.5e-06
M15 VDD I2 9 VDD hvp L=3.0e-07 W=0.5e-06
M16 CO 7 VDD VDD hvp L=3.0e-07 W=0.94e-06
M17 VDD 7 CO VDD hvp L=3.0e-07 W=0.94e-06
M18 CO 7 VDD VDD hvp L=3.0e-07 W=0.94e-06
M19 VDD 7 CO VDD hvp L=3.0e-07 W=0.94e-06
M20 S 5 GND GND hvn L=3.5e-07 W=0.61e-06
M21 GND 5 S GND hvn L=3.5e-07 W=0.61e-06
M22 S 5 GND GND hvn L=3.5e-07 W=0.61e-06
M23 GND 5 S GND hvn L=3.5e-07 W=0.61e-06
M24 12 I1 GND GND hvn L=3.5e-07 W=0.34e-06
M25 13 I2 12 GND hvn L=3.5e-07 W=0.34e-06
M26 5 CI 13 GND hvn L=3.5e-07 W=0.34e-06
M27 14 7 5 GND hvn L=3.5e-07 W=0.34e-06
M28 GND I1 14 GND hvn L=3.5e-07 W=0.34e-06
M29 14 I2 GND GND hvn L=3.5e-07 W=0.34e-06
M30 GND CI 14 GND hvn L=3.5e-07 W=0.34e-06
M31 15 CI 7 GND hvn L=3.5e-07 W=0.34e-06
M32 GND I1 15 GND hvn L=3.5e-07 W=0.34e-06
M33 15 I2 GND GND hvn L=3.5e-07 W=0.34e-06
M34 16 I1 7 GND hvn L=3.5e-07 W=0.35e-06
M35 GND I2 16 GND hvn L=3.5e-07 W=0.35e-06
M36 CO 7 GND GND hvn L=3.5e-07 W=0.61e-06
M37 GND 7 CO GND hvn L=3.5e-07 W=0.61e-06
M38 CO 7 GND GND hvn L=3.5e-07 W=0.61e-06
M39 GND 7 CO GND hvn L=3.5e-07 W=0.61e-06
.ENDS FAX4

.SUBCKT FILLER1
.ENDS FILLER1

.SUBCKT FILLER12
.ENDS FILLER12

.SUBCKT FILLER16
.ENDS FILLER16

.SUBCKT FILLER2
.ENDS FILLER2

.SUBCKT FILLER3
.ENDS FILLER3

.SUBCKT FILLER32
.ENDS FILLER32

.SUBCKT FILLER4
.ENDS FILLER4

.SUBCKT FILLER8
.ENDS FILLER8

.SUBCKT FILLERC16
M0 VDD 1 1 VDD hvp L=3.0e-07 W=0.8e-06
M1 3 5 VDD VDD hvp L=3.0e-07 W=0.8e-06
M2 VDD 5 3 VDD hvp L=3.0e-07 W=0.8e-06
M3 VDD 5 VDD VDD hvp L=1.94e-06 W=0.8e-06
M4 VDD 5 VDD VDD hvp L=1.94e-06 W=0.8e-06
M5 5 1 GND GND hvn L=3.5e-07 W=0.5e-06
M6 GND 1 5 GND hvn L=3.5e-07 W=0.5e-06
M7 GND 3 GND GND hvn L=2.27e-06 W=0.5e-06
M8 GND 3 GND GND hvn L=2.27e-06 W=0.5e-06
.ENDS FILLERC16

.SUBCKT FILLERC32
M0 VDD 5 VDD VDD hvp L=2.4e-06 W=0.8e-06
M1 VDD 5 VDD VDD hvp L=2.4e-06 W=0.8e-06
M2 VDD 2 2 VDD hvp L=3.0e-07 W=0.6e-06
M3 3 5 VDD VDD hvp L=3.0e-07 W=0.8e-06
M4 VDD 5 3 VDD hvp L=3.0e-07 W=0.8e-06
M5 VDD 5 VDD VDD hvp L=2.4e-06 W=0.8e-06
M6 VDD 5 VDD VDD hvp L=2.4e-06 W=0.8e-06
M7 GND 3 GND GND hvn L=2.8e-06 W=0.5e-06
M8 GND 3 GND GND hvn L=2.8e-06 W=0.5e-06
M9 5 2 GND GND hvn L=3.5e-07 W=0.5e-06
M10 GND 2 5 GND hvn L=3.5e-07 W=0.5e-06
M11 GND 3 GND GND hvn L=2.8e-06 W=0.5e-06
M12 GND 3 GND GND hvn L=2.8e-06 W=0.5e-06
.ENDS FILLERC32

.SUBCKT FILLERC8
M0 VDD 1 1 VDD hvp L=3.0e-07 W=0.8e-06
M1 3 4 VDD VDD hvp L=3.0e-07 W=0.8e-06
M2 VDD 4 VDD VDD hvp L=0.72e-06 W=0.8e-06
M3 GND 1 4 GND hvn L=3.5e-07 W=0.5e-06
M4 GND 3 GND GND hvn L=2.04e-06 W=0.5e-06
.ENDS FILLERC8

.SUBCKT GCKGATEX1 Q E CK
M0 VDD CK 7 VDD hvp L=3.0e-07 W=0.6e-06
M1 6 7 VDD VDD hvp L=3.0e-07 W=0.6e-06
M2 VDD E 11 VDD hvp L=3.0e-07 W=0.6e-06
M3 11 6 4 VDD hvp L=3.0e-07 W=0.6e-06
M4 10 2 VDD VDD hvp L=3.0e-07 W=0.35e-06
M5 4 7 10 VDD hvp L=3.0e-07 W=0.35e-06
M6 VDD 4 2 VDD hvp L=3.0e-07 W=1e-06
M7 VDD 2 8 VDD hvp L=3.0e-07 W=0.6e-06
M8 8 CK VDD VDD hvp L=3.0e-07 W=0.6e-06
M9 Q 8 VDD VDD hvp L=3.0e-07 W=1e-06
M10 GND CK 7 GND hvn L=3.5e-07 W=0.35e-06
M11 6 7 GND GND hvn L=3.5e-07 W=0.35e-06
M12 5 7 4 GND hvn L=3.5e-07 W=0.35e-06
M13 GND E 5 GND hvn L=3.5e-07 W=0.35e-06
M14 4 6 3 GND hvn L=3.5e-07 W=0.35e-06
M15 3 2 GND GND hvn L=3.5e-07 W=0.35e-06
M16 GND 4 2 GND hvn L=3.5e-07 W=0.65e-06
M17 9 CK 8 GND hvn L=3.5e-07 W=0.35e-06
M18 GND 2 9 GND hvn L=3.5e-07 W=0.35e-06
M19 Q 8 GND GND hvn L=3.5e-07 W=0.65e-06
.ENDS GCKGATEX1

.SUBCKT GCKGATEX2 Q E CK
M0 VDD CK 7 VDD hvp L=3.0e-07 W=0.6e-06
M1 6 7 VDD VDD hvp L=3.0e-07 W=0.6e-06
M2 VDD E 11 VDD hvp L=3.0e-07 W=0.6e-06
M3 11 6 4 VDD hvp L=3.0e-07 W=0.6e-06
M4 10 2 VDD VDD hvp L=3.0e-07 W=0.35e-06
M5 4 7 10 VDD hvp L=3.0e-07 W=0.35e-06
M6 VDD 4 2 VDD hvp L=3.0e-07 W=1e-06
M7 VDD 2 8 VDD hvp L=3.0e-07 W=0.6e-06
M8 8 CK VDD VDD hvp L=3.0e-07 W=0.6e-06
M9 Q 8 VDD VDD hvp L=3.0e-07 W=1e-06
M10 Q 8 VDD VDD hvp L=3.0e-07 W=1e-06
M11 GND CK 7 GND hvn L=3.5e-07 W=0.35e-06
M12 6 7 GND GND hvn L=3.5e-07 W=0.35e-06
M13 5 7 4 GND hvn L=3.5e-07 W=0.35e-06
M14 GND E 5 GND hvn L=3.5e-07 W=0.35e-06
M15 4 6 3 GND hvn L=3.5e-07 W=0.35e-06
M16 3 2 GND GND hvn L=3.5e-07 W=0.35e-06
M17 GND 4 2 GND hvn L=3.5e-07 W=0.65e-06
M18 9 CK 8 GND hvn L=3.5e-07 W=0.35e-06
M19 GND 2 9 GND hvn L=3.5e-07 W=0.35e-06
M20 Q 8 GND GND hvn L=3.5e-07 W=0.65e-06
M21 Q 8 GND GND hvn L=3.5e-07 W=0.65e-06
.ENDS GCKGATEX2

.SUBCKT GCKGATEX4 Q E CK
M0 VDD CK 7 VDD hvp L=3.0e-07 W=0.6e-06
M1 6 7 VDD VDD hvp L=3.0e-07 W=0.6e-06
M2 VDD E 11 VDD hvp L=3.0e-07 W=0.6e-06
M3 11 6 4 VDD hvp L=3.0e-07 W=0.6e-06
M4 10 2 VDD VDD hvp L=3.0e-07 W=0.35e-06
M5 4 7 10 VDD hvp L=3.0e-07 W=0.35e-06
M6 VDD 4 2 VDD hvp L=3.0e-07 W=1e-06
M7 VDD 2 8 VDD hvp L=3.0e-07 W=0.6e-06
M8 VDD 2 8 VDD hvp L=3.0e-07 W=0.6e-06
M9 8 CK VDD VDD hvp L=3.0e-07 W=0.6e-06
M10 8 CK VDD VDD hvp L=3.0e-07 W=0.6e-06
M11 Q 8 VDD VDD hvp L=3.0e-07 W=1e-06
M12 Q 8 VDD VDD hvp L=3.0e-07 W=1e-06
M13 Q 8 VDD VDD hvp L=3.0e-07 W=1e-06
M14 Q 8 VDD VDD hvp L=3.0e-07 W=1e-06
M15 GND CK 7 GND hvn L=3.5e-07 W=0.35e-06
M16 6 7 GND GND hvn L=3.5e-07 W=0.35e-06
M17 5 7 4 GND hvn L=3.5e-07 W=0.35e-06
M18 GND E 5 GND hvn L=3.5e-07 W=0.35e-06
M19 4 6 3 GND hvn L=3.5e-07 W=0.35e-06
M20 3 2 GND GND hvn L=3.5e-07 W=0.35e-06
M21 GND 4 2 GND hvn L=3.5e-07 W=0.65e-06
M22 9 CK 8 GND hvn L=3.5e-07 W=0.35e-06
M23 GND 2 9 GND hvn L=3.5e-07 W=0.35e-06
M24 12 CK 8 GND hvn L=3.5e-07 W=0.35e-06
M25 GND 2 12 GND hvn L=3.5e-07 W=0.35e-06
M26 Q 8 GND GND hvn L=3.5e-07 W=0.65e-06
M27 Q 8 GND GND hvn L=3.5e-07 W=0.65e-06
M28 Q 8 GND GND hvn L=3.5e-07 W=0.65e-06
M29 Q 8 GND GND hvn L=3.5e-07 W=0.65e-06
.ENDS GCKGATEX4

.SUBCKT GCKHBQX1 Q E TE CK
M0 2 E 1 VDD hvp L=3.0e-07 W=1e-06
M1 VDD TE 2 VDD hvp L=3.0e-07 W=1e-06
M2 VDD CK 4 VDD hvp L=3.0e-07 W=0.35e-06
M3 5 4 VDD VDD hvp L=3.0e-07 W=0.65e-06
M4 6 5 1 VDD hvp L=3.0e-07 W=0.6e-06
M5 7 4 6 VDD hvp L=3.0e-07 W=0.3e-06
M6 VDD 8 7 VDD hvp L=3.0e-07 W=0.3e-06
M7 8 6 VDD VDD hvp L=3.0e-07 W=0.3e-06
M8 10 4 9 VDD hvp L=3.0e-07 W=1e-06
M9 VDD 6 10 VDD hvp L=3.0e-07 W=1e-06
M10 11 9 VDD VDD hvp L=3.0e-07 W=1e-06
M11 Q 11 VDD VDD hvp L=3.0e-07 W=1e-06
M12 1 E GND GND hvn L=3.5e-07 W=0.65e-06
M13 GND TE 1 GND hvn L=3.5e-07 W=0.65e-06
M14 GND CK 4 GND hvn L=3.5e-07 W=0.65e-06
M15 5 4 GND GND hvn L=3.5e-07 W=0.3e-06
M16 6 4 1 GND hvn L=3.5e-07 W=0.6e-06
M17 14 5 6 GND hvn L=3.5e-07 W=0.3e-06
M18 GND 8 14 GND hvn L=3.5e-07 W=0.3e-06
M19 8 6 GND GND hvn L=3.5e-07 W=0.35e-06
M20 9 4 GND GND hvn L=3.5e-07 W=0.65e-06
M21 GND 6 9 GND hvn L=3.5e-07 W=0.65e-06
M22 11 9 GND GND hvn L=3.5e-07 W=0.65e-06
M23 Q 11 GND GND hvn L=3.5e-07 W=0.65e-06
.ENDS GCKHBQX1

.SUBCKT GCKHBQX2 Q E TE CK
M0 2 E 1 VDD hvp L=3.0e-07 W=1e-06
M1 VDD TE 2 VDD hvp L=3.0e-07 W=1e-06
M2 VDD CK 4 VDD hvp L=3.0e-07 W=0.35e-06
M3 5 4 VDD VDD hvp L=3.0e-07 W=0.65e-06
M4 6 5 1 VDD hvp L=3.0e-07 W=0.6e-06
M5 7 4 6 VDD hvp L=3.0e-07 W=0.3e-06
M6 VDD 8 7 VDD hvp L=3.0e-07 W=0.3e-06
M7 8 6 VDD VDD hvp L=3.0e-07 W=0.3e-06
M8 10 4 9 VDD hvp L=3.0e-07 W=1e-06
M9 VDD 6 10 VDD hvp L=3.0e-07 W=1e-06
M10 11 9 VDD VDD hvp L=3.0e-07 W=1e-06
M11 Q 11 VDD VDD hvp L=3.0e-07 W=1e-06
M12 VDD 11 Q VDD hvp L=3.0e-07 W=1e-06
M13 1 E GND GND hvn L=3.5e-07 W=0.65e-06
M14 GND TE 1 GND hvn L=3.5e-07 W=0.65e-06
M15 GND CK 4 GND hvn L=3.5e-07 W=0.65e-06
M16 5 4 GND GND hvn L=3.5e-07 W=0.3e-06
M17 6 4 1 GND hvn L=3.5e-07 W=0.6e-06
M18 14 5 6 GND hvn L=3.5e-07 W=0.3e-06
M19 GND 8 14 GND hvn L=3.5e-07 W=0.3e-06
M20 8 6 GND GND hvn L=3.5e-07 W=0.35e-06
M21 9 4 GND GND hvn L=3.5e-07 W=0.65e-06
M22 GND 6 9 GND hvn L=3.5e-07 W=0.65e-06
M23 11 9 GND GND hvn L=3.5e-07 W=0.65e-06
M24 Q 11 GND GND hvn L=3.5e-07 W=0.65e-06
M25 GND 11 Q GND hvn L=3.5e-07 W=0.65e-06
.ENDS GCKHBQX2

.SUBCKT GCKHBQX4 Q E TE CK
M0 2 E 1 VDD hvp L=3.0e-07 W=1e-06
M1 VDD TE 2 VDD hvp L=3.0e-07 W=1e-06
M2 VDD CK 4 VDD hvp L=3.0e-07 W=0.35e-06
M3 5 4 VDD VDD hvp L=3.0e-07 W=0.65e-06
M4 6 5 1 VDD hvp L=3.0e-07 W=0.6e-06
M5 7 4 6 VDD hvp L=3.0e-07 W=0.3e-06
M6 VDD 8 7 VDD hvp L=3.0e-07 W=0.3e-06
M7 8 6 VDD VDD hvp L=3.0e-07 W=0.3e-06
M8 10 4 9 VDD hvp L=3.0e-07 W=1e-06
M9 VDD 6 10 VDD hvp L=3.0e-07 W=1e-06
M10 11 9 VDD VDD hvp L=3.0e-07 W=1e-06
M11 Q 11 VDD VDD hvp L=3.0e-07 W=1e-06
M12 VDD 11 Q VDD hvp L=3.0e-07 W=1e-06
M13 Q 11 VDD VDD hvp L=3.0e-07 W=1e-06
M14 VDD 11 Q VDD hvp L=3.0e-07 W=1e-06
M15 1 E GND GND hvn L=3.5e-07 W=0.65e-06
M16 GND TE 1 GND hvn L=3.5e-07 W=0.65e-06
M17 GND CK 4 GND hvn L=3.5e-07 W=0.65e-06
M18 5 4 GND GND hvn L=3.5e-07 W=0.3e-06
M19 6 4 1 GND hvn L=3.5e-07 W=0.6e-06
M20 14 5 6 GND hvn L=3.5e-07 W=0.3e-06
M21 GND 8 14 GND hvn L=3.5e-07 W=0.3e-06
M22 8 6 GND GND hvn L=3.5e-07 W=0.35e-06
M23 9 4 GND GND hvn L=3.5e-07 W=0.65e-06
M24 GND 6 9 GND hvn L=3.5e-07 W=0.65e-06
M25 11 9 GND GND hvn L=3.5e-07 W=0.65e-06
M26 Q 11 GND GND hvn L=3.5e-07 W=0.65e-06
M27 GND 11 Q GND hvn L=3.5e-07 W=0.65e-06
M28 Q 11 GND GND hvn L=3.5e-07 W=0.65e-06
M29 GND 11 Q GND hvn L=3.5e-07 W=0.65e-06
.ENDS GCKHBQX4

.SUBCKT GCKLBQX1 Q E TE CKB
M0 2 E 1 VDD hvp L=3.0e-07 W=1e-06
M1 VDD TE 2 VDD hvp L=3.0e-07 W=1e-06
M2 VDD CKB 4 VDD hvp L=3.0e-07 W=0.3e-06
M3 5 4 VDD VDD hvp L=3.0e-07 W=0.65e-06
M4 6 4 1 VDD hvp L=3.0e-07 W=0.85e-06
M5 7 5 6 VDD hvp L=3.0e-07 W=0.3e-06
M6 VDD 8 7 VDD hvp L=3.0e-07 W=0.3e-06
M7 8 6 VDD VDD hvp L=3.0e-07 W=0.6e-06
M8 9 8 VDD VDD hvp L=3.0e-07 W=1e-06
M9 VDD 4 9 VDD hvp L=3.0e-07 W=1e-06
M10 10 9 VDD VDD hvp L=3.0e-07 W=1e-06
M11 Q 10 VDD VDD hvp L=3.0e-07 W=1e-06
M12 1 E GND GND hvn L=3.5e-07 W=0.65e-06
M13 GND TE 1 GND hvn L=3.5e-07 W=0.65e-06
M14 GND CKB 4 GND hvn L=3.5e-07 W=0.65e-06
M15 5 4 GND GND hvn L=3.5e-07 W=0.3e-06
M16 6 5 1 GND hvn L=3.5e-07 W=0.35e-06
M17 13 4 6 GND hvn L=3.5e-07 W=0.3e-06
M18 GND 8 13 GND hvn L=3.5e-07 W=0.3e-06
M19 8 6 GND GND hvn L=3.5e-07 W=0.35e-06
M20 14 8 9 GND hvn L=3.5e-07 W=0.65e-06
M21 GND 4 14 GND hvn L=3.5e-07 W=0.65e-06
M22 10 9 GND GND hvn L=3.5e-07 W=0.65e-06
M23 Q 10 GND GND hvn L=3.5e-07 W=0.65e-06
.ENDS GCKLBQX1

.SUBCKT GCKLBQX2 Q E TE CKB
M0 2 E 1 VDD hvp L=3.0e-07 W=1e-06
M1 VDD TE 2 VDD hvp L=3.0e-07 W=1e-06
M2 VDD CKB 4 VDD hvp L=3.0e-07 W=0.3e-06
M3 5 4 VDD VDD hvp L=3.0e-07 W=0.65e-06
M4 6 4 1 VDD hvp L=3.0e-07 W=0.85e-06
M5 7 5 6 VDD hvp L=3.0e-07 W=0.3e-06
M6 VDD 8 7 VDD hvp L=3.0e-07 W=0.3e-06
M7 8 6 VDD VDD hvp L=3.0e-07 W=0.6e-06
M8 9 8 VDD VDD hvp L=3.0e-07 W=1e-06
M9 VDD 4 9 VDD hvp L=3.0e-07 W=1e-06
M10 10 9 VDD VDD hvp L=3.0e-07 W=1e-06
M11 Q 10 VDD VDD hvp L=3.0e-07 W=1e-06
M12 VDD 10 Q VDD hvp L=3.0e-07 W=1e-06
M13 1 E GND GND hvn L=3.5e-07 W=0.65e-06
M14 GND TE 1 GND hvn L=3.5e-07 W=0.65e-06
M15 GND CKB 4 GND hvn L=3.5e-07 W=0.65e-06
M16 5 4 GND GND hvn L=3.5e-07 W=0.3e-06
M17 6 5 1 GND hvn L=3.5e-07 W=0.35e-06
M18 13 4 6 GND hvn L=3.5e-07 W=0.3e-06
M19 GND 8 13 GND hvn L=3.5e-07 W=0.3e-06
M20 8 6 GND GND hvn L=3.5e-07 W=0.35e-06
M21 14 8 9 GND hvn L=3.5e-07 W=0.65e-06
M22 GND 4 14 GND hvn L=3.5e-07 W=0.65e-06
M23 10 9 GND GND hvn L=3.5e-07 W=0.65e-06
M24 Q 10 GND GND hvn L=3.5e-07 W=0.65e-06
M25 GND 10 Q GND hvn L=3.5e-07 W=0.65e-06
.ENDS GCKLBQX2

.SUBCKT GCKLBQX4 Q E TE CKB
M0 2 E 1 VDD hvp L=3.0e-07 W=1e-06
M1 VDD TE 2 VDD hvp L=3.0e-07 W=1e-06
M2 VDD CKB 4 VDD hvp L=3.0e-07 W=0.3e-06
M3 5 4 VDD VDD hvp L=3.0e-07 W=0.65e-06
M4 6 4 1 VDD hvp L=3.0e-07 W=0.85e-06
M5 7 5 6 VDD hvp L=3.0e-07 W=0.3e-06
M6 VDD 8 7 VDD hvp L=3.0e-07 W=0.3e-06
M7 8 6 VDD VDD hvp L=3.0e-07 W=0.6e-06
M8 9 8 VDD VDD hvp L=3.0e-07 W=1e-06
M9 VDD 4 9 VDD hvp L=3.0e-07 W=1e-06
M10 10 9 VDD VDD hvp L=3.0e-07 W=1e-06
M11 Q 10 VDD VDD hvp L=3.0e-07 W=1e-06
M12 VDD 10 Q VDD hvp L=3.0e-07 W=1e-06
M13 Q 10 VDD VDD hvp L=3.0e-07 W=1e-06
M14 VDD 10 Q VDD hvp L=3.0e-07 W=1e-06
M15 1 E GND GND hvn L=3.5e-07 W=0.65e-06
M16 GND TE 1 GND hvn L=3.5e-07 W=0.65e-06
M17 GND CKB 4 GND hvn L=3.5e-07 W=0.65e-06
M18 5 4 GND GND hvn L=3.5e-07 W=0.3e-06
M19 6 5 1 GND hvn L=3.5e-07 W=0.35e-06
M20 13 4 6 GND hvn L=3.5e-07 W=0.3e-06
M21 GND 8 13 GND hvn L=3.5e-07 W=0.3e-06
M22 8 6 GND GND hvn L=3.5e-07 W=0.35e-06
M23 14 8 9 GND hvn L=3.5e-07 W=0.65e-06
M24 GND 4 14 GND hvn L=3.5e-07 W=0.65e-06
M25 10 9 GND GND hvn L=3.5e-07 W=0.65e-06
M26 Q 10 GND GND hvn L=3.5e-07 W=0.65e-06
M27 GND 10 Q GND hvn L=3.5e-07 W=0.65e-06
M28 Q 10 GND GND hvn L=3.5e-07 W=0.65e-06
M29 GND 10 Q GND hvn L=3.5e-07 W=0.65e-06
.ENDS GCKLBQX4

.SUBCKT HAX1 CO S I1 I2
M0 VDD 3 CO VDD hvp L=3.0e-07 W=1e-06
M1 3 I2 VDD VDD hvp L=3.0e-07 W=0.5e-06
M2 VDD I1 3 VDD hvp L=3.0e-07 W=0.5e-06
M3 VDD I1 4 VDD hvp L=3.0e-07 W=0.5e-06
M4 5 4 VDD VDD hvp L=3.0e-07 W=0.5e-06
M5 6 7 5 VDD hvp L=3.0e-07 W=0.5e-06
M6 4 I2 6 VDD hvp L=3.0e-07 W=0.5e-06
M7 VDD I2 7 VDD hvp L=3.0e-07 W=0.85e-06
M8 S 6 VDD VDD hvp L=3.0e-07 W=1e-06
M9 GND 3 CO GND hvn L=3.5e-07 W=0.65e-06
M10 10 I2 GND GND hvn L=3.5e-07 W=0.35e-06
M11 3 I1 10 GND hvn L=3.5e-07 W=0.35e-06
M12 GND I1 4 GND hvn L=3.5e-07 W=0.35e-06
M13 5 4 GND GND hvn L=3.5e-07 W=0.35e-06
M14 6 I2 5 GND hvn L=3.5e-07 W=0.35e-06
M15 4 7 6 GND hvn L=3.5e-07 W=0.35e-06
M16 GND I2 7 GND hvn L=3.5e-07 W=0.45e-06
M17 S 6 GND GND hvn L=3.5e-07 W=0.65e-06
.ENDS HAX1

.SUBCKT HAX2 CO S I1 I2
M0 CO 3 VDD VDD hvp L=3.0e-07 W=1e-06
M1 VDD 3 CO VDD hvp L=3.0e-07 W=1e-06
M2 3 I2 VDD VDD hvp L=3.0e-07 W=0.5e-06
M3 VDD I1 3 VDD hvp L=3.0e-07 W=0.5e-06
M4 VDD I1 4 VDD hvp L=3.0e-07 W=0.5e-06
M5 5 4 VDD VDD hvp L=3.0e-07 W=0.5e-06
M6 6 7 5 VDD hvp L=3.0e-07 W=0.5e-06
M7 4 I2 6 VDD hvp L=3.0e-07 W=0.5e-06
M8 VDD I2 7 VDD hvp L=3.0e-07 W=0.85e-06
M9 S 6 VDD VDD hvp L=3.0e-07 W=1e-06
M10 VDD 6 S VDD hvp L=3.0e-07 W=1e-06
M11 CO 3 GND GND hvn L=3.5e-07 W=0.65e-06
M12 GND 3 CO GND hvn L=3.5e-07 W=0.65e-06
M13 10 I2 GND GND hvn L=3.5e-07 W=0.35e-06
M14 3 I1 10 GND hvn L=3.5e-07 W=0.35e-06
M15 GND I1 4 GND hvn L=3.5e-07 W=0.35e-06
M16 5 4 GND GND hvn L=3.5e-07 W=0.35e-06
M17 6 I2 5 GND hvn L=3.5e-07 W=0.35e-06
M18 4 7 6 GND hvn L=3.5e-07 W=0.35e-06
M19 GND I2 7 GND hvn L=3.5e-07 W=0.45e-06
M20 S 6 GND GND hvn L=3.5e-07 W=0.65e-06
M21 GND 6 S GND hvn L=3.5e-07 W=0.65e-06
.ENDS HAX2

.SUBCKT HAX4 CO S I1 I2
M0 CO 3 VDD VDD hvp L=3.0e-07 W=1e-06
M1 VDD 3 CO VDD hvp L=3.0e-07 W=1e-06
M2 CO 3 VDD VDD hvp L=3.0e-07 W=1e-06
M3 VDD 3 CO VDD hvp L=3.0e-07 W=1e-06
M4 3 I2 VDD VDD hvp L=3.0e-07 W=0.5e-06
M5 VDD I1 3 VDD hvp L=3.0e-07 W=0.5e-06
M6 VDD I1 4 VDD hvp L=3.0e-07 W=0.5e-06
M7 5 4 VDD VDD hvp L=3.0e-07 W=0.5e-06
M8 6 7 5 VDD hvp L=3.0e-07 W=0.5e-06
M9 4 I2 6 VDD hvp L=3.0e-07 W=0.5e-06
M10 VDD I2 7 VDD hvp L=3.0e-07 W=0.85e-06
M11 S 6 VDD VDD hvp L=3.0e-07 W=1e-06
M12 VDD 6 S VDD hvp L=3.0e-07 W=1e-06
M13 S 6 VDD VDD hvp L=3.0e-07 W=1e-06
M14 VDD 6 S VDD hvp L=3.0e-07 W=1e-06
M15 CO 3 GND GND hvn L=3.5e-07 W=0.65e-06
M16 GND 3 CO GND hvn L=3.5e-07 W=0.65e-06
M17 CO 3 GND GND hvn L=3.5e-07 W=0.65e-06
M18 GND 3 CO GND hvn L=3.5e-07 W=0.65e-06
M19 10 I2 GND GND hvn L=3.5e-07 W=0.35e-06
M20 3 I1 10 GND hvn L=3.5e-07 W=0.35e-06
M21 GND I1 4 GND hvn L=3.5e-07 W=0.35e-06
M22 5 4 GND GND hvn L=3.5e-07 W=0.35e-06
M23 6 I2 5 GND hvn L=3.5e-07 W=0.35e-06
M24 4 7 6 GND hvn L=3.5e-07 W=0.35e-06
M25 GND I2 7 GND hvn L=3.5e-07 W=0.45e-06
M26 S 6 GND GND hvn L=3.5e-07 W=0.65e-06
M27 GND 6 S GND hvn L=3.5e-07 W=0.65e-06
M28 S 6 GND GND hvn L=3.5e-07 W=0.65e-06
M29 GND 6 S GND hvn L=3.5e-07 W=0.65e-06
.ENDS HAX4

.SUBCKT INVX1 O I
M0 O I VDD VDD hvp L=3.0e-07 W=1e-06
M1 O I GND GND hvn L=3.5e-07 W=0.65e-06
.ENDS INVX1

.SUBCKT INVX10 O I
M0 O I VDD VDD hvp L=3.0e-07 W=1e-06
M1 VDD I O VDD hvp L=3.0e-07 W=1e-06
M2 O I VDD VDD hvp L=3.0e-07 W=1e-06
M3 VDD I O VDD hvp L=3.0e-07 W=1e-06
M4 O I VDD VDD hvp L=3.0e-07 W=1e-06
M5 VDD I O VDD hvp L=3.0e-07 W=1e-06
M6 O I VDD VDD hvp L=3.0e-07 W=1e-06
M7 VDD I O VDD hvp L=3.0e-07 W=1e-06
M8 O I VDD VDD hvp L=3.0e-07 W=1e-06
M9 VDD I O VDD hvp L=3.0e-07 W=1e-06
M12 O I GND GND hvn L=3.5e-07 W=0.65e-06
M13 GND I O GND hvn L=3.5e-07 W=0.65e-06
M14 O I GND GND hvn L=3.5e-07 W=0.65e-06
M15 GND I O GND hvn L=3.5e-07 W=0.65e-06
M16 O I GND GND hvn L=3.5e-07 W=0.65e-06
M17 GND I O GND hvn L=3.5e-07 W=0.65e-06
M18 O I GND GND hvn L=3.5e-07 W=0.65e-06
M19 GND I O GND hvn L=3.5e-07 W=0.65e-06
M20 O I GND GND hvn L=3.5e-07 W=0.65e-06
M21 GND I O GND hvn L=3.5e-07 W=0.65e-06
.ENDS INVX10

.SUBCKT INVX12 O I
M0 O I VDD VDD hvp L=3.0e-07 W=1e-06
M1 VDD I O VDD hvp L=3.0e-07 W=1e-06
M2 O I VDD VDD hvp L=3.0e-07 W=1e-06
M3 VDD I O VDD hvp L=3.0e-07 W=1e-06
M4 O I VDD VDD hvp L=3.0e-07 W=1e-06
M5 VDD I O VDD hvp L=3.0e-07 W=1e-06
M6 O I VDD VDD hvp L=3.0e-07 W=1e-06
M7 VDD I O VDD hvp L=3.0e-07 W=1e-06
M8 O I VDD VDD hvp L=3.0e-07 W=1e-06
M9 VDD I O VDD hvp L=3.0e-07 W=1e-06
M10 O I VDD VDD hvp L=3.0e-07 W=1e-06
M11 VDD I O VDD hvp L=3.0e-07 W=1e-06
M12 O I GND GND hvn L=3.5e-07 W=0.65e-06
M13 GND I O GND hvn L=3.5e-07 W=0.65e-06
M14 O I GND GND hvn L=3.5e-07 W=0.65e-06
M15 GND I O GND hvn L=3.5e-07 W=0.65e-06
M16 O I GND GND hvn L=3.5e-07 W=0.65e-06
M17 GND I O GND hvn L=3.5e-07 W=0.65e-06
M18 O I GND GND hvn L=3.5e-07 W=0.65e-06
M19 GND I O GND hvn L=3.5e-07 W=0.65e-06
M20 O I GND GND hvn L=3.5e-07 W=0.65e-06
M21 GND I O GND hvn L=3.5e-07 W=0.65e-06
M22 O I GND GND hvn L=3.5e-07 W=0.65e-06
M23 GND I O GND hvn L=3.5e-07 W=0.65e-06
.ENDS INVX12

.SUBCKT INVX16 O I
M0 O I VDD VDD hvp L=3.0e-07 W=1e-06
M1 VDD I O VDD hvp L=3.0e-07 W=1e-06
M2 O I VDD VDD hvp L=3.0e-07 W=1e-06
M3 VDD I O VDD hvp L=3.0e-07 W=1e-06
M4 O I VDD VDD hvp L=3.0e-07 W=1e-06
M5 VDD I O VDD hvp L=3.0e-07 W=1e-06
M6 O I VDD VDD hvp L=3.0e-07 W=1e-06
M7 VDD I O VDD hvp L=3.0e-07 W=1e-06
M8 O I VDD VDD hvp L=3.0e-07 W=1e-06
M9 VDD I O VDD hvp L=3.0e-07 W=1e-06
M10 O I VDD VDD hvp L=3.0e-07 W=1e-06
M11 VDD I O VDD hvp L=3.0e-07 W=1e-06
M12 O I VDD VDD hvp L=3.0e-07 W=1e-06
M13 VDD I O VDD hvp L=3.0e-07 W=1e-06
M14 O I VDD VDD hvp L=3.0e-07 W=1e-06
M15 VDD I O VDD hvp L=3.0e-07 W=1e-06
M16 O I GND GND hvn L=3.5e-07 W=0.65e-06
M17 GND I O GND hvn L=3.5e-07 W=0.65e-06
M18 O I GND GND hvn L=3.5e-07 W=0.65e-06
M19 GND I O GND hvn L=3.5e-07 W=0.65e-06
M20 O I GND GND hvn L=3.5e-07 W=0.65e-06
M21 GND I O GND hvn L=3.5e-07 W=0.65e-06
M22 O I GND GND hvn L=3.5e-07 W=0.65e-06
M23 GND I O GND hvn L=3.5e-07 W=0.65e-06
M24 O I GND GND hvn L=3.5e-07 W=0.65e-06
M25 GND I O GND hvn L=3.5e-07 W=0.65e-06
M26 O I GND GND hvn L=3.5e-07 W=0.65e-06
M27 GND I O GND hvn L=3.5e-07 W=0.65e-06
M28 O I GND GND hvn L=3.5e-07 W=0.65e-06
M29 GND I O GND hvn L=3.5e-07 W=0.65e-06
M30 O I GND GND hvn L=3.5e-07 W=0.65e-06
M31 GND I O GND hvn L=3.5e-07 W=0.65e-06
.ENDS INVX16

.SUBCKT INVX2 O I
M0 O I VDD VDD hvp L=3.0e-07 W=1e-06
M1 VDD I O VDD hvp L=3.0e-07 W=1e-06
M2 O I GND GND hvn L=3.5e-07 W=0.65e-06
M3 GND I O GND hvn L=3.5e-07 W=0.65e-06
.ENDS INVX2

.SUBCKT INVX20 O I
M0 O I VDD VDD hvp L=3.0e-07 W=1e-06
M1 VDD I O VDD hvp L=3.0e-07 W=1e-06
M2 O I VDD VDD hvp L=3.0e-07 W=1e-06
M3 VDD I O VDD hvp L=3.0e-07 W=1e-06
M4 O I VDD VDD hvp L=3.0e-07 W=1e-06
M5 VDD I O VDD hvp L=3.0e-07 W=1e-06
M6 O I VDD VDD hvp L=3.0e-07 W=1e-06
M7 VDD I O VDD hvp L=3.0e-07 W=1e-06
M8 O I VDD VDD hvp L=3.0e-07 W=1e-06
M9 VDD I O VDD hvp L=3.0e-07 W=1e-06
M10 O I VDD VDD hvp L=3.0e-07 W=1e-06
M11 VDD I O VDD hvp L=3.0e-07 W=1e-06
M12 O I VDD VDD hvp L=3.0e-07 W=1e-06
M13 VDD I O VDD hvp L=3.0e-07 W=1e-06
M14 O I VDD VDD hvp L=3.0e-07 W=1e-06
M15 VDD I O VDD hvp L=3.0e-07 W=1e-06
M16 O I VDD VDD hvp L=3.0e-07 W=1e-06
M17 VDD I O VDD hvp L=3.0e-07 W=1e-06
M18 O I VDD VDD hvp L=3.0e-07 W=1e-06
M19 VDD I O VDD hvp L=3.0e-07 W=1e-06
M20 O I GND GND hvn L=3.5e-07 W=0.65e-06
M21 GND I O GND hvn L=3.5e-07 W=0.65e-06
M22 O I GND GND hvn L=3.5e-07 W=0.65e-06
M23 GND I O GND hvn L=3.5e-07 W=0.65e-06
M24 O I GND GND hvn L=3.5e-07 W=0.65e-06
M25 GND I O GND hvn L=3.5e-07 W=0.65e-06
M26 O I GND GND hvn L=3.5e-07 W=0.65e-06
M27 GND I O GND hvn L=3.5e-07 W=0.65e-06
M28 O I GND GND hvn L=3.5e-07 W=0.65e-06
M29 GND I O GND hvn L=3.5e-07 W=0.65e-06
M30 O I GND GND hvn L=3.5e-07 W=0.65e-06
M31 GND I O GND hvn L=3.5e-07 W=0.65e-06
M32 O I GND GND hvn L=3.5e-07 W=0.65e-06
M33 GND I O GND hvn L=3.5e-07 W=0.65e-06
M34 O I GND GND hvn L=3.5e-07 W=0.65e-06
M35 GND I O GND hvn L=3.5e-07 W=0.65e-06
M36 O I GND GND hvn L=3.5e-07 W=0.65e-06
M37 GND I O GND hvn L=3.5e-07 W=0.65e-06
M38 O I GND GND hvn L=3.5e-07 W=0.65e-06
M39 GND I O GND hvn L=3.5e-07 W=0.65e-06
.ENDS INVX20

.SUBCKT INVX3 O I
M0 O I VDD VDD hvp L=3.0e-07 W=1e-06
M1 VDD I O VDD hvp L=3.0e-07 W=1e-06
M2 O I VDD VDD hvp L=3.0e-07 W=1e-06
M3 O I GND GND hvn L=3.5e-07 W=0.65e-06
M4 GND I O GND hvn L=3.5e-07 W=0.65e-06
M5 O I GND GND hvn L=3.5e-07 W=0.65e-06
.ENDS INVX3

.SUBCKT INVX4 O I
M0 O I VDD VDD hvp L=3.0e-07 W=1e-06
M1 VDD I O VDD hvp L=3.0e-07 W=1e-06
M2 O I VDD VDD hvp L=3.0e-07 W=1e-06
M3 VDD I O VDD hvp L=3.0e-07 W=1e-06
M4 O I GND GND hvn L=3.5e-07 W=0.65e-06
M5 GND I O GND hvn L=3.5e-07 W=0.65e-06
M6 O I GND GND hvn L=3.5e-07 W=0.65e-06
M7 GND I O GND hvn L=3.5e-07 W=0.65e-06
.ENDS INVX4

.SUBCKT INVX5 O I
M0 O I VDD VDD hvp L=3.0e-07 W=1e-06
M1 VDD I O VDD hvp L=3.0e-07 W=1e-06
M2 O I VDD VDD hvp L=3.0e-07 W=1e-06
M3 VDD I O VDD hvp L=3.0e-07 W=1e-06
M4 O I VDD VDD hvp L=3.0e-07 W=1e-06
M6 O I GND GND hvn L=3.5e-07 W=0.65e-06
M7 GND I O GND hvn L=3.5e-07 W=0.65e-06
M8 O I GND GND hvn L=3.5e-07 W=0.65e-06
M9 GND I O GND hvn L=3.5e-07 W=0.65e-06
M10 O I GND GND hvn L=3.5e-07 W=0.65e-06
.ENDS INVX5

.SUBCKT INVX6 O I
M0 O I VDD VDD hvp L=3.0e-07 W=1e-06
M1 VDD I O VDD hvp L=3.0e-07 W=1e-06
M2 O I VDD VDD hvp L=3.0e-07 W=1e-06
M3 VDD I O VDD hvp L=3.0e-07 W=1e-06
M4 O I VDD VDD hvp L=3.0e-07 W=1e-06
M5 VDD I O VDD hvp L=3.0e-07 W=1e-06
M6 O I GND GND hvn L=3.5e-07 W=0.65e-06
M7 GND I O GND hvn L=3.5e-07 W=0.65e-06
M8 O I GND GND hvn L=3.5e-07 W=0.65e-06
M9 GND I O GND hvn L=3.5e-07 W=0.65e-06
M10 O I GND GND hvn L=3.5e-07 W=0.65e-06
M11 GND I O GND hvn L=3.5e-07 W=0.65e-06
.ENDS INVX6

.SUBCKT INVX8 O I
M0 O I VDD VDD hvp L=3.0e-07 W=1e-06
M1 VDD I O VDD hvp L=3.0e-07 W=1e-06
M2 O I VDD VDD hvp L=3.0e-07 W=1e-06
M3 VDD I O VDD hvp L=3.0e-07 W=1e-06
M4 O I VDD VDD hvp L=3.0e-07 W=1e-06
M5 VDD I O VDD hvp L=3.0e-07 W=1e-06
M6 O I VDD VDD hvp L=3.0e-07 W=1e-06
M7 VDD I O VDD hvp L=3.0e-07 W=1e-06
M8 O I GND GND hvn L=3.5e-07 W=0.65e-06
M9 GND I O GND hvn L=3.5e-07 W=0.65e-06
M10 O I GND GND hvn L=3.5e-07 W=0.65e-06
M11 GND I O GND hvn L=3.5e-07 W=0.65e-06
M12 O I GND GND hvn L=3.5e-07 W=0.65e-06
M13 GND I O GND hvn L=3.5e-07 W=0.65e-06
M14 O I GND GND hvn L=3.5e-07 W=0.65e-06
M15 GND I O GND hvn L=3.5e-07 W=0.65e-06
.ENDS INVX8

.SUBCKT LOWLATCHRBX1 Q QB D RB CLB
M0 VDD D 1 VDD hvp L=3.0e-07 W=0.48e-06
M1 3 RB VDD VDD hvp L=3.0e-07 W=0.49e-06
M2 VDD CLB 4 VDD hvp L=3.0e-07 W=0.3e-06
M3 5 4 VDD VDD hvp L=3.0e-07 W=0.6e-06
M4 3 5 1 VDD hvp L=3.0e-07 W=0.6e-06
M5 6 4 3 VDD hvp L=3.0e-07 W=0.3e-06
M6 VDD 7 6 VDD hvp L=4.5e-07 W=0.3e-06
M7 7 3 VDD VDD hvp L=3.0e-07 W=0.3e-06
M8 VDD 3 Q VDD hvp L=3.0e-07 W=1e-06
M9 QB 7 VDD VDD hvp L=3.0e-07 W=1e-06
M10 10 D 1 GND hvn L=3.5e-07 W=0.3e-06
M11 GND RB 10 GND hvn L=3.5e-07 W=0.3e-06
M12 GND CLB 4 GND hvn L=3.5e-07 W=0.65e-06
M13 5 4 GND GND hvn L=3.5e-07 W=0.3e-06
M14 3 4 1 GND hvn L=3.5e-07 W=0.45e-06
M15 12 5 3 GND hvn L=3.5e-07 W=0.3e-06
M16 GND 7 12 GND hvn L=4.5e-07 W=0.3e-06
M17 7 3 GND GND hvn L=3.5e-07 W=0.3e-06
M18 GND 3 Q GND hvn L=3.5e-07 W=0.65e-06
M19 QB 7 GND GND hvn L=3.5e-07 W=0.65e-06
.ENDS LOWLATCHRBX1

.SUBCKT LOWLATCHRBX2 Q QB D RB CLB
M0 VDD D 1 VDD hvp L=3.0e-07 W=0.48e-06
M1 3 RB VDD VDD hvp L=3.0e-07 W=0.49e-06
M2 VDD CLB 4 VDD hvp L=3.0e-07 W=0.3e-06
M3 5 4 VDD VDD hvp L=3.0e-07 W=0.6e-06
M4 3 5 1 VDD hvp L=3.0e-07 W=0.6e-06
M5 6 4 3 VDD hvp L=3.0e-07 W=0.3e-06
M6 VDD 7 6 VDD hvp L=4.5e-07 W=0.3e-06
M7 7 3 VDD VDD hvp L=3.0e-07 W=0.3e-06
M8 Q 3 VDD VDD hvp L=3.0e-07 W=1e-06
M9 VDD 3 Q VDD hvp L=3.0e-07 W=1e-06
M10 QB 7 VDD VDD hvp L=3.0e-07 W=1e-06
M11 VDD 7 QB VDD hvp L=3.0e-07 W=1e-06
M12 10 D 1 GND hvn L=3.5e-07 W=0.3e-06
M13 GND RB 10 GND hvn L=3.5e-07 W=0.3e-06
M14 GND CLB 4 GND hvn L=3.5e-07 W=0.65e-06
M15 5 4 GND GND hvn L=3.5e-07 W=0.3e-06
M16 3 4 1 GND hvn L=3.5e-07 W=0.45e-06
M17 12 5 3 GND hvn L=3.5e-07 W=0.3e-06
M18 GND 7 12 GND hvn L=4.5e-07 W=0.3e-06
M19 7 3 GND GND hvn L=3.5e-07 W=0.3e-06
M20 Q 3 GND GND hvn L=3.5e-07 W=0.65e-06
M21 GND 3 Q GND hvn L=3.5e-07 W=0.65e-06
M22 QB 7 GND GND hvn L=3.5e-07 W=0.65e-06
M23 GND 7 QB GND hvn L=3.5e-07 W=0.65e-06
.ENDS LOWLATCHRBX2

.SUBCKT LOWLATCHRBX4 Q QB D RB CLB
M0 VDD D 1 VDD hvp L=3.0e-07 W=0.48e-06
M1 3 RB VDD VDD hvp L=3.0e-07 W=0.49e-06
M2 VDD CLB 4 VDD hvp L=3.0e-07 W=0.3e-06
M3 5 4 VDD VDD hvp L=3.0e-07 W=0.6e-06
M4 3 5 1 VDD hvp L=3.0e-07 W=0.6e-06
M5 6 4 3 VDD hvp L=3.0e-07 W=0.3e-06
M6 VDD 7 6 VDD hvp L=4.5e-07 W=0.3e-06
M7 7 3 VDD VDD hvp L=3.0e-07 W=0.3e-06
M8 Q 3 VDD VDD hvp L=3.0e-07 W=1e-06
M9 VDD 3 Q VDD hvp L=3.0e-07 W=1e-06
M10 Q 3 VDD VDD hvp L=3.0e-07 W=1e-06
M11 VDD 3 Q VDD hvp L=3.0e-07 W=1e-06
M12 QB 7 VDD VDD hvp L=3.0e-07 W=1e-06
M13 VDD 7 QB VDD hvp L=3.0e-07 W=1e-06
M14 QB 7 VDD VDD hvp L=3.0e-07 W=1e-06
M15 VDD 7 QB VDD hvp L=3.0e-07 W=1e-06
M16 10 D 1 GND hvn L=3.5e-07 W=0.3e-06
M17 GND RB 10 GND hvn L=3.5e-07 W=0.3e-06
M18 GND CLB 4 GND hvn L=3.5e-07 W=0.65e-06
M19 5 4 GND GND hvn L=3.5e-07 W=0.3e-06
M20 3 4 1 GND hvn L=3.5e-07 W=0.45e-06
M21 12 5 3 GND hvn L=3.5e-07 W=0.3e-06
M22 GND 7 12 GND hvn L=4.5e-07 W=0.3e-06
M23 7 3 GND GND hvn L=3.5e-07 W=0.3e-06
M24 Q 3 GND GND hvn L=3.5e-07 W=0.65e-06
M25 GND 3 Q GND hvn L=3.5e-07 W=0.65e-06
M26 Q 3 GND GND hvn L=3.5e-07 W=0.65e-06
M27 GND 3 Q GND hvn L=3.5e-07 W=0.65e-06
M28 QB 7 GND GND hvn L=3.5e-07 W=0.65e-06
M29 GND 7 QB GND hvn L=3.5e-07 W=0.65e-06
M30 QB 7 GND GND hvn L=3.5e-07 W=0.65e-06
M31 GND 7 QB GND hvn L=3.5e-07 W=0.65e-06
.ENDS LOWLATCHRBX4

.SUBCKT LOWLATCHX1 Q QB D CLB
M0 VDD D 1 VDD hvp L=3.0e-07 W=1e-06
M1 3 CLB VDD VDD hvp L=3.0e-07 W=0.3e-06
M2 4 3 VDD VDD hvp L=3.0e-07 W=0.6e-06
M3 5 4 1 VDD hvp L=3.0e-07 W=0.65e-06
M4 6 3 5 VDD hvp L=3.0e-07 W=0.3e-06
M5 VDD 7 6 VDD hvp L=3.0e-07 W=0.3e-06
M6 7 5 VDD VDD hvp L=3.0e-07 W=1e-06
M7 VDD 5 Q VDD hvp L=3.0e-07 W=1e-06
M8 QB 7 VDD VDD hvp L=3.0e-07 W=1e-06
M9 1 D GND GND hvn L=3.5e-07 W=0.65e-06
M10 GND CLB 3 GND hvn L=3.5e-07 W=0.6e-06
M11 4 3 GND GND hvn L=3.5e-07 W=0.3e-06
M12 5 3 1 GND hvn L=3.5e-07 W=0.4e-06
M13 11 4 5 GND hvn L=3.5e-07 W=0.3e-06
M14 GND 7 11 GND hvn L=3.5e-07 W=0.3e-06
M15 7 5 GND GND hvn L=3.5e-07 W=0.65e-06
M16 GND 5 Q GND hvn L=3.5e-07 W=0.65e-06
M17 QB 7 GND GND hvn L=3.5e-07 W=0.65e-06
.ENDS LOWLATCHX1

.SUBCKT LOWLATCHX2 Q QB D CLB
M0 VDD D 1 VDD hvp L=3.0e-07 W=1e-06
M1 3 CLB VDD VDD hvp L=3.0e-07 W=0.3e-06
M2 4 3 VDD VDD hvp L=3.0e-07 W=0.6e-06
M3 5 4 1 VDD hvp L=3.0e-07 W=0.65e-06
M4 6 3 5 VDD hvp L=3.0e-07 W=0.3e-06
M5 VDD 7 6 VDD hvp L=3.0e-07 W=0.3e-06
M6 7 5 VDD VDD hvp L=3.0e-07 W=1e-06
M7 Q 5 VDD VDD hvp L=3.0e-07 W=1e-06
M8 VDD 5 Q VDD hvp L=3.0e-07 W=1e-06
M9 QB 7 VDD VDD hvp L=3.0e-07 W=1e-06
M10 VDD 7 QB VDD hvp L=3.0e-07 W=1e-06
M11 1 D GND GND hvn L=3.5e-07 W=0.65e-06
M12 GND CLB 3 GND hvn L=3.5e-07 W=0.6e-06
M13 4 3 GND GND hvn L=3.5e-07 W=0.3e-06
M14 5 3 1 GND hvn L=3.5e-07 W=0.4e-06
M15 11 4 5 GND hvn L=3.5e-07 W=0.3e-06
M16 GND 7 11 GND hvn L=3.5e-07 W=0.3e-06
M17 7 5 GND GND hvn L=3.5e-07 W=0.65e-06
M18 Q 5 GND GND hvn L=3.5e-07 W=0.65e-06
M19 GND 5 Q GND hvn L=3.5e-07 W=0.65e-06
M20 QB 7 GND GND hvn L=3.5e-07 W=0.65e-06
M21 GND 7 QB GND hvn L=3.5e-07 W=0.65e-06
.ENDS LOWLATCHX2

.SUBCKT LOWLATCHX4 Q QB D CLB
M0 VDD D 1 VDD hvp L=3.0e-07 W=1e-06
M1 3 CLB VDD VDD hvp L=3.0e-07 W=0.3e-06
M2 4 3 VDD VDD hvp L=3.0e-07 W=0.6e-06
M3 5 4 1 VDD hvp L=3.0e-07 W=0.65e-06
M4 6 3 5 VDD hvp L=3.0e-07 W=0.3e-06
M5 VDD 7 6 VDD hvp L=3.0e-07 W=0.3e-06
M6 7 5 VDD VDD hvp L=3.0e-07 W=1e-06
M7 Q 5 VDD VDD hvp L=3.0e-07 W=1e-06
M8 VDD 5 Q VDD hvp L=3.0e-07 W=1e-06
M9 Q 5 VDD VDD hvp L=3.0e-07 W=1e-06
M10 VDD 5 Q VDD hvp L=3.0e-07 W=1e-06
M11 QB 7 VDD VDD hvp L=3.0e-07 W=1e-06
M12 VDD 7 QB VDD hvp L=3.0e-07 W=1e-06
M13 QB 7 VDD VDD hvp L=3.0e-07 W=1e-06
M14 VDD 7 QB VDD hvp L=3.0e-07 W=1e-06
M15 1 D GND GND hvn L=3.5e-07 W=0.65e-06
M16 GND CLB 3 GND hvn L=3.5e-07 W=0.6e-06
M17 4 3 GND GND hvn L=3.5e-07 W=0.3e-06
M18 5 3 1 GND hvn L=3.5e-07 W=0.4e-06
M19 11 4 5 GND hvn L=3.5e-07 W=0.3e-06
M20 GND 7 11 GND hvn L=3.5e-07 W=0.3e-06
M21 7 5 GND GND hvn L=3.5e-07 W=0.65e-06
M22 Q 5 GND GND hvn L=3.5e-07 W=0.65e-06
M23 GND 5 Q GND hvn L=3.5e-07 W=0.65e-06
M24 Q 5 GND GND hvn L=3.5e-07 W=0.65e-06
M25 GND 5 Q GND hvn L=3.5e-07 W=0.65e-06
M26 QB 7 GND GND hvn L=3.5e-07 W=0.65e-06
M27 GND 7 QB GND hvn L=3.5e-07 W=0.65e-06
M28 QB 7 GND GND hvn L=3.5e-07 W=0.65e-06
M29 GND 7 QB GND hvn L=3.5e-07 W=0.65e-06
.ENDS LOWLATCHX4

.SUBCKT LOWMUX2X1 O EB I0 I1 S
M0 VDD S 1 VDD hvp L=3.0e-07 W=1e-06
M1 3 I0 VDD VDD hvp L=3.0e-07 W=1e-06
M2 4 S 3 VDD hvp L=3.0e-07 W=0.6e-06
M3 5 1 4 VDD hvp L=3.0e-07 W=0.6e-06
M4 VDD I1 5 VDD hvp L=3.0e-07 W=1e-06
M5 6 4 VDD VDD hvp L=3.0e-07 W=1e-06
M6 O EB 6 VDD hvp L=3.0e-07 W=1e-06
M7 8 EB O VDD hvp L=3.0e-07 W=1e-06
M8 VDD 4 8 VDD hvp L=3.0e-07 W=1e-06
M9 GND S 1 GND hvn L=3.5e-07 W=0.65e-06
M10 10 I0 GND GND hvn L=3.5e-07 W=0.65e-06
M11 4 1 10 GND hvn L=3.5e-07 W=0.4e-06
M12 11 S 4 GND hvn L=3.5e-07 W=0.4e-06
M13 GND I1 11 GND hvn L=3.5e-07 W=0.65e-06
M14 O 4 GND GND hvn L=3.5e-07 W=0.65e-06
M15 GND EB O GND hvn L=3.5e-07 W=0.65e-06
.ENDS LOWMUX2X1

.SUBCKT LOWMUX2X2 O EB I0 I1 S
M0 VDD S 1 VDD hvp L=3.0e-07 W=0.9e-06
M1 3 I0 VDD VDD hvp L=3.0e-07 W=0.9e-06
M2 4 S 3 VDD hvp L=3.0e-07 W=0.6e-06
M3 5 1 4 VDD hvp L=3.0e-07 W=0.6e-06
M4 VDD I1 5 VDD hvp L=3.0e-07 W=0.9e-06
M5 6 4 VDD VDD hvp L=3.0e-07 W=0.9e-06
M6 O EB 6 VDD hvp L=3.0e-07 W=0.9e-06
M7 8 EB O VDD hvp L=3.0e-07 W=0.9e-06
M8 VDD 4 8 VDD hvp L=3.0e-07 W=0.9e-06
M9 9 4 VDD VDD hvp L=3.0e-07 W=0.9e-06
M10 O EB 9 VDD hvp L=3.0e-07 W=0.9e-06
M11 10 EB O VDD hvp L=3.0e-07 W=0.9e-06
M12 VDD 4 10 VDD hvp L=3.0e-07 W=0.9e-06
M13 GND S 1 GND hvn L=3.5e-07 W=0.6e-06
M14 12 I0 GND GND hvn L=3.5e-07 W=0.6e-06
M15 4 1 12 GND hvn L=3.5e-07 W=0.4e-06
M16 13 S 4 GND hvn L=3.5e-07 W=0.4e-06
M17 GND I1 13 GND hvn L=3.5e-07 W=0.6e-06
M18 O 4 GND GND hvn L=3.5e-07 W=0.6e-06
M19 GND EB O GND hvn L=3.5e-07 W=0.6e-06
M20 O 4 GND GND hvn L=3.5e-07 W=0.6e-06
M21 GND EB O GND hvn L=3.5e-07 W=0.6e-06
.ENDS LOWMUX2X2

.SUBCKT LOWMUX2X3 O EB I0 I1 S
M0 VDD S 1 VDD hvp L=3.0e-07 W=1e-06
M1 3 I0 VDD VDD hvp L=3.0e-07 W=1e-06
M2 4 S 3 VDD hvp L=3.0e-07 W=0.6e-06
M3 5 1 4 VDD hvp L=3.0e-07 W=0.6e-06
M4 VDD I1 5 VDD hvp L=3.0e-07 W=1e-06
M5 6 4 VDD VDD hvp L=3.0e-07 W=1e-06
M6 7 EB 6 VDD hvp L=3.0e-07 W=1e-06
M7 VDD 7 8 VDD hvp L=3.0e-07 W=1e-06
M8 O 8 VDD VDD hvp L=3.0e-07 W=1e-06
M9 VDD 8 O VDD hvp L=3.0e-07 W=1e-06
M10 O 8 VDD VDD hvp L=3.0e-07 W=1e-06
M11 GND S 1 GND hvn L=3.5e-07 W=0.65e-06
M12 11 I0 GND GND hvn L=3.5e-07 W=0.65e-06
M13 4 1 11 GND hvn L=3.5e-07 W=0.4e-06
M14 12 S 4 GND hvn L=3.5e-07 W=0.4e-06
M15 GND I1 12 GND hvn L=3.5e-07 W=0.65e-06
M16 7 4 GND GND hvn L=3.5e-07 W=0.65e-06
M17 GND EB 7 GND hvn L=3.5e-07 W=0.65e-06
M18 GND 7 8 GND hvn L=3.5e-07 W=0.65e-06
M19 O 8 GND GND hvn L=3.5e-07 W=0.65e-06
M20 GND 8 O GND hvn L=3.5e-07 W=0.65e-06
M21 O 8 GND GND hvn L=3.5e-07 W=0.65e-06
.ENDS LOWMUX2X3

.SUBCKT LOWMUX2X4 O EB I0 I1 S
M0 VDD S 1 VDD hvp L=3.0e-07 W=1e-06
M1 3 I0 VDD VDD hvp L=3.0e-07 W=1e-06
M2 4 S 3 VDD hvp L=3.0e-07 W=0.6e-06
M3 5 1 4 VDD hvp L=3.0e-07 W=0.6e-06
M4 VDD I1 5 VDD hvp L=3.0e-07 W=1e-06
M5 6 4 VDD VDD hvp L=3.0e-07 W=1e-06
M6 7 EB 6 VDD hvp L=3.0e-07 W=1e-06
M7 VDD 7 8 VDD hvp L=3.0e-07 W=1e-06
M8 O 8 VDD VDD hvp L=3.0e-07 W=1e-06
M9 VDD 8 O VDD hvp L=3.0e-07 W=1e-06
M10 O 8 VDD VDD hvp L=3.0e-07 W=1e-06
M11 VDD 8 O VDD hvp L=3.0e-07 W=1e-06
M12 GND S 1 GND hvn L=3.5e-07 W=0.65e-06
M13 11 I0 GND GND hvn L=3.5e-07 W=0.65e-06
M14 4 1 11 GND hvn L=3.5e-07 W=0.4e-06
M15 12 S 4 GND hvn L=3.5e-07 W=0.4e-06
M16 GND I1 12 GND hvn L=3.5e-07 W=0.65e-06
M17 7 4 GND GND hvn L=3.5e-07 W=0.65e-06
M18 GND EB 7 GND hvn L=3.5e-07 W=0.65e-06
M19 GND 7 8 GND hvn L=3.5e-07 W=0.65e-06
M20 O 8 GND GND hvn L=3.5e-07 W=0.65e-06
M21 GND 8 O GND hvn L=3.5e-07 W=0.65e-06
M22 O 8 GND GND hvn L=3.5e-07 W=0.65e-06
M23 GND 8 O GND hvn L=3.5e-07 W=0.65e-06
.ENDS LOWMUX2X4

.SUBCKT LOWMUX4X1 O EB I0 I1 I2 I3 S0 S1
M0 2 I0 VDD VDD hvp L=3.0e-07 W=0.65e-06
M1 3 S0 2 VDD hvp L=3.0e-07 W=0.45e-06
M2 4 5 3 VDD hvp L=3.0e-07 W=0.45e-06
M3 VDD I1 4 VDD hvp L=3.0e-07 W=0.5e-06
M4 5 S0 VDD VDD hvp L=3.0e-07 W=0.5e-06
M5 6 I3 VDD VDD hvp L=3.0e-07 W=0.5e-06
M6 7 5 6 VDD hvp L=3.0e-07 W=0.45e-06
M7 8 S0 7 VDD hvp L=3.0e-07 W=0.45e-06
M8 VDD I2 8 VDD hvp L=3.0e-07 W=0.5e-06
M9 9 10 7 VDD hvp L=3.0e-07 W=0.45e-06
M10 3 S1 9 VDD hvp L=3.0e-07 W=0.45e-06
M11 VDD S1 10 VDD hvp L=3.0e-07 W=0.65e-06
M12 11 9 VDD VDD hvp L=3.0e-07 W=0.65e-06
M13 O EB 11 VDD hvp L=3.0e-07 W=1e-06
M14 13 EB O VDD hvp L=3.0e-07 W=1e-06
M15 VDD 9 13 VDD hvp L=3.0e-07 W=0.65e-06
M16 15 I0 GND GND hvn L=3.5e-07 W=0.45e-06
M17 3 5 15 GND hvn L=3.5e-07 W=0.3e-06
M18 16 S0 3 GND hvn L=3.5e-07 W=0.3e-06
M19 GND I1 16 GND hvn L=3.5e-07 W=0.34e-06
M20 5 S0 GND GND hvn L=3.5e-07 W=0.35e-06
M21 17 I3 GND GND hvn L=3.5e-07 W=0.34e-06
M22 7 S0 17 GND hvn L=3.5e-07 W=0.3e-06
M23 18 5 7 GND hvn L=3.5e-07 W=0.3e-06
M24 GND I2 18 GND hvn L=3.5e-07 W=0.35e-06
M25 9 S1 7 GND hvn L=3.5e-07 W=0.3e-06
M26 3 10 9 GND hvn L=3.5e-07 W=0.3e-06
M27 GND S1 10 GND hvn L=3.5e-07 W=0.45e-06
M28 O 9 GND GND hvn L=3.5e-07 W=0.65e-06
M29 GND EB O GND hvn L=3.5e-07 W=0.65e-06
.ENDS LOWMUX4X1

.SUBCKT LOWMUX4X2 O EB I0 I1 I2 I3 S0 S1
M0 2 I0 VDD VDD hvp L=3.0e-07 W=0.65e-06
M1 3 S0 2 VDD hvp L=3.0e-07 W=0.45e-06
M2 4 5 3 VDD hvp L=3.0e-07 W=0.45e-06
M3 VDD I1 4 VDD hvp L=3.0e-07 W=0.5e-06
M4 5 S0 VDD VDD hvp L=3.0e-07 W=0.5e-06
M5 6 I3 VDD VDD hvp L=3.0e-07 W=0.5e-06
M6 7 5 6 VDD hvp L=3.0e-07 W=0.45e-06
M7 8 S0 7 VDD hvp L=3.0e-07 W=0.45e-06
M8 VDD I2 8 VDD hvp L=3.0e-07 W=0.5e-06
M9 9 10 7 VDD hvp L=3.0e-07 W=0.45e-06
M10 3 S1 9 VDD hvp L=3.0e-07 W=0.45e-06
M11 VDD S1 10 VDD hvp L=3.0e-07 W=0.65e-06
M12 11 9 VDD VDD hvp L=3.0e-07 W=0.65e-06
M13 12 EB 11 VDD hvp L=3.0e-07 W=0.65e-06
M14 VDD 12 13 VDD hvp L=3.0e-07 W=1e-06
M15 O 13 VDD VDD hvp L=3.0e-07 W=1e-06
M16 VDD 13 O VDD hvp L=3.0e-07 W=1e-06
M17 16 I0 GND GND hvn L=3.5e-07 W=0.45e-06
M18 3 5 16 GND hvn L=3.5e-07 W=0.3e-06
M19 17 S0 3 GND hvn L=3.5e-07 W=0.3e-06
M20 GND I1 17 GND hvn L=3.5e-07 W=0.34e-06
M21 5 S0 GND GND hvn L=3.5e-07 W=0.35e-06
M22 18 I3 GND GND hvn L=3.5e-07 W=0.34e-06
M23 7 S0 18 GND hvn L=3.5e-07 W=0.3e-06
M24 19 5 7 GND hvn L=3.5e-07 W=0.3e-06
M25 GND I2 19 GND hvn L=3.5e-07 W=0.35e-06
M26 9 S1 7 GND hvn L=3.5e-07 W=0.3e-06
M27 3 10 9 GND hvn L=3.5e-07 W=0.3e-06
M28 GND S1 10 GND hvn L=3.5e-07 W=0.45e-06
M29 12 9 GND GND hvn L=3.5e-07 W=0.45e-06
M30 GND EB 12 GND hvn L=3.5e-07 W=0.45e-06
M31 GND 12 13 GND hvn L=3.5e-07 W=0.65e-06
M32 O 13 GND GND hvn L=3.5e-07 W=0.65e-06
M33 GND 13 O GND hvn L=3.5e-07 W=0.65e-06
.ENDS LOWMUX4X2

.SUBCKT LOWMUX4X3 O EB I0 I1 I2 I3 S0 S1
M0 2 I0 VDD VDD hvp L=3.0e-07 W=0.65e-06
M1 3 S0 2 VDD hvp L=3.0e-07 W=0.45e-06
M2 4 5 3 VDD hvp L=3.0e-07 W=0.45e-06
M3 VDD I1 4 VDD hvp L=3.0e-07 W=0.5e-06
M4 5 S0 VDD VDD hvp L=3.0e-07 W=0.5e-06
M5 6 I3 VDD VDD hvp L=3.0e-07 W=0.5e-06
M6 7 5 6 VDD hvp L=3.0e-07 W=0.45e-06
M7 8 S0 7 VDD hvp L=3.0e-07 W=0.45e-06
M8 VDD I2 8 VDD hvp L=3.0e-07 W=0.5e-06
M9 9 10 7 VDD hvp L=3.0e-07 W=0.45e-06
M10 3 S1 9 VDD hvp L=3.0e-07 W=0.45e-06
M11 VDD S1 10 VDD hvp L=3.0e-07 W=0.65e-06
M12 11 9 VDD VDD hvp L=3.0e-07 W=0.65e-06
M13 12 EB 11 VDD hvp L=3.0e-07 W=0.65e-06
M14 VDD 12 13 VDD hvp L=3.0e-07 W=1e-06
M15 O 13 VDD VDD hvp L=3.0e-07 W=1e-06
M16 VDD 13 O VDD hvp L=3.0e-07 W=1e-06
M17 O 13 VDD VDD hvp L=3.0e-07 W=1e-06
M18 16 I0 GND GND hvn L=3.5e-07 W=0.45e-06
M19 3 5 16 GND hvn L=3.5e-07 W=0.3e-06
M20 17 S0 3 GND hvn L=3.5e-07 W=0.3e-06
M21 GND I1 17 GND hvn L=3.5e-07 W=0.34e-06
M22 5 S0 GND GND hvn L=3.5e-07 W=0.35e-06
M23 18 I3 GND GND hvn L=3.5e-07 W=0.34e-06
M24 7 S0 18 GND hvn L=3.5e-07 W=0.3e-06
M25 19 5 7 GND hvn L=3.5e-07 W=0.3e-06
M26 GND I2 19 GND hvn L=3.5e-07 W=0.35e-06
M27 9 S1 7 GND hvn L=3.5e-07 W=0.3e-06
M28 3 10 9 GND hvn L=3.5e-07 W=0.3e-06
M29 GND S1 10 GND hvn L=3.5e-07 W=0.45e-06
M30 12 9 GND GND hvn L=3.5e-07 W=0.45e-06
M31 GND EB 12 GND hvn L=3.5e-07 W=0.45e-06
M32 GND 12 13 GND hvn L=3.5e-07 W=0.65e-06
M33 O 13 GND GND hvn L=3.5e-07 W=0.65e-06
M34 GND 13 O GND hvn L=3.5e-07 W=0.65e-06
M35 O 13 GND GND hvn L=3.5e-07 W=0.65e-06
.ENDS LOWMUX4X3

.SUBCKT LOWMUX4X4 O EB I0 I1 I2 I3 S0 S1
M0 2 I0 VDD VDD hvp L=3.0e-07 W=0.65e-06
M1 3 S0 2 VDD hvp L=3.0e-07 W=0.45e-06
M2 4 5 3 VDD hvp L=3.0e-07 W=0.45e-06
M3 VDD I1 4 VDD hvp L=3.0e-07 W=0.5e-06
M4 5 S0 VDD VDD hvp L=3.0e-07 W=0.5e-06
M5 6 I3 VDD VDD hvp L=3.0e-07 W=0.5e-06
M6 7 5 6 VDD hvp L=3.0e-07 W=0.45e-06
M7 8 S0 7 VDD hvp L=3.0e-07 W=0.45e-06
M8 VDD I2 8 VDD hvp L=3.0e-07 W=0.5e-06
M9 9 10 7 VDD hvp L=3.0e-07 W=0.45e-06
M10 3 S1 9 VDD hvp L=3.0e-07 W=0.45e-06
M11 VDD S1 10 VDD hvp L=3.0e-07 W=0.65e-06
M12 11 9 VDD VDD hvp L=3.0e-07 W=0.65e-06
M13 12 EB 11 VDD hvp L=3.0e-07 W=0.65e-06
M14 VDD 12 13 VDD hvp L=3.0e-07 W=1e-06
M15 O 13 VDD VDD hvp L=3.0e-07 W=1e-06
M16 VDD 13 O VDD hvp L=3.0e-07 W=1e-06
M17 O 13 VDD VDD hvp L=3.0e-07 W=1e-06
M18 VDD 13 O VDD hvp L=3.0e-07 W=1e-06
M19 16 I0 GND GND hvn L=3.5e-07 W=0.45e-06
M20 3 5 16 GND hvn L=3.5e-07 W=0.3e-06
M21 17 S0 3 GND hvn L=3.5e-07 W=0.3e-06
M22 GND I1 17 GND hvn L=3.5e-07 W=0.34e-06
M23 5 S0 GND GND hvn L=3.5e-07 W=0.35e-06
M24 18 I3 GND GND hvn L=3.5e-07 W=0.34e-06
M25 7 S0 18 GND hvn L=3.5e-07 W=0.3e-06
M26 19 5 7 GND hvn L=3.5e-07 W=0.3e-06
M27 GND I2 19 GND hvn L=3.5e-07 W=0.35e-06
M28 9 S1 7 GND hvn L=3.5e-07 W=0.3e-06
M29 3 10 9 GND hvn L=3.5e-07 W=0.3e-06
M30 GND S1 10 GND hvn L=3.5e-07 W=0.45e-06
M31 12 9 GND GND hvn L=3.5e-07 W=0.45e-06
M32 GND EB 12 GND hvn L=3.5e-07 W=0.45e-06
M33 GND 12 13 GND hvn L=3.5e-07 W=0.65e-06
M34 O 13 GND GND hvn L=3.5e-07 W=0.65e-06
M35 GND 13 O GND hvn L=3.5e-07 W=0.65e-06
M36 O 13 GND GND hvn L=3.5e-07 W=0.65e-06
M37 GND 13 O GND hvn L=3.5e-07 W=0.65e-06
.ENDS LOWMUX4X4

.SUBCKT MUX2BX1 OB I0 I1 S
M0 VDD S 1 VDD hvp L=3.0e-07 W=0.5e-06
M1 3 S VDD VDD hvp L=3.0e-07 W=0.5e-06
M2 OB I0 3 VDD hvp L=3.0e-07 W=0.5e-06
M3 5 I1 OB VDD hvp L=3.0e-07 W=0.5e-06
M4 VDD 1 5 VDD hvp L=3.0e-07 W=0.5e-06
M5 GND S 1 GND hvn L=3.5e-07 W=0.35e-06
M6 7 1 GND GND hvn L=3.5e-07 W=0.35e-06
M7 OB I0 7 GND hvn L=3.5e-07 W=0.35e-06
M8 8 I1 OB GND hvn L=3.5e-07 W=0.35e-06
M9 GND S 8 GND hvn L=3.5e-07 W=0.35e-06
.ENDS MUX2BX1

.SUBCKT MUX2BX2 OB I0 I1 S
M0 VDD S 1 VDD hvp L=3.0e-07 W=1e-06
M1 3 I0 VDD VDD hvp L=3.0e-07 W=1e-06
M2 4 S 3 VDD hvp L=3.0e-07 W=0.6e-06
M3 5 1 4 VDD hvp L=3.0e-07 W=0.6e-06
M4 VDD I1 5 VDD hvp L=3.0e-07 W=1e-06
M5 6 4 VDD VDD hvp L=3.0e-07 W=1e-06
M6 OB 6 VDD VDD hvp L=3.0e-07 W=1e-06
M7 VDD 6 OB VDD hvp L=3.0e-07 W=1e-06
M8 GND S 1 GND hvn L=3.5e-07 W=0.65e-06
M9 9 I0 GND GND hvn L=3.5e-07 W=0.65e-06
M10 4 1 9 GND hvn L=3.5e-07 W=0.4e-06
M11 10 S 4 GND hvn L=3.5e-07 W=0.4e-06
M12 GND I1 10 GND hvn L=3.5e-07 W=0.65e-06
M13 6 4 GND GND hvn L=3.5e-07 W=0.65e-06
M14 OB 6 GND GND hvn L=3.5e-07 W=0.65e-06
M15 GND 6 OB GND hvn L=3.5e-07 W=0.65e-06
.ENDS MUX2BX2

.SUBCKT MUX2BX3 OB I0 I1 S
M0 VDD S 1 VDD hvp L=3.0e-07 W=1e-06
M1 3 I0 VDD VDD hvp L=3.0e-07 W=1e-06
M2 4 S 3 VDD hvp L=3.0e-07 W=0.6e-06
M3 5 1 4 VDD hvp L=3.0e-07 W=0.6e-06
M4 VDD I1 5 VDD hvp L=3.0e-07 W=1e-06
M5 6 4 VDD VDD hvp L=3.0e-07 W=1e-06
M6 OB 6 VDD VDD hvp L=3.0e-07 W=1e-06
M7 VDD 6 OB VDD hvp L=3.0e-07 W=1e-06
M8 OB 6 VDD VDD hvp L=3.0e-07 W=1e-06
M9 GND S 1 GND hvn L=3.5e-07 W=0.65e-06
M10 9 I0 GND GND hvn L=3.5e-07 W=0.65e-06
M11 4 1 9 GND hvn L=3.5e-07 W=0.4e-06
M12 10 S 4 GND hvn L=3.5e-07 W=0.4e-06
M13 GND I1 10 GND hvn L=3.5e-07 W=0.65e-06
M14 6 4 GND GND hvn L=3.5e-07 W=0.65e-06
M15 OB 6 GND GND hvn L=3.5e-07 W=0.65e-06
M16 GND 6 OB GND hvn L=3.5e-07 W=0.65e-06
M17 OB 6 GND GND hvn L=3.5e-07 W=0.65e-06
.ENDS MUX2BX3

.SUBCKT MUX2BX4 OB I0 I1 S
M0 VDD S 1 VDD hvp L=3.0e-07 W=1e-06
M1 3 I0 VDD VDD hvp L=3.0e-07 W=1e-06
M2 4 S 3 VDD hvp L=3.0e-07 W=0.6e-06
M3 5 1 4 VDD hvp L=3.0e-07 W=0.6e-06
M4 VDD I1 5 VDD hvp L=3.0e-07 W=1e-06
M5 6 4 VDD VDD hvp L=3.0e-07 W=1e-06
M6 OB 6 VDD VDD hvp L=3.0e-07 W=1e-06
M7 VDD 6 OB VDD hvp L=3.0e-07 W=1e-06
M8 OB 6 VDD VDD hvp L=3.0e-07 W=1e-06
M9 VDD 6 OB VDD hvp L=3.0e-07 W=1e-06
M10 GND S 1 GND hvn L=3.5e-07 W=0.65e-06
M11 9 I0 GND GND hvn L=3.5e-07 W=0.65e-06
M12 4 1 9 GND hvn L=3.5e-07 W=0.4e-06
M13 10 S 4 GND hvn L=3.5e-07 W=0.4e-06
M14 GND I1 10 GND hvn L=3.5e-07 W=0.65e-06
M15 6 4 GND GND hvn L=3.5e-07 W=0.65e-06
M16 OB 6 GND GND hvn L=3.5e-07 W=0.65e-06
M17 GND 6 OB GND hvn L=3.5e-07 W=0.65e-06
M18 OB 6 GND GND hvn L=3.5e-07 W=0.65e-06
M19 GND 6 OB GND hvn L=3.5e-07 W=0.65e-06
.ENDS MUX2BX4

.SUBCKT MUX2X1 O I0 I1 S
M0 VDD S 1 VDD hvp L=3.0e-07 W=0.6e-06
M1 3 I0 VDD VDD hvp L=3.0e-07 W=1e-06
M2 4 S 3 VDD hvp L=3.0e-07 W=0.6e-06
M3 5 1 4 VDD hvp L=3.0e-07 W=0.6e-06
M4 VDD I1 5 VDD hvp L=3.0e-07 W=1e-06
M5 O 4 VDD VDD hvp L=3.0e-07 W=1e-06
M6 GND S 1 GND hvn L=3.5e-07 W=0.4e-06
M7 8 I0 GND GND hvn L=3.5e-07 W=0.65e-06
M8 4 1 8 GND hvn L=3.5e-07 W=0.4e-06
M9 9 S 4 GND hvn L=3.5e-07 W=0.4e-06
M10 GND I1 9 GND hvn L=3.5e-07 W=0.65e-06
M11 O 4 GND GND hvn L=3.5e-07 W=0.65e-06
.ENDS MUX2X1

.SUBCKT MUX2X2 O I0 I1 S
M0 VDD S 1 VDD hvp L=3.0e-07 W=0.6e-06
M1 3 I0 VDD VDD hvp L=3.0e-07 W=1e-06
M2 4 S 3 VDD hvp L=3.0e-07 W=0.6e-06
M3 5 1 4 VDD hvp L=3.0e-07 W=0.6e-06
M4 VDD I1 5 VDD hvp L=3.0e-07 W=1e-06
M5 O 4 VDD VDD hvp L=3.0e-07 W=1e-06
M6 VDD 4 O VDD hvp L=3.0e-07 W=1e-06
M7 GND S 1 GND hvn L=3.5e-07 W=0.4e-06
M8 8 I0 GND GND hvn L=3.5e-07 W=0.65e-06
M9 4 1 8 GND hvn L=3.5e-07 W=0.4e-06
M10 9 S 4 GND hvn L=3.5e-07 W=0.4e-06
M11 GND I1 9 GND hvn L=3.5e-07 W=0.65e-06
M12 O 4 GND GND hvn L=3.5e-07 W=0.65e-06
M13 GND 4 O GND hvn L=3.5e-07 W=0.65e-06
.ENDS MUX2X2

.SUBCKT MUX2X4 O I0 I1 S
M0 VDD S 1 VDD hvp L=3.0e-07 W=0.6e-06
M1 3 I0 VDD VDD hvp L=3.0e-07 W=1e-06
M2 4 S 3 VDD hvp L=3.0e-07 W=0.6e-06
M3 5 1 4 VDD hvp L=3.0e-07 W=0.6e-06
M4 VDD I1 5 VDD hvp L=3.0e-07 W=1e-06
M5 O 4 VDD VDD hvp L=3.0e-07 W=1e-06
M6 VDD 4 O VDD hvp L=3.0e-07 W=1e-06
M7 O 4 VDD VDD hvp L=3.0e-07 W=1e-06
M8 VDD 4 O VDD hvp L=3.0e-07 W=1e-06
M9 GND S 1 GND hvn L=3.5e-07 W=0.4e-06
M10 8 I0 GND GND hvn L=3.5e-07 W=0.65e-06
M11 4 1 8 GND hvn L=3.5e-07 W=0.4e-06
M12 9 S 4 GND hvn L=3.5e-07 W=0.4e-06
M13 GND I1 9 GND hvn L=3.5e-07 W=0.65e-06
M14 O 4 GND GND hvn L=3.5e-07 W=0.65e-06
M15 GND 4 O GND hvn L=3.5e-07 W=0.65e-06
M16 O 4 GND GND hvn L=3.5e-07 W=0.65e-06
M17 GND 4 O GND hvn L=3.5e-07 W=0.65e-06
.ENDS MUX2X4

.SUBCKT MUX3X1 O I0 I1 I2 S0 S1
M0 VDD S0 1 VDD hvp L=3.0e-07 W=1e-06
M1 3 I1 VDD VDD hvp L=3.0e-07 W=1e-06
M2 4 1 3 VDD hvp L=3.0e-07 W=0.6e-06
M3 5 S0 4 VDD hvp L=3.0e-07 W=0.6e-06
M4 VDD I0 5 VDD hvp L=3.0e-07 W=1e-06
M5 6 I2 VDD VDD hvp L=3.0e-07 W=1e-06
M6 7 8 6 VDD hvp L=3.0e-07 W=0.55e-06
M7 4 S1 7 VDD hvp L=3.0e-07 W=0.55e-06
M8 VDD S1 8 VDD hvp L=3.0e-07 W=0.75e-06
M9 O 7 VDD VDD hvp L=3.0e-07 W=1e-06
M10 GND S0 1 GND hvn L=3.5e-07 W=0.65e-06
M11 11 I1 GND GND hvn L=3.5e-07 W=0.65e-06
M12 4 S0 11 GND hvn L=3.5e-07 W=0.4e-06
M13 12 1 4 GND hvn L=3.5e-07 W=0.4e-06
M14 GND I0 12 GND hvn L=3.5e-07 W=0.65e-06
M15 13 I2 GND GND hvn L=3.5e-07 W=0.65e-06
M16 7 S1 13 GND hvn L=3.5e-07 W=0.35e-06
M17 4 8 7 GND hvn L=3.5e-07 W=0.35e-06
M18 GND S1 8 GND hvn L=3.5e-07 W=0.5e-06
M19 O 7 GND GND hvn L=3.5e-07 W=0.65e-06
.ENDS MUX3X1

.SUBCKT MUX3X2 O I0 I1 I2 S0 S1
M0 VDD S0 1 VDD hvp L=3.0e-07 W=1e-06
M1 3 I1 VDD VDD hvp L=3.0e-07 W=1e-06
M2 4 1 3 VDD hvp L=3.0e-07 W=0.6e-06
M3 5 S0 4 VDD hvp L=3.0e-07 W=0.6e-06
M4 VDD I0 5 VDD hvp L=3.0e-07 W=1e-06
M5 6 I2 VDD VDD hvp L=3.0e-07 W=1e-06
M6 7 8 6 VDD hvp L=3.0e-07 W=0.55e-06
M7 4 S1 7 VDD hvp L=3.0e-07 W=0.55e-06
M8 VDD S1 8 VDD hvp L=3.0e-07 W=0.75e-06
M9 O 7 VDD VDD hvp L=3.0e-07 W=1e-06
M10 VDD 7 O VDD hvp L=3.0e-07 W=1e-06
M11 GND S0 1 GND hvn L=3.5e-07 W=0.65e-06
M12 11 I1 GND GND hvn L=3.5e-07 W=0.65e-06
M13 4 S0 11 GND hvn L=3.5e-07 W=0.4e-06
M14 12 1 4 GND hvn L=3.5e-07 W=0.4e-06
M15 GND I0 12 GND hvn L=3.5e-07 W=0.65e-06
M16 13 I2 GND GND hvn L=3.5e-07 W=0.65e-06
M17 7 S1 13 GND hvn L=3.5e-07 W=0.35e-06
M18 4 8 7 GND hvn L=3.5e-07 W=0.35e-06
M19 GND S1 8 GND hvn L=3.5e-07 W=0.5e-06
M20 O 7 GND GND hvn L=3.5e-07 W=0.65e-06
M21 GND 7 O GND hvn L=3.5e-07 W=0.65e-06
.ENDS MUX3X2

.SUBCKT MUX3X4 O I0 I1 I2 S0 S1
M0 VDD S0 1 VDD hvp L=3.0e-07 W=1e-06
M1 3 I1 VDD VDD hvp L=3.0e-07 W=1e-06
M2 4 1 3 VDD hvp L=3.0e-07 W=0.6e-06
M3 5 S0 4 VDD hvp L=3.0e-07 W=0.6e-06
M4 VDD I0 5 VDD hvp L=3.0e-07 W=1e-06
M5 6 I2 VDD VDD hvp L=3.0e-07 W=1e-06
M6 7 8 6 VDD hvp L=3.0e-07 W=0.55e-06
M7 4 S1 7 VDD hvp L=3.0e-07 W=0.55e-06
M8 VDD S1 8 VDD hvp L=3.0e-07 W=0.75e-06
M9 O 7 VDD VDD hvp L=3.0e-07 W=1e-06
M10 VDD 7 O VDD hvp L=3.0e-07 W=1e-06
M11 O 7 VDD VDD hvp L=3.0e-07 W=1e-06
M12 VDD 7 O VDD hvp L=3.0e-07 W=1e-06
M13 GND S0 1 GND hvn L=3.5e-07 W=0.65e-06
M14 11 I1 GND GND hvn L=3.5e-07 W=0.65e-06
M15 4 S0 11 GND hvn L=3.5e-07 W=0.4e-06
M16 12 1 4 GND hvn L=3.5e-07 W=0.4e-06
M17 GND I0 12 GND hvn L=3.5e-07 W=0.65e-06
M18 13 I2 GND GND hvn L=3.5e-07 W=0.65e-06
M19 7 S1 13 GND hvn L=3.5e-07 W=0.35e-06
M20 4 8 7 GND hvn L=3.5e-07 W=0.35e-06
M21 GND S1 8 GND hvn L=3.5e-07 W=0.5e-06
M22 O 7 GND GND hvn L=3.5e-07 W=0.65e-06
M23 GND 7 O GND hvn L=3.5e-07 W=0.65e-06
M24 O 7 GND GND hvn L=3.5e-07 W=0.65e-06
M25 GND 7 O GND hvn L=3.5e-07 W=0.65e-06
.ENDS MUX3X4

.SUBCKT MUX4X1 O I0 I1 I2 I3 S0 S1
M0 2 I0 VDD VDD hvp L=3.0e-07 W=0.65e-06
M1 3 S0 2 VDD hvp L=3.0e-07 W=0.45e-06
M2 4 5 3 VDD hvp L=3.0e-07 W=0.45e-06
M3 VDD I1 4 VDD hvp L=3.0e-07 W=0.5e-06
M4 5 S0 VDD VDD hvp L=3.0e-07 W=0.5e-06
M5 6 I3 VDD VDD hvp L=3.0e-07 W=0.5e-06
M6 7 5 6 VDD hvp L=3.0e-07 W=0.45e-06
M7 8 S0 7 VDD hvp L=3.0e-07 W=0.45e-06
M8 VDD I2 8 VDD hvp L=3.0e-07 W=0.5e-06
M9 9 10 7 VDD hvp L=3.0e-07 W=0.45e-06
M10 3 S1 9 VDD hvp L=3.0e-07 W=0.45e-06
M11 VDD S1 10 VDD hvp L=3.0e-07 W=0.65e-06
M12 O 9 VDD VDD hvp L=3.0e-07 W=1e-06
M13 13 I0 GND GND hvn L=3.5e-07 W=0.45e-06
M14 3 5 13 GND hvn L=3.5e-07 W=0.3e-06
M15 14 S0 3 GND hvn L=3.5e-07 W=0.3e-06
M16 GND I1 14 GND hvn L=3.5e-07 W=0.34e-06
M17 5 S0 GND GND hvn L=3.5e-07 W=0.35e-06
M18 15 I3 GND GND hvn L=3.5e-07 W=0.34e-06
M19 7 S0 15 GND hvn L=3.5e-07 W=0.3e-06
M20 16 5 7 GND hvn L=3.5e-07 W=0.3e-06
M21 GND I2 16 GND hvn L=3.5e-07 W=0.35e-06
M22 9 S1 7 GND hvn L=3.5e-07 W=0.3e-06
M23 3 10 9 GND hvn L=3.5e-07 W=0.3e-06
M24 GND S1 10 GND hvn L=3.5e-07 W=0.45e-06
M25 O 9 GND GND hvn L=3.5e-07 W=0.65e-06
.ENDS MUX4X1

.SUBCKT MUX4X2 O I0 I1 I2 I3 S0 S1
M0 2 I0 VDD VDD hvp L=3.0e-07 W=0.65e-06
M1 3 S0 2 VDD hvp L=3.0e-07 W=0.45e-06
M2 4 5 3 VDD hvp L=3.0e-07 W=0.45e-06
M3 VDD I1 4 VDD hvp L=3.0e-07 W=0.5e-06
M4 5 S0 VDD VDD hvp L=3.0e-07 W=0.5e-06
M5 6 I3 VDD VDD hvp L=3.0e-07 W=0.5e-06
M6 7 5 6 VDD hvp L=3.0e-07 W=0.45e-06
M7 8 S0 7 VDD hvp L=3.0e-07 W=0.45e-06
M8 VDD I2 8 VDD hvp L=3.0e-07 W=0.5e-06
M9 9 10 7 VDD hvp L=3.0e-07 W=0.45e-06
M10 3 S1 9 VDD hvp L=3.0e-07 W=0.45e-06
M11 VDD S1 10 VDD hvp L=3.0e-07 W=0.65e-06
M12 O 9 VDD VDD hvp L=3.0e-07 W=1e-06
M13 VDD 9 O VDD hvp L=3.0e-07 W=1e-06
M14 13 I0 GND GND hvn L=3.5e-07 W=0.45e-06
M15 3 5 13 GND hvn L=3.5e-07 W=0.3e-06
M16 14 S0 3 GND hvn L=3.5e-07 W=0.3e-06
M17 GND I1 14 GND hvn L=3.5e-07 W=0.34e-06
M18 5 S0 GND GND hvn L=3.5e-07 W=0.35e-06
M19 15 I3 GND GND hvn L=3.5e-07 W=0.34e-06
M20 7 S0 15 GND hvn L=3.5e-07 W=0.3e-06
M21 16 5 7 GND hvn L=3.5e-07 W=0.3e-06
M22 GND I2 16 GND hvn L=3.5e-07 W=0.35e-06
M23 9 S1 7 GND hvn L=3.5e-07 W=0.3e-06
M24 3 10 9 GND hvn L=3.5e-07 W=0.3e-06
M25 GND S1 10 GND hvn L=3.5e-07 W=0.45e-06
M26 O 9 GND GND hvn L=3.5e-07 W=0.65e-06
M27 GND 9 O GND hvn L=3.5e-07 W=0.65e-06
.ENDS MUX4X2

.SUBCKT MUX4X4 O I0 I1 I2 I3 S0 S1
M0 2 I0 VDD VDD hvp L=3.0e-07 W=0.65e-06
M1 3 S0 2 VDD hvp L=3.0e-07 W=0.45e-06
M2 4 5 3 VDD hvp L=3.0e-07 W=0.45e-06
M3 VDD I1 4 VDD hvp L=3.0e-07 W=0.5e-06
M4 5 S0 VDD VDD hvp L=3.0e-07 W=0.5e-06
M5 6 I3 VDD VDD hvp L=3.0e-07 W=0.5e-06
M6 7 5 6 VDD hvp L=3.0e-07 W=0.45e-06
M7 8 S0 7 VDD hvp L=3.0e-07 W=0.45e-06
M8 VDD I2 8 VDD hvp L=3.0e-07 W=0.5e-06
M9 9 10 7 VDD hvp L=3.0e-07 W=0.45e-06
M10 3 S1 9 VDD hvp L=3.0e-07 W=0.45e-06
M11 VDD S1 10 VDD hvp L=3.0e-07 W=0.65e-06
M12 O 9 VDD VDD hvp L=3.0e-07 W=1e-06
M13 VDD 9 O VDD hvp L=3.0e-07 W=1e-06
M14 O 9 VDD VDD hvp L=3.0e-07 W=1e-06
M15 VDD 9 O VDD hvp L=3.0e-07 W=1e-06
M16 13 I0 GND GND hvn L=3.5e-07 W=0.45e-06
M17 3 5 13 GND hvn L=3.5e-07 W=0.3e-06
M18 14 S0 3 GND hvn L=3.5e-07 W=0.3e-06
M19 GND I1 14 GND hvn L=3.5e-07 W=0.34e-06
M20 5 S0 GND GND hvn L=3.5e-07 W=0.35e-06
M21 15 I3 GND GND hvn L=3.5e-07 W=0.34e-06
M22 7 S0 15 GND hvn L=3.5e-07 W=0.3e-06
M23 16 5 7 GND hvn L=3.5e-07 W=0.3e-06
M24 GND I2 16 GND hvn L=3.5e-07 W=0.35e-06
M25 9 S1 7 GND hvn L=3.5e-07 W=0.3e-06
M26 3 10 9 GND hvn L=3.5e-07 W=0.3e-06
M27 GND S1 10 GND hvn L=3.5e-07 W=0.45e-06
M28 O 9 GND GND hvn L=3.5e-07 W=0.65e-06
M29 GND 9 O GND hvn L=3.5e-07 W=0.65e-06
M30 O 9 GND GND hvn L=3.5e-07 W=0.65e-06
M31 GND 9 O GND hvn L=3.5e-07 W=0.65e-06
.ENDS MUX4X4

.SUBCKT MUXLATCHX1 Q QB D1 D2 SEL CL
M0 VDD SEL 1 VDD hvp L=3.0e-07 W=0.6e-06
M1 3 1 VDD VDD hvp L=3.0e-07 W=0.6e-06
M2 4 D2 3 VDD hvp L=3.0e-07 W=0.6e-06
M3 5 D1 4 VDD hvp L=3.0e-07 W=0.6e-06
M4 VDD SEL 5 VDD hvp L=3.0e-07 W=0.6e-06
M5 VDD CL 6 VDD hvp L=3.0e-07 W=0.3e-06
M6 7 6 VDD VDD hvp L=3.0e-07 W=0.6e-06
M7 8 6 4 VDD hvp L=3.0e-07 W=0.8e-06
M8 9 7 8 VDD hvp L=3.0e-07 W=0.3e-06
M9 VDD 10 9 VDD hvp L=3.0e-07 W=0.3e-06
M10 10 8 VDD VDD hvp L=3.0e-07 W=0.6e-06
M11 VDD 8 Q VDD hvp L=3.0e-07 W=1e-06
M12 QB 10 VDD VDD hvp L=3.0e-07 W=1e-06
M13 GND SEL 1 GND hvn L=3.5e-07 W=0.6e-06
M14 14 SEL GND GND hvn L=3.5e-07 W=0.6e-06
M15 4 D2 14 GND hvn L=3.5e-07 W=0.6e-06
M16 15 D1 4 GND hvn L=3.5e-07 W=0.6e-06
M17 GND 1 15 GND hvn L=3.5e-07 W=0.6e-06
M18 GND CL 6 GND hvn L=3.5e-07 W=0.6e-06
M19 7 6 GND GND hvn L=3.5e-07 W=0.3e-06
M20 8 7 4 GND hvn L=3.5e-07 W=0.4e-06
M21 16 6 8 GND hvn L=3.5e-07 W=0.4e-06
M22 GND 10 16 GND hvn L=3.5e-07 W=0.4e-06
M23 10 8 GND GND hvn L=3.5e-07 W=0.4e-06
M24 GND 8 Q GND hvn L=3.5e-07 W=0.65e-06
M25 QB 10 GND GND hvn L=3.5e-07 W=0.65e-06
.ENDS MUXLATCHX1

.SUBCKT MUXLATCHX2 Q QB D1 D2 SEL CL
M0 VDD SEL 1 VDD hvp L=3.0e-07 W=0.6e-06
M1 3 1 VDD VDD hvp L=3.0e-07 W=0.6e-06
M2 4 D2 3 VDD hvp L=3.0e-07 W=0.6e-06
M3 5 D1 4 VDD hvp L=3.0e-07 W=0.6e-06
M4 VDD SEL 5 VDD hvp L=3.0e-07 W=0.6e-06
M5 VDD CL 6 VDD hvp L=3.0e-07 W=0.3e-06
M6 7 6 VDD VDD hvp L=3.0e-07 W=0.6e-06
M7 8 6 4 VDD hvp L=3.0e-07 W=0.8e-06
M8 9 7 8 VDD hvp L=3.0e-07 W=0.3e-06
M9 VDD 10 9 VDD hvp L=3.0e-07 W=0.3e-06
M10 10 8 VDD VDD hvp L=3.0e-07 W=0.6e-06
M11 Q 8 VDD VDD hvp L=3.0e-07 W=1e-06
M12 VDD 8 Q VDD hvp L=3.0e-07 W=1e-06
M13 QB 10 VDD VDD hvp L=3.0e-07 W=1e-06
M14 VDD 10 QB VDD hvp L=3.0e-07 W=1e-06
M15 GND SEL 1 GND hvn L=3.5e-07 W=0.6e-06
M16 14 SEL GND GND hvn L=3.5e-07 W=0.6e-06
M17 4 D2 14 GND hvn L=3.5e-07 W=0.6e-06
M18 15 D1 4 GND hvn L=3.5e-07 W=0.6e-06
M19 GND 1 15 GND hvn L=3.5e-07 W=0.6e-06
M20 GND CL 6 GND hvn L=3.5e-07 W=0.6e-06
M21 7 6 GND GND hvn L=3.5e-07 W=0.3e-06
M22 8 7 4 GND hvn L=3.5e-07 W=0.4e-06
M23 16 6 8 GND hvn L=3.5e-07 W=0.4e-06
M24 GND 10 16 GND hvn L=3.5e-07 W=0.4e-06
M25 10 8 GND GND hvn L=3.5e-07 W=0.4e-06
M26 Q 8 GND GND hvn L=3.5e-07 W=0.65e-06
M27 GND 8 Q GND hvn L=3.5e-07 W=0.65e-06
M28 QB 10 GND GND hvn L=3.5e-07 W=0.65e-06
M29 GND 10 QB GND hvn L=3.5e-07 W=0.65e-06
.ENDS MUXLATCHX2

.SUBCKT MUXLATCHX4 Q QB D1 D2 SEL CL
M0 VDD SEL 1 VDD hvp L=3.0e-07 W=0.6e-06
M1 3 1 VDD VDD hvp L=3.0e-07 W=0.6e-06
M2 4 D2 3 VDD hvp L=3.0e-07 W=0.6e-06
M3 5 D1 4 VDD hvp L=3.0e-07 W=0.6e-06
M4 VDD SEL 5 VDD hvp L=3.0e-07 W=0.6e-06
M5 VDD CL 6 VDD hvp L=3.0e-07 W=0.3e-06
M6 7 6 VDD VDD hvp L=3.0e-07 W=0.6e-06
M7 8 6 4 VDD hvp L=3.0e-07 W=0.8e-06
M8 9 7 8 VDD hvp L=3.0e-07 W=0.3e-06
M9 VDD 10 9 VDD hvp L=3.0e-07 W=0.3e-06
M10 10 8 VDD VDD hvp L=3.0e-07 W=0.6e-06
M11 Q 8 VDD VDD hvp L=3.0e-07 W=1e-06
M12 VDD 8 Q VDD hvp L=3.0e-07 W=1e-06
M13 Q 8 VDD VDD hvp L=3.0e-07 W=1e-06
M14 VDD 8 Q VDD hvp L=3.0e-07 W=1e-06
M15 QB 10 VDD VDD hvp L=3.0e-07 W=1e-06
M16 VDD 10 QB VDD hvp L=3.0e-07 W=1e-06
M17 QB 10 VDD VDD hvp L=3.0e-07 W=1e-06
M18 VDD 10 QB VDD hvp L=3.0e-07 W=1e-06
M19 GND SEL 1 GND hvn L=3.5e-07 W=0.6e-06
M20 14 SEL GND GND hvn L=3.5e-07 W=0.6e-06
M21 4 D2 14 GND hvn L=3.5e-07 W=0.6e-06
M22 15 D1 4 GND hvn L=3.5e-07 W=0.6e-06
M23 GND 1 15 GND hvn L=3.5e-07 W=0.6e-06
M24 GND CL 6 GND hvn L=3.5e-07 W=0.6e-06
M25 7 6 GND GND hvn L=3.5e-07 W=0.3e-06
M26 8 7 4 GND hvn L=3.5e-07 W=0.4e-06
M27 16 6 8 GND hvn L=3.5e-07 W=0.4e-06
M28 GND 10 16 GND hvn L=3.5e-07 W=0.4e-06
M29 10 8 GND GND hvn L=3.5e-07 W=0.4e-06
M30 Q 8 GND GND hvn L=3.5e-07 W=0.65e-06
M31 GND 8 Q GND hvn L=3.5e-07 W=0.65e-06
M32 Q 8 GND GND hvn L=3.5e-07 W=0.65e-06
M33 GND 8 Q GND hvn L=3.5e-07 W=0.65e-06
M34 QB 10 GND GND hvn L=3.5e-07 W=0.65e-06
M35 GND 10 QB GND hvn L=3.5e-07 W=0.65e-06
M36 QB 10 GND GND hvn L=3.5e-07 W=0.65e-06
M37 GND 10 QB GND hvn L=3.5e-07 W=0.65e-06
.ENDS MUXLATCHX4

.SUBCKT NAND2B1X1 O B2 I1
M0 VDD B2 1 VDD hvp L=3.0e-07 W=1e-06
M1 O 1 VDD VDD hvp L=3.0e-07 W=1e-06
M2 VDD I1 O VDD hvp L=3.0e-07 W=1e-06
M3 GND B2 1 GND hvn L=3.5e-07 W=0.65e-06
M4 5 1 GND GND hvn L=3.5e-07 W=0.65e-06
M5 O I1 5 GND hvn L=3.5e-07 W=0.65e-06
.ENDS NAND2B1X1

.SUBCKT NAND2B1X2 O B2 I1
M0 VDD B2 1 VDD hvp L=3.0e-07 W=0.9e-06
M1 O 1 VDD VDD hvp L=3.0e-07 W=0.9e-06
M2 VDD I1 O VDD hvp L=3.0e-07 W=0.9e-06
M3 O I1 VDD VDD hvp L=3.0e-07 W=0.9e-06
M4 VDD 1 O VDD hvp L=3.0e-07 W=0.9e-06
M5 GND B2 1 GND hvn L=3.5e-07 W=0.6e-06
M6 5 1 GND GND hvn L=3.5e-07 W=0.6e-06
M7 O I1 5 GND hvn L=3.5e-07 W=0.6e-06
M8 6 I1 O GND hvn L=3.5e-07 W=0.6e-06
M9 GND 1 6 GND hvn L=3.5e-07 W=0.6e-06
.ENDS NAND2B1X2

.SUBCKT NAND2B1X4 O B2 I1
M0 VDD B2 1 VDD hvp L=3.0e-07 W=0.9e-06
M1 O 1 VDD VDD hvp L=3.0e-07 W=0.9e-06
M2 VDD I1 O VDD hvp L=3.0e-07 W=0.9e-06
M3 O I1 VDD VDD hvp L=3.0e-07 W=0.9e-06
M4 VDD 1 O VDD hvp L=3.0e-07 W=0.9e-06
M5 O 1 VDD VDD hvp L=3.0e-07 W=0.9e-06
M6 VDD I1 O VDD hvp L=3.0e-07 W=0.9e-06
M7 O I1 VDD VDD hvp L=3.0e-07 W=0.9e-06
M8 VDD 1 O VDD hvp L=3.0e-07 W=0.9e-06
M9 GND B2 1 GND hvn L=3.5e-07 W=0.6e-06
M10 5 1 GND GND hvn L=3.5e-07 W=0.6e-06
M11 O I1 5 GND hvn L=3.5e-07 W=0.6e-06
M12 6 I1 O GND hvn L=3.5e-07 W=0.6e-06
M13 GND 1 6 GND hvn L=3.5e-07 W=0.6e-06
M14 7 1 GND GND hvn L=3.5e-07 W=0.6e-06
M15 O I1 7 GND hvn L=3.5e-07 W=0.6e-06
M16 8 I1 O GND hvn L=3.5e-07 W=0.6e-06
M17 GND 1 8 GND hvn L=3.5e-07 W=0.6e-06
.ENDS NAND2B1X4

.SUBCKT NAND2X1 O I1 I2
M0 O I2 VDD VDD hvp L=3.0e-07 W=1e-06
M1 VDD I1 O VDD hvp L=3.0e-07 W=1e-06
M2 4 I2 GND GND hvn L=3.5e-07 W=0.65e-06
M3 O I1 4 GND hvn L=3.5e-07 W=0.65e-06
.ENDS NAND2X1

.SUBCKT NAND2X2 O I1 I2
M0 O I2 VDD VDD hvp L=3.0e-07 W=1e-06
M1 VDD I1 O VDD hvp L=3.0e-07 W=1e-06
M2 O I1 VDD VDD hvp L=3.0e-07 W=1e-06
M3 VDD I2 O VDD hvp L=3.0e-07 W=1e-06
M4 4 I2 GND GND hvn L=3.5e-07 W=0.65e-06
M5 O I1 4 GND hvn L=3.5e-07 W=0.65e-06
M6 5 I1 O GND hvn L=3.5e-07 W=0.65e-06
M7 GND I2 5 GND hvn L=3.5e-07 W=0.65e-06
.ENDS NAND2X2

.SUBCKT NAND2X3 O I1 I2
M0 O I2 VDD VDD hvp L=3.0e-07 W=0.9e-06
M1 VDD I1 O VDD hvp L=3.0e-07 W=0.9e-06
M2 O I1 VDD VDD hvp L=3.0e-07 W=0.9e-06
M3 VDD I2 O VDD hvp L=3.0e-07 W=0.9e-06
M4 O I2 VDD VDD hvp L=3.0e-07 W=0.9e-06
M5 VDD I1 O VDD hvp L=3.0e-07 W=0.9e-06
M6 4 I2 GND GND hvn L=3.5e-07 W=0.6e-06
M7 O I1 4 GND hvn L=3.5e-07 W=0.6e-06
M8 5 I1 O GND hvn L=3.5e-07 W=0.6e-06
M9 GND I2 5 GND hvn L=3.5e-07 W=0.6e-06
M10 6 I2 GND GND hvn L=3.5e-07 W=0.6e-06
M11 O I1 6 GND hvn L=3.5e-07 W=0.6e-06
.ENDS NAND2X3

.SUBCKT NAND2X4 O I1 I2
M0 O I2 VDD VDD hvp L=3.0e-07 W=0.9e-06
M1 VDD I1 O VDD hvp L=3.0e-07 W=0.9e-06
M2 O I1 VDD VDD hvp L=3.0e-07 W=0.9e-06
M3 VDD I2 O VDD hvp L=3.0e-07 W=0.9e-06
M4 O I2 VDD VDD hvp L=3.0e-07 W=0.9e-06
M5 VDD I1 O VDD hvp L=3.0e-07 W=0.9e-06
M6 O I1 VDD VDD hvp L=3.0e-07 W=0.9e-06
M7 VDD I2 O VDD hvp L=3.0e-07 W=0.9e-06
M8 4 I2 GND GND hvn L=3.5e-07 W=0.6e-06
M9 O I1 4 GND hvn L=3.5e-07 W=0.6e-06
M10 5 I1 O GND hvn L=3.5e-07 W=0.6e-06
M11 GND I2 5 GND hvn L=3.5e-07 W=0.6e-06
M12 6 I2 GND GND hvn L=3.5e-07 W=0.6e-06
M13 O I1 6 GND hvn L=3.5e-07 W=0.6e-06
M14 7 I1 O GND hvn L=3.5e-07 W=0.6e-06
M15 GND I2 7 GND hvn L=3.5e-07 W=0.6e-06
.ENDS NAND2X4

.SUBCKT NAND2X6 O I1 I2
M0 O I2 VDD VDD hvp L=3.0e-07 W=0.9e-06
M1 VDD I1 O VDD hvp L=3.0e-07 W=0.9e-06
M2 O I1 VDD VDD hvp L=3.0e-07 W=0.9e-06
M3 VDD I2 O VDD hvp L=3.0e-07 W=0.9e-06
M4 O I2 VDD VDD hvp L=3.0e-07 W=0.9e-06
M5 VDD I1 O VDD hvp L=3.0e-07 W=0.9e-06
M6 O I1 VDD VDD hvp L=3.0e-07 W=0.9e-06
M7 VDD I2 O VDD hvp L=3.0e-07 W=0.9e-06
M8 O I2 VDD VDD hvp L=3.0e-07 W=0.9e-06
M9 VDD I1 O VDD hvp L=3.0e-07 W=0.9e-06
M10 O I1 VDD VDD hvp L=3.0e-07 W=0.9e-06
M11 VDD I2 O VDD hvp L=3.0e-07 W=0.9e-06
M12 4 I2 GND GND hvn L=3.5e-07 W=0.6e-06
M13 O I1 4 GND hvn L=3.5e-07 W=0.6e-06
M14 5 I1 O GND hvn L=3.5e-07 W=0.6e-06
M15 GND I2 5 GND hvn L=3.5e-07 W=0.6e-06
M16 6 I2 GND GND hvn L=3.5e-07 W=0.6e-06
M17 O I1 6 GND hvn L=3.5e-07 W=0.6e-06
M18 7 I1 O GND hvn L=3.5e-07 W=0.6e-06
M19 GND I2 7 GND hvn L=3.5e-07 W=0.6e-06
M20 8 I2 GND GND hvn L=3.5e-07 W=0.6e-06
M21 O I1 8 GND hvn L=3.5e-07 W=0.6e-06
M22 9 I1 O GND hvn L=3.5e-07 W=0.6e-06
M23 GND I2 9 GND hvn L=3.5e-07 W=0.6e-06
.ENDS NAND2X6

.SUBCKT NAND3B1X1 O B3 I1 I2
M0 VDD B3 1 VDD hvp L=3.0e-07 W=1e-06
M1 O I2 VDD VDD hvp L=3.0e-07 W=1e-06
M2 VDD 1 O VDD hvp L=3.0e-07 W=1e-06
M3 O I1 VDD VDD hvp L=3.0e-07 W=1e-06
M4 GND B3 1 GND hvn L=3.5e-07 W=0.65e-06
M5 5 I2 GND GND hvn L=3.5e-07 W=0.65e-06
M6 6 1 5 GND hvn L=3.5e-07 W=0.65e-06
M7 O I1 6 GND hvn L=3.5e-07 W=0.65e-06
.ENDS NAND3B1X1

.SUBCKT NAND3B1X2 O B3 I1 I2
M0 VDD B3 1 VDD hvp L=3.0e-07 W=0.9e-06
M1 O I1 VDD VDD hvp L=3.0e-07 W=0.9e-06
M2 VDD 1 O VDD hvp L=3.0e-07 W=0.9e-06
M3 O I2 VDD VDD hvp L=3.0e-07 W=0.9e-06
M4 VDD I2 O VDD hvp L=3.0e-07 W=0.9e-06
M5 O 1 VDD VDD hvp L=3.0e-07 W=0.9e-06
M6 VDD I1 O VDD hvp L=3.0e-07 W=0.9e-06
M7 1 B3 GND GND hvn L=3.5e-07 W=0.6e-06
M8 5 I1 O GND hvn L=3.5e-07 W=0.6e-06
M9 6 1 5 GND hvn L=3.5e-07 W=0.6e-06
M10 GND I2 6 GND hvn L=3.5e-07 W=0.6e-06
M11 7 I2 GND GND hvn L=3.5e-07 W=0.6e-06
M12 8 1 7 GND hvn L=3.5e-07 W=0.6e-06
M13 O I1 8 GND hvn L=3.5e-07 W=0.6e-06
.ENDS NAND3B1X2

.SUBCKT NAND3B1X3 O B3 I1 I2
M0 VDD B3 1 VDD hvp L=3.0e-07 W=0.65e-06
M1 O I2 VDD VDD hvp L=3.0e-07 W=0.65e-06
M2 VDD I2 O VDD hvp L=3.0e-07 W=0.65e-06
M3 O I2 VDD VDD hvp L=3.0e-07 W=0.65e-06
M4 VDD 1 O VDD hvp L=3.0e-07 W=0.65e-06
M5 O I1 VDD VDD hvp L=3.0e-07 W=0.65e-06
M6 VDD I1 O VDD hvp L=3.0e-07 W=0.65e-06
M7 O 1 VDD VDD hvp L=3.0e-07 W=0.65e-06
M8 VDD 1 O VDD hvp L=3.0e-07 W=0.65e-06
M9 O I1 VDD VDD hvp L=3.0e-07 W=0.65e-06
M10 GND B3 1 GND hvn L=3.5e-07 W=0.45e-06
M11 5 I2 GND GND hvn L=3.5e-07 W=0.45e-06
M12 GND I2 5 GND hvn L=3.5e-07 W=0.45e-06
M13 5 I2 GND GND hvn L=3.5e-07 W=0.45e-06
M14 6 1 5 GND hvn L=3.5e-07 W=0.45e-06
M15 O I1 6 GND hvn L=3.5e-07 W=0.45e-06
M16 7 I1 O GND hvn L=3.5e-07 W=0.45e-06
M17 5 1 7 GND hvn L=3.5e-07 W=0.45e-06
M18 8 1 5 GND hvn L=3.5e-07 W=0.45e-06
M19 O I1 8 GND hvn L=3.5e-07 W=0.45e-06
.ENDS NAND3B1X3

.SUBCKT NAND3B1X4 O B3 I1 I2
M0 2 B3 VDD VDD hvp L=3.0e-07 W=0.9e-06
M1 O 2 VDD VDD hvp L=3.0e-07 W=0.9e-06
M2 VDD 2 O VDD hvp L=3.0e-07 W=0.9e-06
M3 O 2 VDD VDD hvp L=3.0e-07 W=0.9e-06
M4 VDD 2 O VDD hvp L=3.0e-07 W=0.9e-06
M5 O I2 VDD VDD hvp L=3.0e-07 W=0.9e-06
M6 VDD I1 O VDD hvp L=3.0e-07 W=0.9e-06
M7 O I1 VDD VDD hvp L=3.0e-07 W=0.9e-06
M8 VDD I2 O VDD hvp L=3.0e-07 W=0.9e-06
M9 O I2 VDD VDD hvp L=3.0e-07 W=0.9e-06
M10 VDD I1 O VDD hvp L=3.0e-07 W=0.9e-06
M11 O I1 VDD VDD hvp L=3.0e-07 W=0.9e-06
M12 VDD I2 O VDD hvp L=3.0e-07 W=0.9e-06
M13 2 B3 GND GND hvn L=3.5e-07 W=0.6e-06
M14 O 2 5 GND hvn L=3.5e-07 W=0.6e-06
M15 5 2 O GND hvn L=3.5e-07 W=0.6e-06
M16 O 2 5 GND hvn L=3.5e-07 W=0.6e-06
M17 5 2 O GND hvn L=3.5e-07 W=0.6e-06
M18 6 I2 5 GND hvn L=3.5e-07 W=0.6e-06
M19 GND I1 6 GND hvn L=3.5e-07 W=0.6e-06
M20 7 I1 GND GND hvn L=3.5e-07 W=0.6e-06
M21 5 I2 7 GND hvn L=3.5e-07 W=0.6e-06
M22 8 I2 5 GND hvn L=3.5e-07 W=0.6e-06
M23 GND I1 8 GND hvn L=3.5e-07 W=0.6e-06
M24 9 I1 GND GND hvn L=3.5e-07 W=0.6e-06
M25 5 I2 9 GND hvn L=3.5e-07 W=0.6e-06
.ENDS NAND3B1X4

.SUBCKT NAND3X1 O I1 I2 I3
M0 O I3 VDD VDD hvp L=3.0e-07 W=1e-06
M1 VDD I2 O VDD hvp L=3.0e-07 W=1e-06
M2 O I1 VDD VDD hvp L=3.0e-07 W=1e-06
M3 4 I3 GND GND hvn L=3.5e-07 W=0.65e-06
M4 5 I2 4 GND hvn L=3.5e-07 W=0.65e-06
M5 O I1 5 GND hvn L=3.5e-07 W=0.65e-06
.ENDS NAND3X1

.SUBCKT NAND3X2 O I1 I2 I3
M0 O I1 VDD VDD hvp L=3.0e-07 W=1e-06
M1 VDD I2 O VDD hvp L=3.0e-07 W=1e-06
M2 O I3 VDD VDD hvp L=3.0e-07 W=1e-06
M3 VDD I3 O VDD hvp L=3.0e-07 W=1e-06
M4 O I2 VDD VDD hvp L=3.0e-07 W=1e-06
M5 VDD I1 O VDD hvp L=3.0e-07 W=1e-06
M6 3 I1 O GND hvn L=3.5e-07 W=0.65e-06
M7 4 I2 3 GND hvn L=3.5e-07 W=0.65e-06
M8 GND I3 4 GND hvn L=3.5e-07 W=0.65e-06
M9 6 I3 GND GND hvn L=3.5e-07 W=0.65e-06
M10 7 I2 6 GND hvn L=3.5e-07 W=0.65e-06
M11 O I1 7 GND hvn L=3.5e-07 W=0.65e-06
.ENDS NAND3X2

.SUBCKT NAND3X3 O I1 I2 I3
M0 VDD I3 1 VDD hvp L=3.0e-07 W=1e-06
M1 1 I2 VDD VDD hvp L=3.0e-07 W=1e-06
M2 VDD I1 1 VDD hvp L=3.0e-07 W=1e-06
M3 VDD 1 3 VDD hvp L=3.0e-07 W=1e-06
M4 O 3 VDD VDD hvp L=3.0e-07 W=1e-06
M5 VDD 3 O VDD hvp L=3.0e-07 W=1e-06
M6 O 3 VDD VDD hvp L=3.0e-07 W=1e-06
M7 6 I3 GND GND hvn L=3.5e-07 W=0.65e-06
M8 7 I2 6 GND hvn L=3.5e-07 W=0.65e-06
M9 1 I1 7 GND hvn L=3.5e-07 W=0.65e-06
M10 GND 1 3 GND hvn L=3.5e-07 W=0.65e-06
M11 O 3 GND GND hvn L=3.5e-07 W=0.65e-06
M12 GND 3 O GND hvn L=3.5e-07 W=0.65e-06
M13 O 3 GND GND hvn L=3.5e-07 W=0.65e-06
.ENDS NAND3X3

.SUBCKT NAND3X4 O I1 I2 I3
M0 VDD I3 1 VDD hvp L=3.0e-07 W=1e-06
M1 1 I2 VDD VDD hvp L=3.0e-07 W=1e-06
M2 VDD I1 1 VDD hvp L=3.0e-07 W=1e-06
M3 VDD 1 3 VDD hvp L=3.0e-07 W=1e-06
M4 O 3 VDD VDD hvp L=3.0e-07 W=1e-06
M5 VDD 3 O VDD hvp L=3.0e-07 W=1e-06
M6 O 3 VDD VDD hvp L=3.0e-07 W=1e-06
M7 VDD 3 O VDD hvp L=3.0e-07 W=1e-06
M8 6 I3 GND GND hvn L=3.5e-07 W=0.65e-06
M9 7 I2 6 GND hvn L=3.5e-07 W=0.65e-06
M10 1 I1 7 GND hvn L=3.5e-07 W=0.65e-06
M11 GND 1 3 GND hvn L=3.5e-07 W=0.65e-06
M12 O 3 GND GND hvn L=3.5e-07 W=0.65e-06
M13 GND 3 O GND hvn L=3.5e-07 W=0.65e-06
M14 O 3 GND GND hvn L=3.5e-07 W=0.65e-06
M15 GND 3 O GND hvn L=3.5e-07 W=0.65e-06
.ENDS NAND3X4

.SUBCKT NAND4B1X1 O B4 I1 I2 I3
M0 VDD B4 1 VDD hvp L=3.0e-07 W=1e-06
M1 O 1 VDD VDD hvp L=3.0e-07 W=1e-06
M2 VDD I3 O VDD hvp L=3.0e-07 W=1e-06
M3 O I2 VDD VDD hvp L=3.0e-07 W=1e-06
M4 VDD I1 O VDD hvp L=3.0e-07 W=1e-06
M5 GND B4 1 GND hvn L=3.5e-07 W=0.65e-06
M6 5 1 GND GND hvn L=3.5e-07 W=0.65e-06
M7 6 I3 5 GND hvn L=3.5e-07 W=0.65e-06
M8 7 I2 6 GND hvn L=3.5e-07 W=0.65e-06
M9 O I1 7 GND hvn L=3.5e-07 W=0.65e-06
.ENDS NAND4B1X1

.SUBCKT NAND4B1X2 O B4 I1 I2 I3
M0 VDD B4 1 VDD hvp L=3.0e-07 W=0.9e-06
M1 O I3 VDD VDD hvp L=3.0e-07 W=0.9e-06
M2 VDD 1 O VDD hvp L=3.0e-07 W=0.9e-06
M3 O 1 VDD VDD hvp L=3.0e-07 W=0.9e-06
M4 VDD I3 O VDD hvp L=3.0e-07 W=0.9e-06
M5 O I2 VDD VDD hvp L=3.0e-07 W=0.9e-06
M6 VDD I1 O VDD hvp L=3.0e-07 W=0.9e-06
M7 O I1 VDD VDD hvp L=3.0e-07 W=0.9e-06
M8 VDD I2 O VDD hvp L=3.0e-07 W=0.9e-06
M9 1 B4 GND GND hvn L=3.5e-07 W=0.6e-06
M10 6 I3 5 GND hvn L=3.5e-07 W=0.6e-06
M11 GND 1 6 GND hvn L=3.5e-07 W=0.6e-06
M12 7 1 GND GND hvn L=3.5e-07 W=0.6e-06
M13 5 I3 7 GND hvn L=3.5e-07 W=0.6e-06
M14 8 I2 5 GND hvn L=3.5e-07 W=0.6e-06
M15 O I1 8 GND hvn L=3.5e-07 W=0.6e-06
M16 9 I1 O GND hvn L=3.5e-07 W=0.6e-06
M17 5 I2 9 GND hvn L=3.5e-07 W=0.6e-06
.ENDS NAND4B1X2

.SUBCKT NAND4B2X1 O B3 B4 I1 I2
M0 VDD B4 1 VDD hvp L=3.0e-07 W=0.9e-06
M1 O 1 VDD VDD hvp L=3.0e-07 W=0.9e-06
M2 VDD 4 O VDD hvp L=3.0e-07 W=0.9e-06
M3 O I2 VDD VDD hvp L=3.0e-07 W=0.9e-06
M4 VDD I1 O VDD hvp L=3.0e-07 W=0.9e-06
M5 VDD B3 4 VDD hvp L=3.0e-07 W=0.9e-06
M6 GND B4 1 GND hvn L=3.5e-07 W=0.6e-06
M7 6 1 GND GND hvn L=3.5e-07 W=0.6e-06
M8 7 4 6 GND hvn L=3.5e-07 W=0.6e-06
M9 8 I2 7 GND hvn L=3.5e-07 W=0.6e-06
M10 O I1 8 GND hvn L=3.5e-07 W=0.6e-06
M11 GND B3 4 GND hvn L=3.5e-07 W=0.6e-06
.ENDS NAND4B2X1

.SUBCKT NAND4B2X2 O B3 B4 I1 I2
M0 2 B3 VDD VDD hvp L=3.0e-07 W=0.9e-06
M1 VDD B4 3 VDD hvp L=3.0e-07 W=0.9e-06
M2 O 2 VDD VDD hvp L=3.0e-07 W=0.9e-06
M3 VDD 3 O VDD hvp L=3.0e-07 W=0.9e-06
M4 O 3 VDD VDD hvp L=3.0e-07 W=0.9e-06
M5 VDD 2 O VDD hvp L=3.0e-07 W=0.9e-06
M6 O I2 VDD VDD hvp L=3.0e-07 W=0.9e-06
M7 VDD I1 O VDD hvp L=3.0e-07 W=0.9e-06
M8 O I1 VDD VDD hvp L=3.0e-07 W=0.9e-06
M9 VDD I2 O VDD hvp L=3.0e-07 W=0.9e-06
M10 GND B3 2 GND hvn L=3.5e-07 W=0.6e-06
M11 3 B4 GND GND hvn L=3.5e-07 W=0.6e-06
M12 7 2 6 GND hvn L=3.5e-07 W=0.6e-06
M13 GND 3 7 GND hvn L=3.5e-07 W=0.6e-06
M14 8 3 GND GND hvn L=3.5e-07 W=0.6e-06
M15 6 2 8 GND hvn L=3.5e-07 W=0.6e-06
M16 9 I2 6 GND hvn L=3.5e-07 W=0.6e-06
M17 O I1 9 GND hvn L=3.5e-07 W=0.6e-06
M18 10 I1 O GND hvn L=3.5e-07 W=0.6e-06
M19 6 I2 10 GND hvn L=3.5e-07 W=0.6e-06
.ENDS NAND4B2X2

.SUBCKT NAND4X1 O I1 I2 I3 I4
M0 O I4 VDD VDD hvp L=3.0e-07 W=1e-06
M1 VDD I3 O VDD hvp L=3.0e-07 W=1e-06
M2 O I2 VDD VDD hvp L=3.0e-07 W=1e-06
M3 VDD I1 O VDD hvp L=3.0e-07 W=1e-06
M4 4 I4 GND GND hvn L=3.5e-07 W=0.65e-06
M5 5 I3 4 GND hvn L=3.5e-07 W=0.65e-06
M6 6 I2 5 GND hvn L=3.5e-07 W=0.65e-06
M7 O I1 6 GND hvn L=3.5e-07 W=0.65e-06
.ENDS NAND4X1

.SUBCKT NAND4X2 O I1 I2 I3 I4
M0 O I3 VDD VDD hvp L=3.0e-07 W=0.9e-06
M1 VDD I4 O VDD hvp L=3.0e-07 W=0.9e-06
M2 O I4 VDD VDD hvp L=3.0e-07 W=0.9e-06
M3 VDD I3 O VDD hvp L=3.0e-07 W=0.9e-06
M4 O I2 VDD VDD hvp L=3.0e-07 W=0.9e-06
M5 VDD I1 O VDD hvp L=3.0e-07 W=0.9e-06
M6 O I1 VDD VDD hvp L=3.0e-07 W=0.9e-06
M7 VDD I2 O VDD hvp L=3.0e-07 W=0.9e-06
M8 4 I3 3 GND hvn L=3.5e-07 W=0.6e-06
M9 GND I4 4 GND hvn L=3.5e-07 W=0.6e-06
M10 6 I4 GND GND hvn L=3.5e-07 W=0.6e-06
M11 3 I3 6 GND hvn L=3.5e-07 W=0.6e-06
M12 7 I2 3 GND hvn L=3.5e-07 W=0.6e-06
M13 O I1 7 GND hvn L=3.5e-07 W=0.6e-06
M14 8 I1 O GND hvn L=3.5e-07 W=0.6e-06
M15 3 I2 8 GND hvn L=3.5e-07 W=0.6e-06
.ENDS NAND4X2

.SUBCKT NOR2X1 O I1 I2
M0 2 I2 VDD VDD hvp L=3.0e-07 W=1e-06
M1 O I1 2 VDD hvp L=3.0e-07 W=1e-06
M2 O I2 GND GND hvn L=3.5e-07 W=0.65e-06
M3 GND I1 O GND hvn L=3.5e-07 W=0.65e-06
.ENDS NOR2X1

.SUBCKT NOR2X2 O I1 I2
M0 2 I2 VDD VDD hvp L=3.0e-07 W=1e-06
M1 O I1 2 VDD hvp L=3.0e-07 W=1e-06
M2 4 I1 O VDD hvp L=3.0e-07 W=1e-06
M3 VDD I2 4 VDD hvp L=3.0e-07 W=1e-06
M4 O I2 GND GND hvn L=3.5e-07 W=0.65e-06
M5 GND I1 O GND hvn L=3.5e-07 W=0.65e-06
M6 O I1 GND GND hvn L=3.5e-07 W=0.65e-06
M7 GND I2 O GND hvn L=3.5e-07 W=0.65e-06
.ENDS NOR2X2

.SUBCKT NOR2X3 O I1 I2
M0 2 I1 O VDD hvp L=3.0e-07 W=0.9e-06
M1 VDD I2 2 VDD hvp L=3.0e-07 W=0.9e-06
M2 4 I2 VDD VDD hvp L=3.0e-07 W=0.9e-06
M3 O I1 4 VDD hvp L=3.0e-07 W=0.9e-06
M4 5 I1 O VDD hvp L=3.0e-07 W=0.9e-06
M5 VDD I2 5 VDD hvp L=3.0e-07 W=0.9e-06
M6 GND I1 O GND hvn L=3.5e-07 W=0.6e-06
M7 O I2 GND GND hvn L=3.5e-07 W=0.6e-06
M8 GND I2 O GND hvn L=3.5e-07 W=0.6e-06
M9 O I1 GND GND hvn L=3.5e-07 W=0.6e-06
M10 GND I1 O GND hvn L=3.5e-07 W=0.6e-06
M11 O I2 GND GND hvn L=3.5e-07 W=0.6e-06
.ENDS NOR2X3

.SUBCKT NOR2X4 O I1 I2
M0 2 I2 VDD VDD hvp L=3.0e-07 W=1e-06
M1 3 I1 2 VDD hvp L=3.0e-07 W=1e-06
M2 VDD 3 4 VDD hvp L=3.0e-07 W=1e-06
M3 O 4 VDD VDD hvp L=3.0e-07 W=1e-06
M4 VDD 4 O VDD hvp L=3.0e-07 W=1e-06
M5 O 4 VDD VDD hvp L=3.0e-07 W=1e-06
M6 VDD 4 O VDD hvp L=3.0e-07 W=1e-06
M7 3 I2 GND GND hvn L=3.5e-07 W=0.65e-06
M8 GND I1 3 GND hvn L=3.5e-07 W=0.65e-06
M9 GND 3 4 GND hvn L=3.5e-07 W=0.65e-06
M10 O 4 GND GND hvn L=3.5e-07 W=0.65e-06
M11 GND 4 O GND hvn L=3.5e-07 W=0.65e-06
M12 O 4 GND GND hvn L=3.5e-07 W=0.65e-06
M13 GND 4 O GND hvn L=3.5e-07 W=0.65e-06
.ENDS NOR2X4

.SUBCKT NOR2X6 O I1 I2
M0 2 I2 VDD VDD hvp L=3.0e-07 W=1e-06
M1 3 I1 2 VDD hvp L=3.0e-07 W=1e-06
M2 VDD 3 4 VDD hvp L=3.0e-07 W=1e-06
M3 O 4 VDD VDD hvp L=3.0e-07 W=1e-06
M4 VDD 4 O VDD hvp L=3.0e-07 W=1e-06
M5 O 4 VDD VDD hvp L=3.0e-07 W=1e-06
M6 VDD 4 O VDD hvp L=3.0e-07 W=1e-06
M7 O 4 VDD VDD hvp L=3.0e-07 W=1e-06
M8 VDD 4 O VDD hvp L=3.0e-07 W=1e-06
M9 3 I2 GND GND hvn L=3.5e-07 W=0.65e-06
M10 GND I1 3 GND hvn L=3.5e-07 W=0.65e-06
M11 GND 3 4 GND hvn L=3.5e-07 W=0.65e-06
M12 O 4 GND GND hvn L=3.5e-07 W=0.65e-06
M13 GND 4 O GND hvn L=3.5e-07 W=0.65e-06
M14 O 4 GND GND hvn L=3.5e-07 W=0.65e-06
M15 GND 4 O GND hvn L=3.5e-07 W=0.65e-06
M16 O 4 GND GND hvn L=3.5e-07 W=0.65e-06
M17 GND 4 O GND hvn L=3.5e-07 W=0.65e-06
.ENDS NOR2X6

.SUBCKT NOR3X1 O I1 I2 I3
M0 2 I1 O VDD hvp L=3.0e-07 W=1e-06
M1 3 I2 2 VDD hvp L=3.0e-07 W=1e-06
M2 VDD I3 3 VDD hvp L=3.0e-07 W=1e-06
M3 5 I3 VDD VDD hvp L=3.0e-07 W=1e-06
M4 6 I2 5 VDD hvp L=3.0e-07 W=1e-06
M5 O I1 6 VDD hvp L=3.0e-07 W=1e-06
M6 O I1 GND GND hvn L=3.5e-07 W=0.65e-06
M7 GND I2 O GND hvn L=3.5e-07 W=0.65e-06
M8 O I3 GND GND hvn L=3.5e-07 W=0.65e-06
.ENDS NOR3X1

.SUBCKT NOR3X2 O I1 I2 I3
M0 2 I2 1 VDD hvp L=3.0e-07 W=0.9e-06
M1 O I1 2 VDD hvp L=3.0e-07 W=0.9e-06
M2 4 I1 O VDD hvp L=3.0e-07 W=0.9e-06
M3 1 I2 4 VDD hvp L=3.0e-07 W=0.9e-06
M4 5 I2 1 VDD hvp L=3.0e-07 W=0.9e-06
M5 O I1 5 VDD hvp L=3.0e-07 W=0.9e-06
M6 6 I1 O VDD hvp L=3.0e-07 W=0.9e-06
M7 1 I2 6 VDD hvp L=3.0e-07 W=0.9e-06
M8 VDD I3 1 VDD hvp L=3.0e-07 W=0.9e-06
M9 1 I3 VDD VDD hvp L=3.0e-07 W=0.9e-06
M10 VDD I3 1 VDD hvp L=3.0e-07 W=0.9e-06
M11 1 I3 VDD VDD hvp L=3.0e-07 W=0.9e-06
M12 O I2 GND GND hvn L=3.5e-07 W=0.6e-06
M13 GND I1 O GND hvn L=3.5e-07 W=0.6e-06
M14 O I1 GND GND hvn L=3.5e-07 W=0.6e-06
M15 GND I2 O GND hvn L=3.5e-07 W=0.6e-06
M16 O I3 GND GND hvn L=3.5e-07 W=0.6e-06
M17 GND I3 O GND hvn L=3.5e-07 W=0.6e-06
.ENDS NOR3X2

.SUBCKT NOR3X3 O I1 I2 I3
M0 2 I3 VDD VDD hvp L=3.0e-07 W=1e-06
M1 3 I2 2 VDD hvp L=3.0e-07 W=1e-06
M2 4 I1 3 VDD hvp L=3.0e-07 W=1e-06
M3 VDD 4 5 VDD hvp L=3.0e-07 W=1e-06
M4 O 5 VDD VDD hvp L=3.0e-07 W=1e-06
M5 VDD 5 O VDD hvp L=3.0e-07 W=1e-06
M6 O 5 VDD VDD hvp L=3.0e-07 W=1e-06
M7 GND I3 4 GND hvn L=3.5e-07 W=0.65e-06
M8 4 I2 GND GND hvn L=3.5e-07 W=0.65e-06
M9 GND I1 4 GND hvn L=3.5e-07 W=0.65e-06
M10 GND 4 5 GND hvn L=3.5e-07 W=0.65e-06
M11 O 5 GND GND hvn L=3.5e-07 W=0.65e-06
M12 GND 5 O GND hvn L=3.5e-07 W=0.65e-06
M13 O 5 GND GND hvn L=3.5e-07 W=0.65e-06
.ENDS NOR3X3

.SUBCKT NOR3X4 O I1 I2 I3
M0 2 I3 VDD VDD hvp L=3.0e-07 W=1e-06
M1 3 I2 2 VDD hvp L=3.0e-07 W=1e-06
M2 4 I1 3 VDD hvp L=3.0e-07 W=1e-06
M3 VDD 4 5 VDD hvp L=3.0e-07 W=1e-06
M4 O 5 VDD VDD hvp L=3.0e-07 W=1e-06
M5 VDD 5 O VDD hvp L=3.0e-07 W=1e-06
M6 O 5 VDD VDD hvp L=3.0e-07 W=1e-06
M7 VDD 5 O VDD hvp L=3.0e-07 W=1e-06
M8 GND I3 4 GND hvn L=3.5e-07 W=0.65e-06
M9 4 I2 GND GND hvn L=3.5e-07 W=0.65e-06
M10 GND I1 4 GND hvn L=3.5e-07 W=0.65e-06
M11 GND 4 5 GND hvn L=3.5e-07 W=0.65e-06
M12 O 5 GND GND hvn L=3.5e-07 W=0.65e-06
M13 GND 5 O GND hvn L=3.5e-07 W=0.65e-06
M14 O 5 GND GND hvn L=3.5e-07 W=0.65e-06
M15 GND 5 O GND hvn L=3.5e-07 W=0.65e-06
.ENDS NOR3X4

.SUBCKT NOR4B1X1 O B4 I1 I2 I3
M0 2 I2 1 VDD hvp L=3.0e-07 W=0.9e-06
M1 VDD I1 2 VDD hvp L=3.0e-07 W=0.9e-06
M2 4 I1 VDD VDD hvp L=3.0e-07 W=0.9e-06
M3 1 I2 4 VDD hvp L=3.0e-07 W=0.9e-06
M4 5 I3 1 VDD hvp L=3.0e-07 W=0.9e-06
M5 O 8 5 VDD hvp L=3.0e-07 W=0.9e-06
M6 7 8 O VDD hvp L=3.0e-07 W=0.9e-06
M7 1 I3 7 VDD hvp L=3.0e-07 W=0.9e-06
M8 VDD B4 8 VDD hvp L=3.0e-07 W=0.9e-06
M9 O I2 GND GND hvn L=3.5e-07 W=0.6e-06
M10 GND I1 O GND hvn L=3.5e-07 W=0.6e-06
M11 O 8 GND GND hvn L=3.5e-07 W=0.6e-06
M12 GND I3 O GND hvn L=3.5e-07 W=0.6e-06
M13 GND B4 8 GND hvn L=3.5e-07 W=0.6e-06
.ENDS NOR4B1X1

.SUBCKT NOR4B1X2 O B4 I1 I2 I3
M0 2 I2 1 VDD hvp L=3.0e-07 W=0.9e-06
M1 VDD I1 2 VDD hvp L=3.0e-07 W=0.9e-06
M2 4 I1 VDD VDD hvp L=3.0e-07 W=0.9e-06
M3 1 I2 4 VDD hvp L=3.0e-07 W=0.9e-06
M4 5 I2 1 VDD hvp L=3.0e-07 W=0.9e-06
M5 VDD I1 5 VDD hvp L=3.0e-07 W=0.9e-06
M6 6 I1 VDD VDD hvp L=3.0e-07 W=0.9e-06
M7 1 I2 6 VDD hvp L=3.0e-07 W=0.9e-06
M8 7 I3 1 VDD hvp L=3.0e-07 W=0.9e-06
M9 O 12 7 VDD hvp L=3.0e-07 W=0.9e-06
M10 9 12 O VDD hvp L=3.0e-07 W=0.9e-06
M11 1 I3 9 VDD hvp L=3.0e-07 W=0.9e-06
M12 10 I3 1 VDD hvp L=3.0e-07 W=0.9e-06
M13 O 12 10 VDD hvp L=3.0e-07 W=0.9e-06
M14 11 12 O VDD hvp L=3.0e-07 W=0.9e-06
M15 1 I3 11 VDD hvp L=3.0e-07 W=0.9e-06
M16 VDD B4 12 VDD hvp L=3.0e-07 W=0.9e-06
M17 O I2 GND GND hvn L=3.5e-07 W=0.6e-06
M18 GND I1 O GND hvn L=3.5e-07 W=0.6e-06
M19 O I1 GND GND hvn L=3.5e-07 W=0.6e-06
M20 GND I2 O GND hvn L=3.5e-07 W=0.6e-06
M21 O 12 GND GND hvn L=3.5e-07 W=0.6e-06
M22 GND I3 O GND hvn L=3.5e-07 W=0.6e-06
M23 O 12 GND GND hvn L=3.5e-07 W=0.6e-06
M24 GND I3 O GND hvn L=3.5e-07 W=0.6e-06
M25 GND B4 12 GND hvn L=3.5e-07 W=0.6e-06
.ENDS NOR4B1X2

.SUBCKT NOR4B2X1 O B3 B4 I1 I2
M0 2 I2 1 VDD hvp L=3.0e-07 W=0.9e-06
M1 VDD I1 2 VDD hvp L=3.0e-07 W=0.9e-06
M2 4 I1 VDD VDD hvp L=3.0e-07 W=0.9e-06
M3 1 I2 4 VDD hvp L=3.0e-07 W=0.9e-06
M4 5 9 1 VDD hvp L=3.0e-07 W=0.9e-06
M5 O 8 5 VDD hvp L=3.0e-07 W=0.9e-06
M6 7 8 O VDD hvp L=3.0e-07 W=0.9e-06
M7 1 9 7 VDD hvp L=3.0e-07 W=0.9e-06
M8 VDD B4 8 VDD hvp L=3.0e-07 W=0.9e-06
M9 9 B3 VDD VDD hvp L=3.0e-07 W=0.9e-06
M10 O I2 GND GND hvn L=3.5e-07 W=0.6e-06
M11 GND I1 O GND hvn L=3.5e-07 W=0.6e-06
M12 O 8 GND GND hvn L=3.5e-07 W=0.6e-06
M13 GND 9 O GND hvn L=3.5e-07 W=0.6e-06
M14 GND B4 8 GND hvn L=3.5e-07 W=0.6e-06
M15 9 B3 GND GND hvn L=3.5e-07 W=0.6e-06
.ENDS NOR4B2X1

.SUBCKT NOR4B2X2 O B3 B4 I1 I2
M0 2 I2 1 VDD hvp L=3.0e-07 W=0.9e-06
M1 VDD I1 2 VDD hvp L=3.0e-07 W=0.9e-06
M2 4 I1 VDD VDD hvp L=3.0e-07 W=0.9e-06
M3 1 I2 4 VDD hvp L=3.0e-07 W=0.9e-06
M4 5 I2 1 VDD hvp L=3.0e-07 W=0.9e-06
M5 VDD I1 5 VDD hvp L=3.0e-07 W=0.9e-06
M6 6 I1 VDD VDD hvp L=3.0e-07 W=0.9e-06
M7 1 I2 6 VDD hvp L=3.0e-07 W=0.9e-06
M8 7 13 1 VDD hvp L=3.0e-07 W=0.9e-06
M9 O 12 7 VDD hvp L=3.0e-07 W=0.9e-06
M10 9 12 O VDD hvp L=3.0e-07 W=0.9e-06
M11 1 13 9 VDD hvp L=3.0e-07 W=0.9e-06
M12 10 13 1 VDD hvp L=3.0e-07 W=0.9e-06
M13 O 12 10 VDD hvp L=3.0e-07 W=0.9e-06
M14 11 12 O VDD hvp L=3.0e-07 W=0.9e-06
M15 1 13 11 VDD hvp L=3.0e-07 W=0.9e-06
M16 VDD B4 12 VDD hvp L=3.0e-07 W=0.9e-06
M17 13 B3 VDD VDD hvp L=3.0e-07 W=0.9e-06
M18 O I2 GND GND hvn L=3.5e-07 W=0.6e-06
M19 GND I1 O GND hvn L=3.5e-07 W=0.6e-06
M20 O I1 GND GND hvn L=3.5e-07 W=0.6e-06
M21 GND I2 O GND hvn L=3.5e-07 W=0.6e-06
M22 O 12 GND GND hvn L=3.5e-07 W=0.6e-06
M23 GND 13 O GND hvn L=3.5e-07 W=0.6e-06
M24 O 12 GND GND hvn L=3.5e-07 W=0.6e-06
M25 GND 13 O GND hvn L=3.5e-07 W=0.6e-06
M26 GND B4 12 GND hvn L=3.5e-07 W=0.6e-06
M27 13 B3 GND GND hvn L=3.5e-07 W=0.6e-06
.ENDS NOR4B2X2

.SUBCKT NOR4X1 O I1 I2 I3 I4
M0 2 I3 1 VDD hvp L=3.0e-07 W=0.9e-06
M1 VDD I4 2 VDD hvp L=3.0e-07 W=0.9e-06
M2 4 I4 VDD VDD hvp L=3.0e-07 W=0.9e-06
M3 1 I3 4 VDD hvp L=3.0e-07 W=0.9e-06
M4 5 I2 1 VDD hvp L=3.0e-07 W=0.9e-06
M5 O I1 5 VDD hvp L=3.0e-07 W=0.9e-06
M6 7 I1 O VDD hvp L=3.0e-07 W=0.9e-06
M7 1 I2 7 VDD hvp L=3.0e-07 W=0.9e-06
M8 O I3 GND GND hvn L=3.5e-07 W=0.6e-06
M9 GND I4 O GND hvn L=3.5e-07 W=0.6e-06
M10 O I1 GND GND hvn L=3.5e-07 W=0.6e-06
M11 GND I2 O GND hvn L=3.5e-07 W=0.6e-06
.ENDS NOR4X1

.SUBCKT NOR4X2 O I1 I2 I3 I4
M0 2 I3 1 VDD hvp L=3.0e-07 W=0.9e-06
M1 VDD I4 2 VDD hvp L=3.0e-07 W=0.9e-06
M2 4 I4 VDD VDD hvp L=3.0e-07 W=0.9e-06
M3 1 I3 4 VDD hvp L=3.0e-07 W=0.9e-06
M4 5 I3 1 VDD hvp L=3.0e-07 W=0.9e-06
M5 VDD I4 5 VDD hvp L=3.0e-07 W=0.9e-06
M6 6 I4 VDD VDD hvp L=3.0e-07 W=0.9e-06
M7 1 I3 6 VDD hvp L=3.0e-07 W=0.9e-06
M8 7 I2 1 VDD hvp L=3.0e-07 W=0.9e-06
M9 O I1 7 VDD hvp L=3.0e-07 W=0.9e-06
M10 9 I1 O VDD hvp L=3.0e-07 W=0.9e-06
M11 1 I2 9 VDD hvp L=3.0e-07 W=0.9e-06
M12 10 I2 1 VDD hvp L=3.0e-07 W=0.9e-06
M13 O I1 10 VDD hvp L=3.0e-07 W=0.9e-06
M14 11 I1 O VDD hvp L=3.0e-07 W=0.9e-06
M15 1 I2 11 VDD hvp L=3.0e-07 W=0.9e-06
M16 O I3 GND GND hvn L=3.5e-07 W=0.6e-06
M17 GND I4 O GND hvn L=3.5e-07 W=0.6e-06
M18 O I4 GND GND hvn L=3.5e-07 W=0.6e-06
M19 GND I3 O GND hvn L=3.5e-07 W=0.6e-06
M20 O I1 GND GND hvn L=3.5e-07 W=0.6e-06
M21 GND I2 O GND hvn L=3.5e-07 W=0.6e-06
M22 O I1 GND GND hvn L=3.5e-07 W=0.6e-06
M23 GND I2 O GND hvn L=3.5e-07 W=0.6e-06
.ENDS NOR4X2

.SUBCKT OA112X1 O A1 B1 C1 C2
M0 2 A1 VDD VDD hvp L=3.0e-07 W=1e-06
M1 VDD B1 2 VDD hvp L=3.0e-07 W=1e-06
M2 3 C1 2 VDD hvp L=3.0e-07 W=1e-06
M3 VDD C2 3 VDD hvp L=3.0e-07 W=1e-06
M4 O 2 VDD VDD hvp L=3.0e-07 W=1e-06
M5 5 A1 2 GND hvn L=3.5e-07 W=0.65e-06
M6 6 B1 5 GND hvn L=3.5e-07 W=0.65e-06
M7 6 C1 GND GND hvn L=3.5e-07 W=0.65e-06
M8 GND C2 6 GND hvn L=3.5e-07 W=0.65e-06
M9 O 2 GND GND hvn L=3.5e-07 W=0.65e-06
.ENDS OA112X1

.SUBCKT OA112X2 O A1 B1 C1 C2
M0 2 A1 VDD VDD hvp L=3.0e-07 W=1e-06
M1 VDD B1 2 VDD hvp L=3.0e-07 W=1e-06
M2 3 C1 2 VDD hvp L=3.0e-07 W=1e-06
M3 VDD C2 3 VDD hvp L=3.0e-07 W=1e-06
M4 O 2 VDD VDD hvp L=3.0e-07 W=1e-06
M5 VDD 2 O VDD hvp L=3.0e-07 W=1e-06
M6 5 A1 2 GND hvn L=3.5e-07 W=0.65e-06
M7 6 B1 5 GND hvn L=3.5e-07 W=0.65e-06
M8 6 C1 GND GND hvn L=3.5e-07 W=0.65e-06
M9 GND C2 6 GND hvn L=3.5e-07 W=0.65e-06
M10 O 2 GND GND hvn L=3.5e-07 W=0.65e-06
M11 GND 2 O GND hvn L=3.5e-07 W=0.65e-06
.ENDS OA112X2

.SUBCKT OA112X4 O A1 B1 C1 C2
M0 2 A1 VDD VDD hvp L=3.0e-07 W=1e-06
M1 VDD B1 2 VDD hvp L=3.0e-07 W=1e-06
M2 3 C1 2 VDD hvp L=3.0e-07 W=1e-06
M3 VDD C2 3 VDD hvp L=3.0e-07 W=1e-06
M4 O 2 VDD VDD hvp L=3.0e-07 W=1e-06
M5 VDD 2 O VDD hvp L=3.0e-07 W=1e-06
M6 O 2 VDD VDD hvp L=3.0e-07 W=1e-06
M7 VDD 2 O VDD hvp L=3.0e-07 W=1e-06
M8 5 A1 2 GND hvn L=3.5e-07 W=0.65e-06
M9 6 B1 5 GND hvn L=3.5e-07 W=0.65e-06
M10 6 C1 GND GND hvn L=3.5e-07 W=0.65e-06
M11 GND C2 6 GND hvn L=3.5e-07 W=0.65e-06
M12 O 2 GND GND hvn L=3.5e-07 W=0.65e-06
M13 GND 2 O GND hvn L=3.5e-07 W=0.65e-06
M14 O 2 GND GND hvn L=3.5e-07 W=0.65e-06
M15 GND 2 O GND hvn L=3.5e-07 W=0.65e-06
.ENDS OA112X4

.SUBCKT OA122X1 O A1 B1 B2 C1 C2
M0 2 A1 VDD VDD hvp L=3.0e-07 W=0.9e-06
M1 3 B1 2 VDD hvp L=3.0e-07 W=0.9e-06
M2 VDD B2 3 VDD hvp L=3.0e-07 W=0.9e-06
M3 4 C1 2 VDD hvp L=3.0e-07 W=0.9e-06
M4 VDD C2 4 VDD hvp L=3.0e-07 W=0.9e-06
M5 O 2 VDD VDD hvp L=3.0e-07 W=1e-06
M6 6 A1 2 GND hvn L=3.5e-07 W=0.6e-06
M7 7 B1 6 GND hvn L=3.5e-07 W=0.6e-06
M8 6 B2 7 GND hvn L=3.5e-07 W=0.6e-06
M9 7 C1 GND GND hvn L=3.5e-07 W=0.6e-06
M10 GND C2 7 GND hvn L=3.5e-07 W=0.6e-06
M11 O 2 GND GND hvn L=3.5e-07 W=0.65e-06
.ENDS OA122X1

.SUBCKT OA122X2 O A1 B1 B2 C1 C2
M0 2 A1 VDD VDD hvp L=3.0e-07 W=0.9e-06
M1 3 B1 2 VDD hvp L=3.0e-07 W=0.9e-06
M2 VDD B2 3 VDD hvp L=3.0e-07 W=0.9e-06
M3 4 C1 2 VDD hvp L=3.0e-07 W=0.9e-06
M4 VDD C2 4 VDD hvp L=3.0e-07 W=0.9e-06
M5 O 2 VDD VDD hvp L=3.0e-07 W=1e-06
M6 VDD 2 O VDD hvp L=3.0e-07 W=1e-06
M7 6 A1 2 GND hvn L=3.5e-07 W=0.6e-06
M8 7 B1 6 GND hvn L=3.5e-07 W=0.6e-06
M9 6 B2 7 GND hvn L=3.5e-07 W=0.6e-06
M10 7 C1 GND GND hvn L=3.5e-07 W=0.6e-06
M11 GND C2 7 GND hvn L=3.5e-07 W=0.6e-06
M12 O 2 GND GND hvn L=3.5e-07 W=0.65e-06
M13 GND 2 O GND hvn L=3.5e-07 W=0.65e-06
.ENDS OA122X2

.SUBCKT OA122X4 O A1 B1 B2 C1 C2
M0 2 A1 VDD VDD hvp L=3.0e-07 W=0.9e-06
M1 3 B1 2 VDD hvp L=3.0e-07 W=0.9e-06
M2 VDD B2 3 VDD hvp L=3.0e-07 W=0.9e-06
M3 4 C1 2 VDD hvp L=3.0e-07 W=0.9e-06
M4 VDD C2 4 VDD hvp L=3.0e-07 W=0.9e-06
M5 O 2 VDD VDD hvp L=3.0e-07 W=1e-06
M6 VDD 2 O VDD hvp L=3.0e-07 W=1e-06
M7 O 2 VDD VDD hvp L=3.0e-07 W=1e-06
M8 VDD 2 O VDD hvp L=3.0e-07 W=1e-06
M9 6 A1 2 GND hvn L=3.5e-07 W=0.6e-06
M10 7 B1 6 GND hvn L=3.5e-07 W=0.6e-06
M11 6 B2 7 GND hvn L=3.5e-07 W=0.6e-06
M12 7 C1 GND GND hvn L=3.5e-07 W=0.6e-06
M13 GND C2 7 GND hvn L=3.5e-07 W=0.6e-06
M14 O 2 GND GND hvn L=3.5e-07 W=0.65e-06
M15 GND 2 O GND hvn L=3.5e-07 W=0.65e-06
M16 O 2 GND GND hvn L=3.5e-07 W=0.65e-06
M17 GND 2 O GND hvn L=3.5e-07 W=0.65e-06
.ENDS OA122X4

.SUBCKT OA12X1 O A1 B1 B2
M0 2 B2 VDD VDD hvp L=3.0e-07 W=1e-06
M1 3 B1 2 VDD hvp L=3.0e-07 W=1e-06
M2 VDD A1 3 VDD hvp L=3.0e-07 W=1e-06
M3 O 3 VDD VDD hvp L=3.0e-07 W=1e-06
M4 GND B2 5 GND hvn L=3.5e-07 W=0.65e-06
M5 5 B1 GND GND hvn L=3.5e-07 W=0.65e-06
M6 3 A1 5 GND hvn L=3.5e-07 W=0.65e-06
M7 O 3 GND GND hvn L=3.5e-07 W=0.65e-06
.ENDS OA12X1

.SUBCKT OA12X2 O A1 B1 B2
M0 2 B2 VDD VDD hvp L=3.0e-07 W=1e-06
M1 3 B1 2 VDD hvp L=3.0e-07 W=1e-06
M2 VDD A1 3 VDD hvp L=3.0e-07 W=1e-06
M3 O 3 VDD VDD hvp L=3.0e-07 W=1e-06
M4 VDD 3 O VDD hvp L=3.0e-07 W=1e-06
M5 GND B2 5 GND hvn L=3.5e-07 W=0.65e-06
M6 5 B1 GND GND hvn L=3.5e-07 W=0.65e-06
M7 3 A1 5 GND hvn L=3.5e-07 W=0.65e-06
M8 O 3 GND GND hvn L=3.5e-07 W=0.65e-06
M9 GND 3 O GND hvn L=3.5e-07 W=0.65e-06
.ENDS OA12X2

.SUBCKT OA12X4 O A1 B1 B2
M0 2 B2 VDD VDD hvp L=3.0e-07 W=1e-06
M1 3 B1 2 VDD hvp L=3.0e-07 W=1e-06
M2 VDD A1 3 VDD hvp L=3.0e-07 W=1e-06
M3 O 3 VDD VDD hvp L=3.0e-07 W=1e-06
M4 VDD 3 O VDD hvp L=3.0e-07 W=1e-06
M5 O 3 VDD VDD hvp L=3.0e-07 W=1e-06
M6 VDD 3 O VDD hvp L=3.0e-07 W=1e-06
M7 GND B2 5 GND hvn L=3.5e-07 W=0.65e-06
M8 5 B1 GND GND hvn L=3.5e-07 W=0.65e-06
M9 3 A1 5 GND hvn L=3.5e-07 W=0.65e-06
M10 O 3 GND GND hvn L=3.5e-07 W=0.65e-06
M11 GND 3 O GND hvn L=3.5e-07 W=0.65e-06
M12 O 3 GND GND hvn L=3.5e-07 W=0.65e-06
M13 GND 3 O GND hvn L=3.5e-07 W=0.65e-06
.ENDS OA12X4

.SUBCKT OA13X1 O A1 B1 B2 B3
M0 2 A1 VDD VDD hvp L=3.0e-07 W=1e-06
M1 3 B1 2 VDD hvp L=3.0e-07 W=1e-06
M2 4 B2 3 VDD hvp L=3.0e-07 W=1e-06
M3 VDD B3 4 VDD hvp L=3.0e-07 W=1e-06
M4 O 2 VDD VDD hvp L=3.0e-07 W=1e-06
M5 6 A1 2 GND hvn L=3.5e-07 W=0.65e-06
M6 GND B1 6 GND hvn L=3.5e-07 W=0.65e-06
M7 6 B2 GND GND hvn L=3.5e-07 W=0.65e-06
M8 GND B3 6 GND hvn L=3.5e-07 W=0.65e-06
M9 O 2 GND GND hvn L=3.5e-07 W=0.65e-06
.ENDS OA13X1

.SUBCKT OA13X2 O A1 B1 B2 B3
M0 2 A1 VDD VDD hvp L=3.0e-07 W=1e-06
M1 3 B1 2 VDD hvp L=3.0e-07 W=1e-06
M2 4 B2 3 VDD hvp L=3.0e-07 W=1e-06
M3 VDD B3 4 VDD hvp L=3.0e-07 W=1e-06
M4 O 2 VDD VDD hvp L=3.0e-07 W=1e-06
M5 VDD 2 O VDD hvp L=3.0e-07 W=1e-06
M6 6 A1 2 GND hvn L=3.5e-07 W=0.65e-06
M7 GND B1 6 GND hvn L=3.5e-07 W=0.65e-06
M8 6 B2 GND GND hvn L=3.5e-07 W=0.65e-06
M9 GND B3 6 GND hvn L=3.5e-07 W=0.65e-06
M10 O 2 GND GND hvn L=3.5e-07 W=0.65e-06
M11 GND 2 O GND hvn L=3.5e-07 W=0.65e-06
.ENDS OA13X2

.SUBCKT OA13X4 O A1 B1 B2 B3
M0 2 A1 VDD VDD hvp L=3.0e-07 W=1e-06
M1 3 B1 2 VDD hvp L=3.0e-07 W=1e-06
M2 4 B2 3 VDD hvp L=3.0e-07 W=1e-06
M3 VDD B3 4 VDD hvp L=3.0e-07 W=1e-06
M4 O 2 VDD VDD hvp L=3.0e-07 W=1e-06
M5 VDD 2 O VDD hvp L=3.0e-07 W=1e-06
M6 O 2 VDD VDD hvp L=3.0e-07 W=1e-06
M7 VDD 2 O VDD hvp L=3.0e-07 W=1e-06
M8 6 A1 2 GND hvn L=3.5e-07 W=0.65e-06
M9 GND B1 6 GND hvn L=3.5e-07 W=0.65e-06
M10 6 B2 GND GND hvn L=3.5e-07 W=0.65e-06
M11 GND B3 6 GND hvn L=3.5e-07 W=0.65e-06
M12 O 2 GND GND hvn L=3.5e-07 W=0.65e-06
M13 GND 2 O GND hvn L=3.5e-07 W=0.65e-06
M14 O 2 GND GND hvn L=3.5e-07 W=0.65e-06
M15 GND 2 O GND hvn L=3.5e-07 W=0.65e-06
.ENDS OA13X4

.SUBCKT OA2222X1 O A1 A2 B1 B2 C1 C2 D1 D2
M0 2 A2 VDD VDD hvp L=3.0e-07 W=0.9e-06
M1 3 A1 2 VDD hvp L=3.0e-07 W=0.9e-06
M2 4 B1 3 VDD hvp L=3.0e-07 W=0.9e-06
M3 VDD B2 4 VDD hvp L=3.0e-07 W=0.9e-06
M4 5 C1 3 VDD hvp L=3.0e-07 W=0.9e-06
M5 VDD C2 5 VDD hvp L=3.0e-07 W=0.9e-06
M6 6 D2 VDD VDD hvp L=3.0e-07 W=0.9e-06
M7 3 D1 6 VDD hvp L=3.0e-07 W=0.9e-06
M8 O 3 VDD VDD hvp L=3.0e-07 W=1e-06
M9 3 A2 8 GND hvn L=3.5e-07 W=0.6e-06
M10 8 A1 3 GND hvn L=3.5e-07 W=0.6e-06
M11 9 B1 8 GND hvn L=3.5e-07 W=0.6e-06
M12 8 B2 9 GND hvn L=3.5e-07 W=0.6e-06
M13 9 C1 10 GND hvn L=3.5e-07 W=0.6e-06
M14 10 C2 9 GND hvn L=3.5e-07 W=0.6e-06
M15 GND D2 10 GND hvn L=3.5e-07 W=0.6e-06
M16 10 D1 GND GND hvn L=3.5e-07 W=0.6e-06
M17 O 3 GND GND hvn L=3.5e-07 W=0.65e-06
.ENDS OA2222X1

.SUBCKT OA2222X2 O A1 A2 B1 B2 C1 C2 D1 D2
M0 2 A2 VDD VDD hvp L=3.0e-07 W=0.9e-06
M1 3 A1 2 VDD hvp L=3.0e-07 W=0.9e-06
M2 4 B1 3 VDD hvp L=3.0e-07 W=0.9e-06
M3 VDD B2 4 VDD hvp L=3.0e-07 W=0.9e-06
M4 5 C1 3 VDD hvp L=3.0e-07 W=0.9e-06
M5 VDD C2 5 VDD hvp L=3.0e-07 W=0.9e-06
M6 6 D2 VDD VDD hvp L=3.0e-07 W=0.9e-06
M7 3 D1 6 VDD hvp L=3.0e-07 W=0.9e-06
M8 O 3 VDD VDD hvp L=3.0e-07 W=1e-06
M9 VDD 3 O VDD hvp L=3.0e-07 W=1e-06
M10 3 A2 8 GND hvn L=3.5e-07 W=0.6e-06
M11 8 A1 3 GND hvn L=3.5e-07 W=0.6e-06
M12 9 B1 8 GND hvn L=3.5e-07 W=0.6e-06
M13 8 B2 9 GND hvn L=3.5e-07 W=0.6e-06
M14 9 C1 10 GND hvn L=3.5e-07 W=0.6e-06
M15 10 C2 9 GND hvn L=3.5e-07 W=0.6e-06
M16 GND D2 10 GND hvn L=3.5e-07 W=0.6e-06
M17 10 D1 GND GND hvn L=3.5e-07 W=0.6e-06
M18 O 3 GND GND hvn L=3.5e-07 W=0.65e-06
M19 GND 3 O GND hvn L=3.5e-07 W=0.65e-06
.ENDS OA2222X2

.SUBCKT OA2222X4 O A1 A2 B1 B2 C1 C2 D1 D2
M0 2 A2 VDD VDD hvp L=3.0e-07 W=0.9e-06
M1 3 A1 2 VDD hvp L=3.0e-07 W=0.9e-06
M2 4 B1 3 VDD hvp L=3.0e-07 W=0.9e-06
M3 VDD B2 4 VDD hvp L=3.0e-07 W=0.9e-06
M4 5 C1 3 VDD hvp L=3.0e-07 W=0.9e-06
M5 VDD C2 5 VDD hvp L=3.0e-07 W=0.9e-06
M6 6 D2 VDD VDD hvp L=3.0e-07 W=0.9e-06
M7 3 D1 6 VDD hvp L=3.0e-07 W=0.9e-06
M8 O 3 VDD VDD hvp L=3.0e-07 W=1e-06
M9 VDD 3 O VDD hvp L=3.0e-07 W=1e-06
M10 O 3 VDD VDD hvp L=3.0e-07 W=1e-06
M11 VDD 3 O VDD hvp L=3.0e-07 W=1e-06
M12 3 A2 8 GND hvn L=3.5e-07 W=0.6e-06
M13 8 A1 3 GND hvn L=3.5e-07 W=0.6e-06
M14 9 B1 8 GND hvn L=3.5e-07 W=0.6e-06
M15 8 B2 9 GND hvn L=3.5e-07 W=0.6e-06
M16 9 C1 10 GND hvn L=3.5e-07 W=0.6e-06
M17 10 C2 9 GND hvn L=3.5e-07 W=0.6e-06
M18 GND D2 10 GND hvn L=3.5e-07 W=0.6e-06
M19 10 D1 GND GND hvn L=3.5e-07 W=0.6e-06
M20 O 3 GND GND hvn L=3.5e-07 W=0.65e-06
M21 GND 3 O GND hvn L=3.5e-07 W=0.65e-06
M22 O 3 GND GND hvn L=3.5e-07 W=0.65e-06
M23 GND 3 O GND hvn L=3.5e-07 W=0.65e-06
.ENDS OA2222X4

.SUBCKT OA222X1 O A1 A2 B1 B2 C1 C2
M0 2 A2 VDD VDD hvp L=3.0e-07 W=0.9e-06
M1 3 A1 2 VDD hvp L=3.0e-07 W=0.9e-06
M2 4 B1 3 VDD hvp L=3.0e-07 W=0.9e-06
M3 VDD B2 4 VDD hvp L=3.0e-07 W=0.9e-06
M4 5 C1 3 VDD hvp L=3.0e-07 W=0.9e-06
M5 VDD C2 5 VDD hvp L=3.0e-07 W=0.9e-06
M6 O 3 VDD VDD hvp L=3.0e-07 W=1e-06
M7 3 A2 7 GND hvn L=3.5e-07 W=0.6e-06
M8 7 A1 3 GND hvn L=3.5e-07 W=0.6e-06
M9 8 B1 7 GND hvn L=3.5e-07 W=0.6e-06
M10 7 B2 8 GND hvn L=3.5e-07 W=0.6e-06
M11 8 C1 GND GND hvn L=3.5e-07 W=0.6e-06
M12 GND C2 8 GND hvn L=3.5e-07 W=0.6e-06
M13 O 3 GND GND hvn L=3.5e-07 W=0.65e-06
.ENDS OA222X1

.SUBCKT OA222X2 O A1 A2 B1 B2 C1 C2
M0 2 A2 VDD VDD hvp L=3.0e-07 W=0.9e-06
M1 3 A1 2 VDD hvp L=3.0e-07 W=0.9e-06
M2 4 B1 3 VDD hvp L=3.0e-07 W=0.9e-06
M3 VDD B2 4 VDD hvp L=3.0e-07 W=0.9e-06
M4 5 C1 3 VDD hvp L=3.0e-07 W=0.9e-06
M5 VDD C2 5 VDD hvp L=3.0e-07 W=0.9e-06
M6 O 3 VDD VDD hvp L=3.0e-07 W=1e-06
M7 VDD 3 O VDD hvp L=3.0e-07 W=1e-06
M8 3 A2 7 GND hvn L=3.5e-07 W=0.6e-06
M9 7 A1 3 GND hvn L=3.5e-07 W=0.6e-06
M10 8 B1 7 GND hvn L=3.5e-07 W=0.6e-06
M11 7 B2 8 GND hvn L=3.5e-07 W=0.6e-06
M12 8 C1 GND GND hvn L=3.5e-07 W=0.6e-06
M13 GND C2 8 GND hvn L=3.5e-07 W=0.6e-06
M14 O 3 GND GND hvn L=3.5e-07 W=0.65e-06
M15 GND 3 O GND hvn L=3.5e-07 W=0.65e-06
.ENDS OA222X2

.SUBCKT OA222X4 O A1 A2 B1 B2 C1 C2
M0 2 A2 VDD VDD hvp L=3.0e-07 W=0.9e-06
M1 3 A1 2 VDD hvp L=3.0e-07 W=0.9e-06
M2 4 B1 3 VDD hvp L=3.0e-07 W=0.9e-06
M3 VDD B2 4 VDD hvp L=3.0e-07 W=0.9e-06
M4 5 C1 3 VDD hvp L=3.0e-07 W=0.9e-06
M5 VDD C2 5 VDD hvp L=3.0e-07 W=0.9e-06
M6 O 3 VDD VDD hvp L=3.0e-07 W=1e-06
M7 VDD 3 O VDD hvp L=3.0e-07 W=1e-06
M8 O 3 VDD VDD hvp L=3.0e-07 W=1e-06
M9 VDD 3 O VDD hvp L=3.0e-07 W=1e-06
M10 3 A2 7 GND hvn L=3.5e-07 W=0.6e-06
M11 7 A1 3 GND hvn L=3.5e-07 W=0.6e-06
M12 8 B1 7 GND hvn L=3.5e-07 W=0.6e-06
M13 7 B2 8 GND hvn L=3.5e-07 W=0.6e-06
M14 8 C1 GND GND hvn L=3.5e-07 W=0.6e-06
M15 GND C2 8 GND hvn L=3.5e-07 W=0.6e-06
M16 O 3 GND GND hvn L=3.5e-07 W=0.65e-06
M17 GND 3 O GND hvn L=3.5e-07 W=0.65e-06
M18 O 3 GND GND hvn L=3.5e-07 W=0.65e-06
M19 GND 3 O GND hvn L=3.5e-07 W=0.65e-06
.ENDS OA222X4

.SUBCKT OA22X1 O A1 A2 B1 B2
M0 2 B2 VDD VDD hvp L=3.0e-07 W=0.9e-06
M1 3 B1 2 VDD hvp L=3.0e-07 W=0.9e-06
M2 4 A1 3 VDD hvp L=3.0e-07 W=0.9e-06
M3 VDD A2 4 VDD hvp L=3.0e-07 W=0.9e-06
M4 O 3 VDD VDD hvp L=3.0e-07 W=1e-06
M5 GND B2 6 GND hvn L=3.5e-07 W=0.6e-06
M6 6 B1 GND GND hvn L=3.5e-07 W=0.6e-06
M7 3 A1 6 GND hvn L=3.5e-07 W=0.6e-06
M8 6 A2 3 GND hvn L=3.5e-07 W=0.6e-06
M9 O 3 GND GND hvn L=3.5e-07 W=0.65e-06
.ENDS OA22X1

.SUBCKT OA22X2 O A1 A2 B1 B2
M0 2 B2 VDD VDD hvp L=3.0e-07 W=0.9e-06
M1 3 B1 2 VDD hvp L=3.0e-07 W=0.9e-06
M2 4 A1 3 VDD hvp L=3.0e-07 W=0.9e-06
M3 VDD A2 4 VDD hvp L=3.0e-07 W=0.9e-06
M4 O 3 VDD VDD hvp L=3.0e-07 W=1e-06
M5 VDD 3 O VDD hvp L=3.0e-07 W=1e-06
M6 GND B2 6 GND hvn L=3.5e-07 W=0.6e-06
M7 6 B1 GND GND hvn L=3.5e-07 W=0.6e-06
M8 3 A1 6 GND hvn L=3.5e-07 W=0.6e-06
M9 6 A2 3 GND hvn L=3.5e-07 W=0.6e-06
M10 O 3 GND GND hvn L=3.5e-07 W=0.65e-06
M11 GND 3 O GND hvn L=3.5e-07 W=0.65e-06
.ENDS OA22X2

.SUBCKT OA22X4 O A1 A2 B1 B2
M0 2 B2 VDD VDD hvp L=3.0e-07 W=0.9e-06
M1 3 B1 2 VDD hvp L=3.0e-07 W=0.9e-06
M2 4 A1 3 VDD hvp L=3.0e-07 W=0.9e-06
M3 VDD A2 4 VDD hvp L=3.0e-07 W=0.9e-06
M4 O 3 VDD VDD hvp L=3.0e-07 W=1e-06
M5 VDD 3 O VDD hvp L=3.0e-07 W=1e-06
M6 O 3 VDD VDD hvp L=3.0e-07 W=1e-06
M7 VDD 3 O VDD hvp L=3.0e-07 W=1e-06
M8 GND B2 6 GND hvn L=3.5e-07 W=0.6e-06
M9 6 B1 GND GND hvn L=3.5e-07 W=0.6e-06
M10 3 A1 6 GND hvn L=3.5e-07 W=0.6e-06
M11 6 A2 3 GND hvn L=3.5e-07 W=0.6e-06
M12 O 3 GND GND hvn L=3.5e-07 W=0.65e-06
M13 GND 3 O GND hvn L=3.5e-07 W=0.65e-06
M14 O 3 GND GND hvn L=3.5e-07 W=0.65e-06
M15 GND 3 O GND hvn L=3.5e-07 W=0.65e-06
.ENDS OA22X4

.SUBCKT OAI112X1 O A1 B1 C1 C2
M0 O A1 VDD VDD hvp L=3.0e-07 W=0.9e-06
M1 VDD B1 O VDD hvp L=3.0e-07 W=0.9e-06
M2 O C1 3 VDD hvp L=3.0e-07 W=0.9e-06
M3 4 C1 O VDD hvp L=3.0e-07 W=0.9e-06
M4 VDD C2 4 VDD hvp L=3.0e-07 W=0.9e-06
M5 3 C2 VDD VDD hvp L=3.0e-07 W=0.9e-06
M6 5 A1 O GND hvn L=3.5e-07 W=0.6e-06
M7 6 B1 5 GND hvn L=3.5e-07 W=0.6e-06
M8 6 C1 GND GND hvn L=3.5e-07 W=0.6e-06
M9 GND C1 6 GND hvn L=3.5e-07 W=0.6e-06
M10 6 C2 GND GND hvn L=3.5e-07 W=0.6e-06
M11 GND C2 6 GND hvn L=3.5e-07 W=0.6e-06
.ENDS OAI112X1

.SUBCKT OAI112X2 O A1 B1 C1 C2
M0 VDD A1 O VDD hvp L=3.0e-07 W=0.9e-06
M1 O A1 VDD VDD hvp L=3.0e-07 W=0.9e-06
M2 VDD B1 O VDD hvp L=3.0e-07 W=0.9e-06
M3 O B1 VDD VDD hvp L=3.0e-07 W=0.9e-06
M4 O C1 3 VDD hvp L=3.0e-07 W=0.9e-06
M5 3 C1 O VDD hvp L=3.0e-07 W=0.9e-06
M6 O C1 3 VDD hvp L=3.0e-07 W=0.9e-06
M7 3 C1 O VDD hvp L=3.0e-07 W=0.9e-06
M8 VDD C2 3 VDD hvp L=3.0e-07 W=0.9e-06
M9 3 C2 VDD VDD hvp L=3.0e-07 W=0.9e-06
M10 VDD C2 3 VDD hvp L=3.0e-07 W=0.9e-06
M11 3 C2 VDD VDD hvp L=3.0e-07 W=0.9e-06
M12 4 A1 O GND hvn L=3.5e-07 W=0.6e-06
M13 O A1 4 GND hvn L=3.5e-07 W=0.6e-06
M14 4 A1 O GND hvn L=3.5e-07 W=0.6e-06
M15 5 B1 4 GND hvn L=3.5e-07 W=0.6e-06
M16 4 B1 5 GND hvn L=3.5e-07 W=0.6e-06
M17 5 B1 4 GND hvn L=3.5e-07 W=0.6e-06
M18 GND C1 5 GND hvn L=3.5e-07 W=0.6e-06
M19 5 C1 GND GND hvn L=3.5e-07 W=0.6e-06
M20 GND C1 5 GND hvn L=3.5e-07 W=0.6e-06
M21 5 C2 GND GND hvn L=3.5e-07 W=0.6e-06
M22 GND C2 5 GND hvn L=3.5e-07 W=0.6e-06
M23 5 C2 GND GND hvn L=3.5e-07 W=0.6e-06
.ENDS OAI112X2

.SUBCKT OAI112X3 O A1 B1 C1 C2
M0 O A1 VDD VDD hvp L=3.0e-07 W=0.9e-06
M1 VDD A1 O VDD hvp L=3.0e-07 W=0.9e-06
M2 O A1 VDD VDD hvp L=3.0e-07 W=0.9e-06
M3 VDD B1 O VDD hvp L=3.0e-07 W=0.9e-06
M4 O B1 VDD VDD hvp L=3.0e-07 W=0.9e-06
M5 VDD B1 O VDD hvp L=3.0e-07 W=0.9e-06
M6 3 C1 O VDD hvp L=3.0e-07 W=0.9e-06
M7 O C1 3 VDD hvp L=3.0e-07 W=0.9e-06
M8 3 C1 O VDD hvp L=3.0e-07 W=0.9e-06
M9 O C1 3 VDD hvp L=3.0e-07 W=0.9e-06
M10 3 C1 O VDD hvp L=3.0e-07 W=0.9e-06
M11 VDD C2 3 VDD hvp L=3.0e-07 W=0.9e-06
M12 3 C2 VDD VDD hvp L=3.0e-07 W=0.9e-06
M13 VDD C2 3 VDD hvp L=3.0e-07 W=0.9e-06
M14 3 C2 VDD VDD hvp L=3.0e-07 W=0.9e-06
M15 VDD C2 3 VDD hvp L=3.0e-07 W=0.9e-06
M16 O A1 4 GND hvn L=3.5e-07 W=0.6e-06
M17 4 A1 O GND hvn L=3.5e-07 W=0.6e-06
M18 O A1 4 GND hvn L=3.5e-07 W=0.6e-06
M19 4 A1 O GND hvn L=3.5e-07 W=0.6e-06
M20 5 B1 4 GND hvn L=3.5e-07 W=0.6e-06
M21 4 B1 5 GND hvn L=3.5e-07 W=0.6e-06
M22 5 B1 4 GND hvn L=3.5e-07 W=0.6e-06
M23 4 B1 5 GND hvn L=3.5e-07 W=0.6e-06
M24 5 C1 GND GND hvn L=3.5e-07 W=0.6e-06
M25 GND C1 5 GND hvn L=3.5e-07 W=0.6e-06
M26 5 C1 GND GND hvn L=3.5e-07 W=0.6e-06
M27 GND C1 5 GND hvn L=3.5e-07 W=0.6e-06
M28 5 C2 GND GND hvn L=3.5e-07 W=0.6e-06
M29 GND C2 5 GND hvn L=3.5e-07 W=0.6e-06
M30 5 C2 GND GND hvn L=3.5e-07 W=0.6e-06
M31 GND C2 5 GND hvn L=3.5e-07 W=0.6e-06
.ENDS OAI112X3

.SUBCKT OAI112X4 O A1 B1 C1 C2
M0 VDD A1 1 VDD hvp L=3.0e-07 W=1e-06
M1 1 B1 VDD VDD hvp L=3.0e-07 W=1e-06
M2 3 C1 1 VDD hvp L=3.0e-07 W=1e-06
M3 VDD C2 3 VDD hvp L=3.0e-07 W=1e-06
M4 VDD 1 4 VDD hvp L=3.0e-07 W=1e-06
M5 O 4 VDD VDD hvp L=3.0e-07 W=1e-06
M6 VDD 4 O VDD hvp L=3.0e-07 W=1e-06
M7 O 4 VDD VDD hvp L=3.0e-07 W=1e-06
M8 VDD 4 O VDD hvp L=3.0e-07 W=1e-06
M9 6 A1 1 GND hvn L=3.5e-07 W=0.65e-06
M10 7 B1 6 GND hvn L=3.5e-07 W=0.65e-06
M11 GND C1 7 GND hvn L=3.5e-07 W=0.65e-06
M12 7 C2 GND GND hvn L=3.5e-07 W=0.65e-06
M13 GND 1 4 GND hvn L=3.5e-07 W=0.65e-06
M14 O 4 GND GND hvn L=3.5e-07 W=0.65e-06
M15 GND 4 O GND hvn L=3.5e-07 W=0.65e-06
M16 O 4 GND GND hvn L=3.5e-07 W=0.65e-06
M17 GND 4 O GND hvn L=3.5e-07 W=0.65e-06
.ENDS OAI112X4

.SUBCKT OAI122X1 O A1 B1 B2 C1 C2
M0 O A1 VDD VDD hvp L=3.0e-07 W=0.9e-06
M1 VDD B2 3 VDD hvp L=3.0e-07 W=0.9e-06
M2 4 B2 VDD VDD hvp L=3.0e-07 W=0.9e-06
M3 O B1 4 VDD hvp L=3.0e-07 W=0.9e-06
M4 3 B1 O VDD hvp L=3.0e-07 W=0.9e-06
M5 VDD C2 5 VDD hvp L=3.0e-07 W=0.9e-06
M6 5 C2 VDD VDD hvp L=3.0e-07 W=0.9e-06
M7 O C1 5 VDD hvp L=3.0e-07 W=0.9e-06
M8 5 C1 O VDD hvp L=3.0e-07 W=0.9e-06
M9 O A1 6 GND hvn L=3.5e-07 W=0.6e-06
M10 6 A1 O GND hvn L=3.5e-07 W=0.6e-06
M11 7 B2 6 GND hvn L=3.5e-07 W=0.6e-06
M12 6 B2 7 GND hvn L=3.5e-07 W=0.6e-06
M13 7 B1 6 GND hvn L=3.5e-07 W=0.6e-06
M14 6 B1 7 GND hvn L=3.5e-07 W=0.6e-06
M15 7 C2 GND GND hvn L=3.5e-07 W=0.6e-06
M16 GND C2 7 GND hvn L=3.5e-07 W=0.6e-06
M17 7 C1 GND GND hvn L=3.5e-07 W=0.6e-06
M18 GND C1 7 GND hvn L=3.5e-07 W=0.6e-06
.ENDS OAI122X1

.SUBCKT OAI122X2 O A1 B1 B2 C1 C2
M0 VDD A1 O VDD hvp L=3.0e-07 W=0.9e-06
M1 O A1 VDD VDD hvp L=3.0e-07 W=0.9e-06
M2 3 B2 VDD VDD hvp L=3.0e-07 W=0.9e-06
M3 VDD B2 3 VDD hvp L=3.0e-07 W=0.9e-06
M4 3 B2 VDD VDD hvp L=3.0e-07 W=0.9e-06
M5 O B1 3 VDD hvp L=3.0e-07 W=0.9e-06
M6 3 B1 O VDD hvp L=3.0e-07 W=0.9e-06
M7 O B1 3 VDD hvp L=3.0e-07 W=0.9e-06
M8 4 C1 O VDD hvp L=3.0e-07 W=0.9e-06
M9 O C1 4 VDD hvp L=3.0e-07 W=0.9e-06
M10 4 C1 O VDD hvp L=3.0e-07 W=0.9e-06
M11 VDD C2 4 VDD hvp L=3.0e-07 W=0.9e-06
M12 4 C2 VDD VDD hvp L=3.0e-07 W=0.9e-06
M13 VDD C2 4 VDD hvp L=3.0e-07 W=0.9e-06
M14 5 A1 O GND hvn L=3.5e-07 W=0.6e-06
M15 O A1 5 GND hvn L=3.5e-07 W=0.6e-06
M16 5 A1 O GND hvn L=3.5e-07 W=0.6e-06
M17 6 B2 5 GND hvn L=3.5e-07 W=0.6e-06
M18 5 B2 6 GND hvn L=3.5e-07 W=0.6e-06
M19 6 B2 5 GND hvn L=3.5e-07 W=0.6e-06
M20 5 B1 6 GND hvn L=3.5e-07 W=0.6e-06
M21 6 B1 5 GND hvn L=3.5e-07 W=0.6e-06
M22 5 B1 6 GND hvn L=3.5e-07 W=0.6e-06
M23 GND C1 6 GND hvn L=3.5e-07 W=0.6e-06
M24 6 C1 GND GND hvn L=3.5e-07 W=0.6e-06
M25 GND C1 6 GND hvn L=3.5e-07 W=0.6e-06
M26 6 C2 GND GND hvn L=3.5e-07 W=0.6e-06
M27 GND C2 6 GND hvn L=3.5e-07 W=0.6e-06
M28 6 C2 GND GND hvn L=3.5e-07 W=0.6e-06
.ENDS OAI122X2

.SUBCKT OAI12B2X1 O A1 B1B B2B
M0 2 B1B VDD VDD hvp L=3.0e-07 W=1e-06
M1 VDD B2B 2 VDD hvp L=3.0e-07 W=1e-06
M2 O 2 VDD VDD hvp L=3.0e-07 W=1e-06
M3 VDD A1 O VDD hvp L=3.0e-07 W=1e-06
M4 4 B1B 2 GND hvn L=3.5e-07 W=0.65e-06
M5 GND B2B 4 GND hvn L=3.5e-07 W=0.65e-06
M6 6 2 GND GND hvn L=3.5e-07 W=0.65e-06
M7 O A1 6 GND hvn L=3.5e-07 W=0.65e-06
.ENDS OAI12B2X1

.SUBCKT OAI12B2X2 O A1 B1B B2B
M0 2 B1B VDD VDD hvp L=3.0e-07 W=0.9e-06
M1 VDD B2B 2 VDD hvp L=3.0e-07 W=0.9e-06
M2 O 2 VDD VDD hvp L=3.0e-07 W=0.9e-06
M3 VDD A1 O VDD hvp L=3.0e-07 W=0.9e-06
M4 O A1 VDD VDD hvp L=3.0e-07 W=0.9e-06
M5 VDD 2 O VDD hvp L=3.0e-07 W=0.9e-06
M6 4 B1B 2 GND hvn L=3.5e-07 W=0.6e-06
M7 GND B2B 4 GND hvn L=3.5e-07 W=0.6e-06
M8 6 2 GND GND hvn L=3.5e-07 W=0.6e-06
M9 O A1 6 GND hvn L=3.5e-07 W=0.6e-06
M10 7 A1 O GND hvn L=3.5e-07 W=0.6e-06
M11 GND 2 7 GND hvn L=3.5e-07 W=0.6e-06
.ENDS OAI12B2X2

.SUBCKT OAI12X1 O A1 B1 B2
M0 O A1 VDD VDD hvp L=3.0e-07 W=0.9e-06
M1 O B1 3 VDD hvp L=3.0e-07 W=0.9e-06
M2 4 B1 O VDD hvp L=3.0e-07 W=0.9e-06
M3 VDD B2 4 VDD hvp L=3.0e-07 W=0.9e-06
M4 3 B2 VDD VDD hvp L=3.0e-07 W=0.9e-06
M5 O A1 5 GND hvn L=3.5e-07 W=0.6e-06
M6 5 A1 O GND hvn L=3.5e-07 W=0.6e-06
M7 GND B1 5 GND hvn L=3.5e-07 W=0.6e-06
M8 5 B1 GND GND hvn L=3.5e-07 W=0.6e-06
M9 GND B2 5 GND hvn L=3.5e-07 W=0.6e-06
M10 5 B2 GND GND hvn L=3.5e-07 W=0.6e-06
.ENDS OAI12X1

.SUBCKT OAI12X2 O A1 B1 B2
M0 2 A1 VDD VDD hvp L=3.0e-07 W=1e-06
M1 3 B1 2 VDD hvp L=3.0e-07 W=1e-06
M2 VDD B2 3 VDD hvp L=3.0e-07 W=1e-06
M3 VDD 2 4 VDD hvp L=3.0e-07 W=1e-06
M4 O 4 VDD VDD hvp L=3.0e-07 W=1e-06
M5 VDD 4 O VDD hvp L=3.0e-07 W=1e-06
M6 6 A1 2 GND hvn L=3.5e-07 W=0.65e-06
M7 GND B1 6 GND hvn L=3.5e-07 W=0.65e-06
M8 6 B2 GND GND hvn L=3.5e-07 W=0.65e-06
M9 GND 2 4 GND hvn L=3.5e-07 W=0.65e-06
M10 O 4 GND GND hvn L=3.5e-07 W=0.65e-06
M11 GND 4 O GND hvn L=3.5e-07 W=0.65e-06
.ENDS OAI12X2

.SUBCKT OAI12X3 O A1 B1 B2
M0 2 A1 VDD VDD hvp L=3.0e-07 W=1e-06
M1 3 B1 2 VDD hvp L=3.0e-07 W=1e-06
M2 VDD B2 3 VDD hvp L=3.0e-07 W=1e-06
M3 VDD 2 4 VDD hvp L=3.0e-07 W=1e-06
M4 O 4 VDD VDD hvp L=3.0e-07 W=1e-06
M5 VDD 4 O VDD hvp L=3.0e-07 W=1e-06
M6 O 4 VDD VDD hvp L=3.0e-07 W=1e-06
M7 6 A1 2 GND hvn L=3.5e-07 W=0.65e-06
M8 GND B1 6 GND hvn L=3.5e-07 W=0.65e-06
M9 6 B2 GND GND hvn L=3.5e-07 W=0.65e-06
M10 GND 2 4 GND hvn L=3.5e-07 W=0.65e-06
M11 O 4 GND GND hvn L=3.5e-07 W=0.65e-06
M12 GND 4 O GND hvn L=3.5e-07 W=0.65e-06
M13 O 4 GND GND hvn L=3.5e-07 W=0.65e-06
.ENDS OAI12X3

.SUBCKT OAI12X4 O A1 B1 B2
M0 2 A1 VDD VDD hvp L=3.0e-07 W=1e-06
M1 3 B1 2 VDD hvp L=3.0e-07 W=1e-06
M2 VDD B2 3 VDD hvp L=3.0e-07 W=1e-06
M3 VDD 2 4 VDD hvp L=3.0e-07 W=1e-06
M4 O 4 VDD VDD hvp L=3.0e-07 W=1e-06
M5 VDD 4 O VDD hvp L=3.0e-07 W=1e-06
M6 O 4 VDD VDD hvp L=3.0e-07 W=1e-06
M7 VDD 4 O VDD hvp L=3.0e-07 W=1e-06
M8 6 A1 2 GND hvn L=3.5e-07 W=0.65e-06
M9 GND B1 6 GND hvn L=3.5e-07 W=0.65e-06
M10 6 B2 GND GND hvn L=3.5e-07 W=0.65e-06
M11 GND 2 4 GND hvn L=3.5e-07 W=0.65e-06
M12 O 4 GND GND hvn L=3.5e-07 W=0.65e-06
M13 GND 4 O GND hvn L=3.5e-07 W=0.65e-06
M14 O 4 GND GND hvn L=3.5e-07 W=0.65e-06
M15 GND 4 O GND hvn L=3.5e-07 W=0.65e-06
.ENDS OAI12X4

.SUBCKT OAI13X1 O A1 B1 B2 B3
M0 O A1 VDD VDD hvp L=3.0e-07 W=0.9e-06
M1 3 B1 O VDD hvp L=3.0e-07 W=0.9e-06
M2 O B1 3 VDD hvp L=3.0e-07 W=0.9e-06
M3 3 B1 O VDD hvp L=3.0e-07 W=0.9e-06
M4 4 B2 3 VDD hvp L=3.0e-07 W=0.9e-06
M5 3 B2 4 VDD hvp L=3.0e-07 W=0.9e-06
M6 4 B2 3 VDD hvp L=3.0e-07 W=0.9e-06
M7 VDD B3 4 VDD hvp L=3.0e-07 W=0.9e-06
M8 4 B3 VDD VDD hvp L=3.0e-07 W=0.9e-06
M9 VDD B3 4 VDD hvp L=3.0e-07 W=0.9e-06
M10 O A1 5 GND hvn L=3.5e-07 W=0.6e-06
M11 5 A1 O GND hvn L=3.5e-07 W=0.6e-06
M12 GND B1 5 GND hvn L=3.5e-07 W=0.6e-06
M13 5 B1 GND GND hvn L=3.5e-07 W=0.6e-06
M14 GND B2 5 GND hvn L=3.5e-07 W=0.6e-06
M15 5 B2 GND GND hvn L=3.5e-07 W=0.6e-06
M16 5 B3 GND GND hvn L=3.5e-07 W=0.6e-06
M17 GND B3 5 GND hvn L=3.5e-07 W=0.6e-06
.ENDS OAI13X1

.SUBCKT OAI13X2 O A1 B1 B2 B3
M0 2 A1 VDD VDD hvp L=3.0e-07 W=1e-06
M1 3 B1 2 VDD hvp L=3.0e-07 W=1e-06
M2 4 B2 3 VDD hvp L=3.0e-07 W=1e-06
M3 VDD B3 4 VDD hvp L=3.0e-07 W=1e-06
M4 VDD 2 5 VDD hvp L=3.0e-07 W=1e-06
M5 O 5 VDD VDD hvp L=3.0e-07 W=1e-06
M6 VDD 5 O VDD hvp L=3.0e-07 W=1e-06
M7 7 A1 2 GND hvn L=3.5e-07 W=0.65e-06
M8 GND B1 7 GND hvn L=3.5e-07 W=0.65e-06
M9 7 B2 GND GND hvn L=3.5e-07 W=0.65e-06
M10 GND B3 7 GND hvn L=3.5e-07 W=0.65e-06
M11 GND 2 5 GND hvn L=3.5e-07 W=0.65e-06
M12 O 5 GND GND hvn L=3.5e-07 W=0.65e-06
M13 GND 5 O GND hvn L=3.5e-07 W=0.65e-06
.ENDS OAI13X2

.SUBCKT OAI13X3 O A1 B1 B2 B3
M0 2 A1 VDD VDD hvp L=3.0e-07 W=1e-06
M1 3 B1 2 VDD hvp L=3.0e-07 W=1e-06
M2 4 B2 3 VDD hvp L=3.0e-07 W=1e-06
M3 VDD B3 4 VDD hvp L=3.0e-07 W=1e-06
M4 VDD 2 5 VDD hvp L=3.0e-07 W=1e-06
M5 O 5 VDD VDD hvp L=3.0e-07 W=1e-06
M6 VDD 5 O VDD hvp L=3.0e-07 W=1e-06
M7 O 5 VDD VDD hvp L=3.0e-07 W=1e-06
M8 7 A1 2 GND hvn L=3.5e-07 W=0.65e-06
M9 GND B1 7 GND hvn L=3.5e-07 W=0.65e-06
M10 7 B2 GND GND hvn L=3.5e-07 W=0.65e-06
M11 GND B3 7 GND hvn L=3.5e-07 W=0.65e-06
M12 GND 2 5 GND hvn L=3.5e-07 W=0.65e-06
M13 O 5 GND GND hvn L=3.5e-07 W=0.65e-06
M14 GND 5 O GND hvn L=3.5e-07 W=0.65e-06
M15 O 5 GND GND hvn L=3.5e-07 W=0.65e-06
.ENDS OAI13X3

.SUBCKT OAI13X4 O A1 B1 B2 B3
M0 2 A1 VDD VDD hvp L=3.0e-07 W=1e-06
M1 3 B1 2 VDD hvp L=3.0e-07 W=1e-06
M2 4 B2 3 VDD hvp L=3.0e-07 W=1e-06
M3 VDD B3 4 VDD hvp L=3.0e-07 W=1e-06
M4 VDD 2 5 VDD hvp L=3.0e-07 W=1e-06
M5 O 5 VDD VDD hvp L=3.0e-07 W=1e-06
M6 VDD 5 O VDD hvp L=3.0e-07 W=1e-06
M7 O 5 VDD VDD hvp L=3.0e-07 W=1e-06
M8 VDD 5 O VDD hvp L=3.0e-07 W=1e-06
M9 7 A1 2 GND hvn L=3.5e-07 W=0.65e-06
M10 GND B1 7 GND hvn L=3.5e-07 W=0.65e-06
M11 7 B2 GND GND hvn L=3.5e-07 W=0.65e-06
M12 GND B3 7 GND hvn L=3.5e-07 W=0.65e-06
M13 GND 2 5 GND hvn L=3.5e-07 W=0.65e-06
M14 O 5 GND GND hvn L=3.5e-07 W=0.65e-06
M15 GND 5 O GND hvn L=3.5e-07 W=0.65e-06
M16 O 5 GND GND hvn L=3.5e-07 W=0.65e-06
M17 GND 5 O GND hvn L=3.5e-07 W=0.65e-06
.ENDS OAI13X4

.SUBCKT OAI21B1X1 O A1 A2 B1B
M0 VDD B1B 1 VDD hvp L=3.0e-07 W=0.9e-06
M1 O 1 VDD VDD hvp L=3.0e-07 W=0.9e-06
M2 4 A1 O VDD hvp L=3.0e-07 W=0.9e-06
M3 VDD A2 4 VDD hvp L=3.0e-07 W=0.9e-06
M4 5 A2 VDD VDD hvp L=3.0e-07 W=0.9e-06
M5 O A1 5 VDD hvp L=3.0e-07 W=0.9e-06
M6 1 B1B GND GND hvn L=3.5e-07 W=0.6e-06
M7 O 1 7 GND hvn L=3.5e-07 W=0.6e-06
M8 7 1 O GND hvn L=3.5e-07 W=0.6e-06
M9 GND A2 7 GND hvn L=3.5e-07 W=0.6e-06
M10 7 A1 GND GND hvn L=3.5e-07 W=0.6e-06
.ENDS OAI21B1X1

.SUBCKT OAI21B1X2 O A1 A2 B1B
M0 VDD B1B 1 VDD hvp L=3.0e-07 W=0.9e-06
M1 O 1 VDD VDD hvp L=3.0e-07 W=0.9e-06
M2 VDD 1 O VDD hvp L=3.0e-07 W=0.9e-06
M3 4 A2 VDD VDD hvp L=3.0e-07 W=0.9e-06
M4 VDD A2 4 VDD hvp L=3.0e-07 W=0.9e-06
M5 4 A2 VDD VDD hvp L=3.0e-07 W=0.9e-06
M6 O A1 4 VDD hvp L=3.0e-07 W=0.9e-06
M7 4 A1 O VDD hvp L=3.0e-07 W=0.9e-06
M8 O A1 4 VDD hvp L=3.0e-07 W=0.9e-06
M9 1 B1B GND GND hvn L=3.5e-07 W=0.6e-06
M10 6 1 O GND hvn L=3.5e-07 W=0.6e-06
M11 O 1 6 GND hvn L=3.5e-07 W=0.6e-06
M12 6 1 O GND hvn L=3.5e-07 W=0.6e-06
M13 GND A2 6 GND hvn L=3.5e-07 W=0.6e-06
M14 6 A2 GND GND hvn L=3.5e-07 W=0.6e-06
M15 GND A1 6 GND hvn L=3.5e-07 W=0.6e-06
M16 6 A1 GND GND hvn L=3.5e-07 W=0.6e-06
.ENDS OAI21B1X2

.SUBCKT OAI21B1X3 O A1 A2 B1B
M0 2 A1 1 VDD hvp L=3.0e-07 W=1e-06
M1 VDD A2 2 VDD hvp L=3.0e-07 W=1e-06
M2 4 B1B VDD VDD hvp L=3.0e-07 W=1e-06
M3 5 1 4 VDD hvp L=3.0e-07 W=1e-06
M4 O 5 VDD VDD hvp L=3.0e-07 W=1e-06
M5 VDD 5 O VDD hvp L=3.0e-07 W=1e-06
M6 O 5 VDD VDD hvp L=3.0e-07 W=1e-06
M7 1 A1 GND GND hvn L=3.5e-07 W=0.65e-06
M8 GND A2 1 GND hvn L=3.5e-07 W=0.65e-06
M9 5 B1B GND GND hvn L=3.5e-07 W=0.65e-06
M10 GND 1 5 GND hvn L=3.5e-07 W=0.65e-06
M11 O 5 GND GND hvn L=3.5e-07 W=0.65e-06
M12 GND 5 O GND hvn L=3.5e-07 W=0.65e-06
M13 O 5 GND GND hvn L=3.5e-07 W=0.65e-06
.ENDS OAI21B1X3

.SUBCKT OAI21B1X4 O A1 A2 B1B
M0 2 A1 1 VDD hvp L=3.0e-07 W=1e-06
M1 VDD A2 2 VDD hvp L=3.0e-07 W=1e-06
M2 4 B1B VDD VDD hvp L=3.0e-07 W=1e-06
M3 5 1 4 VDD hvp L=3.0e-07 W=1e-06
M4 O 5 VDD VDD hvp L=3.0e-07 W=1e-06
M5 VDD 5 O VDD hvp L=3.0e-07 W=1e-06
M6 O 5 VDD VDD hvp L=3.0e-07 W=1e-06
M7 VDD 5 O VDD hvp L=3.0e-07 W=1e-06
M8 1 A1 GND GND hvn L=3.5e-07 W=0.65e-06
M9 GND A2 1 GND hvn L=3.5e-07 W=0.65e-06
M10 5 B1B GND GND hvn L=3.5e-07 W=0.65e-06
M11 GND 1 5 GND hvn L=3.5e-07 W=0.65e-06
M12 O 5 GND GND hvn L=3.5e-07 W=0.65e-06
M13 GND 5 O GND hvn L=3.5e-07 W=0.65e-06
M14 O 5 GND GND hvn L=3.5e-07 W=0.65e-06
M15 GND 5 O GND hvn L=3.5e-07 W=0.65e-06
.ENDS OAI21B1X4

.SUBCKT OAI2222X1 O A1 A2 B1 B2 C1 C2 D1 D2
M0 2 A2 VDD VDD hvp L=3.0e-07 W=0.9e-06
M1 O A1 2 VDD hvp L=3.0e-07 W=0.9e-06
M2 4 B1 O VDD hvp L=3.0e-07 W=0.9e-06
M3 VDD B2 4 VDD hvp L=3.0e-07 W=0.9e-06
M4 5 C1 O VDD hvp L=3.0e-07 W=0.9e-06
M5 VDD C2 5 VDD hvp L=3.0e-07 W=0.9e-06
M6 6 D2 VDD VDD hvp L=3.0e-07 W=0.9e-06
M7 O D1 6 VDD hvp L=3.0e-07 W=0.9e-06
M8 O A2 7 GND hvn L=3.5e-07 W=0.6e-06
M9 7 A1 O GND hvn L=3.5e-07 W=0.6e-06
M10 8 B1 7 GND hvn L=3.5e-07 W=0.6e-06
M11 7 B2 8 GND hvn L=3.5e-07 W=0.6e-06
M12 8 C1 9 GND hvn L=3.5e-07 W=0.6e-06
M13 9 C2 8 GND hvn L=3.5e-07 W=0.6e-06
M14 GND D2 9 GND hvn L=3.5e-07 W=0.6e-06
M15 9 D1 GND GND hvn L=3.5e-07 W=0.6e-06
.ENDS OAI2222X1

.SUBCKT OAI2222X2 O A1 A2 B1 B2 C1 C2 D1 D2
M0 VDD A2 1 VDD hvp L=3.0e-07 W=0.9e-06
M1 1 A2 VDD VDD hvp L=3.0e-07 W=0.9e-06
M2 O A1 1 VDD hvp L=3.0e-07 W=0.9e-06
M3 1 A1 O VDD hvp L=3.0e-07 W=0.9e-06
M4 O B1 4 VDD hvp L=3.0e-07 W=0.9e-06
M5 4 B1 O VDD hvp L=3.0e-07 W=0.9e-06
M6 VDD B2 4 VDD hvp L=3.0e-07 W=0.9e-06
M7 4 B2 VDD VDD hvp L=3.0e-07 W=0.9e-06
M8 O C1 5 VDD hvp L=3.0e-07 W=0.9e-06
M9 5 C1 O VDD hvp L=3.0e-07 W=0.9e-06
M10 VDD C2 5 VDD hvp L=3.0e-07 W=0.9e-06
M11 5 C2 VDD VDD hvp L=3.0e-07 W=0.9e-06
M12 VDD D2 6 VDD hvp L=3.0e-07 W=0.9e-06
M13 6 D2 VDD VDD hvp L=3.0e-07 W=0.9e-06
M14 O D1 6 VDD hvp L=3.0e-07 W=0.9e-06
M15 6 D1 O VDD hvp L=3.0e-07 W=0.9e-06
M16 O A2 7 GND hvn L=3.5e-07 W=0.6e-06
M17 7 A2 O GND hvn L=3.5e-07 W=0.6e-06
M18 O A1 7 GND hvn L=3.5e-07 W=0.6e-06
M19 7 A1 O GND hvn L=3.5e-07 W=0.6e-06
M20 8 B1 7 GND hvn L=3.5e-07 W=0.6e-06
M21 7 B1 8 GND hvn L=3.5e-07 W=0.6e-06
M22 8 B2 7 GND hvn L=3.5e-07 W=0.6e-06
M23 7 B2 8 GND hvn L=3.5e-07 W=0.6e-06
M24 8 C1 9 GND hvn L=3.5e-07 W=0.6e-06
M25 9 C1 8 GND hvn L=3.5e-07 W=0.6e-06
M26 8 C2 9 GND hvn L=3.5e-07 W=0.6e-06
M27 9 C2 8 GND hvn L=3.5e-07 W=0.6e-06
M28 GND D2 9 GND hvn L=3.5e-07 W=0.6e-06
M29 9 D2 GND GND hvn L=3.5e-07 W=0.6e-06
M30 GND D1 9 GND hvn L=3.5e-07 W=0.6e-06
M31 9 D1 GND GND hvn L=3.5e-07 W=0.6e-06
.ENDS OAI2222X2

.SUBCKT OAI222X1 O A1 A2 B1 B2 C1 C2
M0 VDD A2 1 VDD hvp L=3.0e-07 W=0.9e-06
M1 3 A2 VDD VDD hvp L=3.0e-07 W=0.9e-06
M2 O A1 3 VDD hvp L=3.0e-07 W=0.9e-06
M3 1 A1 O VDD hvp L=3.0e-07 W=0.9e-06
M4 VDD B2 5 VDD hvp L=3.0e-07 W=0.9e-06
M5 6 B2 VDD VDD hvp L=3.0e-07 W=0.9e-06
M6 O B1 6 VDD hvp L=3.0e-07 W=0.9e-06
M7 5 B1 O VDD hvp L=3.0e-07 W=0.9e-06
M8 O C1 7 VDD hvp L=3.0e-07 W=0.9e-06
M9 8 C1 O VDD hvp L=3.0e-07 W=0.9e-06
M10 VDD C2 8 VDD hvp L=3.0e-07 W=0.9e-06
M11 7 C2 VDD VDD hvp L=3.0e-07 W=0.9e-06
M12 O A2 9 GND hvn L=3.5e-07 W=0.6e-06
M13 9 A2 O GND hvn L=3.5e-07 W=0.6e-06
M14 O A1 9 GND hvn L=3.5e-07 W=0.6e-06
M15 9 A1 O GND hvn L=3.5e-07 W=0.6e-06
M16 10 B2 9 GND hvn L=3.5e-07 W=0.6e-06
M17 9 B2 10 GND hvn L=3.5e-07 W=0.6e-06
M18 10 B1 9 GND hvn L=3.5e-07 W=0.6e-06
M19 9 B1 10 GND hvn L=3.5e-07 W=0.6e-06
M20 10 C1 GND GND hvn L=3.5e-07 W=0.6e-06
M21 GND C1 10 GND hvn L=3.5e-07 W=0.6e-06
M22 10 C2 GND GND hvn L=3.5e-07 W=0.6e-06
M23 GND C2 10 GND hvn L=3.5e-07 W=0.6e-06
.ENDS OAI222X1

.SUBCKT OAI222X2 O A1 A2 B1 B2 C1 C2
M0 2 A2 VDD VDD hvp L=3.0e-07 W=0.9e-06
M1 VDD A2 2 VDD hvp L=3.0e-07 W=0.9e-06
M2 2 A2 VDD VDD hvp L=3.0e-07 W=0.9e-06
M3 O A1 2 VDD hvp L=3.0e-07 W=0.9e-06
M4 2 A1 O VDD hvp L=3.0e-07 W=0.9e-06
M5 O A1 2 VDD hvp L=3.0e-07 W=0.9e-06
M6 4 B2 VDD VDD hvp L=3.0e-07 W=0.9e-06
M7 VDD B2 4 VDD hvp L=3.0e-07 W=0.9e-06
M8 4 B2 VDD VDD hvp L=3.0e-07 W=0.9e-06
M9 O B1 4 VDD hvp L=3.0e-07 W=0.9e-06
M10 4 B1 O VDD hvp L=3.0e-07 W=0.9e-06
M11 O B1 4 VDD hvp L=3.0e-07 W=0.9e-06
M12 5 C1 O VDD hvp L=3.0e-07 W=0.9e-06
M13 O C1 5 VDD hvp L=3.0e-07 W=0.9e-06
M14 5 C1 O VDD hvp L=3.0e-07 W=0.9e-06
M15 VDD C2 5 VDD hvp L=3.0e-07 W=0.9e-06
M16 5 C2 VDD VDD hvp L=3.0e-07 W=0.9e-06
M17 VDD C2 5 VDD hvp L=3.0e-07 W=0.9e-06
M18 6 A2 O GND hvn L=3.5e-07 W=0.6e-06
M19 O A2 6 GND hvn L=3.5e-07 W=0.6e-06
M20 6 A2 O GND hvn L=3.5e-07 W=0.6e-06
M21 O A1 6 GND hvn L=3.5e-07 W=0.6e-06
M22 6 A1 O GND hvn L=3.5e-07 W=0.6e-06
M23 O A1 6 GND hvn L=3.5e-07 W=0.6e-06
M24 6 B2 7 GND hvn L=3.5e-07 W=0.6e-06
M25 7 B2 6 GND hvn L=3.5e-07 W=0.6e-06
M26 6 B2 7 GND hvn L=3.5e-07 W=0.6e-06
M27 7 B1 6 GND hvn L=3.5e-07 W=0.6e-06
M28 6 B1 7 GND hvn L=3.5e-07 W=0.6e-06
M29 7 B1 6 GND hvn L=3.5e-07 W=0.6e-06
M30 GND C1 7 GND hvn L=3.5e-07 W=0.6e-06
M31 7 C1 GND GND hvn L=3.5e-07 W=0.6e-06
M32 GND C1 7 GND hvn L=3.5e-07 W=0.6e-06
M33 7 C2 GND GND hvn L=3.5e-07 W=0.6e-06
M34 GND C2 7 GND hvn L=3.5e-07 W=0.6e-06
M35 7 C2 GND GND hvn L=3.5e-07 W=0.6e-06
.ENDS OAI222X2

.SUBCKT OAI22B2X1 O A1 A2 B1B B2B
M0 2 B2B VDD VDD hvp L=3.0e-07 W=1e-06
M1 VDD B1B 2 VDD hvp L=3.0e-07 W=1e-06
M2 O 2 VDD VDD hvp L=3.0e-07 W=1e-06
M3 4 A1 O VDD hvp L=3.0e-07 W=1e-06
M4 VDD A2 4 VDD hvp L=3.0e-07 W=1e-06
M5 5 A2 VDD VDD hvp L=3.0e-07 W=1e-06
M6 O A1 5 VDD hvp L=3.0e-07 W=1e-06
M7 7 B2B GND GND hvn L=3.5e-07 W=0.65e-06
M8 2 B1B 7 GND hvn L=3.5e-07 W=0.65e-06
M9 8 2 O GND hvn L=3.5e-07 W=0.65e-06
M10 8 A1 GND GND hvn L=3.5e-07 W=0.65e-06
M11 GND A2 8 GND hvn L=3.5e-07 W=0.65e-06
.ENDS OAI22B2X1

.SUBCKT OAI22B2X2 O A1 A2 B1B B2B
M0 2 B2B VDD VDD hvp L=3.0e-07 W=0.9e-06
M1 VDD B1B 2 VDD hvp L=3.0e-07 W=0.9e-06
M2 O 2 VDD VDD hvp L=3.0e-07 W=0.9e-06
M3 VDD 2 O VDD hvp L=3.0e-07 W=0.9e-06
M4 O A1 4 VDD hvp L=3.0e-07 W=0.9e-06
M5 4 A1 O VDD hvp L=3.0e-07 W=0.9e-06
M6 VDD A2 4 VDD hvp L=3.0e-07 W=0.9e-06
M7 4 A2 VDD VDD hvp L=3.0e-07 W=0.9e-06
M8 6 B2B GND GND hvn L=3.5e-07 W=0.6e-06
M9 2 B1B 6 GND hvn L=3.5e-07 W=0.6e-06
M10 7 2 O GND hvn L=3.5e-07 W=0.6e-06
M11 O 2 7 GND hvn L=3.5e-07 W=0.6e-06
M12 GND A1 7 GND hvn L=3.5e-07 W=0.6e-06
M13 7 A1 GND GND hvn L=3.5e-07 W=0.6e-06
M14 GND A2 7 GND hvn L=3.5e-07 W=0.6e-06
M15 7 A2 GND GND hvn L=3.5e-07 W=0.6e-06
.ENDS OAI22B2X2

.SUBCKT OAI22X1 O A1 A2 B1 B2
M0 VDD A2 1 VDD hvp L=3.0e-07 W=0.9e-06
M1 1 A2 VDD VDD hvp L=3.0e-07 W=0.9e-06
M2 O A1 1 VDD hvp L=3.0e-07 W=0.9e-06
M3 1 A1 O VDD hvp L=3.0e-07 W=0.9e-06
M4 O B1 4 VDD hvp L=3.0e-07 W=0.9e-06
M5 5 B1 O VDD hvp L=3.0e-07 W=0.9e-06
M6 VDD B2 5 VDD hvp L=3.0e-07 W=0.9e-06
M7 4 B2 VDD VDD hvp L=3.0e-07 W=0.9e-06
M8 O A2 6 GND hvn L=3.5e-07 W=0.6e-06
M9 6 A2 O GND hvn L=3.5e-07 W=0.6e-06
M10 O A1 6 GND hvn L=3.5e-07 W=0.6e-06
M11 6 A1 O GND hvn L=3.5e-07 W=0.6e-06
M12 6 B1 GND GND hvn L=3.5e-07 W=0.6e-06
M13 GND B1 6 GND hvn L=3.5e-07 W=0.6e-06
M14 6 B2 GND GND hvn L=3.5e-07 W=0.6e-06
M15 GND B2 6 GND hvn L=3.5e-07 W=0.6e-06
.ENDS OAI22X1

.SUBCKT OAI22X2 O A1 A2 B1 B2
M0 2 A2 VDD VDD hvp L=3.0e-07 W=0.9e-06
M1 3 A1 2 VDD hvp L=3.0e-07 W=0.9e-06
M2 4 B1 3 VDD hvp L=3.0e-07 W=0.9e-06
M3 VDD B2 4 VDD hvp L=3.0e-07 W=0.9e-06
M4 VDD 3 5 VDD hvp L=3.0e-07 W=0.9e-06
M5 O 5 VDD VDD hvp L=3.0e-07 W=1e-06
M6 VDD 5 O VDD hvp L=3.0e-07 W=1e-06
M7 3 A2 7 GND hvn L=3.5e-07 W=0.6e-06
M8 7 A1 3 GND hvn L=3.5e-07 W=0.6e-06
M9 GND B1 7 GND hvn L=3.5e-07 W=0.6e-06
M10 7 B2 GND GND hvn L=3.5e-07 W=0.6e-06
M11 GND 3 5 GND hvn L=3.5e-07 W=0.6e-06
M12 O 5 GND GND hvn L=3.5e-07 W=0.65e-06
M13 GND 5 O GND hvn L=3.5e-07 W=0.65e-06
.ENDS OAI22X2

.SUBCKT OAI22X3 O A1 A2 B1 B2
M0 2 A2 VDD VDD hvp L=3.0e-07 W=0.9e-06
M1 3 A1 2 VDD hvp L=3.0e-07 W=0.9e-06
M2 4 B1 3 VDD hvp L=3.0e-07 W=0.9e-06
M3 VDD B2 4 VDD hvp L=3.0e-07 W=0.9e-06
M4 VDD 3 5 VDD hvp L=3.0e-07 W=0.9e-06
M5 O 5 VDD VDD hvp L=3.0e-07 W=1e-06
M6 VDD 5 O VDD hvp L=3.0e-07 W=1e-06
M7 O 5 VDD VDD hvp L=3.0e-07 W=1e-06
M8 3 A2 7 GND hvn L=3.5e-07 W=0.6e-06
M9 7 A1 3 GND hvn L=3.5e-07 W=0.6e-06
M10 GND B1 7 GND hvn L=3.5e-07 W=0.6e-06
M11 7 B2 GND GND hvn L=3.5e-07 W=0.6e-06
M12 GND 3 5 GND hvn L=3.5e-07 W=0.6e-06
M13 O 5 GND GND hvn L=3.5e-07 W=0.65e-06
M14 GND 5 O GND hvn L=3.5e-07 W=0.65e-06
M15 O 5 GND GND hvn L=3.5e-07 W=0.65e-06
.ENDS OAI22X3

.SUBCKT OAI22X4 O A1 A2 B1 B2
M0 2 A2 VDD VDD hvp L=3.0e-07 W=0.9e-06
M1 3 A1 2 VDD hvp L=3.0e-07 W=0.9e-06
M2 4 B1 3 VDD hvp L=3.0e-07 W=0.9e-06
M3 VDD B2 4 VDD hvp L=3.0e-07 W=0.9e-06
M4 VDD 3 5 VDD hvp L=3.0e-07 W=0.9e-06
M5 O 5 VDD VDD hvp L=3.0e-07 W=1e-06
M6 VDD 5 O VDD hvp L=3.0e-07 W=1e-06
M7 O 5 VDD VDD hvp L=3.0e-07 W=1e-06
M8 VDD 5 O VDD hvp L=3.0e-07 W=1e-06
M9 3 A2 7 GND hvn L=3.5e-07 W=0.6e-06
M10 7 A1 3 GND hvn L=3.5e-07 W=0.6e-06
M11 GND B1 7 GND hvn L=3.5e-07 W=0.6e-06
M12 7 B2 GND GND hvn L=3.5e-07 W=0.6e-06
M13 GND 3 5 GND hvn L=3.5e-07 W=0.6e-06
M14 O 5 GND GND hvn L=3.5e-07 W=0.65e-06
M15 GND 5 O GND hvn L=3.5e-07 W=0.65e-06
M16 O 5 GND GND hvn L=3.5e-07 W=0.65e-06
M17 GND 5 O GND hvn L=3.5e-07 W=0.65e-06
.ENDS OAI22X4

.SUBCKT OR2B1X1 O B2 I1
M0 2 I1 VDD VDD hvp L=3.0e-07 W=1e-06
M1 O 2 VDD VDD hvp L=3.0e-07 W=1e-06
M2 VDD B2 O VDD hvp L=3.0e-07 W=1e-06
M3 2 I1 GND GND hvn L=3.5e-07 W=0.65e-06
M4 5 2 GND GND hvn L=3.5e-07 W=0.65e-06
M5 O B2 5 GND hvn L=3.5e-07 W=0.65e-06
.ENDS OR2B1X1

.SUBCKT OR2B1X2 O B2 I1
M0 VDD I1 1 VDD hvp L=3.0e-07 W=0.9e-06
M1 O 1 VDD VDD hvp L=3.0e-07 W=0.9e-06
M2 VDD B2 O VDD hvp L=3.0e-07 W=0.9e-06
M3 GND I1 1 GND hvn L=3.5e-07 W=0.6e-06
M4 5 B2 GND GND hvn L=3.5e-07 W=0.6e-06
M5 O 1 5 GND hvn L=3.5e-07 W=0.6e-06
M6 6 1 O GND hvn L=3.5e-07 W=0.6e-06
M7 GND B2 6 GND hvn L=3.5e-07 W=0.6e-06
.ENDS OR2B1X2

.SUBCKT OR2B1X4 O B2 I1
M0 VDD B2 1 VDD hvp L=3.0e-07 W=1e-06
M1 3 1 VDD VDD hvp L=3.0e-07 W=1e-06
M2 4 I1 3 VDD hvp L=3.0e-07 W=1e-06
M3 O 4 VDD VDD hvp L=3.0e-07 W=1e-06
M4 VDD 4 O VDD hvp L=3.0e-07 W=1e-06
M5 O 4 VDD VDD hvp L=3.0e-07 W=1e-06
M6 VDD 4 O VDD hvp L=3.0e-07 W=1e-06
M7 GND B2 1 GND hvn L=3.5e-07 W=0.65e-06
M8 4 1 GND GND hvn L=3.5e-07 W=0.65e-06
M9 GND I1 4 GND hvn L=3.5e-07 W=0.65e-06
M10 O 4 GND GND hvn L=3.5e-07 W=0.65e-06
M11 GND 4 O GND hvn L=3.5e-07 W=0.65e-06
M12 O 4 GND GND hvn L=3.5e-07 W=0.65e-06
M13 GND 4 O GND hvn L=3.5e-07 W=0.65e-06
.ENDS OR2B1X4

.SUBCKT OR2X1 O I1 I2
M0 2 I1 1 VDD hvp L=3.0e-07 W=1e-06
M1 VDD I2 2 VDD hvp L=3.0e-07 W=1e-06
M2 O 1 VDD VDD hvp L=3.0e-07 W=1e-06
M3 1 I1 GND GND hvn L=3.5e-07 W=0.65e-06
M4 GND I2 1 GND hvn L=3.5e-07 W=0.65e-06
M5 O 1 GND GND hvn L=3.5e-07 W=0.65e-06
.ENDS OR2X1

.SUBCKT OR2X2 O I1 I2
M0 2 I1 1 VDD hvp L=3.0e-07 W=1e-06
M1 VDD I2 2 VDD hvp L=3.0e-07 W=1e-06
M2 O 1 VDD VDD hvp L=3.0e-07 W=1e-06
M3 VDD 1 O VDD hvp L=3.0e-07 W=1e-06
M4 1 I1 GND GND hvn L=3.5e-07 W=0.65e-06
M5 GND I2 1 GND hvn L=3.5e-07 W=0.65e-06
M6 O 1 GND GND hvn L=3.5e-07 W=0.65e-06
M7 GND 1 O GND hvn L=3.5e-07 W=0.65e-06
.ENDS OR2X2

.SUBCKT OR2X4 O I1 I2
M0 2 I1 1 VDD hvp L=3.0e-07 W=1e-06
M1 VDD I2 2 VDD hvp L=3.0e-07 W=1e-06
M2 O 1 VDD VDD hvp L=3.0e-07 W=1e-06
M3 VDD 1 O VDD hvp L=3.0e-07 W=1e-06
M4 O 1 VDD VDD hvp L=3.0e-07 W=1e-06
M5 VDD 1 O VDD hvp L=3.0e-07 W=1e-06
M6 1 I1 GND GND hvn L=3.5e-07 W=0.65e-06
M7 GND I2 1 GND hvn L=3.5e-07 W=0.65e-06
M8 O 1 GND GND hvn L=3.5e-07 W=0.65e-06
M9 GND 1 O GND hvn L=3.5e-07 W=0.65e-06
M10 O 1 GND GND hvn L=3.5e-07 W=0.65e-06
M11 GND 1 O GND hvn L=3.5e-07 W=0.65e-06
.ENDS OR2X4

.SUBCKT OR3B1X1 O B3 I1 I2
M0 VDD I2 1 VDD hvp L=3.0e-07 W=1e-06
M1 O B3 VDD VDD hvp L=3.0e-07 W=1e-06
M2 VDD 1 O VDD hvp L=3.0e-07 W=1e-06
M3 O 4 VDD VDD hvp L=3.0e-07 W=1e-06
M4 VDD I1 4 VDD hvp L=3.0e-07 W=1e-06
M5 GND I2 1 GND hvn L=3.5e-07 W=0.65e-06
M6 6 B3 GND GND hvn L=3.5e-07 W=0.65e-06
M7 7 1 6 GND hvn L=3.5e-07 W=0.65e-06
M8 O 4 7 GND hvn L=3.5e-07 W=0.65e-06
M9 GND I1 4 GND hvn L=3.5e-07 W=0.65e-06
.ENDS OR3B1X1

.SUBCKT OR3B1X2 O B3 I1 I2
M0 VDD B3 1 VDD hvp L=3.0e-07 W=1e-06
M1 3 1 VDD VDD hvp L=3.0e-07 W=1e-06
M2 4 I2 3 VDD hvp L=3.0e-07 W=1e-06
M3 5 I1 4 VDD hvp L=3.0e-07 W=1e-06
M4 O 5 VDD VDD hvp L=3.0e-07 W=1e-06
M5 VDD 5 O VDD hvp L=3.0e-07 W=1e-06
M6 GND B3 1 GND hvn L=3.5e-07 W=0.65e-06
M7 5 1 GND GND hvn L=3.5e-07 W=0.65e-06
M8 GND I2 5 GND hvn L=3.5e-07 W=0.65e-06
M9 5 I1 GND GND hvn L=3.5e-07 W=0.65e-06
M10 O 5 GND GND hvn L=3.5e-07 W=0.65e-06
M11 GND 5 O GND hvn L=3.5e-07 W=0.65e-06
.ENDS OR3B1X2

.SUBCKT OR3B1X4 O B3 I1 I2
M0 VDD B3 1 VDD hvp L=3.0e-07 W=1e-06
M1 3 1 VDD VDD hvp L=3.0e-07 W=1e-06
M2 4 I2 3 VDD hvp L=3.0e-07 W=1e-06
M3 5 I1 4 VDD hvp L=3.0e-07 W=1e-06
M4 O 5 VDD VDD hvp L=3.0e-07 W=1e-06
M5 VDD 5 O VDD hvp L=3.0e-07 W=1e-06
M6 O 5 VDD VDD hvp L=3.0e-07 W=1e-06
M7 VDD 5 O VDD hvp L=3.0e-07 W=1e-06
M8 GND B3 1 GND hvn L=3.5e-07 W=0.65e-06
M9 5 1 GND GND hvn L=3.5e-07 W=0.65e-06
M10 GND I2 5 GND hvn L=3.5e-07 W=0.65e-06
M11 5 I1 GND GND hvn L=3.5e-07 W=0.65e-06
M12 O 5 GND GND hvn L=3.5e-07 W=0.65e-06
M13 GND 5 O GND hvn L=3.5e-07 W=0.65e-06
M14 O 5 GND GND hvn L=3.5e-07 W=0.65e-06
M15 GND 5 O GND hvn L=3.5e-07 W=0.65e-06
.ENDS OR3B1X4

.SUBCKT OR3B2X1 O B2 B3 I1
M0 VDD 3 O VDD hvp L=3.0e-07 W=1e-06
M1 O B2 VDD VDD hvp L=3.0e-07 W=1e-06
M2 VDD B3 O VDD hvp L=3.0e-07 W=1e-06
M3 3 I1 VDD VDD hvp L=3.0e-07 W=1e-06
M4 4 3 O GND hvn L=3.5e-07 W=0.65e-06
M5 5 B2 4 GND hvn L=3.5e-07 W=0.65e-06
M6 GND B3 5 GND hvn L=3.5e-07 W=0.65e-06
M7 3 I1 GND GND hvn L=3.5e-07 W=0.65e-06
.ENDS OR3B2X1

.SUBCKT OR3B2X2 O B2 B3 I1
M0 2 I1 VDD VDD hvp L=3.0e-07 W=0.65e-06
M1 O 2 VDD VDD hvp L=3.0e-07 W=0.65e-06
M2 VDD B2 O VDD hvp L=3.0e-07 W=0.65e-06
M3 O B2 VDD VDD hvp L=3.0e-07 W=0.65e-06
M4 VDD 2 O VDD hvp L=3.0e-07 W=0.65e-06
M5 O B3 VDD VDD hvp L=3.0e-07 W=0.65e-06
M6 VDD B3 O VDD hvp L=3.0e-07 W=0.65e-06
M7 2 I1 GND GND hvn L=3.5e-07 W=0.45e-06
M8 5 2 O GND hvn L=3.5e-07 W=0.45e-06
M9 6 B2 5 GND hvn L=3.5e-07 W=0.45e-06
M10 7 B2 6 GND hvn L=3.5e-07 W=0.45e-06
M11 O 2 7 GND hvn L=3.5e-07 W=0.45e-06
M12 6 B3 GND GND hvn L=3.5e-07 W=0.45e-06
M13 GND B3 6 GND hvn L=3.5e-07 W=0.45e-06
.ENDS OR3B2X2

.SUBCKT OR3B2X4 O B2 B3 I1
M0 2 I1 VDD VDD hvp L=3.0e-07 W=0.65e-06
M1 O 2 VDD VDD hvp L=3.0e-07 W=0.65e-06
M2 VDD B2 O VDD hvp L=3.0e-07 W=0.65e-06
M3 O B2 VDD VDD hvp L=3.0e-07 W=0.65e-06
M4 VDD 2 O VDD hvp L=3.0e-07 W=0.65e-06
M5 O 2 VDD VDD hvp L=3.0e-07 W=0.65e-06
M6 VDD B2 O VDD hvp L=3.0e-07 W=0.65e-06
M7 O B2 VDD VDD hvp L=3.0e-07 W=0.65e-06
M8 VDD 2 O VDD hvp L=3.0e-07 W=0.65e-06
M9 O B3 VDD VDD hvp L=3.0e-07 W=0.65e-06
M10 VDD B3 O VDD hvp L=3.0e-07 W=0.65e-06
M11 O B3 VDD VDD hvp L=3.0e-07 W=0.65e-06
M12 VDD B3 O VDD hvp L=3.0e-07 W=0.65e-06
M13 2 I1 GND GND hvn L=3.5e-07 W=0.45e-06
M14 5 2 O GND hvn L=3.5e-07 W=0.45e-06
M15 6 B2 5 GND hvn L=3.5e-07 W=0.45e-06
M16 7 B2 6 GND hvn L=3.5e-07 W=0.45e-06
M17 O 2 7 GND hvn L=3.5e-07 W=0.45e-06
M18 8 2 O GND hvn L=3.5e-07 W=0.45e-06
M19 6 B2 8 GND hvn L=3.5e-07 W=0.45e-06
M20 9 B2 6 GND hvn L=3.5e-07 W=0.45e-06
M21 O 2 9 GND hvn L=3.5e-07 W=0.45e-06
M22 6 B3 GND GND hvn L=3.5e-07 W=0.45e-06
M23 GND B3 6 GND hvn L=3.5e-07 W=0.45e-06
M24 6 B3 GND GND hvn L=3.5e-07 W=0.45e-06
M25 GND B3 6 GND hvn L=3.5e-07 W=0.45e-06
.ENDS OR3B2X4

.SUBCKT OR3X1 O I1 I2 I3
M0 2 I1 1 VDD hvp L=3.0e-07 W=1e-06
M1 3 I2 2 VDD hvp L=3.0e-07 W=1e-06
M2 VDD I3 3 VDD hvp L=3.0e-07 W=1e-06
M3 O 1 VDD VDD hvp L=3.0e-07 W=1e-06
M4 GND I1 1 GND hvn L=3.5e-07 W=0.65e-06
M5 1 I2 GND GND hvn L=3.5e-07 W=0.65e-06
M6 GND I3 1 GND hvn L=3.5e-07 W=0.65e-06
M7 O 1 GND GND hvn L=3.5e-07 W=0.65e-06
.ENDS OR3X1

.SUBCKT OR3X2 O I1 I2 I3
M0 2 I1 1 VDD hvp L=3.0e-07 W=1e-06
M1 3 I2 2 VDD hvp L=3.0e-07 W=1e-06
M2 VDD I3 3 VDD hvp L=3.0e-07 W=1e-06
M3 O 1 VDD VDD hvp L=3.0e-07 W=1e-06
M4 VDD 1 O VDD hvp L=3.0e-07 W=1e-06
M5 GND I1 1 GND hvn L=3.5e-07 W=0.65e-06
M6 1 I2 GND GND hvn L=3.5e-07 W=0.65e-06
M7 GND I3 1 GND hvn L=3.5e-07 W=0.65e-06
M8 O 1 GND GND hvn L=3.5e-07 W=0.65e-06
M9 GND 1 O GND hvn L=3.5e-07 W=0.65e-06
.ENDS OR3X2

.SUBCKT OR3X4 O I1 I2 I3
M0 2 I1 1 VDD hvp L=3.0e-07 W=1e-06
M1 3 I2 2 VDD hvp L=3.0e-07 W=1e-06
M2 VDD I3 3 VDD hvp L=3.0e-07 W=1e-06
M3 O 1 VDD VDD hvp L=3.0e-07 W=1e-06
M4 VDD 1 O VDD hvp L=3.0e-07 W=1e-06
M5 O 1 VDD VDD hvp L=3.0e-07 W=1e-06
M6 VDD 1 O VDD hvp L=3.0e-07 W=1e-06
M7 GND I1 1 GND hvn L=3.5e-07 W=0.65e-06
M8 1 I2 GND GND hvn L=3.5e-07 W=0.65e-06
M9 GND I3 1 GND hvn L=3.5e-07 W=0.65e-06
M10 O 1 GND GND hvn L=3.5e-07 W=0.65e-06
M11 GND 1 O GND hvn L=3.5e-07 W=0.65e-06
M12 O 1 GND GND hvn L=3.5e-07 W=0.65e-06
M13 GND 1 O GND hvn L=3.5e-07 W=0.65e-06
.ENDS OR3X4

.SUBCKT OR4X1 O I1 I2 I3 I4
M0 2 I1 1 VDD hvp L=3.0e-07 W=0.9e-06
M1 VDD I2 2 VDD hvp L=3.0e-07 W=0.9e-06
M2 4 I4 VDD VDD hvp L=3.0e-07 W=0.9e-06
M3 5 I3 4 VDD hvp L=3.0e-07 W=0.9e-06
M4 O 1 VDD VDD hvp L=3.0e-07 W=0.9e-06
M5 VDD 5 O VDD hvp L=3.0e-07 W=0.9e-06
M6 1 I1 GND GND hvn L=3.5e-07 W=0.6e-06
M7 GND I2 1 GND hvn L=3.5e-07 W=0.6e-06
M8 5 I4 GND GND hvn L=3.5e-07 W=0.6e-06
M9 GND I3 5 GND hvn L=3.5e-07 W=0.6e-06
M10 8 1 O GND hvn L=3.5e-07 W=0.6e-06
M11 GND 5 8 GND hvn L=3.5e-07 W=0.6e-06
.ENDS OR4X1

.SUBCKT OR4X2 O I1 I2 I3 I4
M0 2 I1 1 VDD hvp L=3.0e-07 W=0.9e-06
M1 VDD I2 2 VDD hvp L=3.0e-07 W=0.9e-06
M2 4 I4 VDD VDD hvp L=3.0e-07 W=0.9e-06
M3 5 I3 4 VDD hvp L=3.0e-07 W=0.9e-06
M4 O 1 VDD VDD hvp L=3.0e-07 W=0.9e-06
M5 VDD 5 O VDD hvp L=3.0e-07 W=0.9e-06
M6 O 5 VDD VDD hvp L=3.0e-07 W=0.9e-06
M7 VDD 1 O VDD hvp L=3.0e-07 W=0.9e-06
M8 1 I1 GND GND hvn L=3.5e-07 W=0.6e-06
M9 GND I2 1 GND hvn L=3.5e-07 W=0.6e-06
M10 5 I4 GND GND hvn L=3.5e-07 W=0.6e-06
M11 GND I3 5 GND hvn L=3.5e-07 W=0.6e-06
M12 8 1 O GND hvn L=3.5e-07 W=0.6e-06
M13 GND 5 8 GND hvn L=3.5e-07 W=0.6e-06
M14 9 5 GND GND hvn L=3.5e-07 W=0.6e-06
M15 O 1 9 GND hvn L=3.5e-07 W=0.6e-06
.ENDS OR4X2

.SUBCKT OR4X4 O I1 I2 I3 I4
M0 2 I1 1 VDD hvp L=3.0e-07 W=0.9e-06
M1 VDD I2 2 VDD hvp L=3.0e-07 W=0.9e-06
M2 4 I4 VDD VDD hvp L=3.0e-07 W=0.9e-06
M3 5 I3 4 VDD hvp L=3.0e-07 W=0.9e-06
M4 O 1 VDD VDD hvp L=3.0e-07 W=0.9e-06
M5 VDD 5 O VDD hvp L=3.0e-07 W=0.9e-06
M6 O 5 VDD VDD hvp L=3.0e-07 W=0.9e-06
M7 VDD 1 O VDD hvp L=3.0e-07 W=0.9e-06
M8 O 1 VDD VDD hvp L=3.0e-07 W=0.9e-06
M9 VDD 5 O VDD hvp L=3.0e-07 W=0.9e-06
M10 O 5 VDD VDD hvp L=3.0e-07 W=0.9e-06
M11 VDD 1 O VDD hvp L=3.0e-07 W=0.9e-06
M12 1 I1 GND GND hvn L=3.5e-07 W=0.6e-06
M13 GND I2 1 GND hvn L=3.5e-07 W=0.6e-06
M14 5 I4 GND GND hvn L=3.5e-07 W=0.6e-06
M15 GND I3 5 GND hvn L=3.5e-07 W=0.6e-06
M16 8 1 O GND hvn L=3.5e-07 W=0.6e-06
M17 GND 5 8 GND hvn L=3.5e-07 W=0.6e-06
M18 9 5 GND GND hvn L=3.5e-07 W=0.6e-06
M19 O 1 9 GND hvn L=3.5e-07 W=0.6e-06
M20 10 1 O GND hvn L=3.5e-07 W=0.6e-06
M21 GND 5 10 GND hvn L=3.5e-07 W=0.6e-06
M22 11 5 GND GND hvn L=3.5e-07 W=0.6e-06
M23 O 1 11 GND hvn L=3.5e-07 W=0.6e-06
.ENDS OR4X4

.SUBCKT SFFCKBQX1 Q D SEL TD CKB
M0 VDD SEL 1 VDD hvp L=3.0e-07 W=0.3e-06
M1 3 SEL VDD VDD hvp L=3.0e-07 W=0.9e-06
M2 4 D 3 VDD hvp L=3.0e-07 W=0.9e-06
M3 5 1 4 VDD hvp L=3.0e-07 W=0.9e-06
M4 VDD TD 5 VDD hvp L=3.0e-07 W=0.9e-06
M5 6 CKB VDD VDD hvp L=3.0e-07 W=0.6e-06
M6 7 6 VDD VDD hvp L=3.0e-07 W=0.3e-06
M7 8 6 4 VDD hvp L=3.0e-07 W=0.6e-06
M8 9 7 8 VDD hvp L=3.0e-07 W=0.4e-06
M9 VDD 10 9 VDD hvp L=3.0e-07 W=0.3e-06
M10 10 8 VDD VDD hvp L=3.0e-07 W=0.5e-06
M11 11 7 10 VDD hvp L=3.0e-07 W=0.5e-06
M12 12 6 11 VDD hvp L=3.0e-07 W=0.3e-06
M13 VDD 13 12 VDD hvp L=3.0e-07 W=0.3e-06
M14 VDD 11 13 VDD hvp L=3.0e-07 W=1e-06
M15 Q 13 VDD VDD hvp L=3.0e-07 W=1e-06
M16 GND SEL 1 GND hvn L=3.5e-07 W=0.3e-06
M17 16 1 GND GND hvn L=3.5e-07 W=0.35e-06
M18 4 D 16 GND hvn L=3.5e-07 W=0.35e-06
M19 17 SEL 4 GND hvn L=3.5e-07 W=0.35e-06
M20 GND TD 17 GND hvn L=3.5e-07 W=0.35e-06
M21 GND CKB 6 GND hvn L=3.5e-07 W=0.3e-06
M22 7 6 GND GND hvn L=3.5e-07 W=0.6e-06
M23 8 7 4 GND hvn L=3.5e-07 W=0.6e-06
M24 18 6 8 GND hvn L=3.5e-07 W=0.3e-06
M25 GND 10 18 GND hvn L=3.5e-07 W=0.3e-06
M26 10 8 GND GND hvn L=3.5e-07 W=0.3e-06
M27 11 6 10 GND hvn L=3.5e-07 W=0.3e-06
M28 19 7 11 GND hvn L=3.5e-07 W=0.3e-06
M29 GND 13 19 GND hvn L=3.5e-07 W=0.3e-06
M30 GND 11 13 GND hvn L=3.5e-07 W=0.65e-06
M31 Q 13 GND GND hvn L=3.5e-07 W=0.65e-06
.ENDS SFFCKBQX1

.SUBCKT SFFCKBQX2 Q D SEL TD CKB
M0 VDD SEL 1 VDD hvp L=3.0e-07 W=0.3e-06
M1 3 SEL VDD VDD hvp L=3.0e-07 W=0.9e-06
M2 4 D 3 VDD hvp L=3.0e-07 W=0.9e-06
M3 5 1 4 VDD hvp L=3.0e-07 W=0.9e-06
M4 VDD TD 5 VDD hvp L=3.0e-07 W=0.9e-06
M5 6 CKB VDD VDD hvp L=3.0e-07 W=0.6e-06
M6 7 6 VDD VDD hvp L=3.0e-07 W=0.3e-06
M7 8 6 4 VDD hvp L=3.0e-07 W=0.6e-06
M8 9 7 8 VDD hvp L=3.0e-07 W=0.4e-06
M9 VDD 10 9 VDD hvp L=3.0e-07 W=0.3e-06
M10 10 8 VDD VDD hvp L=3.0e-07 W=0.5e-06
M11 11 7 10 VDD hvp L=3.0e-07 W=0.5e-06
M12 12 6 11 VDD hvp L=3.0e-07 W=0.3e-06
M13 VDD 13 12 VDD hvp L=3.0e-07 W=0.3e-06
M14 VDD 11 13 VDD hvp L=3.0e-07 W=1e-06
M15 Q 13 VDD VDD hvp L=3.0e-07 W=1e-06
M16 VDD 13 Q VDD hvp L=3.0e-07 W=1e-06
M17 GND SEL 1 GND hvn L=3.5e-07 W=0.3e-06
M18 16 1 GND GND hvn L=3.5e-07 W=0.35e-06
M19 4 D 16 GND hvn L=3.5e-07 W=0.35e-06
M20 17 SEL 4 GND hvn L=3.5e-07 W=0.35e-06
M21 GND TD 17 GND hvn L=3.5e-07 W=0.35e-06
M22 GND CKB 6 GND hvn L=3.5e-07 W=0.3e-06
M23 7 6 GND GND hvn L=3.5e-07 W=0.6e-06
M24 8 7 4 GND hvn L=3.5e-07 W=0.6e-06
M25 18 6 8 GND hvn L=3.5e-07 W=0.3e-06
M26 GND 10 18 GND hvn L=3.5e-07 W=0.3e-06
M27 10 8 GND GND hvn L=3.5e-07 W=0.3e-06
M28 11 6 10 GND hvn L=3.5e-07 W=0.3e-06
M29 19 7 11 GND hvn L=3.5e-07 W=0.3e-06
M30 GND 13 19 GND hvn L=3.5e-07 W=0.3e-06
M31 GND 11 13 GND hvn L=3.5e-07 W=0.65e-06
M32 Q 13 GND GND hvn L=3.5e-07 W=0.65e-06
M33 GND 13 Q GND hvn L=3.5e-07 W=0.65e-06
.ENDS SFFCKBQX2

.SUBCKT SFFCKBQX4 Q D SEL TD CKB
M0 VDD SEL 1 VDD hvp L=3.0e-07 W=0.3e-06
M1 3 SEL VDD VDD hvp L=3.0e-07 W=0.9e-06
M2 4 D 3 VDD hvp L=3.0e-07 W=0.9e-06
M3 5 1 4 VDD hvp L=3.0e-07 W=0.9e-06
M4 VDD TD 5 VDD hvp L=3.0e-07 W=0.9e-06
M5 6 CKB VDD VDD hvp L=3.0e-07 W=0.6e-06
M6 7 6 VDD VDD hvp L=3.0e-07 W=0.3e-06
M7 8 6 4 VDD hvp L=3.0e-07 W=0.6e-06
M8 9 7 8 VDD hvp L=3.0e-07 W=0.4e-06
M9 VDD 10 9 VDD hvp L=3.0e-07 W=0.3e-06
M10 10 8 VDD VDD hvp L=3.0e-07 W=0.5e-06
M11 11 7 10 VDD hvp L=3.0e-07 W=0.5e-06
M12 12 6 11 VDD hvp L=3.0e-07 W=0.3e-06
M13 VDD 13 12 VDD hvp L=3.0e-07 W=0.3e-06
M14 VDD 11 13 VDD hvp L=3.0e-07 W=1e-06
M15 Q 13 VDD VDD hvp L=3.0e-07 W=1e-06
M16 VDD 13 Q VDD hvp L=3.0e-07 W=1e-06
M17 Q 13 VDD VDD hvp L=3.0e-07 W=1e-06
M18 VDD 13 Q VDD hvp L=3.0e-07 W=1e-06
M19 GND SEL 1 GND hvn L=3.5e-07 W=0.3e-06
M20 16 1 GND GND hvn L=3.5e-07 W=0.35e-06
M21 4 D 16 GND hvn L=3.5e-07 W=0.35e-06
M22 17 SEL 4 GND hvn L=3.5e-07 W=0.35e-06
M23 GND TD 17 GND hvn L=3.5e-07 W=0.35e-06
M24 GND CKB 6 GND hvn L=3.5e-07 W=0.3e-06
M25 7 6 GND GND hvn L=3.5e-07 W=0.6e-06
M26 8 7 4 GND hvn L=3.5e-07 W=0.6e-06
M27 18 6 8 GND hvn L=3.5e-07 W=0.3e-06
M28 GND 10 18 GND hvn L=3.5e-07 W=0.3e-06
M29 10 8 GND GND hvn L=3.5e-07 W=0.3e-06
M30 11 6 10 GND hvn L=3.5e-07 W=0.3e-06
M31 19 7 11 GND hvn L=3.5e-07 W=0.3e-06
M32 GND 13 19 GND hvn L=3.5e-07 W=0.3e-06
M33 GND 11 13 GND hvn L=3.5e-07 W=0.65e-06
M34 Q 13 GND GND hvn L=3.5e-07 W=0.65e-06
M35 GND 13 Q GND hvn L=3.5e-07 W=0.65e-06
M36 Q 13 GND GND hvn L=3.5e-07 W=0.65e-06
M37 GND 13 Q GND hvn L=3.5e-07 W=0.65e-06
.ENDS SFFCKBQX4

.SUBCKT SFFCKBRBQBX1 QB D SEL TD RB CKB
M0 VDD SEL 1 VDD hvp L=3.0e-07 W=0.3e-06
M1 3 SEL VDD VDD hvp L=3.0e-07 W=0.9e-06
M2 4 D 3 VDD hvp L=3.0e-07 W=0.9e-06
M3 5 1 4 VDD hvp L=3.0e-07 W=0.9e-06
M4 VDD TD 5 VDD hvp L=3.0e-07 W=0.9e-06
M5 6 CKB VDD VDD hvp L=3.0e-07 W=0.3e-06
M6 7 6 VDD VDD hvp L=3.0e-07 W=0.3e-06
M7 8 6 4 VDD hvp L=3.0e-07 W=0.5e-06
M8 9 CKB 8 VDD hvp L=3.0e-07 W=0.5e-06
M9 VDD RB 9 VDD hvp L=3.0e-07 W=0.5e-06
M10 9 10 VDD VDD hvp L=3.0e-07 W=0.3e-06
M11 10 8 VDD VDD hvp L=3.0e-07 W=0.5e-06
M12 11 7 10 VDD hvp L=3.0e-07 W=0.5e-06
M13 12 6 11 VDD hvp L=3.0e-07 W=0.3e-06
M14 VDD 13 12 VDD hvp L=3.0e-07 W=0.3e-06
M15 13 RB VDD VDD hvp L=3.0e-07 W=0.3e-06
M16 VDD 11 13 VDD hvp L=3.0e-07 W=0.3e-06
M17 QB 11 VDD VDD hvp L=3.0e-07 W=1e-06
M18 GND SEL 1 GND hvn L=3.5e-07 W=0.3e-06
M19 16 1 GND GND hvn L=3.5e-07 W=0.35e-06
M20 4 D 16 GND hvn L=3.5e-07 W=0.35e-06
M21 17 SEL 4 GND hvn L=3.5e-07 W=0.35e-06
M22 GND TD 17 GND hvn L=3.5e-07 W=0.35e-06
M23 GND CKB 6 GND hvn L=3.5e-07 W=0.3e-06
M24 7 6 GND GND hvn L=3.5e-07 W=0.3e-06
M25 8 CKB 4 GND hvn L=3.5e-07 W=0.3e-06
M26 9 6 8 GND hvn L=3.5e-07 W=0.3e-06
M27 18 RB 9 GND hvn L=3.5e-07 W=0.3e-06
M28 GND 10 18 GND hvn L=3.5e-07 W=0.3e-06
M29 10 8 GND GND hvn L=3.5e-07 W=0.3e-06
M30 11 6 10 GND hvn L=3.5e-07 W=0.3e-06
M31 19 7 11 GND hvn L=3.5e-07 W=0.3e-06
M32 GND 13 19 GND hvn L=3.5e-07 W=0.3e-06
M33 20 RB GND GND hvn L=3.5e-07 W=0.3e-06
M34 13 11 20 GND hvn L=3.5e-07 W=0.3e-06
M35 QB 11 GND GND hvn L=3.5e-07 W=0.65e-06
.ENDS SFFCKBRBQBX1

.SUBCKT SFFCKBRBQBX2 QB D SEL TD RB CKB
M0 VDD SEL 1 VDD hvp L=3.0e-07 W=0.3e-06
M1 3 SEL VDD VDD hvp L=3.0e-07 W=0.9e-06
M2 4 D 3 VDD hvp L=3.0e-07 W=0.9e-06
M3 5 1 4 VDD hvp L=3.0e-07 W=0.9e-06
M4 VDD TD 5 VDD hvp L=3.0e-07 W=0.9e-06
M5 6 CKB VDD VDD hvp L=3.0e-07 W=0.3e-06
M6 7 6 VDD VDD hvp L=3.0e-07 W=0.3e-06
M7 8 6 4 VDD hvp L=3.0e-07 W=0.5e-06
M8 9 CKB 8 VDD hvp L=3.0e-07 W=0.5e-06
M9 VDD RB 9 VDD hvp L=3.0e-07 W=0.5e-06
M10 9 10 VDD VDD hvp L=3.0e-07 W=0.3e-06
M11 10 8 VDD VDD hvp L=3.0e-07 W=0.5e-06
M12 11 7 10 VDD hvp L=3.0e-07 W=0.5e-06
M13 12 6 11 VDD hvp L=3.0e-07 W=0.3e-06
M14 VDD 13 12 VDD hvp L=3.0e-07 W=0.3e-06
M15 13 RB VDD VDD hvp L=3.0e-07 W=0.3e-06
M16 VDD 11 13 VDD hvp L=3.0e-07 W=0.3e-06
M17 QB 11 VDD VDD hvp L=3.0e-07 W=1e-06
M18 VDD 11 QB VDD hvp L=3.0e-07 W=1e-06
M19 GND SEL 1 GND hvn L=3.5e-07 W=0.3e-06
M20 16 1 GND GND hvn L=3.5e-07 W=0.35e-06
M21 4 D 16 GND hvn L=3.5e-07 W=0.35e-06
M22 17 SEL 4 GND hvn L=3.5e-07 W=0.35e-06
M23 GND TD 17 GND hvn L=3.5e-07 W=0.35e-06
M24 GND CKB 6 GND hvn L=3.5e-07 W=0.3e-06
M25 7 6 GND GND hvn L=3.5e-07 W=0.3e-06
M26 8 CKB 4 GND hvn L=3.5e-07 W=0.3e-06
M27 9 6 8 GND hvn L=3.5e-07 W=0.3e-06
M28 18 RB 9 GND hvn L=3.5e-07 W=0.3e-06
M29 GND 10 18 GND hvn L=3.5e-07 W=0.3e-06
M30 10 8 GND GND hvn L=3.5e-07 W=0.3e-06
M31 11 6 10 GND hvn L=3.5e-07 W=0.3e-06
M32 19 7 11 GND hvn L=3.5e-07 W=0.3e-06
M33 GND 13 19 GND hvn L=3.5e-07 W=0.3e-06
M34 20 RB GND GND hvn L=3.5e-07 W=0.3e-06
M35 13 11 20 GND hvn L=3.5e-07 W=0.3e-06
M36 QB 11 GND GND hvn L=3.5e-07 W=0.65e-06
M37 GND 11 QB GND hvn L=3.5e-07 W=0.65e-06
.ENDS SFFCKBRBQBX2

.SUBCKT SFFCKBRBQBX4 QB D SEL TD RB CKB
M0 VDD SEL 1 VDD hvp L=3.0e-07 W=0.3e-06
M1 3 SEL VDD VDD hvp L=3.0e-07 W=0.9e-06
M2 4 D 3 VDD hvp L=3.0e-07 W=0.9e-06
M3 5 1 4 VDD hvp L=3.0e-07 W=0.9e-06
M4 VDD TD 5 VDD hvp L=3.0e-07 W=0.9e-06
M5 6 CKB VDD VDD hvp L=3.0e-07 W=0.3e-06
M6 7 6 VDD VDD hvp L=3.0e-07 W=0.3e-06
M7 8 6 4 VDD hvp L=3.0e-07 W=0.5e-06
M8 9 CKB 8 VDD hvp L=3.0e-07 W=0.5e-06
M9 VDD RB 9 VDD hvp L=3.0e-07 W=0.5e-06
M10 9 10 VDD VDD hvp L=3.0e-07 W=0.3e-06
M11 10 8 VDD VDD hvp L=3.0e-07 W=0.5e-06
M12 11 7 10 VDD hvp L=3.0e-07 W=0.5e-06
M13 12 6 11 VDD hvp L=3.0e-07 W=0.3e-06
M14 VDD 13 12 VDD hvp L=3.0e-07 W=0.3e-06
M15 13 RB VDD VDD hvp L=3.0e-07 W=0.3e-06
M16 VDD 11 13 VDD hvp L=3.0e-07 W=0.3e-06
M17 QB 11 VDD VDD hvp L=3.0e-07 W=1e-06
M18 VDD 11 QB VDD hvp L=3.0e-07 W=1e-06
M19 QB 11 VDD VDD hvp L=3.0e-07 W=1e-06
M20 VDD 11 QB VDD hvp L=3.0e-07 W=1e-06
M21 GND SEL 1 GND hvn L=3.5e-07 W=0.3e-06
M22 16 1 GND GND hvn L=3.5e-07 W=0.35e-06
M23 4 D 16 GND hvn L=3.5e-07 W=0.35e-06
M24 17 SEL 4 GND hvn L=3.5e-07 W=0.35e-06
M25 GND TD 17 GND hvn L=3.5e-07 W=0.35e-06
M26 GND CKB 6 GND hvn L=3.5e-07 W=0.3e-06
M27 7 6 GND GND hvn L=3.5e-07 W=0.3e-06
M28 8 CKB 4 GND hvn L=3.5e-07 W=0.3e-06
M29 9 6 8 GND hvn L=3.5e-07 W=0.3e-06
M30 18 RB 9 GND hvn L=3.5e-07 W=0.3e-06
M31 GND 10 18 GND hvn L=3.5e-07 W=0.3e-06
M32 10 8 GND GND hvn L=3.5e-07 W=0.3e-06
M33 11 6 10 GND hvn L=3.5e-07 W=0.3e-06
M34 19 7 11 GND hvn L=3.5e-07 W=0.3e-06
M35 GND 13 19 GND hvn L=3.5e-07 W=0.3e-06
M36 20 RB GND GND hvn L=3.5e-07 W=0.3e-06
M37 13 11 20 GND hvn L=3.5e-07 W=0.3e-06
M38 QB 11 GND GND hvn L=3.5e-07 W=0.65e-06
M39 GND 11 QB GND hvn L=3.5e-07 W=0.65e-06
M40 QB 11 GND GND hvn L=3.5e-07 W=0.65e-06
M41 GND 11 QB GND hvn L=3.5e-07 W=0.65e-06
.ENDS SFFCKBRBQBX4

.SUBCKT SFFCKBRBQX1 Q D SEL TD RB CKB
M0 VDD SEL 1 VDD hvp L=3.0e-07 W=0.3e-06
M1 3 SEL VDD VDD hvp L=3.0e-07 W=0.9e-06
M2 4 D 3 VDD hvp L=3.0e-07 W=0.9e-06
M3 5 1 4 VDD hvp L=3.0e-07 W=0.9e-06
M4 VDD TD 5 VDD hvp L=3.0e-07 W=0.9e-06
M5 6 CKB VDD VDD hvp L=3.0e-07 W=0.6e-06
M6 7 6 VDD VDD hvp L=3.0e-07 W=0.3e-06
M7 8 6 4 VDD hvp L=3.0e-07 W=0.6e-06
M8 9 7 8 VDD hvp L=3.0e-07 W=0.3e-06
M9 VDD RB 9 VDD hvp L=3.0e-07 W=0.3e-06
M10 9 10 VDD VDD hvp L=3.0e-07 W=0.3e-06
M11 10 8 VDD VDD hvp L=3.0e-07 W=0.5e-06
M12 11 7 10 VDD hvp L=3.0e-07 W=0.5e-06
M13 12 6 11 VDD hvp L=3.0e-07 W=0.3e-06
M14 VDD 13 12 VDD hvp L=3.0e-07 W=0.3e-06
M15 13 RB VDD VDD hvp L=3.0e-07 W=0.9e-06
M16 VDD 11 13 VDD hvp L=3.0e-07 W=1e-06
M17 Q 13 VDD VDD hvp L=3.0e-07 W=1e-06
M18 GND SEL 1 GND hvn L=3.5e-07 W=0.3e-06
M19 16 1 GND GND hvn L=3.5e-07 W=0.35e-06
M20 4 D 16 GND hvn L=3.5e-07 W=0.35e-06
M21 17 SEL 4 GND hvn L=3.5e-07 W=0.35e-06
M22 GND TD 17 GND hvn L=3.5e-07 W=0.35e-06
M23 GND CKB 6 GND hvn L=3.5e-07 W=0.3e-06
M24 7 6 GND GND hvn L=3.5e-07 W=0.6e-06
M25 8 7 4 GND hvn L=3.5e-07 W=0.6e-06
M26 9 6 8 GND hvn L=3.5e-07 W=0.3e-06
M27 18 RB 9 GND hvn L=3.5e-07 W=0.3e-06
M28 GND 10 18 GND hvn L=3.5e-07 W=0.3e-06
M29 10 8 GND GND hvn L=3.5e-07 W=0.3e-06
M30 11 6 10 GND hvn L=3.5e-07 W=0.3e-06
M31 19 7 11 GND hvn L=3.5e-07 W=0.3e-06
M32 GND 13 19 GND hvn L=3.5e-07 W=0.3e-06
M33 20 RB GND GND hvn L=3.5e-07 W=0.55e-06
M34 13 11 20 GND hvn L=3.5e-07 W=0.55e-06
M35 Q 13 GND GND hvn L=3.5e-07 W=0.65e-06
.ENDS SFFCKBRBQX1

.SUBCKT SFFCKBRBQX2 Q D SEL TD RB CKB
M0 VDD SEL 1 VDD hvp L=3.0e-07 W=0.3e-06
M1 3 SEL VDD VDD hvp L=3.0e-07 W=0.9e-06
M2 4 D 3 VDD hvp L=3.0e-07 W=0.9e-06
M3 5 1 4 VDD hvp L=3.0e-07 W=0.9e-06
M4 VDD TD 5 VDD hvp L=3.0e-07 W=0.9e-06
M5 6 CKB VDD VDD hvp L=3.0e-07 W=0.6e-06
M6 7 6 VDD VDD hvp L=3.0e-07 W=0.3e-06
M7 8 6 4 VDD hvp L=3.0e-07 W=0.6e-06
M8 9 7 8 VDD hvp L=3.0e-07 W=0.3e-06
M9 VDD RB 9 VDD hvp L=3.0e-07 W=0.3e-06
M10 9 10 VDD VDD hvp L=3.0e-07 W=0.3e-06
M11 10 8 VDD VDD hvp L=3.0e-07 W=0.5e-06
M12 11 7 10 VDD hvp L=3.0e-07 W=0.5e-06
M13 12 6 11 VDD hvp L=3.0e-07 W=0.3e-06
M14 VDD 13 12 VDD hvp L=3.0e-07 W=0.3e-06
M15 13 RB VDD VDD hvp L=3.0e-07 W=0.9e-06
M16 VDD 11 13 VDD hvp L=3.0e-07 W=1e-06
M17 Q 13 VDD VDD hvp L=3.0e-07 W=1e-06
M18 VDD 13 Q VDD hvp L=3.0e-07 W=1e-06
M19 GND SEL 1 GND hvn L=3.5e-07 W=0.3e-06
M20 16 1 GND GND hvn L=3.5e-07 W=0.35e-06
M21 4 D 16 GND hvn L=3.5e-07 W=0.35e-06
M22 17 SEL 4 GND hvn L=3.5e-07 W=0.35e-06
M23 GND TD 17 GND hvn L=3.5e-07 W=0.35e-06
M24 GND CKB 6 GND hvn L=3.5e-07 W=0.3e-06
M25 7 6 GND GND hvn L=3.5e-07 W=0.6e-06
M26 8 7 4 GND hvn L=3.5e-07 W=0.6e-06
M27 9 6 8 GND hvn L=3.5e-07 W=0.3e-06
M28 18 RB 9 GND hvn L=3.5e-07 W=0.3e-06
M29 GND 10 18 GND hvn L=3.5e-07 W=0.3e-06
M30 10 8 GND GND hvn L=3.5e-07 W=0.3e-06
M31 11 6 10 GND hvn L=3.5e-07 W=0.3e-06
M32 19 7 11 GND hvn L=3.5e-07 W=0.3e-06
M33 GND 13 19 GND hvn L=3.5e-07 W=0.3e-06
M34 20 RB GND GND hvn L=3.5e-07 W=0.55e-06
M35 13 11 20 GND hvn L=3.5e-07 W=0.55e-06
M36 Q 13 GND GND hvn L=3.5e-07 W=0.65e-06
M37 GND 13 Q GND hvn L=3.5e-07 W=0.65e-06
.ENDS SFFCKBRBQX2

.SUBCKT SFFCKBRBQX4 Q D SEL TD RB CKB
M0 VDD SEL 1 VDD hvp L=3.0e-07 W=0.3e-06
M1 3 SEL VDD VDD hvp L=3.0e-07 W=0.9e-06
M2 4 D 3 VDD hvp L=3.0e-07 W=0.9e-06
M3 5 1 4 VDD hvp L=3.0e-07 W=0.9e-06
M4 VDD TD 5 VDD hvp L=3.0e-07 W=0.9e-06
M5 6 CKB VDD VDD hvp L=3.0e-07 W=0.6e-06
M6 7 6 VDD VDD hvp L=3.0e-07 W=0.3e-06
M7 8 6 4 VDD hvp L=3.0e-07 W=0.6e-06
M8 9 7 8 VDD hvp L=3.0e-07 W=0.3e-06
M9 VDD RB 9 VDD hvp L=3.0e-07 W=0.3e-06
M10 9 10 VDD VDD hvp L=3.0e-07 W=0.3e-06
M11 10 8 VDD VDD hvp L=3.0e-07 W=0.5e-06
M12 11 7 10 VDD hvp L=3.0e-07 W=0.5e-06
M13 12 6 11 VDD hvp L=3.0e-07 W=0.3e-06
M14 VDD 13 12 VDD hvp L=3.0e-07 W=0.3e-06
M15 13 RB VDD VDD hvp L=3.0e-07 W=0.9e-06
M16 VDD 11 13 VDD hvp L=3.0e-07 W=1e-06
M17 Q 13 VDD VDD hvp L=3.0e-07 W=1e-06
M18 VDD 13 Q VDD hvp L=3.0e-07 W=1e-06
M19 Q 13 VDD VDD hvp L=3.0e-07 W=1e-06
M20 VDD 13 Q VDD hvp L=3.0e-07 W=1e-06
M21 GND SEL 1 GND hvn L=3.5e-07 W=0.3e-06
M22 16 1 GND GND hvn L=3.5e-07 W=0.35e-06
M23 4 D 16 GND hvn L=3.5e-07 W=0.35e-06
M24 17 SEL 4 GND hvn L=3.5e-07 W=0.35e-06
M25 GND TD 17 GND hvn L=3.5e-07 W=0.35e-06
M26 GND CKB 6 GND hvn L=3.5e-07 W=0.3e-06
M27 7 6 GND GND hvn L=3.5e-07 W=0.6e-06
M28 8 7 4 GND hvn L=3.5e-07 W=0.6e-06
M29 9 6 8 GND hvn L=3.5e-07 W=0.3e-06
M30 18 RB 9 GND hvn L=3.5e-07 W=0.3e-06
M31 GND 10 18 GND hvn L=3.5e-07 W=0.3e-06
M32 10 8 GND GND hvn L=3.5e-07 W=0.3e-06
M33 11 6 10 GND hvn L=3.5e-07 W=0.3e-06
M34 19 7 11 GND hvn L=3.5e-07 W=0.3e-06
M35 GND 13 19 GND hvn L=3.5e-07 W=0.3e-06
M36 20 RB GND GND hvn L=3.5e-07 W=0.55e-06
M37 13 11 20 GND hvn L=3.5e-07 W=0.55e-06
M38 Q 13 GND GND hvn L=3.5e-07 W=0.65e-06
M39 GND 13 Q GND hvn L=3.5e-07 W=0.65e-06
M40 Q 13 GND GND hvn L=3.5e-07 W=0.65e-06
M41 GND 13 Q GND hvn L=3.5e-07 W=0.65e-06
.ENDS SFFCKBRBQX4

.SUBCKT SFFCKBRSBQX1 Q D SEL TD RB SB CKB
M0 VDD SEL 1 VDD hvp L=3.0e-07 W=0.3e-06
M1 3 SEL VDD VDD hvp L=3.0e-07 W=0.9e-06
M2 4 D 3 VDD hvp L=3.0e-07 W=0.9e-06
M3 5 1 4 VDD hvp L=3.0e-07 W=0.9e-06
M4 VDD TD 5 VDD hvp L=3.0e-07 W=0.9e-06
M5 6 CKB VDD VDD hvp L=3.0e-07 W=0.6e-06
M6 7 6 VDD VDD hvp L=3.0e-07 W=0.3e-06
M7 8 6 4 VDD hvp L=3.0e-07 W=0.6e-06
M8 9 7 8 VDD hvp L=3.0e-07 W=0.3e-06
M9 VDD RB 9 VDD hvp L=3.0e-07 W=0.3e-06
M10 9 10 VDD VDD hvp L=3.0e-07 W=0.3e-06
M11 VDD 8 10 VDD hvp L=3.0e-07 W=0.45e-06
M12 10 SB VDD VDD hvp L=3.0e-07 W=0.39e-06
M13 11 7 10 VDD hvp L=3.0e-07 W=0.35e-06
M14 12 6 11 VDD hvp L=3.0e-07 W=0.35e-06
M15 VDD SB 12 VDD hvp L=3.0e-07 W=0.33e-06
M16 12 13 VDD VDD hvp L=3.0e-07 W=0.28e-06
M17 13 RB VDD VDD hvp L=3.0e-07 W=0.75e-06
M18 VDD 11 13 VDD hvp L=3.0e-07 W=0.75e-06
M19 Q 13 VDD VDD hvp L=3.0e-07 W=1e-06
M20 GND SEL 1 GND hvn L=3.5e-07 W=0.3e-06
M21 16 1 GND GND hvn L=3.5e-07 W=0.35e-06
M22 4 D 16 GND hvn L=3.5e-07 W=0.35e-06
M23 17 SEL 4 GND hvn L=3.5e-07 W=0.35e-06
M24 GND TD 17 GND hvn L=3.5e-07 W=0.35e-06
M25 GND CKB 6 GND hvn L=3.5e-07 W=0.3e-06
M26 7 6 GND GND hvn L=3.5e-07 W=0.6e-06
M27 8 7 4 GND hvn L=3.5e-07 W=0.51e-06
M28 9 6 8 GND hvn L=3.5e-07 W=0.3e-06
M29 18 RB 9 GND hvn L=3.5e-07 W=0.3e-06
M30 GND 10 18 GND hvn L=3.5e-07 W=0.3e-06
M31 19 8 GND GND hvn L=3.5e-07 W=0.28e-06
M32 10 SB 19 GND hvn L=3.5e-07 W=0.28e-06
M33 11 6 10 GND hvn L=3.5e-07 W=0.28e-06
M34 12 7 11 GND hvn L=3.5e-07 W=0.3e-06
M35 20 SB 12 GND hvn L=3.5e-07 W=0.28e-06
M36 GND 13 20 GND hvn L=3.5e-07 W=0.3e-06
M37 21 RB GND GND hvn L=3.5e-07 W=0.38e-06
M38 13 11 21 GND hvn L=3.5e-07 W=0.38e-06
M39 Q 13 GND GND hvn L=3.5e-07 W=0.65e-06
.ENDS SFFCKBRSBQX1

.SUBCKT SFFCKBRSBQX2 Q D SEL TD RB SB CKB
M0 VDD SEL 1 VDD hvp L=3.0e-07 W=0.3e-06
M1 3 SEL VDD VDD hvp L=3.0e-07 W=0.9e-06
M2 4 D 3 VDD hvp L=3.0e-07 W=0.9e-06
M3 5 1 4 VDD hvp L=3.0e-07 W=0.9e-06
M4 VDD TD 5 VDD hvp L=3.0e-07 W=0.9e-06
M5 6 CKB VDD VDD hvp L=3.0e-07 W=0.6e-06
M6 7 6 VDD VDD hvp L=3.0e-07 W=0.3e-06
M7 8 6 4 VDD hvp L=3.0e-07 W=0.6e-06
M8 9 7 8 VDD hvp L=3.0e-07 W=0.3e-06
M9 VDD RB 9 VDD hvp L=3.0e-07 W=0.3e-06
M10 9 10 VDD VDD hvp L=3.0e-07 W=0.3e-06
M11 VDD 8 10 VDD hvp L=3.0e-07 W=0.45e-06
M12 10 SB VDD VDD hvp L=3.0e-07 W=0.39e-06
M13 11 7 10 VDD hvp L=3.0e-07 W=0.35e-06
M14 12 6 11 VDD hvp L=3.0e-07 W=0.35e-06
M15 VDD SB 12 VDD hvp L=3.0e-07 W=0.33e-06
M16 12 13 VDD VDD hvp L=3.0e-07 W=0.28e-06
M17 13 RB VDD VDD hvp L=3.0e-07 W=0.75e-06
M18 VDD 11 13 VDD hvp L=3.0e-07 W=0.75e-06
M19 Q 13 VDD VDD hvp L=3.0e-07 W=1e-06
M20 VDD 13 Q VDD hvp L=3.0e-07 W=1e-06
M21 GND SEL 1 GND hvn L=3.5e-07 W=0.3e-06
M22 16 1 GND GND hvn L=3.5e-07 W=0.35e-06
M23 4 D 16 GND hvn L=3.5e-07 W=0.35e-06
M24 17 SEL 4 GND hvn L=3.5e-07 W=0.35e-06
M25 GND TD 17 GND hvn L=3.5e-07 W=0.35e-06
M26 GND CKB 6 GND hvn L=3.5e-07 W=0.3e-06
M27 7 6 GND GND hvn L=3.5e-07 W=0.6e-06
M28 8 7 4 GND hvn L=3.5e-07 W=0.51e-06
M29 9 6 8 GND hvn L=3.5e-07 W=0.3e-06
M30 18 RB 9 GND hvn L=3.5e-07 W=0.3e-06
M31 GND 10 18 GND hvn L=3.5e-07 W=0.3e-06
M32 19 8 GND GND hvn L=3.5e-07 W=0.28e-06
M33 10 SB 19 GND hvn L=3.5e-07 W=0.28e-06
M34 11 6 10 GND hvn L=3.5e-07 W=0.28e-06
M35 12 7 11 GND hvn L=3.5e-07 W=0.3e-06
M36 20 SB 12 GND hvn L=3.5e-07 W=0.28e-06
M37 GND 13 20 GND hvn L=3.5e-07 W=0.3e-06
M38 21 RB GND GND hvn L=3.5e-07 W=0.38e-06
M39 13 11 21 GND hvn L=3.5e-07 W=0.38e-06
M40 Q 13 GND GND hvn L=3.5e-07 W=0.65e-06
M41 GND 13 Q GND hvn L=3.5e-07 W=0.65e-06
.ENDS SFFCKBRSBQX2

.SUBCKT SFFCKBRSBQX4 Q D SEL TD RB SB CKB
M0 VDD SEL 1 VDD hvp L=3.0e-07 W=0.3e-06
M1 3 SEL VDD VDD hvp L=3.0e-07 W=0.9e-06
M2 4 D 3 VDD hvp L=3.0e-07 W=0.9e-06
M3 5 1 4 VDD hvp L=3.0e-07 W=0.9e-06
M4 VDD TD 5 VDD hvp L=3.0e-07 W=0.9e-06
M5 6 CKB VDD VDD hvp L=3.0e-07 W=0.6e-06
M6 7 6 VDD VDD hvp L=3.0e-07 W=0.3e-06
M7 8 6 4 VDD hvp L=3.0e-07 W=0.6e-06
M8 9 7 8 VDD hvp L=3.0e-07 W=0.3e-06
M9 VDD RB 9 VDD hvp L=3.0e-07 W=0.3e-06
M10 9 10 VDD VDD hvp L=3.0e-07 W=0.3e-06
M11 VDD 8 10 VDD hvp L=3.0e-07 W=0.45e-06
M12 10 SB VDD VDD hvp L=3.0e-07 W=0.39e-06
M13 11 7 10 VDD hvp L=3.0e-07 W=0.35e-06
M14 12 6 11 VDD hvp L=3.0e-07 W=0.35e-06
M15 VDD SB 12 VDD hvp L=3.0e-07 W=0.33e-06
M16 12 13 VDD VDD hvp L=3.0e-07 W=0.28e-06
M17 13 RB VDD VDD hvp L=3.0e-07 W=0.75e-06
M18 VDD 11 13 VDD hvp L=3.0e-07 W=0.75e-06
M19 Q 13 VDD VDD hvp L=3.0e-07 W=1e-06
M20 VDD 13 Q VDD hvp L=3.0e-07 W=1e-06
M21 Q 13 VDD VDD hvp L=3.0e-07 W=1e-06
M22 VDD 13 Q VDD hvp L=3.0e-07 W=1e-06
M23 GND SEL 1 GND hvn L=3.5e-07 W=0.3e-06
M24 16 1 GND GND hvn L=3.5e-07 W=0.35e-06
M25 4 D 16 GND hvn L=3.5e-07 W=0.35e-06
M26 17 SEL 4 GND hvn L=3.5e-07 W=0.35e-06
M27 GND TD 17 GND hvn L=3.5e-07 W=0.35e-06
M28 GND CKB 6 GND hvn L=3.5e-07 W=0.3e-06
M29 7 6 GND GND hvn L=3.5e-07 W=0.6e-06
M30 8 7 4 GND hvn L=3.5e-07 W=0.51e-06
M31 9 6 8 GND hvn L=3.5e-07 W=0.3e-06
M32 18 RB 9 GND hvn L=3.5e-07 W=0.3e-06
M33 GND 10 18 GND hvn L=3.5e-07 W=0.3e-06
M34 19 8 GND GND hvn L=3.5e-07 W=0.28e-06
M35 10 SB 19 GND hvn L=3.5e-07 W=0.28e-06
M36 11 6 10 GND hvn L=3.5e-07 W=0.28e-06
M37 12 7 11 GND hvn L=3.5e-07 W=0.3e-06
M38 20 SB 12 GND hvn L=3.5e-07 W=0.28e-06
M39 GND 13 20 GND hvn L=3.5e-07 W=0.3e-06
M40 21 RB GND GND hvn L=3.5e-07 W=0.38e-06
M41 13 11 21 GND hvn L=3.5e-07 W=0.38e-06
M42 Q 13 GND GND hvn L=3.5e-07 W=0.65e-06
M43 GND 13 Q GND hvn L=3.5e-07 W=0.65e-06
M44 Q 13 GND GND hvn L=3.5e-07 W=0.65e-06
M45 GND 13 Q GND hvn L=3.5e-07 W=0.65e-06
.ENDS SFFCKBRSBQX4

.SUBCKT SFFCNLDQBX1 QB CN D LD SEL TD CK
M0 VDD SEL 1 VDD hvp L=3.0e-07 W=0.3e-06
M1 3 SEL VDD VDD hvp L=3.0e-07 W=1e-06
M2 VDD 4 3 VDD hvp L=3.0e-07 W=1e-06
M3 4 TD VDD VDD hvp L=3.0e-07 W=0.35e-06
M4 5 3 VDD VDD hvp L=3.0e-07 W=0.65e-06
M5 VDD 6 5 VDD hvp L=3.0e-07 W=0.65e-06
M6 6 8 VDD VDD hvp L=3.0e-07 W=0.65e-06
M7 VDD 1 6 VDD hvp L=3.0e-07 W=0.65e-06
M8 7 CN VDD VDD hvp L=3.0e-07 W=0.65e-06
M9 8 CN 7 VDD hvp L=3.0e-07 W=0.65e-06
M10 9 7 8 VDD hvp L=3.0e-07 W=0.65e-06
M11 10 D 9 VDD hvp L=3.0e-07 W=0.65e-06
M12 VDD 11 10 VDD hvp L=3.0e-07 W=0.65e-06
M13 11 LD VDD VDD hvp L=3.0e-07 W=0.3e-06
M14 12 LD VDD VDD hvp L=3.0e-07 W=0.6e-06
M15 9 19 12 VDD hvp L=3.0e-07 W=0.6e-06
M16 VDD CK 13 VDD hvp L=3.0e-07 W=0.3e-06
M17 14 13 VDD VDD hvp L=3.0e-07 W=0.7e-06
M18 15 14 5 VDD hvp L=3.0e-07 W=0.5e-06
M19 16 13 15 VDD hvp L=3.0e-07 W=0.3e-06
M20 VDD 17 16 VDD hvp L=3.0e-07 W=0.3e-06
M21 17 15 VDD VDD hvp L=3.0e-07 W=0.5e-06
M22 18 13 17 VDD hvp L=3.0e-07 W=0.7e-06
M23 19 14 18 VDD hvp L=3.0e-07 W=0.3e-06
M24 VDD 20 19 VDD hvp L=3.0e-07 W=0.3e-06
M25 VDD 18 20 VDD hvp L=3.0e-07 W=0.3e-06
M26 QB 18 VDD VDD hvp L=3.0e-07 W=1e-06
M27 GND SEL 1 GND hvn L=3.5e-07 W=0.3e-06
M28 23 SEL GND GND hvn L=3.5e-07 W=0.65e-06
M29 3 4 23 GND hvn L=3.5e-07 W=0.65e-06
M30 GND TD 4 GND hvn L=3.5e-07 W=0.3e-06
M31 24 3 GND GND hvn L=3.5e-07 W=0.4e-06
M32 5 6 24 GND hvn L=3.5e-07 W=0.4e-06
M33 25 8 6 GND hvn L=3.5e-07 W=0.55e-06
M34 GND 1 25 GND hvn L=3.5e-07 W=0.55e-06
M35 7 CN GND GND hvn L=3.5e-07 W=0.3e-06
M36 8 7 7 GND hvn L=3.5e-07 W=0.3e-06
M37 9 CN 8 GND hvn L=3.5e-07 W=0.3e-06
M38 26 D 9 GND hvn L=3.5e-07 W=0.65e-06
M39 GND LD 26 GND hvn L=3.5e-07 W=0.65e-06
M40 11 LD GND GND hvn L=3.5e-07 W=0.3e-06
M41 27 11 GND GND hvn L=3.5e-07 W=0.4e-06
M42 9 19 27 GND hvn L=3.5e-07 W=0.4e-06
M43 GND CK 13 GND hvn L=3.5e-07 W=0.6e-06
M44 14 13 GND GND hvn L=3.5e-07 W=0.3e-06
M45 15 13 5 GND hvn L=3.5e-07 W=0.6e-06
M46 28 14 15 GND hvn L=3.5e-07 W=0.3e-06
M47 GND 17 28 GND hvn L=3.5e-07 W=0.3e-06
M48 17 15 GND GND hvn L=3.5e-07 W=0.3e-06
M49 18 14 17 GND hvn L=3.5e-07 W=0.6e-06
M50 19 13 18 GND hvn L=3.5e-07 W=0.3e-06
M51 GND 20 19 GND hvn L=3.5e-07 W=0.3e-06
M52 GND 18 20 GND hvn L=3.5e-07 W=0.3e-06
M53 QB 18 GND GND hvn L=3.5e-07 W=0.65e-06
.ENDS SFFCNLDQBX1

.SUBCKT SFFCNLDQBX2 QB CN D LD SEL TD CK
M0 VDD SEL 1 VDD hvp L=3.0e-07 W=0.3e-06
M1 3 SEL VDD VDD hvp L=3.0e-07 W=1e-06
M2 VDD 4 3 VDD hvp L=3.0e-07 W=1e-06
M3 4 TD VDD VDD hvp L=3.0e-07 W=0.35e-06
M4 5 3 VDD VDD hvp L=3.0e-07 W=0.65e-06
M5 VDD 6 5 VDD hvp L=3.0e-07 W=0.65e-06
M6 6 8 VDD VDD hvp L=3.0e-07 W=0.65e-06
M7 VDD 1 6 VDD hvp L=3.0e-07 W=0.65e-06
M8 7 CN VDD VDD hvp L=3.0e-07 W=0.65e-06
M9 8 CN 7 VDD hvp L=3.0e-07 W=0.65e-06
M10 9 7 8 VDD hvp L=3.0e-07 W=0.65e-06
M11 10 D 9 VDD hvp L=3.0e-07 W=0.65e-06
M12 VDD 11 10 VDD hvp L=3.0e-07 W=0.65e-06
M13 11 LD VDD VDD hvp L=3.0e-07 W=0.3e-06
M14 12 LD VDD VDD hvp L=3.0e-07 W=0.6e-06
M15 9 19 12 VDD hvp L=3.0e-07 W=0.6e-06
M16 VDD CK 13 VDD hvp L=3.0e-07 W=0.3e-06
M17 14 13 VDD VDD hvp L=3.0e-07 W=0.7e-06
M18 15 14 5 VDD hvp L=3.0e-07 W=0.5e-06
M19 16 13 15 VDD hvp L=3.0e-07 W=0.3e-06
M20 VDD 17 16 VDD hvp L=3.0e-07 W=0.3e-06
M21 17 15 VDD VDD hvp L=3.0e-07 W=0.5e-06
M22 18 13 17 VDD hvp L=3.0e-07 W=0.7e-06
M23 19 14 18 VDD hvp L=3.0e-07 W=0.3e-06
M24 VDD 20 19 VDD hvp L=3.0e-07 W=0.3e-06
M25 VDD 18 20 VDD hvp L=3.0e-07 W=0.3e-06
M26 QB 18 VDD VDD hvp L=3.0e-07 W=1e-06
M27 VDD 18 QB VDD hvp L=3.0e-07 W=1e-06
M28 GND SEL 1 GND hvn L=3.5e-07 W=0.3e-06
M29 23 SEL GND GND hvn L=3.5e-07 W=0.65e-06
M30 3 4 23 GND hvn L=3.5e-07 W=0.65e-06
M31 GND TD 4 GND hvn L=3.5e-07 W=0.3e-06
M32 24 3 GND GND hvn L=3.5e-07 W=0.4e-06
M33 5 6 24 GND hvn L=3.5e-07 W=0.4e-06
M34 25 8 6 GND hvn L=3.5e-07 W=0.55e-06
M35 GND 1 25 GND hvn L=3.5e-07 W=0.55e-06
M36 7 CN GND GND hvn L=3.5e-07 W=0.3e-06
M37 8 7 7 GND hvn L=3.5e-07 W=0.3e-06
M38 9 CN 8 GND hvn L=3.5e-07 W=0.3e-06
M39 26 D 9 GND hvn L=3.5e-07 W=0.65e-06
M40 GND LD 26 GND hvn L=3.5e-07 W=0.65e-06
M41 11 LD GND GND hvn L=3.5e-07 W=0.3e-06
M42 27 11 GND GND hvn L=3.5e-07 W=0.4e-06
M43 9 19 27 GND hvn L=3.5e-07 W=0.4e-06
M44 GND CK 13 GND hvn L=3.5e-07 W=0.6e-06
M45 14 13 GND GND hvn L=3.5e-07 W=0.3e-06
M46 15 13 5 GND hvn L=3.5e-07 W=0.6e-06
M47 28 14 15 GND hvn L=3.5e-07 W=0.3e-06
M48 GND 17 28 GND hvn L=3.5e-07 W=0.3e-06
M49 17 15 GND GND hvn L=3.5e-07 W=0.3e-06
M50 18 14 17 GND hvn L=3.5e-07 W=0.6e-06
M51 19 13 18 GND hvn L=3.5e-07 W=0.3e-06
M52 GND 20 19 GND hvn L=3.5e-07 W=0.3e-06
M53 GND 18 20 GND hvn L=3.5e-07 W=0.3e-06
M54 QB 18 GND GND hvn L=3.5e-07 W=0.65e-06
M55 GND 18 QB GND hvn L=3.5e-07 W=0.65e-06
.ENDS SFFCNLDQBX2

.SUBCKT SFFCNLDQBX4 QB CN D LD SEL TD CK
M0 VDD SEL 1 VDD hvp L=3.0e-07 W=0.3e-06
M1 3 SEL VDD VDD hvp L=3.0e-07 W=1e-06
M2 VDD 4 3 VDD hvp L=3.0e-07 W=1e-06
M3 4 TD VDD VDD hvp L=3.0e-07 W=0.35e-06
M4 5 3 VDD VDD hvp L=3.0e-07 W=0.65e-06
M5 VDD 6 5 VDD hvp L=3.0e-07 W=0.65e-06
M6 6 8 VDD VDD hvp L=3.0e-07 W=0.65e-06
M7 VDD 1 6 VDD hvp L=3.0e-07 W=0.65e-06
M8 7 CN VDD VDD hvp L=3.0e-07 W=0.65e-06
M9 8 CN 7 VDD hvp L=3.0e-07 W=0.65e-06
M10 9 7 8 VDD hvp L=3.0e-07 W=0.65e-06
M11 10 D 9 VDD hvp L=3.0e-07 W=0.65e-06
M12 VDD 11 10 VDD hvp L=3.0e-07 W=0.65e-06
M13 11 LD VDD VDD hvp L=3.0e-07 W=0.3e-06
M14 12 LD VDD VDD hvp L=3.0e-07 W=0.6e-06
M15 9 19 12 VDD hvp L=3.0e-07 W=0.6e-06
M16 VDD CK 13 VDD hvp L=3.0e-07 W=0.3e-06
M17 14 13 VDD VDD hvp L=3.0e-07 W=0.7e-06
M18 15 14 5 VDD hvp L=3.0e-07 W=0.5e-06
M19 16 13 15 VDD hvp L=3.0e-07 W=0.3e-06
M20 VDD 17 16 VDD hvp L=3.0e-07 W=0.3e-06
M21 17 15 VDD VDD hvp L=3.0e-07 W=0.5e-06
M22 18 13 17 VDD hvp L=3.0e-07 W=0.7e-06
M23 19 14 18 VDD hvp L=3.0e-07 W=0.3e-06
M24 VDD 20 19 VDD hvp L=3.0e-07 W=0.3e-06
M25 VDD 18 20 VDD hvp L=3.0e-07 W=0.3e-06
M26 QB 18 VDD VDD hvp L=3.0e-07 W=1e-06
M27 VDD 18 QB VDD hvp L=3.0e-07 W=1e-06
M28 QB 18 VDD VDD hvp L=3.0e-07 W=1e-06
M29 VDD 18 QB VDD hvp L=3.0e-07 W=1e-06
M30 GND SEL 1 GND hvn L=3.5e-07 W=0.3e-06
M31 23 SEL GND GND hvn L=3.5e-07 W=0.65e-06
M32 3 4 23 GND hvn L=3.5e-07 W=0.65e-06
M33 GND TD 4 GND hvn L=3.5e-07 W=0.3e-06
M34 24 3 GND GND hvn L=3.5e-07 W=0.4e-06
M35 5 6 24 GND hvn L=3.5e-07 W=0.4e-06
M36 25 8 6 GND hvn L=3.5e-07 W=0.55e-06
M37 GND 1 25 GND hvn L=3.5e-07 W=0.55e-06
M38 7 CN GND GND hvn L=3.5e-07 W=0.3e-06
M39 8 7 7 GND hvn L=3.5e-07 W=0.3e-06
M40 9 CN 8 GND hvn L=3.5e-07 W=0.3e-06
M41 26 D 9 GND hvn L=3.5e-07 W=0.65e-06
M42 GND LD 26 GND hvn L=3.5e-07 W=0.65e-06
M43 11 LD GND GND hvn L=3.5e-07 W=0.3e-06
M44 27 11 GND GND hvn L=3.5e-07 W=0.4e-06
M45 9 19 27 GND hvn L=3.5e-07 W=0.4e-06
M46 GND CK 13 GND hvn L=3.5e-07 W=0.6e-06
M47 14 13 GND GND hvn L=3.5e-07 W=0.3e-06
M48 15 13 5 GND hvn L=3.5e-07 W=0.6e-06
M49 28 14 15 GND hvn L=3.5e-07 W=0.3e-06
M50 GND 17 28 GND hvn L=3.5e-07 W=0.3e-06
M51 17 15 GND GND hvn L=3.5e-07 W=0.3e-06
M52 18 14 17 GND hvn L=3.5e-07 W=0.6e-06
M53 19 13 18 GND hvn L=3.5e-07 W=0.3e-06
M54 GND 20 19 GND hvn L=3.5e-07 W=0.3e-06
M55 GND 18 20 GND hvn L=3.5e-07 W=0.3e-06
M56 QB 18 GND GND hvn L=3.5e-07 W=0.65e-06
M57 GND 18 QB GND hvn L=3.5e-07 W=0.65e-06
M58 QB 18 GND GND hvn L=3.5e-07 W=0.65e-06
M59 GND 18 QB GND hvn L=3.5e-07 W=0.65e-06
.ENDS SFFCNLDQBX4

.SUBCKT SFFCNLDQX1 Q CN D LD SEL TD CK
M0 VDD SEL 1 VDD hvp L=3.0e-07 W=0.3e-06
M1 3 SEL VDD VDD hvp L=3.0e-07 W=1e-06
M2 VDD 4 3 VDD hvp L=3.0e-07 W=1e-06
M3 4 TD VDD VDD hvp L=3.0e-07 W=0.35e-06
M4 5 3 VDD VDD hvp L=3.0e-07 W=0.65e-06
M5 VDD 6 5 VDD hvp L=3.0e-07 W=0.65e-06
M6 6 8 VDD VDD hvp L=3.0e-07 W=0.65e-06
M7 VDD 1 6 VDD hvp L=3.0e-07 W=0.65e-06
M8 7 CN VDD VDD hvp L=3.0e-07 W=0.65e-06
M9 8 CN 7 VDD hvp L=3.0e-07 W=0.65e-06
M10 9 7 8 VDD hvp L=3.0e-07 W=0.65e-06
M11 10 D 9 VDD hvp L=3.0e-07 W=0.65e-06
M12 VDD 11 10 VDD hvp L=3.0e-07 W=0.65e-06
M13 11 LD VDD VDD hvp L=3.0e-07 W=0.3e-06
M14 12 LD VDD VDD hvp L=3.0e-07 W=0.6e-06
M15 9 19 12 VDD hvp L=3.0e-07 W=0.6e-06
M16 VDD CK 13 VDD hvp L=3.0e-07 W=0.3e-06
M17 14 13 VDD VDD hvp L=3.0e-07 W=0.7e-06
M18 15 14 5 VDD hvp L=3.0e-07 W=0.5e-06
M19 16 13 15 VDD hvp L=3.0e-07 W=0.3e-06
M20 VDD 17 16 VDD hvp L=3.0e-07 W=0.3e-06
M21 17 15 VDD VDD hvp L=3.0e-07 W=0.5e-06
M22 18 13 17 VDD hvp L=3.0e-07 W=0.7e-06
M23 19 14 18 VDD hvp L=3.0e-07 W=0.3e-06
M24 VDD 20 19 VDD hvp L=3.0e-07 W=0.3e-06
M25 VDD 18 20 VDD hvp L=3.0e-07 W=0.9e-06
M26 Q 20 VDD VDD hvp L=3.0e-07 W=1e-06
M27 GND SEL 1 GND hvn L=3.5e-07 W=0.3e-06
M28 23 SEL GND GND hvn L=3.5e-07 W=0.65e-06
M29 3 4 23 GND hvn L=3.5e-07 W=0.65e-06
M30 GND TD 4 GND hvn L=3.5e-07 W=0.3e-06
M31 24 3 GND GND hvn L=3.5e-07 W=0.4e-06
M32 5 6 24 GND hvn L=3.5e-07 W=0.4e-06
M33 25 8 6 GND hvn L=3.5e-07 W=0.55e-06
M34 GND 1 25 GND hvn L=3.5e-07 W=0.55e-06
M35 7 CN GND GND hvn L=3.5e-07 W=0.3e-06
M36 8 7 7 GND hvn L=3.5e-07 W=0.3e-06
M37 9 CN 8 GND hvn L=3.5e-07 W=0.3e-06
M38 26 D 9 GND hvn L=3.5e-07 W=0.65e-06
M39 GND LD 26 GND hvn L=3.5e-07 W=0.65e-06
M40 11 LD GND GND hvn L=3.5e-07 W=0.3e-06
M41 27 11 GND GND hvn L=3.5e-07 W=0.4e-06
M42 9 19 27 GND hvn L=3.5e-07 W=0.4e-06
M43 GND CK 13 GND hvn L=3.5e-07 W=0.6e-06
M44 14 13 GND GND hvn L=3.5e-07 W=0.3e-06
M45 15 13 5 GND hvn L=3.5e-07 W=0.6e-06
M46 28 14 15 GND hvn L=3.5e-07 W=0.3e-06
M47 GND 17 28 GND hvn L=3.5e-07 W=0.3e-06
M48 17 15 GND GND hvn L=3.5e-07 W=0.3e-06
M49 18 14 17 GND hvn L=3.5e-07 W=0.6e-06
M50 19 13 18 GND hvn L=3.5e-07 W=0.3e-06
M51 GND 20 19 GND hvn L=3.5e-07 W=0.3e-06
M52 GND 18 20 GND hvn L=3.5e-07 W=0.6e-06
M53 Q 20 GND GND hvn L=3.5e-07 W=0.65e-06
.ENDS SFFCNLDQX1

.SUBCKT SFFCNLDQX2 Q CN D LD SEL TD CK
M0 VDD SEL 1 VDD hvp L=3.0e-07 W=0.3e-06
M1 3 SEL VDD VDD hvp L=3.0e-07 W=1e-06
M2 VDD 4 3 VDD hvp L=3.0e-07 W=1e-06
M3 4 TD VDD VDD hvp L=3.0e-07 W=0.35e-06
M4 5 3 VDD VDD hvp L=3.0e-07 W=0.65e-06
M5 VDD 6 5 VDD hvp L=3.0e-07 W=0.65e-06
M6 6 8 VDD VDD hvp L=3.0e-07 W=0.65e-06
M7 VDD 1 6 VDD hvp L=3.0e-07 W=0.65e-06
M8 7 CN VDD VDD hvp L=3.0e-07 W=0.65e-06
M9 8 CN 7 VDD hvp L=3.0e-07 W=0.65e-06
M10 9 7 8 VDD hvp L=3.0e-07 W=0.65e-06
M11 10 D 9 VDD hvp L=3.0e-07 W=0.65e-06
M12 VDD 11 10 VDD hvp L=3.0e-07 W=0.65e-06
M13 11 LD VDD VDD hvp L=3.0e-07 W=0.3e-06
M14 12 LD VDD VDD hvp L=3.0e-07 W=0.6e-06
M15 9 19 12 VDD hvp L=3.0e-07 W=0.6e-06
M16 VDD CK 13 VDD hvp L=3.0e-07 W=0.3e-06
M17 14 13 VDD VDD hvp L=3.0e-07 W=0.7e-06
M18 15 14 5 VDD hvp L=3.0e-07 W=0.5e-06
M19 16 13 15 VDD hvp L=3.0e-07 W=0.3e-06
M20 VDD 17 16 VDD hvp L=3.0e-07 W=0.3e-06
M21 17 15 VDD VDD hvp L=3.0e-07 W=0.5e-06
M22 18 13 17 VDD hvp L=3.0e-07 W=0.7e-06
M23 19 14 18 VDD hvp L=3.0e-07 W=0.3e-06
M24 VDD 20 19 VDD hvp L=3.0e-07 W=0.3e-06
M25 VDD 18 20 VDD hvp L=3.0e-07 W=0.9e-06
M26 Q 20 VDD VDD hvp L=3.0e-07 W=1e-06
M27 VDD 20 Q VDD hvp L=3.0e-07 W=1e-06
M28 GND SEL 1 GND hvn L=3.5e-07 W=0.3e-06
M29 23 SEL GND GND hvn L=3.5e-07 W=0.65e-06
M30 3 4 23 GND hvn L=3.5e-07 W=0.65e-06
M31 GND TD 4 GND hvn L=3.5e-07 W=0.3e-06
M32 24 3 GND GND hvn L=3.5e-07 W=0.4e-06
M33 5 6 24 GND hvn L=3.5e-07 W=0.4e-06
M34 25 8 6 GND hvn L=3.5e-07 W=0.55e-06
M35 GND 1 25 GND hvn L=3.5e-07 W=0.55e-06
M36 7 CN GND GND hvn L=3.5e-07 W=0.3e-06
M37 8 7 7 GND hvn L=3.5e-07 W=0.3e-06
M38 9 CN 8 GND hvn L=3.5e-07 W=0.3e-06
M39 26 D 9 GND hvn L=3.5e-07 W=0.65e-06
M40 GND LD 26 GND hvn L=3.5e-07 W=0.65e-06
M41 11 LD GND GND hvn L=3.5e-07 W=0.3e-06
M42 27 11 GND GND hvn L=3.5e-07 W=0.4e-06
M43 9 19 27 GND hvn L=3.5e-07 W=0.4e-06
M44 GND CK 13 GND hvn L=3.5e-07 W=0.6e-06
M45 14 13 GND GND hvn L=3.5e-07 W=0.3e-06
M46 15 13 5 GND hvn L=3.5e-07 W=0.6e-06
M47 28 14 15 GND hvn L=3.5e-07 W=0.3e-06
M48 GND 17 28 GND hvn L=3.5e-07 W=0.3e-06
M49 17 15 GND GND hvn L=3.5e-07 W=0.3e-06
M50 18 14 17 GND hvn L=3.5e-07 W=0.6e-06
M51 19 13 18 GND hvn L=3.5e-07 W=0.3e-06
M52 GND 20 19 GND hvn L=3.5e-07 W=0.3e-06
M53 GND 18 20 GND hvn L=3.5e-07 W=0.6e-06
M54 Q 20 GND GND hvn L=3.5e-07 W=0.65e-06
M55 GND 20 Q GND hvn L=3.5e-07 W=0.65e-06
.ENDS SFFCNLDQX2

.SUBCKT SFFCNLDQX4 Q CN D LD SEL TD CK
M0 VDD SEL 1 VDD hvp L=3.0e-07 W=0.3e-06
M1 3 SEL VDD VDD hvp L=3.0e-07 W=1e-06
M2 VDD 4 3 VDD hvp L=3.0e-07 W=1e-06
M3 4 TD VDD VDD hvp L=3.0e-07 W=0.35e-06
M4 5 3 VDD VDD hvp L=3.0e-07 W=0.65e-06
M5 VDD 6 5 VDD hvp L=3.0e-07 W=0.65e-06
M6 6 8 VDD VDD hvp L=3.0e-07 W=0.65e-06
M7 VDD 1 6 VDD hvp L=3.0e-07 W=0.65e-06
M8 7 CN VDD VDD hvp L=3.0e-07 W=0.65e-06
M9 8 CN 7 VDD hvp L=3.0e-07 W=0.65e-06
M10 9 7 8 VDD hvp L=3.0e-07 W=0.65e-06
M11 10 D 9 VDD hvp L=3.0e-07 W=0.65e-06
M12 VDD 11 10 VDD hvp L=3.0e-07 W=0.65e-06
M13 11 LD VDD VDD hvp L=3.0e-07 W=0.3e-06
M14 12 LD VDD VDD hvp L=3.0e-07 W=0.6e-06
M15 9 19 12 VDD hvp L=3.0e-07 W=0.6e-06
M16 VDD CK 13 VDD hvp L=3.0e-07 W=0.3e-06
M17 14 13 VDD VDD hvp L=3.0e-07 W=0.7e-06
M18 15 14 5 VDD hvp L=3.0e-07 W=0.5e-06
M19 16 13 15 VDD hvp L=3.0e-07 W=0.3e-06
M20 VDD 17 16 VDD hvp L=3.0e-07 W=0.3e-06
M21 17 15 VDD VDD hvp L=3.0e-07 W=0.5e-06
M22 18 13 17 VDD hvp L=3.0e-07 W=0.7e-06
M23 19 14 18 VDD hvp L=3.0e-07 W=0.3e-06
M24 VDD 20 19 VDD hvp L=3.0e-07 W=0.3e-06
M25 VDD 18 20 VDD hvp L=3.0e-07 W=0.9e-06
M26 Q 20 VDD VDD hvp L=3.0e-07 W=1e-06
M27 VDD 20 Q VDD hvp L=3.0e-07 W=1e-06
M28 Q 20 VDD VDD hvp L=3.0e-07 W=1e-06
M29 VDD 20 Q VDD hvp L=3.0e-07 W=1e-06
M30 GND SEL 1 GND hvn L=3.5e-07 W=0.3e-06
M31 23 SEL GND GND hvn L=3.5e-07 W=0.65e-06
M32 3 4 23 GND hvn L=3.5e-07 W=0.65e-06
M33 GND TD 4 GND hvn L=3.5e-07 W=0.3e-06
M34 24 3 GND GND hvn L=3.5e-07 W=0.4e-06
M35 5 6 24 GND hvn L=3.5e-07 W=0.4e-06
M36 25 8 6 GND hvn L=3.5e-07 W=0.55e-06
M37 GND 1 25 GND hvn L=3.5e-07 W=0.55e-06
M38 7 CN GND GND hvn L=3.5e-07 W=0.3e-06
M39 8 7 7 GND hvn L=3.5e-07 W=0.3e-06
M40 9 CN 8 GND hvn L=3.5e-07 W=0.3e-06
M41 26 D 9 GND hvn L=3.5e-07 W=0.65e-06
M42 GND LD 26 GND hvn L=3.5e-07 W=0.65e-06
M43 11 LD GND GND hvn L=3.5e-07 W=0.3e-06
M44 27 11 GND GND hvn L=3.5e-07 W=0.4e-06
M45 9 19 27 GND hvn L=3.5e-07 W=0.4e-06
M46 GND CK 13 GND hvn L=3.5e-07 W=0.6e-06
M47 14 13 GND GND hvn L=3.5e-07 W=0.3e-06
M48 15 13 5 GND hvn L=3.5e-07 W=0.6e-06
M49 28 14 15 GND hvn L=3.5e-07 W=0.3e-06
M50 GND 17 28 GND hvn L=3.5e-07 W=0.3e-06
M51 17 15 GND GND hvn L=3.5e-07 W=0.3e-06
M52 18 14 17 GND hvn L=3.5e-07 W=0.6e-06
M53 19 13 18 GND hvn L=3.5e-07 W=0.3e-06
M54 GND 20 19 GND hvn L=3.5e-07 W=0.3e-06
M55 GND 18 20 GND hvn L=3.5e-07 W=0.6e-06
M56 Q 20 GND GND hvn L=3.5e-07 W=0.65e-06
M57 GND 20 Q GND hvn L=3.5e-07 W=0.65e-06
M58 Q 20 GND GND hvn L=3.5e-07 W=0.65e-06
M59 GND 20 Q GND hvn L=3.5e-07 W=0.65e-06
.ENDS SFFCNLDQX4

.SUBCKT SFFCNQBX1 QB CN D SEL TD CK
M0 2 TD VDD VDD hvp L=3.0e-07 W=0.3e-06
M1 4 2 3 VDD hvp L=3.0e-07 W=0.9e-06
M2 VDD 5 4 VDD hvp L=3.0e-07 W=0.9e-06
M3 5 SEL VDD VDD hvp L=3.0e-07 W=0.3e-06
M4 6 SEL VDD VDD hvp L=3.0e-07 W=0.5e-06
M5 3 7 6 VDD hvp L=3.0e-07 W=0.5e-06
M6 7 D VDD VDD hvp L=3.0e-07 W=0.6e-06
M7 VDD CN 7 VDD hvp L=3.0e-07 W=0.6e-06
M8 VDD CK 8 VDD hvp L=3.0e-07 W=0.35e-06
M9 9 8 VDD VDD hvp L=3.0e-07 W=0.9e-06
M10 10 9 3 VDD hvp L=3.0e-07 W=0.54e-06
M11 11 8 10 VDD hvp L=3.0e-07 W=0.3e-06
M12 VDD 12 11 VDD hvp L=3.0e-07 W=0.3e-06
M13 12 10 VDD VDD hvp L=3.0e-07 W=0.5e-06
M14 13 8 12 VDD hvp L=3.0e-07 W=0.5e-06
M15 14 9 13 VDD hvp L=3.0e-07 W=0.3e-06
M16 VDD 15 14 VDD hvp L=3.0e-07 W=0.3e-06
M17 VDD 13 15 VDD hvp L=3.0e-07 W=1e-06
M18 QB 15 VDD VDD hvp L=3.0e-07 W=1e-06
M19 2 TD GND GND hvn L=3.5e-07 W=0.3e-06
M20 18 2 3 GND hvn L=3.5e-07 W=0.65e-06
M21 GND SEL 18 GND hvn L=3.5e-07 W=0.65e-06
M22 5 SEL GND GND hvn L=3.5e-07 W=0.3e-06
M23 19 5 GND GND hvn L=3.5e-07 W=0.3e-06
M24 3 7 19 GND hvn L=3.5e-07 W=0.3e-06
M25 20 D 7 GND hvn L=3.5e-07 W=0.6e-06
M26 GND CN 20 GND hvn L=3.5e-07 W=0.6e-06
M27 GND CK 8 GND hvn L=3.5e-07 W=0.6e-06
M28 9 8 GND GND hvn L=3.5e-07 W=0.3e-06
M29 10 8 3 GND hvn L=3.5e-07 W=0.35e-06
M30 21 9 10 GND hvn L=3.5e-07 W=0.3e-06
M31 GND 12 21 GND hvn L=3.5e-07 W=0.3e-06
M32 12 10 GND GND hvn L=3.5e-07 W=0.3e-06
M33 13 9 12 GND hvn L=3.5e-07 W=0.3e-06
M34 22 8 13 GND hvn L=3.5e-07 W=0.3e-06
M35 GND 15 22 GND hvn L=3.5e-07 W=0.3e-06
M36 GND 13 15 GND hvn L=3.5e-07 W=0.65e-06
M37 QB 15 GND GND hvn L=3.5e-07 W=0.65e-06
.ENDS SFFCNQBX1

.SUBCKT SFFCNQBX2 QB CN D SEL TD CK
M0 2 TD VDD VDD hvp L=3.0e-07 W=0.3e-06
M1 4 2 3 VDD hvp L=3.0e-07 W=0.9e-06
M2 VDD 5 4 VDD hvp L=3.0e-07 W=0.9e-06
M3 5 SEL VDD VDD hvp L=3.0e-07 W=0.3e-06
M4 6 SEL VDD VDD hvp L=3.0e-07 W=0.5e-06
M5 3 7 6 VDD hvp L=3.0e-07 W=0.5e-06
M6 7 D VDD VDD hvp L=3.0e-07 W=0.6e-06
M7 VDD CN 7 VDD hvp L=3.0e-07 W=0.6e-06
M8 VDD CK 8 VDD hvp L=3.0e-07 W=0.35e-06
M9 9 8 VDD VDD hvp L=3.0e-07 W=0.9e-06
M10 10 9 3 VDD hvp L=3.0e-07 W=0.54e-06
M11 11 8 10 VDD hvp L=3.0e-07 W=0.3e-06
M12 VDD 12 11 VDD hvp L=3.0e-07 W=0.3e-06
M13 12 10 VDD VDD hvp L=3.0e-07 W=0.5e-06
M14 13 8 12 VDD hvp L=3.0e-07 W=0.5e-06
M15 14 9 13 VDD hvp L=3.0e-07 W=0.3e-06
M16 VDD 15 14 VDD hvp L=3.0e-07 W=0.3e-06
M17 VDD 13 15 VDD hvp L=3.0e-07 W=1e-06
M18 QB 15 VDD VDD hvp L=3.0e-07 W=1e-06
M19 VDD 15 QB VDD hvp L=3.0e-07 W=1e-06
M20 2 TD GND GND hvn L=3.5e-07 W=0.3e-06
M21 18 2 3 GND hvn L=3.5e-07 W=0.65e-06
M22 GND SEL 18 GND hvn L=3.5e-07 W=0.65e-06
M23 5 SEL GND GND hvn L=3.5e-07 W=0.3e-06
M24 19 5 GND GND hvn L=3.5e-07 W=0.3e-06
M25 3 7 19 GND hvn L=3.5e-07 W=0.3e-06
M26 20 D 7 GND hvn L=3.5e-07 W=0.6e-06
M27 GND CN 20 GND hvn L=3.5e-07 W=0.6e-06
M28 GND CK 8 GND hvn L=3.5e-07 W=0.6e-06
M29 9 8 GND GND hvn L=3.5e-07 W=0.3e-06
M30 10 8 3 GND hvn L=3.5e-07 W=0.35e-06
M31 21 9 10 GND hvn L=3.5e-07 W=0.3e-06
M32 GND 12 21 GND hvn L=3.5e-07 W=0.3e-06
M33 12 10 GND GND hvn L=3.5e-07 W=0.3e-06
M34 13 9 12 GND hvn L=3.5e-07 W=0.3e-06
M35 22 8 13 GND hvn L=3.5e-07 W=0.3e-06
M36 GND 15 22 GND hvn L=3.5e-07 W=0.3e-06
M37 GND 13 15 GND hvn L=3.5e-07 W=0.65e-06
M38 QB 15 GND GND hvn L=3.5e-07 W=0.65e-06
M39 GND 15 QB GND hvn L=3.5e-07 W=0.65e-06
.ENDS SFFCNQBX2

.SUBCKT SFFCNQBX4 QB CN D SEL TD CK
M0 2 TD VDD VDD hvp L=3.0e-07 W=0.3e-06
M1 4 2 3 VDD hvp L=3.0e-07 W=0.9e-06
M2 VDD 5 4 VDD hvp L=3.0e-07 W=0.9e-06
M3 5 SEL VDD VDD hvp L=3.0e-07 W=0.3e-06
M4 6 SEL VDD VDD hvp L=3.0e-07 W=0.5e-06
M5 3 7 6 VDD hvp L=3.0e-07 W=0.5e-06
M6 7 D VDD VDD hvp L=3.0e-07 W=0.6e-06
M7 VDD CN 7 VDD hvp L=3.0e-07 W=0.6e-06
M8 VDD CK 8 VDD hvp L=3.0e-07 W=0.35e-06
M9 9 8 VDD VDD hvp L=3.0e-07 W=0.9e-06
M10 10 9 3 VDD hvp L=3.0e-07 W=0.54e-06
M11 11 8 10 VDD hvp L=3.0e-07 W=0.3e-06
M12 VDD 12 11 VDD hvp L=3.0e-07 W=0.3e-06
M13 12 10 VDD VDD hvp L=3.0e-07 W=0.5e-06
M14 13 8 12 VDD hvp L=3.0e-07 W=0.5e-06
M15 14 9 13 VDD hvp L=3.0e-07 W=0.3e-06
M16 VDD 15 14 VDD hvp L=3.0e-07 W=0.3e-06
M17 VDD 13 15 VDD hvp L=3.0e-07 W=1e-06
M18 QB 15 VDD VDD hvp L=3.0e-07 W=1e-06
M19 VDD 15 QB VDD hvp L=3.0e-07 W=1e-06
M20 QB 15 VDD VDD hvp L=3.0e-07 W=1e-06
M21 VDD 15 QB VDD hvp L=3.0e-07 W=1e-06
M22 2 TD GND GND hvn L=3.5e-07 W=0.3e-06
M23 18 2 3 GND hvn L=3.5e-07 W=0.65e-06
M24 GND SEL 18 GND hvn L=3.5e-07 W=0.65e-06
M25 5 SEL GND GND hvn L=3.5e-07 W=0.3e-06
M26 19 5 GND GND hvn L=3.5e-07 W=0.3e-06
M27 3 7 19 GND hvn L=3.5e-07 W=0.3e-06
M28 20 D 7 GND hvn L=3.5e-07 W=0.6e-06
M29 GND CN 20 GND hvn L=3.5e-07 W=0.6e-06
M30 GND CK 8 GND hvn L=3.5e-07 W=0.6e-06
M31 9 8 GND GND hvn L=3.5e-07 W=0.3e-06
M32 10 8 3 GND hvn L=3.5e-07 W=0.35e-06
M33 21 9 10 GND hvn L=3.5e-07 W=0.3e-06
M34 GND 12 21 GND hvn L=3.5e-07 W=0.3e-06
M35 12 10 GND GND hvn L=3.5e-07 W=0.3e-06
M36 13 9 12 GND hvn L=3.5e-07 W=0.3e-06
M37 22 8 13 GND hvn L=3.5e-07 W=0.3e-06
M38 GND 15 22 GND hvn L=3.5e-07 W=0.3e-06
M39 GND 13 15 GND hvn L=3.5e-07 W=0.65e-06
M40 QB 15 GND GND hvn L=3.5e-07 W=0.65e-06
M41 GND 15 QB GND hvn L=3.5e-07 W=0.65e-06
M42 QB 15 GND GND hvn L=3.5e-07 W=0.65e-06
M43 GND 15 QB GND hvn L=3.5e-07 W=0.65e-06
.ENDS SFFCNQBX4

.SUBCKT SFFCNQX1 Q CN D SEL TD CK
M0 2 TD VDD VDD hvp L=3.0e-07 W=0.3e-06
M1 4 2 3 VDD hvp L=3.0e-07 W=0.9e-06
M2 VDD 5 4 VDD hvp L=3.0e-07 W=0.9e-06
M3 5 SEL VDD VDD hvp L=3.0e-07 W=0.3e-06
M4 6 SEL VDD VDD hvp L=3.0e-07 W=0.5e-06
M5 3 7 6 VDD hvp L=3.0e-07 W=0.5e-06
M6 7 D VDD VDD hvp L=3.0e-07 W=0.6e-06
M7 VDD CN 7 VDD hvp L=3.0e-07 W=0.6e-06
M8 VDD CK 8 VDD hvp L=3.0e-07 W=0.35e-06
M9 9 8 VDD VDD hvp L=3.0e-07 W=0.9e-06
M10 10 9 3 VDD hvp L=3.0e-07 W=0.54e-06
M11 11 8 10 VDD hvp L=3.0e-07 W=0.3e-06
M12 VDD 12 11 VDD hvp L=3.0e-07 W=0.3e-06
M13 12 10 VDD VDD hvp L=3.0e-07 W=0.5e-06
M14 13 8 12 VDD hvp L=3.0e-07 W=0.5e-06
M15 14 9 13 VDD hvp L=3.0e-07 W=0.3e-06
M16 VDD 15 14 VDD hvp L=3.0e-07 W=0.3e-06
M17 15 13 VDD VDD hvp L=3.0e-07 W=0.3e-06
M18 Q 13 VDD VDD hvp L=3.0e-07 W=1e-06
M19 2 TD GND GND hvn L=3.5e-07 W=0.3e-06
M20 18 2 3 GND hvn L=3.5e-07 W=0.65e-06
M21 GND SEL 18 GND hvn L=3.5e-07 W=0.65e-06
M22 5 SEL GND GND hvn L=3.5e-07 W=0.3e-06
M23 19 5 GND GND hvn L=3.5e-07 W=0.3e-06
M24 3 7 19 GND hvn L=3.5e-07 W=0.3e-06
M25 20 D 7 GND hvn L=3.5e-07 W=0.6e-06
M26 GND CN 20 GND hvn L=3.5e-07 W=0.6e-06
M27 GND CK 8 GND hvn L=3.5e-07 W=0.6e-06
M28 9 8 GND GND hvn L=3.5e-07 W=0.3e-06
M29 10 8 3 GND hvn L=3.5e-07 W=0.35e-06
M30 21 9 10 GND hvn L=3.5e-07 W=0.3e-06
M31 GND 12 21 GND hvn L=3.5e-07 W=0.3e-06
M32 12 10 GND GND hvn L=3.5e-07 W=0.3e-06
M33 13 9 12 GND hvn L=3.5e-07 W=0.3e-06
M34 22 8 13 GND hvn L=3.5e-07 W=0.3e-06
M35 GND 15 22 GND hvn L=3.5e-07 W=0.3e-06
M36 15 13 GND GND hvn L=3.5e-07 W=0.3e-06
M37 Q 13 GND GND hvn L=3.5e-07 W=0.65e-06
.ENDS SFFCNQX1

.SUBCKT SFFCNQX2 Q CN D SEL TD CK
M0 2 TD VDD VDD hvp L=3.0e-07 W=0.3e-06
M1 4 2 3 VDD hvp L=3.0e-07 W=0.9e-06
M2 VDD 5 4 VDD hvp L=3.0e-07 W=0.9e-06
M3 5 SEL VDD VDD hvp L=3.0e-07 W=0.3e-06
M4 6 SEL VDD VDD hvp L=3.0e-07 W=0.5e-06
M5 3 7 6 VDD hvp L=3.0e-07 W=0.5e-06
M6 7 D VDD VDD hvp L=3.0e-07 W=0.6e-06
M7 VDD CN 7 VDD hvp L=3.0e-07 W=0.6e-06
M8 VDD CK 8 VDD hvp L=3.0e-07 W=0.35e-06
M9 9 8 VDD VDD hvp L=3.0e-07 W=0.9e-06
M10 10 9 3 VDD hvp L=3.0e-07 W=0.54e-06
M11 11 8 10 VDD hvp L=3.0e-07 W=0.3e-06
M12 VDD 12 11 VDD hvp L=3.0e-07 W=0.3e-06
M13 12 10 VDD VDD hvp L=3.0e-07 W=0.5e-06
M14 13 8 12 VDD hvp L=3.0e-07 W=0.5e-06
M15 14 9 13 VDD hvp L=3.0e-07 W=0.3e-06
M16 VDD 15 14 VDD hvp L=3.0e-07 W=0.3e-06
M17 15 13 VDD VDD hvp L=3.0e-07 W=0.3e-06
M18 Q 13 VDD VDD hvp L=3.0e-07 W=1e-06
M19 VDD 13 Q VDD hvp L=3.0e-07 W=1e-06
M20 2 TD GND GND hvn L=3.5e-07 W=0.3e-06
M21 18 2 3 GND hvn L=3.5e-07 W=0.65e-06
M22 GND SEL 18 GND hvn L=3.5e-07 W=0.65e-06
M23 5 SEL GND GND hvn L=3.5e-07 W=0.3e-06
M24 19 5 GND GND hvn L=3.5e-07 W=0.3e-06
M25 3 7 19 GND hvn L=3.5e-07 W=0.3e-06
M26 20 D 7 GND hvn L=3.5e-07 W=0.6e-06
M27 GND CN 20 GND hvn L=3.5e-07 W=0.6e-06
M28 GND CK 8 GND hvn L=3.5e-07 W=0.6e-06
M29 9 8 GND GND hvn L=3.5e-07 W=0.3e-06
M30 10 8 3 GND hvn L=3.5e-07 W=0.35e-06
M31 21 9 10 GND hvn L=3.5e-07 W=0.3e-06
M32 GND 12 21 GND hvn L=3.5e-07 W=0.3e-06
M33 12 10 GND GND hvn L=3.5e-07 W=0.3e-06
M34 13 9 12 GND hvn L=3.5e-07 W=0.3e-06
M35 22 8 13 GND hvn L=3.5e-07 W=0.3e-06
M36 GND 15 22 GND hvn L=3.5e-07 W=0.3e-06
M37 15 13 GND GND hvn L=3.5e-07 W=0.3e-06
M38 Q 13 GND GND hvn L=3.5e-07 W=0.65e-06
M39 GND 13 Q GND hvn L=3.5e-07 W=0.65e-06
.ENDS SFFCNQX2

.SUBCKT SFFCNQX4 Q CN D SEL TD CK
M0 2 TD VDD VDD hvp L=3.0e-07 W=0.3e-06
M1 4 2 3 VDD hvp L=3.0e-07 W=0.9e-06
M2 VDD 5 4 VDD hvp L=3.0e-07 W=0.9e-06
M3 5 SEL VDD VDD hvp L=3.0e-07 W=0.3e-06
M4 6 SEL VDD VDD hvp L=3.0e-07 W=0.5e-06
M5 3 7 6 VDD hvp L=3.0e-07 W=0.5e-06
M6 7 D VDD VDD hvp L=3.0e-07 W=0.6e-06
M7 VDD CN 7 VDD hvp L=3.0e-07 W=0.6e-06
M8 VDD CK 8 VDD hvp L=3.0e-07 W=0.35e-06
M9 9 8 VDD VDD hvp L=3.0e-07 W=0.9e-06
M10 10 9 3 VDD hvp L=3.0e-07 W=0.54e-06
M11 11 8 10 VDD hvp L=3.0e-07 W=0.3e-06
M12 VDD 12 11 VDD hvp L=3.0e-07 W=0.3e-06
M13 12 10 VDD VDD hvp L=3.0e-07 W=0.5e-06
M14 13 8 12 VDD hvp L=3.0e-07 W=0.5e-06
M15 14 9 13 VDD hvp L=3.0e-07 W=0.3e-06
M16 VDD 15 14 VDD hvp L=3.0e-07 W=0.3e-06
M17 15 13 VDD VDD hvp L=3.0e-07 W=0.3e-06
M18 Q 13 VDD VDD hvp L=3.0e-07 W=1e-06
M19 VDD 13 Q VDD hvp L=3.0e-07 W=1e-06
M20 Q 13 VDD VDD hvp L=3.0e-07 W=1e-06
M21 VDD 13 Q VDD hvp L=3.0e-07 W=1e-06
M22 2 TD GND GND hvn L=3.5e-07 W=0.3e-06
M23 18 2 3 GND hvn L=3.5e-07 W=0.65e-06
M24 GND SEL 18 GND hvn L=3.5e-07 W=0.65e-06
M25 5 SEL GND GND hvn L=3.5e-07 W=0.3e-06
M26 19 5 GND GND hvn L=3.5e-07 W=0.3e-06
M27 3 7 19 GND hvn L=3.5e-07 W=0.3e-06
M28 20 D 7 GND hvn L=3.5e-07 W=0.6e-06
M29 GND CN 20 GND hvn L=3.5e-07 W=0.6e-06
M30 GND CK 8 GND hvn L=3.5e-07 W=0.6e-06
M31 9 8 GND GND hvn L=3.5e-07 W=0.3e-06
M32 10 8 3 GND hvn L=3.5e-07 W=0.35e-06
M33 21 9 10 GND hvn L=3.5e-07 W=0.3e-06
M34 GND 12 21 GND hvn L=3.5e-07 W=0.3e-06
M35 12 10 GND GND hvn L=3.5e-07 W=0.3e-06
M36 13 9 12 GND hvn L=3.5e-07 W=0.3e-06
M37 22 8 13 GND hvn L=3.5e-07 W=0.3e-06
M38 GND 15 22 GND hvn L=3.5e-07 W=0.3e-06
M39 15 13 GND GND hvn L=3.5e-07 W=0.3e-06
M40 Q 13 GND GND hvn L=3.5e-07 W=0.65e-06
M41 GND 13 Q GND hvn L=3.5e-07 W=0.65e-06
M42 Q 13 GND GND hvn L=3.5e-07 W=0.65e-06
M43 GND 13 Q GND hvn L=3.5e-07 W=0.65e-06
.ENDS SFFCNQX4

.SUBCKT SFFQBX1 QB D SEL TD CK
M0 VDD SEL 1 VDD hvp L=3.0e-07 W=0.3e-06
M1 3 SEL VDD VDD hvp L=3.0e-07 W=0.9e-06
M2 4 D 3 VDD hvp L=3.0e-07 W=0.9e-06
M3 5 1 4 VDD hvp L=3.0e-07 W=0.9e-06
M4 VDD TD 5 VDD hvp L=3.0e-07 W=0.9e-06
M5 6 CK VDD VDD hvp L=3.0e-07 W=0.3e-06
M6 7 6 VDD VDD hvp L=3.0e-07 W=0.6e-06
M7 8 7 4 VDD hvp L=3.0e-07 W=0.6e-06
M8 9 6 8 VDD hvp L=3.0e-07 W=0.4e-06
M9 VDD 10 9 VDD hvp L=3.0e-07 W=0.4e-06
M10 10 8 VDD VDD hvp L=3.0e-07 W=0.5e-06
M11 11 6 10 VDD hvp L=3.0e-07 W=0.5e-06
M12 12 7 11 VDD hvp L=3.0e-07 W=0.3e-06
M13 VDD 13 12 VDD hvp L=3.0e-07 W=0.3e-06
M14 13 11 VDD VDD hvp L=3.0e-07 W=0.3e-06
M15 QB 11 VDD VDD hvp L=3.0e-07 W=1e-06
M16 GND SEL 1 GND hvn L=3.5e-07 W=0.3e-06
M17 16 1 GND GND hvn L=3.5e-07 W=0.35e-06
M18 4 D 16 GND hvn L=3.5e-07 W=0.35e-06
M19 17 SEL 4 GND hvn L=3.5e-07 W=0.35e-06
M20 GND TD 17 GND hvn L=3.5e-07 W=0.35e-06
M21 GND CK 6 GND hvn L=3.5e-07 W=0.6e-06
M22 7 6 GND GND hvn L=3.5e-07 W=0.3e-06
M23 8 6 4 GND hvn L=3.5e-07 W=0.6e-06
M24 18 7 8 GND hvn L=3.5e-07 W=0.3e-06
M25 GND 10 18 GND hvn L=3.5e-07 W=0.3e-06
M26 10 8 GND GND hvn L=3.5e-07 W=0.3e-06
M27 11 7 10 GND hvn L=3.5e-07 W=0.4e-06
M28 19 6 11 GND hvn L=3.5e-07 W=0.3e-06
M29 GND 13 19 GND hvn L=3.5e-07 W=0.3e-06
M30 13 11 GND GND hvn L=3.5e-07 W=0.3e-06
M31 QB 11 GND GND hvn L=3.5e-07 W=0.65e-06
.ENDS SFFQBX1

.SUBCKT SFFQBX2 QB D SEL TD CK
M0 VDD SEL 1 VDD hvp L=3.0e-07 W=0.3e-06
M1 3 SEL VDD VDD hvp L=3.0e-07 W=0.9e-06
M2 4 D 3 VDD hvp L=3.0e-07 W=0.9e-06
M3 5 1 4 VDD hvp L=3.0e-07 W=0.9e-06
M4 VDD TD 5 VDD hvp L=3.0e-07 W=0.9e-06
M5 6 CK VDD VDD hvp L=3.0e-07 W=0.3e-06
M6 7 6 VDD VDD hvp L=3.0e-07 W=0.6e-06
M7 8 7 4 VDD hvp L=3.0e-07 W=0.6e-06
M8 9 6 8 VDD hvp L=3.0e-07 W=0.4e-06
M9 VDD 10 9 VDD hvp L=3.0e-07 W=0.4e-06
M10 10 8 VDD VDD hvp L=3.0e-07 W=0.5e-06
M11 11 6 10 VDD hvp L=3.0e-07 W=0.5e-06
M12 12 7 11 VDD hvp L=3.0e-07 W=0.3e-06
M13 VDD 13 12 VDD hvp L=3.0e-07 W=0.3e-06
M14 13 11 VDD VDD hvp L=3.0e-07 W=0.3e-06
M15 QB 11 VDD VDD hvp L=3.0e-07 W=1e-06
M16 VDD 11 QB VDD hvp L=3.0e-07 W=1e-06
M17 GND SEL 1 GND hvn L=3.5e-07 W=0.3e-06
M18 16 1 GND GND hvn L=3.5e-07 W=0.35e-06
M19 4 D 16 GND hvn L=3.5e-07 W=0.35e-06
M20 17 SEL 4 GND hvn L=3.5e-07 W=0.35e-06
M21 GND TD 17 GND hvn L=3.5e-07 W=0.35e-06
M22 GND CK 6 GND hvn L=3.5e-07 W=0.6e-06
M23 7 6 GND GND hvn L=3.5e-07 W=0.3e-06
M24 8 6 4 GND hvn L=3.5e-07 W=0.6e-06
M25 18 7 8 GND hvn L=3.5e-07 W=0.3e-06
M26 GND 10 18 GND hvn L=3.5e-07 W=0.3e-06
M27 10 8 GND GND hvn L=3.5e-07 W=0.3e-06
M28 11 7 10 GND hvn L=3.5e-07 W=0.4e-06
M29 19 6 11 GND hvn L=3.5e-07 W=0.3e-06
M30 GND 13 19 GND hvn L=3.5e-07 W=0.3e-06
M31 13 11 GND GND hvn L=3.5e-07 W=0.3e-06
M32 QB 11 GND GND hvn L=3.5e-07 W=0.65e-06
M33 GND 11 QB GND hvn L=3.5e-07 W=0.65e-06
.ENDS SFFQBX2

.SUBCKT SFFQBX4 QB D SEL TD CK
M0 VDD SEL 1 VDD hvp L=3.0e-07 W=0.3e-06
M1 3 SEL VDD VDD hvp L=3.0e-07 W=0.9e-06
M2 4 D 3 VDD hvp L=3.0e-07 W=0.9e-06
M3 5 1 4 VDD hvp L=3.0e-07 W=0.9e-06
M4 VDD TD 5 VDD hvp L=3.0e-07 W=0.9e-06
M5 6 CK VDD VDD hvp L=3.0e-07 W=0.3e-06
M6 7 6 VDD VDD hvp L=3.0e-07 W=0.6e-06
M7 8 7 4 VDD hvp L=3.0e-07 W=0.6e-06
M8 9 6 8 VDD hvp L=3.0e-07 W=0.4e-06
M9 VDD 10 9 VDD hvp L=3.0e-07 W=0.4e-06
M10 10 8 VDD VDD hvp L=3.0e-07 W=0.5e-06
M11 11 6 10 VDD hvp L=3.0e-07 W=0.5e-06
M12 12 7 11 VDD hvp L=3.0e-07 W=0.3e-06
M13 VDD 13 12 VDD hvp L=3.0e-07 W=0.3e-06
M14 13 11 VDD VDD hvp L=3.0e-07 W=0.3e-06
M15 QB 11 VDD VDD hvp L=3.0e-07 W=1e-06
M16 VDD 11 QB VDD hvp L=3.0e-07 W=1e-06
M17 QB 11 VDD VDD hvp L=3.0e-07 W=1e-06
M18 VDD 11 QB VDD hvp L=3.0e-07 W=1e-06
M19 GND SEL 1 GND hvn L=3.5e-07 W=0.3e-06
M20 16 1 GND GND hvn L=3.5e-07 W=0.35e-06
M21 4 D 16 GND hvn L=3.5e-07 W=0.35e-06
M22 17 SEL 4 GND hvn L=3.5e-07 W=0.35e-06
M23 GND TD 17 GND hvn L=3.5e-07 W=0.35e-06
M24 GND CK 6 GND hvn L=3.5e-07 W=0.6e-06
M25 7 6 GND GND hvn L=3.5e-07 W=0.3e-06
M26 8 6 4 GND hvn L=3.5e-07 W=0.6e-06
M27 18 7 8 GND hvn L=3.5e-07 W=0.3e-06
M28 GND 10 18 GND hvn L=3.5e-07 W=0.3e-06
M29 10 8 GND GND hvn L=3.5e-07 W=0.3e-06
M30 11 7 10 GND hvn L=3.5e-07 W=0.4e-06
M31 19 6 11 GND hvn L=3.5e-07 W=0.3e-06
M32 GND 13 19 GND hvn L=3.5e-07 W=0.3e-06
M33 13 11 GND GND hvn L=3.5e-07 W=0.3e-06
M34 QB 11 GND GND hvn L=3.5e-07 W=0.65e-06
M35 GND 11 QB GND hvn L=3.5e-07 W=0.65e-06
M36 QB 11 GND GND hvn L=3.5e-07 W=0.65e-06
M37 GND 11 QB GND hvn L=3.5e-07 W=0.65e-06
.ENDS SFFQBX4

.SUBCKT SFFQBX6 QB D SEL TD CK
M0 VDD SEL 1 VDD hvp L=3.0e-07 W=0.3e-06
M1 3 SEL VDD VDD hvp L=3.0e-07 W=0.9e-06
M2 4 D 3 VDD hvp L=3.0e-07 W=0.9e-06
M3 5 1 4 VDD hvp L=3.0e-07 W=0.9e-06
M4 VDD TD 5 VDD hvp L=3.0e-07 W=0.9e-06
M5 6 CK VDD VDD hvp L=3.0e-07 W=0.3e-06
M6 7 6 VDD VDD hvp L=3.0e-07 W=0.6e-06
M7 8 7 4 VDD hvp L=3.0e-07 W=0.6e-06
M8 9 6 8 VDD hvp L=3.0e-07 W=0.4e-06
M9 VDD 10 9 VDD hvp L=3.0e-07 W=0.4e-06
M10 10 8 VDD VDD hvp L=3.0e-07 W=0.5e-06
M11 11 6 10 VDD hvp L=3.0e-07 W=0.5e-06
M12 12 7 11 VDD hvp L=3.0e-07 W=0.3e-06
M13 VDD 13 12 VDD hvp L=3.0e-07 W=0.3e-06
M14 13 11 VDD VDD hvp L=3.0e-07 W=0.3e-06
M15 QB 11 VDD VDD hvp L=3.0e-07 W=1e-06
M16 VDD 11 QB VDD hvp L=3.0e-07 W=1e-06
M17 QB 11 VDD VDD hvp L=3.0e-07 W=1e-06
M18 VDD 11 QB VDD hvp L=3.0e-07 W=1e-06
M19 QB 11 VDD VDD hvp L=3.0e-07 W=1e-06
M20 VDD 11 QB VDD hvp L=3.0e-07 W=1e-06
M21 GND SEL 1 GND hvn L=3.5e-07 W=0.3e-06
M22 16 1 GND GND hvn L=3.5e-07 W=0.35e-06
M23 4 D 16 GND hvn L=3.5e-07 W=0.35e-06
M24 17 SEL 4 GND hvn L=3.5e-07 W=0.35e-06
M25 GND TD 17 GND hvn L=3.5e-07 W=0.35e-06
M26 GND CK 6 GND hvn L=3.5e-07 W=0.6e-06
M27 7 6 GND GND hvn L=3.5e-07 W=0.3e-06
M28 8 6 4 GND hvn L=3.5e-07 W=0.6e-06
M29 18 7 8 GND hvn L=3.5e-07 W=0.3e-06
M30 GND 10 18 GND hvn L=3.5e-07 W=0.3e-06
M31 10 8 GND GND hvn L=3.5e-07 W=0.3e-06
M32 11 7 10 GND hvn L=3.5e-07 W=0.4e-06
M33 19 6 11 GND hvn L=3.5e-07 W=0.3e-06
M34 GND 13 19 GND hvn L=3.5e-07 W=0.3e-06
M35 13 11 GND GND hvn L=3.5e-07 W=0.3e-06
M36 QB 11 GND GND hvn L=3.5e-07 W=0.65e-06
M37 GND 11 QB GND hvn L=3.5e-07 W=0.65e-06
M38 QB 11 GND GND hvn L=3.5e-07 W=0.65e-06
M39 GND 11 QB GND hvn L=3.5e-07 W=0.65e-06
M40 QB 11 GND GND hvn L=3.5e-07 W=0.65e-06
M41 GND 11 QB GND hvn L=3.5e-07 W=0.65e-06
.ENDS SFFQBX6

.SUBCKT SFFQX1 Q D SEL TD CK
M0 VDD SEL 1 VDD hvp L=3.0e-07 W=0.3e-06
M1 3 SEL VDD VDD hvp L=3.0e-07 W=0.9e-06
M2 4 D 3 VDD hvp L=3.0e-07 W=0.9e-06
M3 5 1 4 VDD hvp L=3.0e-07 W=0.9e-06
M4 VDD TD 5 VDD hvp L=3.0e-07 W=0.9e-06
M5 6 CK VDD VDD hvp L=3.0e-07 W=0.3e-06
M6 7 6 VDD VDD hvp L=3.0e-07 W=0.6e-06
M7 8 7 4 VDD hvp L=3.0e-07 W=0.6e-06
M8 9 6 8 VDD hvp L=3.0e-07 W=0.4e-06
M9 VDD 10 9 VDD hvp L=3.0e-07 W=0.4e-06
M10 10 8 VDD VDD hvp L=3.0e-07 W=0.5e-06
M11 11 6 10 VDD hvp L=3.0e-07 W=0.5e-06
M12 12 7 11 VDD hvp L=3.0e-07 W=0.3e-06
M13 VDD 13 12 VDD hvp L=3.0e-07 W=0.3e-06
M14 VDD 11 13 VDD hvp L=3.0e-07 W=1e-06
M15 Q 13 VDD VDD hvp L=3.0e-07 W=1e-06
M16 GND SEL 1 GND hvn L=3.5e-07 W=0.3e-06
M17 16 1 GND GND hvn L=3.5e-07 W=0.35e-06
M18 4 D 16 GND hvn L=3.5e-07 W=0.35e-06
M19 17 SEL 4 GND hvn L=3.5e-07 W=0.35e-06
M20 GND TD 17 GND hvn L=3.5e-07 W=0.35e-06
M21 GND CK 6 GND hvn L=3.5e-07 W=0.6e-06
M22 7 6 GND GND hvn L=3.5e-07 W=0.3e-06
M23 8 6 4 GND hvn L=3.5e-07 W=0.6e-06
M24 18 7 8 GND hvn L=3.5e-07 W=0.3e-06
M25 GND 10 18 GND hvn L=3.5e-07 W=0.3e-06
M26 10 8 GND GND hvn L=3.5e-07 W=0.3e-06
M27 11 7 10 GND hvn L=3.5e-07 W=0.4e-06
M28 19 6 11 GND hvn L=3.5e-07 W=0.3e-06
M29 GND 13 19 GND hvn L=3.5e-07 W=0.3e-06
M30 GND 11 13 GND hvn L=3.5e-07 W=0.65e-06
M31 Q 13 GND GND hvn L=3.5e-07 W=0.65e-06
.ENDS SFFQX1

.SUBCKT SFFQX2 Q D SEL TD CK
M0 VDD SEL 1 VDD hvp L=3.0e-07 W=0.3e-06
M1 3 SEL VDD VDD hvp L=3.0e-07 W=0.9e-06
M2 4 D 3 VDD hvp L=3.0e-07 W=0.9e-06
M3 5 1 4 VDD hvp L=3.0e-07 W=0.9e-06
M4 VDD TD 5 VDD hvp L=3.0e-07 W=0.9e-06
M5 6 CK VDD VDD hvp L=3.0e-07 W=0.3e-06
M6 7 6 VDD VDD hvp L=3.0e-07 W=0.6e-06
M7 8 7 4 VDD hvp L=3.0e-07 W=0.6e-06
M8 9 6 8 VDD hvp L=3.0e-07 W=0.4e-06
M9 VDD 10 9 VDD hvp L=3.0e-07 W=0.4e-06
M10 10 8 VDD VDD hvp L=3.0e-07 W=0.5e-06
M11 11 6 10 VDD hvp L=3.0e-07 W=0.5e-06
M12 12 7 11 VDD hvp L=3.0e-07 W=0.3e-06
M13 VDD 13 12 VDD hvp L=3.0e-07 W=0.3e-06
M14 VDD 11 13 VDD hvp L=3.0e-07 W=1e-06
M15 Q 13 VDD VDD hvp L=3.0e-07 W=1e-06
M16 VDD 13 Q VDD hvp L=3.0e-07 W=1e-06
M17 GND SEL 1 GND hvn L=3.5e-07 W=0.3e-06
M18 16 1 GND GND hvn L=3.5e-07 W=0.35e-06
M19 4 D 16 GND hvn L=3.5e-07 W=0.35e-06
M20 17 SEL 4 GND hvn L=3.5e-07 W=0.35e-06
M21 GND TD 17 GND hvn L=3.5e-07 W=0.35e-06
M22 GND CK 6 GND hvn L=3.5e-07 W=0.6e-06
M23 7 6 GND GND hvn L=3.5e-07 W=0.3e-06
M24 8 6 4 GND hvn L=3.5e-07 W=0.6e-06
M25 18 7 8 GND hvn L=3.5e-07 W=0.3e-06
M26 GND 10 18 GND hvn L=3.5e-07 W=0.3e-06
M27 10 8 GND GND hvn L=3.5e-07 W=0.3e-06
M28 11 7 10 GND hvn L=3.5e-07 W=0.4e-06
M29 19 6 11 GND hvn L=3.5e-07 W=0.3e-06
M30 GND 13 19 GND hvn L=3.5e-07 W=0.3e-06
M31 GND 11 13 GND hvn L=3.5e-07 W=0.65e-06
M32 Q 13 GND GND hvn L=3.5e-07 W=0.65e-06
M33 GND 13 Q GND hvn L=3.5e-07 W=0.65e-06
.ENDS SFFQX2

.SUBCKT SFFQX4 Q D SEL TD CK
M0 VDD SEL 1 VDD hvp L=3.0e-07 W=0.3e-06
M1 3 SEL VDD VDD hvp L=3.0e-07 W=0.9e-06
M2 4 D 3 VDD hvp L=3.0e-07 W=0.9e-06
M3 5 1 4 VDD hvp L=3.0e-07 W=0.9e-06
M4 VDD TD 5 VDD hvp L=3.0e-07 W=0.9e-06
M5 6 CK VDD VDD hvp L=3.0e-07 W=0.3e-06
M6 7 6 VDD VDD hvp L=3.0e-07 W=0.6e-06
M7 8 7 4 VDD hvp L=3.0e-07 W=0.6e-06
M8 9 6 8 VDD hvp L=3.0e-07 W=0.4e-06
M9 VDD 10 9 VDD hvp L=3.0e-07 W=0.4e-06
M10 10 8 VDD VDD hvp L=3.0e-07 W=0.5e-06
M11 11 6 10 VDD hvp L=3.0e-07 W=0.5e-06
M12 12 7 11 VDD hvp L=3.0e-07 W=0.3e-06
M13 VDD 13 12 VDD hvp L=3.0e-07 W=0.3e-06
M14 VDD 11 13 VDD hvp L=3.0e-07 W=1e-06
M15 Q 13 VDD VDD hvp L=3.0e-07 W=1e-06
M16 VDD 13 Q VDD hvp L=3.0e-07 W=1e-06
M17 Q 13 VDD VDD hvp L=3.0e-07 W=1e-06
M18 VDD 13 Q VDD hvp L=3.0e-07 W=1e-06
M19 GND SEL 1 GND hvn L=3.5e-07 W=0.3e-06
M20 16 1 GND GND hvn L=3.5e-07 W=0.35e-06
M21 4 D 16 GND hvn L=3.5e-07 W=0.35e-06
M22 17 SEL 4 GND hvn L=3.5e-07 W=0.35e-06
M23 GND TD 17 GND hvn L=3.5e-07 W=0.35e-06
M24 GND CK 6 GND hvn L=3.5e-07 W=0.6e-06
M25 7 6 GND GND hvn L=3.5e-07 W=0.3e-06
M26 8 6 4 GND hvn L=3.5e-07 W=0.6e-06
M27 18 7 8 GND hvn L=3.5e-07 W=0.3e-06
M28 GND 10 18 GND hvn L=3.5e-07 W=0.3e-06
M29 10 8 GND GND hvn L=3.5e-07 W=0.3e-06
M30 11 7 10 GND hvn L=3.5e-07 W=0.4e-06
M31 19 6 11 GND hvn L=3.5e-07 W=0.3e-06
M32 GND 13 19 GND hvn L=3.5e-07 W=0.3e-06
M33 GND 11 13 GND hvn L=3.5e-07 W=0.65e-06
M34 Q 13 GND GND hvn L=3.5e-07 W=0.65e-06
M35 GND 13 Q GND hvn L=3.5e-07 W=0.65e-06
M36 Q 13 GND GND hvn L=3.5e-07 W=0.65e-06
M37 GND 13 Q GND hvn L=3.5e-07 W=0.65e-06
.ENDS SFFQX4

.SUBCKT SFFQX6 Q D SEL TD CK
M0 VDD SEL 1 VDD hvp L=3.0e-07 W=0.3e-06
M1 3 SEL VDD VDD hvp L=3.0e-07 W=0.9e-06
M2 4 D 3 VDD hvp L=3.0e-07 W=0.9e-06
M3 5 1 4 VDD hvp L=3.0e-07 W=0.9e-06
M4 VDD TD 5 VDD hvp L=3.0e-07 W=0.9e-06
M5 6 CK VDD VDD hvp L=3.0e-07 W=0.3e-06
M6 7 6 VDD VDD hvp L=3.0e-07 W=0.6e-06
M7 8 7 4 VDD hvp L=3.0e-07 W=0.6e-06
M8 9 6 8 VDD hvp L=3.0e-07 W=0.4e-06
M9 VDD 10 9 VDD hvp L=3.0e-07 W=0.4e-06
M10 10 8 VDD VDD hvp L=3.0e-07 W=0.5e-06
M11 11 6 10 VDD hvp L=3.0e-07 W=0.5e-06
M12 12 7 11 VDD hvp L=3.0e-07 W=0.3e-06
M13 VDD 13 12 VDD hvp L=3.0e-07 W=0.3e-06
M14 VDD 11 13 VDD hvp L=3.0e-07 W=1e-06
M15 Q 13 VDD VDD hvp L=3.0e-07 W=1e-06
M16 VDD 13 Q VDD hvp L=3.0e-07 W=1e-06
M17 Q 13 VDD VDD hvp L=3.0e-07 W=1e-06
M18 VDD 13 Q VDD hvp L=3.0e-07 W=1e-06
M19 Q 13 VDD VDD hvp L=3.0e-07 W=1e-06
M20 VDD 13 Q VDD hvp L=3.0e-07 W=1e-06
M21 GND SEL 1 GND hvn L=3.5e-07 W=0.3e-06
M22 16 1 GND GND hvn L=3.5e-07 W=0.35e-06
M23 4 D 16 GND hvn L=3.5e-07 W=0.35e-06
M24 17 SEL 4 GND hvn L=3.5e-07 W=0.35e-06
M25 GND TD 17 GND hvn L=3.5e-07 W=0.35e-06
M26 GND CK 6 GND hvn L=3.5e-07 W=0.6e-06
M27 7 6 GND GND hvn L=3.5e-07 W=0.3e-06
M28 8 6 4 GND hvn L=3.5e-07 W=0.6e-06
M29 18 7 8 GND hvn L=3.5e-07 W=0.3e-06
M30 GND 10 18 GND hvn L=3.5e-07 W=0.3e-06
M31 10 8 GND GND hvn L=3.5e-07 W=0.3e-06
M32 11 7 10 GND hvn L=3.5e-07 W=0.4e-06
M33 19 6 11 GND hvn L=3.5e-07 W=0.3e-06
M34 GND 13 19 GND hvn L=3.5e-07 W=0.3e-06
M35 GND 11 13 GND hvn L=3.5e-07 W=0.65e-06
M36 Q 13 GND GND hvn L=3.5e-07 W=0.65e-06
M37 GND 13 Q GND hvn L=3.5e-07 W=0.65e-06
M38 Q 13 GND GND hvn L=3.5e-07 W=0.65e-06
M39 GND 13 Q GND hvn L=3.5e-07 W=0.65e-06
M40 Q 13 GND GND hvn L=3.5e-07 W=0.65e-06
M41 GND 13 Q GND hvn L=3.5e-07 W=0.65e-06
.ENDS SFFQX6

.SUBCKT SFFHQBX1 QB D SEL TD CK
M0 VDD SEL 3 VDD hvp L=3.0e-07 W=0.3e-06
M1 18 TD VDD VDD hvp L=3.0e-07 W=0.3e-06
M2 7 3 18 VDD hvp L=3.0e-07 W=0.3e-06
M3 4 SEL 7 VDD hvp L=3.0e-07 W=0.3e-06
M4 VDD D 4 VDD hvp L=3.0e-07 W=0.55e-06
M5 19 CK VDD VDD hvp L=3.0e-07 W=0.6e-06
M6 12 10 19 VDD hvp L=3.0e-07 W=0.6e-06
M7 VDD CK 8 VDD hvp L=3.0e-07 W=0.3e-06
M8 10 8 VDD VDD hvp L=3.0e-07 W=0.56e-06
M9 20 10 VDD VDD hvp L=3.0e-07 W=0.55e-06
M10 9 7 20 VDD hvp L=3.0e-07 W=0.55e-06
M11 21 12 9 VDD hvp L=3.0e-07 W=0.3e-06
M12 VDD 11 21 VDD hvp L=3.0e-07 W=0.3e-06
M13 11 9 VDD VDD hvp L=3.0e-07 W=0.75e-06
M14 13 12 11 VDD hvp L=3.0e-07 W=0.65e-06
M15 22 10 13 VDD hvp L=3.0e-07 W=0.28e-06
M16 VDD 14 22 VDD hvp L=3.0e-07 W=0.28e-06
M17 VDD 13 14 VDD hvp L=3.0e-07 W=0.3e-06
M18 QB 14 VDD VDD hvp L=3.0e-07 W=1e-06
M19 GND SEL 3 GND hvn L=3.5e-07 W=0.3e-06
M20 23 TD GND GND hvn L=3.5e-07 W=0.3e-06
M21 7 SEL 23 GND hvn L=3.5e-07 W=0.3e-06
M22 4 3 7 GND hvn L=3.5e-07 W=0.3e-06
M23 GND D 4 GND hvn L=3.5e-07 W=0.28e-06
M24 12 CK GND GND hvn L=3.5e-07 W=0.28e-06
M25 GND CK 8 GND hvn L=3.5e-07 W=0.28e-06
M26 10 8 GND GND hvn L=3.5e-07 W=0.28e-06
M27 24 12 GND GND hvn L=3.5e-07 W=0.3e-06
M28 9 7 24 GND hvn L=3.5e-07 W=0.3e-06
M29 25 10 9 GND hvn L=3.5e-07 W=0.28e-06
M30 GND 11 25 GND hvn L=3.5e-07 W=0.28e-06
M31 11 9 GND GND hvn L=3.5e-07 W=0.35e-06
M32 13 10 11 GND hvn L=3.5e-07 W=0.4e-06
M33 26 12 13 GND hvn L=3.5e-07 W=0.28e-06
M34 GND 14 26 GND hvn L=3.5e-07 W=0.28e-06
M35 GND 13 14 GND hvn L=3.5e-07 W=0.28e-06
M36 QB 14 GND GND hvn L=3.5e-07 W=0.65e-06
.ENDS SFFHQBX1

.SUBCKT SFFHQBX2 QB D SEL TD CK
M0 VDD SEL 3 VDD hvp L=3.0e-07 W=0.3e-06
M1 18 TD VDD VDD hvp L=3.0e-07 W=0.3e-06
M2 7 3 18 VDD hvp L=3.0e-07 W=0.3e-06
M3 4 SEL 7 VDD hvp L=3.0e-07 W=0.3e-06
M4 VDD D 4 VDD hvp L=3.0e-07 W=0.55e-06
M5 19 CK VDD VDD hvp L=3.0e-07 W=0.6e-06
M6 12 10 19 VDD hvp L=3.0e-07 W=0.6e-06
M7 VDD CK 8 VDD hvp L=3.0e-07 W=0.3e-06
M8 10 8 VDD VDD hvp L=3.0e-07 W=0.56e-06
M9 20 10 VDD VDD hvp L=3.0e-07 W=0.55e-06
M10 9 7 20 VDD hvp L=3.0e-07 W=0.55e-06
M11 21 12 9 VDD hvp L=3.0e-07 W=0.3e-06
M12 VDD 11 21 VDD hvp L=3.0e-07 W=0.3e-06
M13 11 9 VDD VDD hvp L=3.0e-07 W=0.75e-06
M14 13 12 11 VDD hvp L=3.0e-07 W=0.65e-06
M15 22 10 13 VDD hvp L=3.0e-07 W=0.28e-06
M16 VDD 14 22 VDD hvp L=3.0e-07 W=0.28e-06
M17 VDD 13 14 VDD hvp L=3.0e-07 W=0.3e-06
M18 QB 14 VDD VDD hvp L=3.0e-07 W=1e-06
M19 VDD 14 QB VDD hvp L=3.0e-07 W=1e-06
M20 GND SEL 3 GND hvn L=3.5e-07 W=0.3e-06
M21 23 TD GND GND hvn L=3.5e-07 W=0.3e-06
M22 7 SEL 23 GND hvn L=3.5e-07 W=0.3e-06
M23 4 3 7 GND hvn L=3.5e-07 W=0.3e-06
M24 GND D 4 GND hvn L=3.5e-07 W=0.28e-06
M25 12 CK GND GND hvn L=3.5e-07 W=0.28e-06
M26 GND CK 8 GND hvn L=3.5e-07 W=0.28e-06
M27 10 8 GND GND hvn L=3.5e-07 W=0.28e-06
M28 24 12 GND GND hvn L=3.5e-07 W=0.3e-06
M29 9 7 24 GND hvn L=3.5e-07 W=0.3e-06
M30 25 10 9 GND hvn L=3.5e-07 W=0.28e-06
M31 GND 11 25 GND hvn L=3.5e-07 W=0.28e-06
M32 11 9 GND GND hvn L=3.5e-07 W=0.35e-06
M33 13 10 11 GND hvn L=3.5e-07 W=0.4e-06
M34 26 12 13 GND hvn L=3.5e-07 W=0.28e-06
M35 GND 14 26 GND hvn L=3.5e-07 W=0.28e-06
M36 GND 13 14 GND hvn L=3.5e-07 W=0.28e-06
M37 QB 14 GND GND hvn L=3.5e-07 W=0.65e-06
M38 GND 14 QB GND hvn L=3.5e-07 W=0.65e-06
.ENDS SFFHQBX2

.SUBCKT SFFHQBX4 QB D SEL TD CK
M0 VDD SEL 3 VDD hvp L=3.0e-07 W=0.3e-06
M1 18 TD VDD VDD hvp L=3.0e-07 W=0.3e-06
M2 7 3 18 VDD hvp L=3.0e-07 W=0.3e-06
M3 4 SEL 7 VDD hvp L=3.0e-07 W=0.3e-06
M4 VDD D 4 VDD hvp L=3.0e-07 W=0.55e-06
M5 19 CK VDD VDD hvp L=3.0e-07 W=0.6e-06
M6 12 10 19 VDD hvp L=3.0e-07 W=0.6e-06
M7 VDD CK 8 VDD hvp L=3.0e-07 W=0.3e-06
M8 10 8 VDD VDD hvp L=3.0e-07 W=0.56e-06
M9 20 10 VDD VDD hvp L=3.0e-07 W=0.55e-06
M10 9 7 20 VDD hvp L=3.0e-07 W=0.55e-06
M11 21 12 9 VDD hvp L=3.0e-07 W=0.3e-06
M12 VDD 11 21 VDD hvp L=3.0e-07 W=0.3e-06
M13 11 9 VDD VDD hvp L=3.0e-07 W=0.75e-06
M14 13 12 11 VDD hvp L=3.0e-07 W=0.65e-06
M15 22 10 13 VDD hvp L=3.0e-07 W=0.28e-06
M16 VDD 14 22 VDD hvp L=3.0e-07 W=0.28e-06
M17 VDD 13 14 VDD hvp L=3.0e-07 W=0.3e-06
M18 QB 14 VDD VDD hvp L=3.0e-07 W=1e-06
M19 VDD 14 QB VDD hvp L=3.0e-07 W=1e-06
M20 QB 14 VDD VDD hvp L=3.0e-07 W=1e-06
M21 VDD 14 QB VDD hvp L=3.0e-07 W=1e-06
M22 GND SEL 3 GND hvn L=3.5e-07 W=0.3e-06
M23 23 TD GND GND hvn L=3.5e-07 W=0.3e-06
M24 7 SEL 23 GND hvn L=3.5e-07 W=0.3e-06
M25 4 3 7 GND hvn L=3.5e-07 W=0.3e-06
M26 GND D 4 GND hvn L=3.5e-07 W=0.28e-06
M27 12 CK GND GND hvn L=3.5e-07 W=0.28e-06
M28 GND CK 8 GND hvn L=3.5e-07 W=0.28e-06
M29 10 8 GND GND hvn L=3.5e-07 W=0.28e-06
M30 24 12 GND GND hvn L=3.5e-07 W=0.3e-06
M31 9 7 24 GND hvn L=3.5e-07 W=0.3e-06
M32 25 10 9 GND hvn L=3.5e-07 W=0.28e-06
M33 GND 11 25 GND hvn L=3.5e-07 W=0.28e-06
M34 11 9 GND GND hvn L=3.5e-07 W=0.35e-06
M35 13 10 11 GND hvn L=3.5e-07 W=0.4e-06
M36 26 12 13 GND hvn L=3.5e-07 W=0.28e-06
M37 GND 14 26 GND hvn L=3.5e-07 W=0.28e-06
M38 GND 13 14 GND hvn L=3.5e-07 W=0.28e-06
M39 QB 14 GND GND hvn L=3.5e-07 W=0.65e-06
M40 GND 14 QB GND hvn L=3.5e-07 W=0.65e-06
M41 QB 14 GND GND hvn L=3.5e-07 W=0.65e-06
M42 GND 14 QB GND hvn L=3.5e-07 W=0.65e-06
.ENDS SFFHQBX4

.SUBCKT SFFHQBX6 QB D SEL TD CK
M0 VDD SEL 3 VDD hvp L=3.0e-07 W=0.3e-06
M1 18 TD VDD VDD hvp L=3.0e-07 W=0.3e-06
M2 7 3 18 VDD hvp L=3.0e-07 W=0.3e-06
M3 4 SEL 7 VDD hvp L=3.0e-07 W=0.3e-06
M4 VDD D 4 VDD hvp L=3.0e-07 W=0.55e-06
M5 19 CK VDD VDD hvp L=3.0e-07 W=0.6e-06
M6 12 10 19 VDD hvp L=3.0e-07 W=0.6e-06
M7 VDD CK 8 VDD hvp L=3.0e-07 W=0.3e-06
M8 10 8 VDD VDD hvp L=3.0e-07 W=0.56e-06
M9 20 10 VDD VDD hvp L=3.0e-07 W=0.55e-06
M10 9 7 20 VDD hvp L=3.0e-07 W=0.55e-06
M11 21 12 9 VDD hvp L=3.0e-07 W=0.3e-06
M12 VDD 11 21 VDD hvp L=3.0e-07 W=0.3e-06
M13 11 9 VDD VDD hvp L=3.0e-07 W=0.75e-06
M14 13 12 11 VDD hvp L=3.0e-07 W=0.65e-06
M15 22 10 13 VDD hvp L=3.0e-07 W=0.28e-06
M16 VDD 14 22 VDD hvp L=3.0e-07 W=0.28e-06
M17 VDD 13 14 VDD hvp L=3.0e-07 W=0.3e-06
M18 QB 14 VDD VDD hvp L=3.0e-07 W=1e-06
M19 VDD 14 QB VDD hvp L=3.0e-07 W=1e-06
M20 QB 14 VDD VDD hvp L=3.0e-07 W=1e-06
M21 VDD 14 QB VDD hvp L=3.0e-07 W=1e-06
M22 QB 14 VDD VDD hvp L=3.0e-07 W=1e-06
M23 VDD 14 QB VDD hvp L=3.0e-07 W=1e-06
M24 GND SEL 3 GND hvn L=3.5e-07 W=0.3e-06
M25 23 TD GND GND hvn L=3.5e-07 W=0.3e-06
M26 7 SEL 23 GND hvn L=3.5e-07 W=0.3e-06
M27 4 3 7 GND hvn L=3.5e-07 W=0.3e-06
M28 GND D 4 GND hvn L=3.5e-07 W=0.28e-06
M29 12 CK GND GND hvn L=3.5e-07 W=0.28e-06
M30 GND CK 8 GND hvn L=3.5e-07 W=0.28e-06
M31 10 8 GND GND hvn L=3.5e-07 W=0.28e-06
M32 24 12 GND GND hvn L=3.5e-07 W=0.3e-06
M33 9 7 24 GND hvn L=3.5e-07 W=0.3e-06
M34 25 10 9 GND hvn L=3.5e-07 W=0.28e-06
M35 GND 11 25 GND hvn L=3.5e-07 W=0.28e-06
M36 11 9 GND GND hvn L=3.5e-07 W=0.35e-06
M37 13 10 11 GND hvn L=3.5e-07 W=0.4e-06
M38 26 12 13 GND hvn L=3.5e-07 W=0.28e-06
M39 GND 14 26 GND hvn L=3.5e-07 W=0.28e-06
M40 GND 13 14 GND hvn L=3.5e-07 W=0.28e-06
M41 QB 14 GND GND hvn L=3.5e-07 W=0.65e-06
M42 GND 14 QB GND hvn L=3.5e-07 W=0.65e-06
M43 QB 14 GND GND hvn L=3.5e-07 W=0.65e-06
M44 GND 14 QB GND hvn L=3.5e-07 W=0.65e-06
M45 QB 14 GND GND hvn L=3.5e-07 W=0.65e-06
M46 GND 14 QB GND hvn L=3.5e-07 W=0.65e-06
.ENDS SFFHQBX6

.SUBCKT SFFHQX1 Q D SEL TD CK
M0 VDD SEL 3 VDD hvp L=3.0e-07 W=0.3e-06
M1 18 TD VDD VDD hvp L=3.0e-07 W=0.3e-06
M2 7 3 18 VDD hvp L=3.0e-07 W=0.3e-06
M3 4 SEL 7 VDD hvp L=3.0e-07 W=0.3e-06
M4 VDD D 4 VDD hvp L=3.0e-07 W=0.55e-06
M5 19 CK VDD VDD hvp L=3.0e-07 W=0.6e-06
M6 12 10 19 VDD hvp L=3.0e-07 W=0.6e-06
M7 VDD CK 8 VDD hvp L=3.0e-07 W=0.3e-06
M8 10 8 VDD VDD hvp L=3.0e-07 W=0.56e-06
M9 20 10 VDD VDD hvp L=3.0e-07 W=0.55e-06
M10 9 7 20 VDD hvp L=3.0e-07 W=0.55e-06
M11 21 12 9 VDD hvp L=3.0e-07 W=0.3e-06
M12 VDD 11 21 VDD hvp L=3.0e-07 W=0.3e-06
M13 11 9 VDD VDD hvp L=3.0e-07 W=0.75e-06
M14 14 12 11 VDD hvp L=3.0e-07 W=0.65e-06
M15 22 10 14 VDD hvp L=3.0e-07 W=0.28e-06
M16 VDD 13 22 VDD hvp L=3.0e-07 W=0.28e-06
M17 VDD 14 13 VDD hvp L=3.0e-07 W=0.3e-06
M18 Q 14 VDD VDD hvp L=3.0e-07 W=1e-06
M19 GND SEL 3 GND hvn L=3.5e-07 W=0.3e-06
M20 23 TD GND GND hvn L=3.5e-07 W=0.3e-06
M21 7 SEL 23 GND hvn L=3.5e-07 W=0.3e-06
M22 4 3 7 GND hvn L=3.5e-07 W=0.3e-06
M23 GND D 4 GND hvn L=3.5e-07 W=0.28e-06
M24 12 CK GND GND hvn L=3.5e-07 W=0.28e-06
M25 GND CK 8 GND hvn L=3.5e-07 W=0.28e-06
M26 10 8 GND GND hvn L=3.5e-07 W=0.28e-06
M27 24 12 GND GND hvn L=3.5e-07 W=0.3e-06
M28 9 7 24 GND hvn L=3.5e-07 W=0.3e-06
M29 25 10 9 GND hvn L=3.5e-07 W=0.28e-06
M30 GND 11 25 GND hvn L=3.5e-07 W=0.28e-06
M31 11 9 GND GND hvn L=3.5e-07 W=0.35e-06
M32 14 10 11 GND hvn L=3.5e-07 W=0.4e-06
M33 26 12 14 GND hvn L=3.5e-07 W=0.28e-06
M34 GND 13 26 GND hvn L=3.5e-07 W=0.28e-06
M35 GND 14 13 GND hvn L=3.5e-07 W=0.28e-06
M36 Q 14 GND GND hvn L=3.5e-07 W=0.65e-06
.ENDS SFFHQX1

.SUBCKT SFFHQX2 Q D SEL TD CK
M0 VDD SEL 3 VDD hvp L=3.0e-07 W=0.3e-06
M1 18 TD VDD VDD hvp L=3.0e-07 W=0.3e-06
M2 7 3 18 VDD hvp L=3.0e-07 W=0.3e-06
M3 4 SEL 7 VDD hvp L=3.0e-07 W=0.3e-06
M4 VDD D 4 VDD hvp L=3.0e-07 W=0.55e-06
M5 19 CK VDD VDD hvp L=3.0e-07 W=0.6e-06
M6 12 10 19 VDD hvp L=3.0e-07 W=0.6e-06
M7 VDD CK 8 VDD hvp L=3.0e-07 W=0.3e-06
M8 10 8 VDD VDD hvp L=3.0e-07 W=0.56e-06
M9 20 10 VDD VDD hvp L=3.0e-07 W=0.55e-06
M10 9 7 20 VDD hvp L=3.0e-07 W=0.55e-06
M11 21 12 9 VDD hvp L=3.0e-07 W=0.3e-06
M12 VDD 11 21 VDD hvp L=3.0e-07 W=0.3e-06
M13 11 9 VDD VDD hvp L=3.0e-07 W=0.75e-06
M14 14 12 11 VDD hvp L=3.0e-07 W=0.65e-06
M15 22 10 14 VDD hvp L=3.0e-07 W=0.28e-06
M16 VDD 13 22 VDD hvp L=3.0e-07 W=0.28e-06
M17 VDD 14 13 VDD hvp L=3.0e-07 W=0.3e-06
M18 Q 14 VDD VDD hvp L=3.0e-07 W=1e-06
M19 VDD 14 Q VDD hvp L=3.0e-07 W=1e-06
M20 GND SEL 3 GND hvn L=3.5e-07 W=0.3e-06
M21 23 TD GND GND hvn L=3.5e-07 W=0.3e-06
M22 7 SEL 23 GND hvn L=3.5e-07 W=0.3e-06
M23 4 3 7 GND hvn L=3.5e-07 W=0.3e-06
M24 GND D 4 GND hvn L=3.5e-07 W=0.28e-06
M25 12 CK GND GND hvn L=3.5e-07 W=0.28e-06
M26 GND CK 8 GND hvn L=3.5e-07 W=0.28e-06
M27 10 8 GND GND hvn L=3.5e-07 W=0.28e-06
M28 24 12 GND GND hvn L=3.5e-07 W=0.3e-06
M29 9 7 24 GND hvn L=3.5e-07 W=0.3e-06
M30 25 10 9 GND hvn L=3.5e-07 W=0.28e-06
M31 GND 11 25 GND hvn L=3.5e-07 W=0.28e-06
M32 11 9 GND GND hvn L=3.5e-07 W=0.35e-06
M33 14 10 11 GND hvn L=3.5e-07 W=0.4e-06
M34 26 12 14 GND hvn L=3.5e-07 W=0.28e-06
M35 GND 13 26 GND hvn L=3.5e-07 W=0.28e-06
M36 GND 14 13 GND hvn L=3.5e-07 W=0.28e-06
M37 Q 14 GND GND hvn L=3.5e-07 W=0.65e-06
M38 GND 14 Q GND hvn L=3.5e-07 W=0.65e-06
.ENDS SFFHQX2

.SUBCKT SFFHQX4 Q D SEL TD CK
M0 VDD SEL 3 VDD hvp L=3.0e-07 W=0.3e-06
M1 18 TD VDD VDD hvp L=3.0e-07 W=0.3e-06
M2 7 3 18 VDD hvp L=3.0e-07 W=0.3e-06
M3 4 SEL 7 VDD hvp L=3.0e-07 W=0.3e-06
M4 VDD D 4 VDD hvp L=3.0e-07 W=0.55e-06
M5 19 CK VDD VDD hvp L=3.0e-07 W=0.6e-06
M6 12 10 19 VDD hvp L=3.0e-07 W=0.6e-06
M7 VDD CK 8 VDD hvp L=3.0e-07 W=0.3e-06
M8 10 8 VDD VDD hvp L=3.0e-07 W=0.56e-06
M9 20 10 VDD VDD hvp L=3.0e-07 W=0.55e-06
M10 9 7 20 VDD hvp L=3.0e-07 W=0.55e-06
M11 21 12 9 VDD hvp L=3.0e-07 W=0.3e-06
M12 VDD 11 21 VDD hvp L=3.0e-07 W=0.3e-06
M13 11 9 VDD VDD hvp L=3.0e-07 W=0.75e-06
M14 14 12 11 VDD hvp L=3.0e-07 W=0.65e-06
M15 22 10 14 VDD hvp L=3.0e-07 W=0.28e-06
M16 VDD 13 22 VDD hvp L=3.0e-07 W=0.28e-06
M17 VDD 14 13 VDD hvp L=3.0e-07 W=0.3e-06
M18 Q 14 VDD VDD hvp L=3.0e-07 W=1e-06
M19 VDD 14 Q VDD hvp L=3.0e-07 W=1e-06
M20 Q 14 VDD VDD hvp L=3.0e-07 W=1e-06
M21 VDD 14 Q VDD hvp L=3.0e-07 W=1e-06
M22 GND SEL 3 GND hvn L=3.5e-07 W=0.3e-06
M23 23 TD GND GND hvn L=3.5e-07 W=0.3e-06
M24 7 SEL 23 GND hvn L=3.5e-07 W=0.3e-06
M25 4 3 7 GND hvn L=3.5e-07 W=0.3e-06
M26 GND D 4 GND hvn L=3.5e-07 W=0.28e-06
M27 12 CK GND GND hvn L=3.5e-07 W=0.28e-06
M28 GND CK 8 GND hvn L=3.5e-07 W=0.28e-06
M29 10 8 GND GND hvn L=3.5e-07 W=0.28e-06
M30 24 12 GND GND hvn L=3.5e-07 W=0.3e-06
M31 9 7 24 GND hvn L=3.5e-07 W=0.3e-06
M32 25 10 9 GND hvn L=3.5e-07 W=0.28e-06
M33 GND 11 25 GND hvn L=3.5e-07 W=0.28e-06
M34 11 9 GND GND hvn L=3.5e-07 W=0.35e-06
M35 14 10 11 GND hvn L=3.5e-07 W=0.4e-06
M36 26 12 14 GND hvn L=3.5e-07 W=0.28e-06
M37 GND 13 26 GND hvn L=3.5e-07 W=0.28e-06
M38 GND 14 13 GND hvn L=3.5e-07 W=0.28e-06
M39 Q 14 GND GND hvn L=3.5e-07 W=0.65e-06
M40 GND 14 Q GND hvn L=3.5e-07 W=0.65e-06
M41 Q 14 GND GND hvn L=3.5e-07 W=0.65e-06
M42 GND 14 Q GND hvn L=3.5e-07 W=0.65e-06
.ENDS SFFHQX4

.SUBCKT SFFHQX6 Q D SEL TD CK
M0 VDD SEL 3 VDD hvp L=3.0e-07 W=0.3e-06
M1 18 TD VDD VDD hvp L=3.0e-07 W=0.3e-06
M2 7 3 18 VDD hvp L=3.0e-07 W=0.3e-06
M3 4 SEL 7 VDD hvp L=3.0e-07 W=0.3e-06
M4 VDD D 4 VDD hvp L=3.0e-07 W=0.55e-06
M5 19 CK VDD VDD hvp L=3.0e-07 W=0.6e-06
M6 12 10 19 VDD hvp L=3.0e-07 W=0.6e-06
M7 VDD CK 8 VDD hvp L=3.0e-07 W=0.3e-06
M8 10 8 VDD VDD hvp L=3.0e-07 W=0.56e-06
M9 20 10 VDD VDD hvp L=3.0e-07 W=0.55e-06
M10 9 7 20 VDD hvp L=3.0e-07 W=0.55e-06
M11 21 12 9 VDD hvp L=3.0e-07 W=0.3e-06
M12 VDD 11 21 VDD hvp L=3.0e-07 W=0.3e-06
M13 11 9 VDD VDD hvp L=3.0e-07 W=0.75e-06
M14 14 12 11 VDD hvp L=3.0e-07 W=0.65e-06
M15 22 10 14 VDD hvp L=3.0e-07 W=0.28e-06
M16 VDD 13 22 VDD hvp L=3.0e-07 W=0.28e-06
M17 VDD 14 13 VDD hvp L=3.0e-07 W=0.3e-06
M18 Q 14 VDD VDD hvp L=3.0e-07 W=1e-06
M19 VDD 14 Q VDD hvp L=3.0e-07 W=1e-06
M20 Q 14 VDD VDD hvp L=3.0e-07 W=1e-06
M21 VDD 14 Q VDD hvp L=3.0e-07 W=1e-06
M22 Q 14 VDD VDD hvp L=3.0e-07 W=1e-06
M23 VDD 14 Q VDD hvp L=3.0e-07 W=1e-06
M24 GND SEL 3 GND hvn L=3.5e-07 W=0.3e-06
M25 23 TD GND GND hvn L=3.5e-07 W=0.3e-06
M26 7 SEL 23 GND hvn L=3.5e-07 W=0.3e-06
M27 4 3 7 GND hvn L=3.5e-07 W=0.3e-06
M28 GND D 4 GND hvn L=3.5e-07 W=0.28e-06
M29 12 CK GND GND hvn L=3.5e-07 W=0.28e-06
M30 GND CK 8 GND hvn L=3.5e-07 W=0.28e-06
M31 10 8 GND GND hvn L=3.5e-07 W=0.28e-06
M32 24 12 GND GND hvn L=3.5e-07 W=0.3e-06
M33 9 7 24 GND hvn L=3.5e-07 W=0.3e-06
M34 25 10 9 GND hvn L=3.5e-07 W=0.28e-06
M35 GND 11 25 GND hvn L=3.5e-07 W=0.28e-06
M36 11 9 GND GND hvn L=3.5e-07 W=0.35e-06
M37 14 10 11 GND hvn L=3.5e-07 W=0.4e-06
M38 26 12 14 GND hvn L=3.5e-07 W=0.28e-06
M39 GND 13 26 GND hvn L=3.5e-07 W=0.28e-06
M40 GND 14 13 GND hvn L=3.5e-07 W=0.28e-06
M41 Q 14 GND GND hvn L=3.5e-07 W=0.65e-06
M42 GND 14 Q GND hvn L=3.5e-07 W=0.65e-06
M43 Q 14 GND GND hvn L=3.5e-07 W=0.65e-06
M44 GND 14 Q GND hvn L=3.5e-07 W=0.65e-06
M45 Q 14 GND GND hvn L=3.5e-07 W=0.65e-06
M46 GND 14 Q GND hvn L=3.5e-07 W=0.65e-06
.ENDS SFFHQX6

.SUBCKT SFFRBQBX1 QB D SEL TD RB CK
M0 VDD SEL 1 VDD hvp L=3.0e-07 W=0.3e-06
M1 3 SEL VDD VDD hvp L=3.0e-07 W=0.9e-06
M2 4 D 3 VDD hvp L=3.0e-07 W=0.9e-06
M3 5 1 4 VDD hvp L=3.0e-07 W=0.9e-06
M4 VDD TD 5 VDD hvp L=3.0e-07 W=0.9e-06
M5 6 CK VDD VDD hvp L=3.0e-07 W=0.3e-06
M6 7 6 VDD VDD hvp L=3.0e-07 W=0.6e-06
M7 8 7 4 VDD hvp L=3.0e-07 W=0.6e-06
M8 9 6 8 VDD hvp L=3.0e-07 W=0.6e-06
M9 VDD RB 9 VDD hvp L=3.0e-07 W=0.6e-06
M10 9 10 VDD VDD hvp L=3.0e-07 W=0.3e-06
M11 10 8 VDD VDD hvp L=3.0e-07 W=0.5e-06
M12 11 6 10 VDD hvp L=3.0e-07 W=0.3e-06
M13 12 7 11 VDD hvp L=3.0e-07 W=0.3e-06
M14 VDD 13 12 VDD hvp L=3.0e-07 W=0.3e-06
M15 13 RB VDD VDD hvp L=3.0e-07 W=0.3e-06
M16 VDD 11 13 VDD hvp L=3.0e-07 W=0.3e-06
M17 QB 11 VDD VDD hvp L=3.0e-07 W=1e-06
M18 GND SEL 1 GND hvn L=3.5e-07 W=0.3e-06
M19 16 1 GND GND hvn L=3.5e-07 W=0.35e-06
M20 4 D 16 GND hvn L=3.5e-07 W=0.35e-06
M21 17 SEL 4 GND hvn L=3.5e-07 W=0.35e-06
M22 GND TD 17 GND hvn L=3.5e-07 W=0.35e-06
M23 GND CK 6 GND hvn L=3.5e-07 W=0.6e-06
M24 7 6 GND GND hvn L=3.5e-07 W=0.3e-06
M25 8 6 4 GND hvn L=3.5e-07 W=0.3e-06
M26 9 7 8 GND hvn L=3.5e-07 W=0.6e-06
M27 18 RB 9 GND hvn L=3.5e-07 W=0.3e-06
M28 GND 10 18 GND hvn L=3.5e-07 W=0.3e-06
M29 10 8 GND GND hvn L=3.5e-07 W=0.3e-06
M30 11 7 10 GND hvn L=3.5e-07 W=0.3e-06
M31 19 6 11 GND hvn L=3.5e-07 W=0.3e-06
M32 GND 13 19 GND hvn L=3.5e-07 W=0.3e-06
M33 20 RB GND GND hvn L=3.5e-07 W=0.3e-06
M34 13 11 20 GND hvn L=3.5e-07 W=0.3e-06
M35 QB 11 GND GND hvn L=3.5e-07 W=0.65e-06
.ENDS SFFRBQBX1

.SUBCKT SFFRBQBX2 QB D SEL TD RB CK
M0 VDD SEL 1 VDD hvp L=3.0e-07 W=0.3e-06
M1 3 SEL VDD VDD hvp L=3.0e-07 W=0.9e-06
M2 4 D 3 VDD hvp L=3.0e-07 W=0.9e-06
M3 5 1 4 VDD hvp L=3.0e-07 W=0.9e-06
M4 VDD TD 5 VDD hvp L=3.0e-07 W=0.9e-06
M5 6 CK VDD VDD hvp L=3.0e-07 W=0.3e-06
M6 7 6 VDD VDD hvp L=3.0e-07 W=0.6e-06
M7 8 7 4 VDD hvp L=3.0e-07 W=0.6e-06
M8 9 6 8 VDD hvp L=3.0e-07 W=0.6e-06
M9 VDD RB 9 VDD hvp L=3.0e-07 W=0.6e-06
M10 9 10 VDD VDD hvp L=3.0e-07 W=0.3e-06
M11 10 8 VDD VDD hvp L=3.0e-07 W=0.5e-06
M12 11 6 10 VDD hvp L=3.0e-07 W=0.3e-06
M13 12 7 11 VDD hvp L=3.0e-07 W=0.3e-06
M14 VDD 13 12 VDD hvp L=3.0e-07 W=0.3e-06
M15 13 RB VDD VDD hvp L=3.0e-07 W=0.3e-06
M16 VDD 11 13 VDD hvp L=3.0e-07 W=0.3e-06
M17 QB 11 VDD VDD hvp L=3.0e-07 W=1e-06
M18 VDD 11 QB VDD hvp L=3.0e-07 W=1e-06
M19 GND SEL 1 GND hvn L=3.5e-07 W=0.3e-06
M20 16 1 GND GND hvn L=3.5e-07 W=0.35e-06
M21 4 D 16 GND hvn L=3.5e-07 W=0.35e-06
M22 17 SEL 4 GND hvn L=3.5e-07 W=0.35e-06
M23 GND TD 17 GND hvn L=3.5e-07 W=0.35e-06
M24 GND CK 6 GND hvn L=3.5e-07 W=0.6e-06
M25 7 6 GND GND hvn L=3.5e-07 W=0.3e-06
M26 8 6 4 GND hvn L=3.5e-07 W=0.3e-06
M27 9 7 8 GND hvn L=3.5e-07 W=0.6e-06
M28 18 RB 9 GND hvn L=3.5e-07 W=0.3e-06
M29 GND 10 18 GND hvn L=3.5e-07 W=0.3e-06
M30 10 8 GND GND hvn L=3.5e-07 W=0.3e-06
M31 11 7 10 GND hvn L=3.5e-07 W=0.3e-06
M32 19 6 11 GND hvn L=3.5e-07 W=0.3e-06
M33 GND 13 19 GND hvn L=3.5e-07 W=0.3e-06
M34 20 RB GND GND hvn L=3.5e-07 W=0.3e-06
M35 13 11 20 GND hvn L=3.5e-07 W=0.3e-06
M36 QB 11 GND GND hvn L=3.5e-07 W=0.65e-06
M37 GND 11 QB GND hvn L=3.5e-07 W=0.65e-06
.ENDS SFFRBQBX2

.SUBCKT SFFRBQBX4 QB D SEL TD RB CK
M0 VDD SEL 1 VDD hvp L=3.0e-07 W=0.3e-06
M1 3 SEL VDD VDD hvp L=3.0e-07 W=0.9e-06
M2 4 D 3 VDD hvp L=3.0e-07 W=0.9e-06
M3 5 1 4 VDD hvp L=3.0e-07 W=0.9e-06
M4 VDD TD 5 VDD hvp L=3.0e-07 W=0.9e-06
M5 6 CK VDD VDD hvp L=3.0e-07 W=0.3e-06
M6 7 6 VDD VDD hvp L=3.0e-07 W=0.6e-06
M7 8 7 4 VDD hvp L=3.0e-07 W=0.6e-06
M8 9 6 8 VDD hvp L=3.0e-07 W=0.6e-06
M9 VDD RB 9 VDD hvp L=3.0e-07 W=0.6e-06
M10 9 10 VDD VDD hvp L=3.0e-07 W=0.3e-06
M11 10 8 VDD VDD hvp L=3.0e-07 W=0.5e-06
M12 11 6 10 VDD hvp L=3.0e-07 W=0.3e-06
M13 12 7 11 VDD hvp L=3.0e-07 W=0.3e-06
M14 VDD 13 12 VDD hvp L=3.0e-07 W=0.3e-06
M15 13 RB VDD VDD hvp L=3.0e-07 W=0.3e-06
M16 VDD 11 13 VDD hvp L=3.0e-07 W=0.3e-06
M17 QB 11 VDD VDD hvp L=3.0e-07 W=1e-06
M18 VDD 11 QB VDD hvp L=3.0e-07 W=1e-06
M19 QB 11 VDD VDD hvp L=3.0e-07 W=1e-06
M20 VDD 11 QB VDD hvp L=3.0e-07 W=1e-06
M21 GND SEL 1 GND hvn L=3.5e-07 W=0.3e-06
M22 16 1 GND GND hvn L=3.5e-07 W=0.35e-06
M23 4 D 16 GND hvn L=3.5e-07 W=0.35e-06
M24 17 SEL 4 GND hvn L=3.5e-07 W=0.35e-06
M25 GND TD 17 GND hvn L=3.5e-07 W=0.35e-06
M26 GND CK 6 GND hvn L=3.5e-07 W=0.6e-06
M27 7 6 GND GND hvn L=3.5e-07 W=0.3e-06
M28 8 6 4 GND hvn L=3.5e-07 W=0.3e-06
M29 9 7 8 GND hvn L=3.5e-07 W=0.6e-06
M30 18 RB 9 GND hvn L=3.5e-07 W=0.3e-06
M31 GND 10 18 GND hvn L=3.5e-07 W=0.3e-06
M32 10 8 GND GND hvn L=3.5e-07 W=0.3e-06
M33 11 7 10 GND hvn L=3.5e-07 W=0.3e-06
M34 19 6 11 GND hvn L=3.5e-07 W=0.3e-06
M35 GND 13 19 GND hvn L=3.5e-07 W=0.3e-06
M36 20 RB GND GND hvn L=3.5e-07 W=0.3e-06
M37 13 11 20 GND hvn L=3.5e-07 W=0.3e-06
M38 QB 11 GND GND hvn L=3.5e-07 W=0.65e-06
M39 GND 11 QB GND hvn L=3.5e-07 W=0.65e-06
M40 QB 11 GND GND hvn L=3.5e-07 W=0.65e-06
M41 GND 11 QB GND hvn L=3.5e-07 W=0.65e-06
.ENDS SFFRBQBX4

.SUBCKT SFFRBQBX6 QB D SEL TD RB CK
M0 VDD SEL 1 VDD hvp L=3.0e-07 W=0.3e-06
M1 3 SEL VDD VDD hvp L=3.0e-07 W=0.9e-06
M2 4 D 3 VDD hvp L=3.0e-07 W=0.9e-06
M3 5 1 4 VDD hvp L=3.0e-07 W=0.9e-06
M4 VDD TD 5 VDD hvp L=3.0e-07 W=0.9e-06
M5 6 CK VDD VDD hvp L=3.0e-07 W=0.3e-06
M6 7 6 VDD VDD hvp L=3.0e-07 W=0.6e-06
M7 8 7 4 VDD hvp L=3.0e-07 W=0.6e-06
M8 9 6 8 VDD hvp L=3.0e-07 W=0.6e-06
M9 VDD RB 9 VDD hvp L=3.0e-07 W=0.6e-06
M10 9 10 VDD VDD hvp L=3.0e-07 W=0.3e-06
M11 10 8 VDD VDD hvp L=3.0e-07 W=0.5e-06
M12 11 6 10 VDD hvp L=3.0e-07 W=0.3e-06
M13 12 7 11 VDD hvp L=3.0e-07 W=0.3e-06
M14 VDD 13 12 VDD hvp L=3.0e-07 W=0.3e-06
M15 13 RB VDD VDD hvp L=3.0e-07 W=0.3e-06
M16 VDD 11 13 VDD hvp L=3.0e-07 W=0.3e-06
M17 QB 11 VDD VDD hvp L=3.0e-07 W=1e-06
M18 VDD 11 QB VDD hvp L=3.0e-07 W=1e-06
M19 QB 11 VDD VDD hvp L=3.0e-07 W=1e-06
M20 VDD 11 QB VDD hvp L=3.0e-07 W=1e-06
M21 QB 11 VDD VDD hvp L=3.0e-07 W=1e-06
M22 VDD 11 QB VDD hvp L=3.0e-07 W=1e-06
M23 GND SEL 1 GND hvn L=3.5e-07 W=0.3e-06
M24 16 1 GND GND hvn L=3.5e-07 W=0.35e-06
M25 4 D 16 GND hvn L=3.5e-07 W=0.35e-06
M26 17 SEL 4 GND hvn L=3.5e-07 W=0.35e-06
M27 GND TD 17 GND hvn L=3.5e-07 W=0.35e-06
M28 GND CK 6 GND hvn L=3.5e-07 W=0.6e-06
M29 7 6 GND GND hvn L=3.5e-07 W=0.3e-06
M30 8 6 4 GND hvn L=3.5e-07 W=0.3e-06
M31 9 7 8 GND hvn L=3.5e-07 W=0.6e-06
M32 18 RB 9 GND hvn L=3.5e-07 W=0.3e-06
M33 GND 10 18 GND hvn L=3.5e-07 W=0.3e-06
M34 10 8 GND GND hvn L=3.5e-07 W=0.3e-06
M35 11 7 10 GND hvn L=3.5e-07 W=0.3e-06
M36 19 6 11 GND hvn L=3.5e-07 W=0.3e-06
M37 GND 13 19 GND hvn L=3.5e-07 W=0.3e-06
M38 20 RB GND GND hvn L=3.5e-07 W=0.3e-06
M39 13 11 20 GND hvn L=3.5e-07 W=0.3e-06
M40 QB 11 GND GND hvn L=3.5e-07 W=0.65e-06
M41 GND 11 QB GND hvn L=3.5e-07 W=0.65e-06
M42 QB 11 GND GND hvn L=3.5e-07 W=0.65e-06
M43 GND 11 QB GND hvn L=3.5e-07 W=0.65e-06
M44 QB 11 GND GND hvn L=3.5e-07 W=0.65e-06
M45 GND 11 QB GND hvn L=3.5e-07 W=0.65e-06
.ENDS SFFRBQBX6

.SUBCKT SFFRBQX1 Q D SEL TD RB CK
M0 VDD SEL 1 VDD hvp L=3.0e-07 W=0.3e-06
M1 3 SEL VDD VDD hvp L=3.0e-07 W=0.9e-06
M2 4 D 3 VDD hvp L=3.0e-07 W=0.9e-06
M3 5 1 4 VDD hvp L=3.0e-07 W=0.9e-06
M4 VDD TD 5 VDD hvp L=3.0e-07 W=0.9e-06
M5 6 CK VDD VDD hvp L=3.0e-07 W=0.3e-06
M6 7 6 VDD VDD hvp L=3.0e-07 W=0.6e-06
M7 8 7 4 VDD hvp L=3.0e-07 W=0.6e-06
M8 9 6 8 VDD hvp L=3.0e-07 W=0.3e-06
M9 VDD RB 9 VDD hvp L=3.0e-07 W=0.3e-06
M10 9 10 VDD VDD hvp L=3.0e-07 W=0.3e-06
M11 10 8 VDD VDD hvp L=3.0e-07 W=0.5e-06
M12 11 6 10 VDD hvp L=3.0e-07 W=0.5e-06
M13 12 7 11 VDD hvp L=3.0e-07 W=0.3e-06
M14 VDD 13 12 VDD hvp L=3.0e-07 W=0.3e-06
M15 13 RB VDD VDD hvp L=3.0e-07 W=0.9e-06
M16 VDD 11 13 VDD hvp L=3.0e-07 W=1e-06
M17 Q 13 VDD VDD hvp L=3.0e-07 W=1e-06
M18 GND SEL 1 GND hvn L=3.5e-07 W=0.3e-06
M19 16 1 GND GND hvn L=3.5e-07 W=0.35e-06
M20 4 D 16 GND hvn L=3.5e-07 W=0.35e-06
M21 17 SEL 4 GND hvn L=3.5e-07 W=0.35e-06
M22 GND TD 17 GND hvn L=3.5e-07 W=0.35e-06
M23 GND CK 6 GND hvn L=3.5e-07 W=0.6e-06
M24 7 6 GND GND hvn L=3.5e-07 W=0.3e-06
M25 8 6 4 GND hvn L=3.5e-07 W=0.6e-06
M26 9 7 8 GND hvn L=3.5e-07 W=0.3e-06
M27 18 RB 9 GND hvn L=3.5e-07 W=0.3e-06
M28 GND 10 18 GND hvn L=3.5e-07 W=0.3e-06
M29 10 8 GND GND hvn L=3.5e-07 W=0.3e-06
M30 11 7 10 GND hvn L=3.5e-07 W=0.3e-06
M31 19 6 11 GND hvn L=3.5e-07 W=0.3e-06
M32 GND 13 19 GND hvn L=3.5e-07 W=0.3e-06
M33 20 RB GND GND hvn L=3.5e-07 W=0.55e-06
M34 13 11 20 GND hvn L=3.5e-07 W=0.55e-06
M35 Q 13 GND GND hvn L=3.5e-07 W=0.65e-06
.ENDS SFFRBQX1

.SUBCKT SFFRBQX2 Q D SEL TD RB CK
M0 VDD SEL 1 VDD hvp L=3.0e-07 W=0.3e-06
M1 3 SEL VDD VDD hvp L=3.0e-07 W=0.9e-06
M2 4 D 3 VDD hvp L=3.0e-07 W=0.9e-06
M3 5 1 4 VDD hvp L=3.0e-07 W=0.9e-06
M4 VDD TD 5 VDD hvp L=3.0e-07 W=0.9e-06
M5 6 CK VDD VDD hvp L=3.0e-07 W=0.3e-06
M6 7 6 VDD VDD hvp L=3.0e-07 W=0.6e-06
M7 8 7 4 VDD hvp L=3.0e-07 W=0.6e-06
M8 9 6 8 VDD hvp L=3.0e-07 W=0.3e-06
M9 VDD RB 9 VDD hvp L=3.0e-07 W=0.3e-06
M10 9 10 VDD VDD hvp L=3.0e-07 W=0.3e-06
M11 10 8 VDD VDD hvp L=3.0e-07 W=0.5e-06
M12 11 6 10 VDD hvp L=3.0e-07 W=0.5e-06
M13 12 7 11 VDD hvp L=3.0e-07 W=0.3e-06
M14 VDD 13 12 VDD hvp L=3.0e-07 W=0.3e-06
M15 13 RB VDD VDD hvp L=3.0e-07 W=0.9e-06
M16 VDD 11 13 VDD hvp L=3.0e-07 W=1e-06
M17 Q 13 VDD VDD hvp L=3.0e-07 W=1e-06
M18 VDD 13 Q VDD hvp L=3.0e-07 W=1e-06
M19 GND SEL 1 GND hvn L=3.5e-07 W=0.3e-06
M20 16 1 GND GND hvn L=3.5e-07 W=0.35e-06
M21 4 D 16 GND hvn L=3.5e-07 W=0.35e-06
M22 17 SEL 4 GND hvn L=3.5e-07 W=0.35e-06
M23 GND TD 17 GND hvn L=3.5e-07 W=0.35e-06
M24 GND CK 6 GND hvn L=3.5e-07 W=0.6e-06
M25 7 6 GND GND hvn L=3.5e-07 W=0.3e-06
M26 8 6 4 GND hvn L=3.5e-07 W=0.6e-06
M27 9 7 8 GND hvn L=3.5e-07 W=0.3e-06
M28 18 RB 9 GND hvn L=3.5e-07 W=0.3e-06
M29 GND 10 18 GND hvn L=3.5e-07 W=0.3e-06
M30 10 8 GND GND hvn L=3.5e-07 W=0.3e-06
M31 11 7 10 GND hvn L=3.5e-07 W=0.3e-06
M32 19 6 11 GND hvn L=3.5e-07 W=0.3e-06
M33 GND 13 19 GND hvn L=3.5e-07 W=0.3e-06
M34 20 RB GND GND hvn L=3.5e-07 W=0.55e-06
M35 13 11 20 GND hvn L=3.5e-07 W=0.55e-06
M36 Q 13 GND GND hvn L=3.5e-07 W=0.65e-06
M37 GND 13 Q GND hvn L=3.5e-07 W=0.65e-06
.ENDS SFFRBQX2

.SUBCKT SFFRBQX4 Q D SEL TD RB CK
M0 VDD SEL 1 VDD hvp L=3.0e-07 W=0.3e-06
M1 3 SEL VDD VDD hvp L=3.0e-07 W=0.9e-06
M2 4 D 3 VDD hvp L=3.0e-07 W=0.9e-06
M3 5 1 4 VDD hvp L=3.0e-07 W=0.9e-06
M4 VDD TD 5 VDD hvp L=3.0e-07 W=0.9e-06
M5 6 CK VDD VDD hvp L=3.0e-07 W=0.3e-06
M6 7 6 VDD VDD hvp L=3.0e-07 W=0.6e-06
M7 8 7 4 VDD hvp L=3.0e-07 W=0.6e-06
M8 9 6 8 VDD hvp L=3.0e-07 W=0.3e-06
M9 VDD RB 9 VDD hvp L=3.0e-07 W=0.3e-06
M10 9 10 VDD VDD hvp L=3.0e-07 W=0.3e-06
M11 10 8 VDD VDD hvp L=3.0e-07 W=0.5e-06
M12 11 6 10 VDD hvp L=3.0e-07 W=0.5e-06
M13 12 7 11 VDD hvp L=3.0e-07 W=0.3e-06
M14 VDD 13 12 VDD hvp L=3.0e-07 W=0.3e-06
M15 13 RB VDD VDD hvp L=3.0e-07 W=0.9e-06
M16 VDD 11 13 VDD hvp L=3.0e-07 W=1e-06
M17 Q 13 VDD VDD hvp L=3.0e-07 W=1e-06
M18 VDD 13 Q VDD hvp L=3.0e-07 W=1e-06
M19 Q 13 VDD VDD hvp L=3.0e-07 W=1e-06
M20 VDD 13 Q VDD hvp L=3.0e-07 W=1e-06
M21 GND SEL 1 GND hvn L=3.5e-07 W=0.3e-06
M22 16 1 GND GND hvn L=3.5e-07 W=0.35e-06
M23 4 D 16 GND hvn L=3.5e-07 W=0.35e-06
M24 17 SEL 4 GND hvn L=3.5e-07 W=0.35e-06
M25 GND TD 17 GND hvn L=3.5e-07 W=0.35e-06
M26 GND CK 6 GND hvn L=3.5e-07 W=0.6e-06
M27 7 6 GND GND hvn L=3.5e-07 W=0.3e-06
M28 8 6 4 GND hvn L=3.5e-07 W=0.6e-06
M29 9 7 8 GND hvn L=3.5e-07 W=0.3e-06
M30 18 RB 9 GND hvn L=3.5e-07 W=0.3e-06
M31 GND 10 18 GND hvn L=3.5e-07 W=0.3e-06
M32 10 8 GND GND hvn L=3.5e-07 W=0.3e-06
M33 11 7 10 GND hvn L=3.5e-07 W=0.3e-06
M34 19 6 11 GND hvn L=3.5e-07 W=0.3e-06
M35 GND 13 19 GND hvn L=3.5e-07 W=0.3e-06
M36 20 RB GND GND hvn L=3.5e-07 W=0.55e-06
M37 13 11 20 GND hvn L=3.5e-07 W=0.55e-06
M38 Q 13 GND GND hvn L=3.5e-07 W=0.65e-06
M39 GND 13 Q GND hvn L=3.5e-07 W=0.65e-06
M40 Q 13 GND GND hvn L=3.5e-07 W=0.65e-06
M41 GND 13 Q GND hvn L=3.5e-07 W=0.65e-06
.ENDS SFFRBQX4

.SUBCKT SFFRBQX6 Q D SEL TD RB CK
M0 VDD SEL 1 VDD hvp L=3.0e-07 W=0.3e-06
M1 3 SEL VDD VDD hvp L=3.0e-07 W=0.9e-06
M2 4 D 3 VDD hvp L=3.0e-07 W=0.9e-06
M3 5 1 4 VDD hvp L=3.0e-07 W=0.9e-06
M4 VDD TD 5 VDD hvp L=3.0e-07 W=0.9e-06
M5 6 CK VDD VDD hvp L=3.0e-07 W=0.3e-06
M6 7 6 VDD VDD hvp L=3.0e-07 W=0.6e-06
M7 8 7 4 VDD hvp L=3.0e-07 W=0.6e-06
M8 9 6 8 VDD hvp L=3.0e-07 W=0.3e-06
M9 VDD RB 9 VDD hvp L=3.0e-07 W=0.3e-06
M10 9 10 VDD VDD hvp L=3.0e-07 W=0.3e-06
M11 10 8 VDD VDD hvp L=3.0e-07 W=0.5e-06
M12 11 6 10 VDD hvp L=3.0e-07 W=0.5e-06
M13 12 7 11 VDD hvp L=3.0e-07 W=0.3e-06
M14 VDD 13 12 VDD hvp L=3.0e-07 W=0.3e-06
M15 13 RB VDD VDD hvp L=3.0e-07 W=0.9e-06
M16 VDD 11 13 VDD hvp L=3.0e-07 W=1e-06
M17 Q 13 VDD VDD hvp L=3.0e-07 W=1e-06
M18 VDD 13 Q VDD hvp L=3.0e-07 W=1e-06
M19 Q 13 VDD VDD hvp L=3.0e-07 W=1e-06
M20 VDD 13 Q VDD hvp L=3.0e-07 W=1e-06
M21 Q 13 VDD VDD hvp L=3.0e-07 W=1e-06
M22 VDD 13 Q VDD hvp L=3.0e-07 W=1e-06
M23 GND SEL 1 GND hvn L=3.5e-07 W=0.3e-06
M24 16 1 GND GND hvn L=3.5e-07 W=0.35e-06
M25 4 D 16 GND hvn L=3.5e-07 W=0.35e-06
M26 17 SEL 4 GND hvn L=3.5e-07 W=0.35e-06
M27 GND TD 17 GND hvn L=3.5e-07 W=0.35e-06
M28 GND CK 6 GND hvn L=3.5e-07 W=0.6e-06
M29 7 6 GND GND hvn L=3.5e-07 W=0.3e-06
M30 8 6 4 GND hvn L=3.5e-07 W=0.6e-06
M31 9 7 8 GND hvn L=3.5e-07 W=0.3e-06
M32 18 RB 9 GND hvn L=3.5e-07 W=0.3e-06
M33 GND 10 18 GND hvn L=3.5e-07 W=0.3e-06
M34 10 8 GND GND hvn L=3.5e-07 W=0.3e-06
M35 11 7 10 GND hvn L=3.5e-07 W=0.3e-06
M36 19 6 11 GND hvn L=3.5e-07 W=0.3e-06
M37 GND 13 19 GND hvn L=3.5e-07 W=0.3e-06
M38 20 RB GND GND hvn L=3.5e-07 W=0.55e-06
M39 13 11 20 GND hvn L=3.5e-07 W=0.55e-06
M40 Q 13 GND GND hvn L=3.5e-07 W=0.65e-06
M41 GND 13 Q GND hvn L=3.5e-07 W=0.65e-06
M42 Q 13 GND GND hvn L=3.5e-07 W=0.65e-06
M43 GND 13 Q GND hvn L=3.5e-07 W=0.65e-06
M44 Q 13 GND GND hvn L=3.5e-07 W=0.65e-06
M45 GND 13 Q GND hvn L=3.5e-07 W=0.65e-06
.ENDS SFFRBQX6

.SUBCKT SFFRSBQBX1 QB D SEL TD RB SB CK
M0 VDD SEL 1 VDD hvp L=3.0e-07 W=0.3e-06
M1 3 SEL VDD VDD hvp L=3.0e-07 W=0.75e-06
M2 4 D 3 VDD hvp L=3.0e-07 W=0.75e-06
M3 5 1 4 VDD hvp L=3.0e-07 W=0.75e-06
M4 VDD TD 5 VDD hvp L=3.0e-07 W=0.75e-06
M5 6 CK VDD VDD hvp L=3.0e-07 W=0.3e-06
M6 7 6 VDD VDD hvp L=3.0e-07 W=0.6e-06
M7 8 7 4 VDD hvp L=3.0e-07 W=0.6e-06
M8 9 6 8 VDD hvp L=3.0e-07 W=0.3e-06
M9 VDD RB 9 VDD hvp L=3.0e-07 W=0.3e-06
M10 9 10 VDD VDD hvp L=3.0e-07 W=0.3e-06
M11 VDD 8 10 VDD hvp L=3.0e-07 W=0.45e-06
M12 10 SB VDD VDD hvp L=3.0e-07 W=0.4e-06
M13 11 6 10 VDD hvp L=3.0e-07 W=0.4e-06
M14 12 7 11 VDD hvp L=3.0e-07 W=0.3e-06
M15 VDD SB 12 VDD hvp L=3.0e-07 W=0.3e-06
M16 12 13 VDD VDD hvp L=3.0e-07 W=0.28e-06
M17 13 RB VDD VDD hvp L=3.0e-07 W=0.3e-06
M18 VDD 11 13 VDD hvp L=3.0e-07 W=0.3e-06
M19 QB 11 VDD VDD hvp L=3.0e-07 W=1e-06
M20 GND SEL 1 GND hvn L=3.5e-07 W=0.3e-06
M21 16 1 GND GND hvn L=3.5e-07 W=0.35e-06
M22 4 D 16 GND hvn L=3.5e-07 W=0.35e-06
M23 17 SEL 4 GND hvn L=3.5e-07 W=0.35e-06
M24 GND TD 17 GND hvn L=3.5e-07 W=0.35e-06
M25 GND CK 6 GND hvn L=3.5e-07 W=0.6e-06
M26 7 6 GND GND hvn L=3.5e-07 W=0.3e-06
M27 8 6 4 GND hvn L=3.5e-07 W=0.6e-06
M28 9 7 8 GND hvn L=3.5e-07 W=0.3e-06
M29 18 RB 9 GND hvn L=3.5e-07 W=0.3e-06
M30 GND 10 18 GND hvn L=3.5e-07 W=0.3e-06
M31 19 8 GND GND hvn L=3.5e-07 W=0.3e-06
M32 10 SB 19 GND hvn L=3.5e-07 W=0.3e-06
M33 11 7 10 GND hvn L=3.5e-07 W=0.28e-06
M34 12 6 11 GND hvn L=3.5e-07 W=0.28e-06
M35 20 SB 12 GND hvn L=3.5e-07 W=0.3e-06
M36 GND 13 20 GND hvn L=3.5e-07 W=0.3e-06
M37 21 RB GND GND hvn L=3.5e-07 W=0.3e-06
M38 13 11 21 GND hvn L=3.5e-07 W=0.3e-06
M39 QB 11 GND GND hvn L=3.5e-07 W=0.65e-06
.ENDS SFFRSBQBX1

.SUBCKT SFFRSBQBX2 QB D SEL TD RB SB CK
M0 VDD SEL 1 VDD hvp L=3.0e-07 W=0.3e-06
M1 3 SEL VDD VDD hvp L=3.0e-07 W=0.75e-06
M2 4 D 3 VDD hvp L=3.0e-07 W=0.75e-06
M3 5 1 4 VDD hvp L=3.0e-07 W=0.75e-06
M4 VDD TD 5 VDD hvp L=3.0e-07 W=0.75e-06
M5 6 CK VDD VDD hvp L=3.0e-07 W=0.3e-06
M6 7 6 VDD VDD hvp L=3.0e-07 W=0.6e-06
M7 8 7 4 VDD hvp L=3.0e-07 W=0.6e-06
M8 9 6 8 VDD hvp L=3.0e-07 W=0.3e-06
M9 VDD RB 9 VDD hvp L=3.0e-07 W=0.3e-06
M10 9 10 VDD VDD hvp L=3.0e-07 W=0.3e-06
M11 VDD 8 10 VDD hvp L=3.0e-07 W=0.45e-06
M12 10 SB VDD VDD hvp L=3.0e-07 W=0.4e-06
M13 11 6 10 VDD hvp L=3.0e-07 W=0.4e-06
M14 12 7 11 VDD hvp L=3.0e-07 W=0.3e-06
M15 VDD SB 12 VDD hvp L=3.0e-07 W=0.3e-06
M16 12 13 VDD VDD hvp L=3.0e-07 W=0.28e-06
M17 13 RB VDD VDD hvp L=3.0e-07 W=0.3e-06
M18 VDD 11 13 VDD hvp L=3.0e-07 W=0.3e-06
M19 QB 11 VDD VDD hvp L=3.0e-07 W=1e-06
M20 VDD 11 QB VDD hvp L=3.0e-07 W=1e-06
M21 GND SEL 1 GND hvn L=3.5e-07 W=0.3e-06
M22 16 1 GND GND hvn L=3.5e-07 W=0.35e-06
M23 4 D 16 GND hvn L=3.5e-07 W=0.35e-06
M24 17 SEL 4 GND hvn L=3.5e-07 W=0.35e-06
M25 GND TD 17 GND hvn L=3.5e-07 W=0.35e-06
M26 GND CK 6 GND hvn L=3.5e-07 W=0.6e-06
M27 7 6 GND GND hvn L=3.5e-07 W=0.3e-06
M28 8 6 4 GND hvn L=3.5e-07 W=0.6e-06
M29 9 7 8 GND hvn L=3.5e-07 W=0.3e-06
M30 18 RB 9 GND hvn L=3.5e-07 W=0.3e-06
M31 GND 10 18 GND hvn L=3.5e-07 W=0.3e-06
M32 19 8 GND GND hvn L=3.5e-07 W=0.3e-06
M33 10 SB 19 GND hvn L=3.5e-07 W=0.3e-06
M34 11 7 10 GND hvn L=3.5e-07 W=0.28e-06
M35 12 6 11 GND hvn L=3.5e-07 W=0.28e-06
M36 20 SB 12 GND hvn L=3.5e-07 W=0.3e-06
M37 GND 13 20 GND hvn L=3.5e-07 W=0.3e-06
M38 21 RB GND GND hvn L=3.5e-07 W=0.3e-06
M39 13 11 21 GND hvn L=3.5e-07 W=0.3e-06
M40 QB 11 GND GND hvn L=3.5e-07 W=0.65e-06
M41 GND 11 QB GND hvn L=3.5e-07 W=0.65e-06
.ENDS SFFRSBQBX2

.SUBCKT SFFRSBQBX4 QB D SEL TD RB SB CK
M0 VDD SEL 1 VDD hvp L=3.0e-07 W=0.3e-06
M1 3 SEL VDD VDD hvp L=3.0e-07 W=0.75e-06
M2 4 D 3 VDD hvp L=3.0e-07 W=0.75e-06
M3 5 1 4 VDD hvp L=3.0e-07 W=0.75e-06
M4 VDD TD 5 VDD hvp L=3.0e-07 W=0.75e-06
M5 6 CK VDD VDD hvp L=3.0e-07 W=0.3e-06
M6 7 6 VDD VDD hvp L=3.0e-07 W=0.6e-06
M7 8 7 4 VDD hvp L=3.0e-07 W=0.6e-06
M8 9 6 8 VDD hvp L=3.0e-07 W=0.3e-06
M9 VDD RB 9 VDD hvp L=3.0e-07 W=0.3e-06
M10 9 10 VDD VDD hvp L=3.0e-07 W=0.3e-06
M11 VDD 8 10 VDD hvp L=3.0e-07 W=0.45e-06
M12 10 SB VDD VDD hvp L=3.0e-07 W=0.4e-06
M13 11 6 10 VDD hvp L=3.0e-07 W=0.4e-06
M14 12 7 11 VDD hvp L=3.0e-07 W=0.3e-06
M15 VDD SB 12 VDD hvp L=3.0e-07 W=0.3e-06
M16 12 13 VDD VDD hvp L=3.0e-07 W=0.28e-06
M17 13 RB VDD VDD hvp L=3.0e-07 W=0.3e-06
M18 VDD 11 13 VDD hvp L=3.0e-07 W=0.3e-06
M19 QB 11 VDD VDD hvp L=3.0e-07 W=1e-06
M20 VDD 11 QB VDD hvp L=3.0e-07 W=1e-06
M21 QB 11 VDD VDD hvp L=3.0e-07 W=1e-06
M22 VDD 11 QB VDD hvp L=3.0e-07 W=1e-06
M23 GND SEL 1 GND hvn L=3.5e-07 W=0.3e-06
M24 16 1 GND GND hvn L=3.5e-07 W=0.35e-06
M25 4 D 16 GND hvn L=3.5e-07 W=0.35e-06
M26 17 SEL 4 GND hvn L=3.5e-07 W=0.35e-06
M27 GND TD 17 GND hvn L=3.5e-07 W=0.35e-06
M28 GND CK 6 GND hvn L=3.5e-07 W=0.6e-06
M29 7 6 GND GND hvn L=3.5e-07 W=0.3e-06
M30 8 6 4 GND hvn L=3.5e-07 W=0.6e-06
M31 9 7 8 GND hvn L=3.5e-07 W=0.3e-06
M32 18 RB 9 GND hvn L=3.5e-07 W=0.3e-06
M33 GND 10 18 GND hvn L=3.5e-07 W=0.3e-06
M34 19 8 GND GND hvn L=3.5e-07 W=0.3e-06
M35 10 SB 19 GND hvn L=3.5e-07 W=0.3e-06
M36 11 7 10 GND hvn L=3.5e-07 W=0.28e-06
M37 12 6 11 GND hvn L=3.5e-07 W=0.28e-06
M38 20 SB 12 GND hvn L=3.5e-07 W=0.3e-06
M39 GND 13 20 GND hvn L=3.5e-07 W=0.3e-06
M40 21 RB GND GND hvn L=3.5e-07 W=0.3e-06
M41 13 11 21 GND hvn L=3.5e-07 W=0.3e-06
M42 QB 11 GND GND hvn L=3.5e-07 W=0.65e-06
M43 GND 11 QB GND hvn L=3.5e-07 W=0.65e-06
M44 QB 11 GND GND hvn L=3.5e-07 W=0.65e-06
M45 GND 11 QB GND hvn L=3.5e-07 W=0.65e-06
.ENDS SFFRSBQBX4

.SUBCKT SFFRSBQX1 Q D SEL TD RB SB CK
M0 VDD SEL 1 VDD hvp L=3.0e-07 W=0.3e-06
M1 3 SEL VDD VDD hvp L=3.0e-07 W=0.75e-06
M2 4 D 3 VDD hvp L=3.0e-07 W=0.75e-06
M3 5 1 4 VDD hvp L=3.0e-07 W=0.75e-06
M4 VDD TD 5 VDD hvp L=3.0e-07 W=0.75e-06
M5 6 CK VDD VDD hvp L=3.0e-07 W=0.3e-06
M6 7 6 VDD VDD hvp L=3.0e-07 W=0.3e-06
M7 8 7 4 VDD hvp L=3.0e-07 W=0.6e-06
M8 9 6 8 VDD hvp L=3.0e-07 W=0.4e-06
M9 VDD RB 9 VDD hvp L=3.0e-07 W=0.6e-06
M10 9 10 VDD VDD hvp L=3.0e-07 W=0.3e-06
M11 VDD 8 10 VDD hvp L=3.0e-07 W=0.45e-06
M12 10 SB VDD VDD hvp L=3.0e-07 W=0.4e-06
M13 11 6 10 VDD hvp L=3.0e-07 W=0.4e-06
M14 12 7 11 VDD hvp L=3.0e-07 W=0.3e-06
M15 VDD SB 12 VDD hvp L=3.0e-07 W=0.3e-06
M16 12 13 VDD VDD hvp L=3.0e-07 W=0.28e-06
M17 13 RB VDD VDD hvp L=3.0e-07 W=0.75e-06
M18 VDD 11 13 VDD hvp L=3.0e-07 W=0.75e-06
M19 Q 13 VDD VDD hvp L=3.0e-07 W=1e-06
M20 GND SEL 1 GND hvn L=3.5e-07 W=0.3e-06
M21 16 1 GND GND hvn L=3.5e-07 W=0.35e-06
M22 4 D 16 GND hvn L=3.5e-07 W=0.35e-06
M23 17 SEL 4 GND hvn L=3.5e-07 W=0.35e-06
M24 GND TD 17 GND hvn L=3.5e-07 W=0.35e-06
M25 GND CK 6 GND hvn L=3.5e-07 W=0.3e-06
M26 7 6 GND GND hvn L=3.5e-07 W=0.3e-06
M27 8 6 4 GND hvn L=3.5e-07 W=0.3e-06
M28 9 7 8 GND hvn L=3.5e-07 W=0.3e-06
M29 18 RB 9 GND hvn L=3.5e-07 W=0.3e-06
M30 GND 10 18 GND hvn L=3.5e-07 W=0.3e-06
M31 19 8 GND GND hvn L=3.5e-07 W=0.3e-06
M32 10 SB 19 GND hvn L=3.5e-07 W=0.3e-06
M33 11 7 10 GND hvn L=3.5e-07 W=0.28e-06
M34 12 6 11 GND hvn L=3.5e-07 W=0.28e-06
M35 20 SB 12 GND hvn L=3.5e-07 W=0.3e-06
M36 GND 13 20 GND hvn L=3.5e-07 W=0.3e-06
M37 21 RB GND GND hvn L=3.5e-07 W=0.44e-06
M38 13 11 21 GND hvn L=3.5e-07 W=0.44e-06
M39 Q 13 GND GND hvn L=3.5e-07 W=0.65e-06
.ENDS SFFRSBQX1

.SUBCKT SFFRSBQX2 Q D SEL TD RB SB CK
M0 VDD SEL 1 VDD hvp L=3.0e-07 W=0.3e-06
M1 3 SEL VDD VDD hvp L=3.0e-07 W=0.75e-06
M2 4 D 3 VDD hvp L=3.0e-07 W=0.75e-06
M3 5 1 4 VDD hvp L=3.0e-07 W=0.75e-06
M4 VDD TD 5 VDD hvp L=3.0e-07 W=0.75e-06
M5 6 CK VDD VDD hvp L=3.0e-07 W=0.3e-06
M6 7 6 VDD VDD hvp L=3.0e-07 W=0.3e-06
M7 8 7 4 VDD hvp L=3.0e-07 W=0.6e-06
M8 9 6 8 VDD hvp L=3.0e-07 W=0.4e-06
M9 VDD RB 9 VDD hvp L=3.0e-07 W=0.6e-06
M10 9 10 VDD VDD hvp L=3.0e-07 W=0.3e-06
M11 VDD 8 10 VDD hvp L=3.0e-07 W=0.45e-06
M12 10 SB VDD VDD hvp L=3.0e-07 W=0.4e-06
M13 11 6 10 VDD hvp L=3.0e-07 W=0.4e-06
M14 12 7 11 VDD hvp L=3.0e-07 W=0.3e-06
M15 VDD SB 12 VDD hvp L=3.0e-07 W=0.3e-06
M16 12 13 VDD VDD hvp L=3.0e-07 W=0.28e-06
M17 13 RB VDD VDD hvp L=3.0e-07 W=0.75e-06
M18 VDD 11 13 VDD hvp L=3.0e-07 W=0.75e-06
M19 Q 13 VDD VDD hvp L=3.0e-07 W=1e-06
M20 VDD 13 Q VDD hvp L=3.0e-07 W=1e-06
M21 GND SEL 1 GND hvn L=3.5e-07 W=0.3e-06
M22 16 1 GND GND hvn L=3.5e-07 W=0.35e-06
M23 4 D 16 GND hvn L=3.5e-07 W=0.35e-06
M24 17 SEL 4 GND hvn L=3.5e-07 W=0.35e-06
M25 GND TD 17 GND hvn L=3.5e-07 W=0.35e-06
M26 GND CK 6 GND hvn L=3.5e-07 W=0.3e-06
M27 7 6 GND GND hvn L=3.5e-07 W=0.3e-06
M28 8 6 4 GND hvn L=3.5e-07 W=0.3e-06
M29 9 7 8 GND hvn L=3.5e-07 W=0.3e-06
M30 18 RB 9 GND hvn L=3.5e-07 W=0.3e-06
M31 GND 10 18 GND hvn L=3.5e-07 W=0.3e-06
M32 19 8 GND GND hvn L=3.5e-07 W=0.3e-06
M33 10 SB 19 GND hvn L=3.5e-07 W=0.3e-06
M34 11 7 10 GND hvn L=3.5e-07 W=0.28e-06
M35 12 6 11 GND hvn L=3.5e-07 W=0.28e-06
M36 20 SB 12 GND hvn L=3.5e-07 W=0.3e-06
M37 GND 13 20 GND hvn L=3.5e-07 W=0.3e-06
M38 21 RB GND GND hvn L=3.5e-07 W=0.44e-06
M39 13 11 21 GND hvn L=3.5e-07 W=0.44e-06
M40 Q 13 GND GND hvn L=3.5e-07 W=0.65e-06
M41 GND 13 Q GND hvn L=3.5e-07 W=0.65e-06
.ENDS SFFRSBQX2

.SUBCKT SFFRSBQX4 Q D SEL TD RB SB CK
M0 VDD SEL 1 VDD hvp L=3.0e-07 W=0.3e-06
M1 3 SEL VDD VDD hvp L=3.0e-07 W=0.75e-06
M2 4 D 3 VDD hvp L=3.0e-07 W=0.75e-06
M3 5 1 4 VDD hvp L=3.0e-07 W=0.75e-06
M4 VDD TD 5 VDD hvp L=3.0e-07 W=0.75e-06
M5 6 CK VDD VDD hvp L=3.0e-07 W=0.3e-06
M6 7 6 VDD VDD hvp L=3.0e-07 W=0.3e-06
M7 8 7 4 VDD hvp L=3.0e-07 W=0.6e-06
M8 9 6 8 VDD hvp L=3.0e-07 W=0.4e-06
M9 VDD RB 9 VDD hvp L=3.0e-07 W=0.6e-06
M10 9 10 VDD VDD hvp L=3.0e-07 W=0.3e-06
M11 VDD 8 10 VDD hvp L=3.0e-07 W=0.45e-06
M12 10 SB VDD VDD hvp L=3.0e-07 W=0.4e-06
M13 11 6 10 VDD hvp L=3.0e-07 W=0.4e-06
M14 12 7 11 VDD hvp L=3.0e-07 W=0.3e-06
M15 VDD SB 12 VDD hvp L=3.0e-07 W=0.3e-06
M16 12 13 VDD VDD hvp L=3.0e-07 W=0.28e-06
M17 13 RB VDD VDD hvp L=3.0e-07 W=0.75e-06
M18 VDD 11 13 VDD hvp L=3.0e-07 W=0.75e-06
M19 Q 13 VDD VDD hvp L=3.0e-07 W=1e-06
M20 VDD 13 Q VDD hvp L=3.0e-07 W=1e-06
M21 Q 13 VDD VDD hvp L=3.0e-07 W=1e-06
M22 VDD 13 Q VDD hvp L=3.0e-07 W=1e-06
M23 GND SEL 1 GND hvn L=3.5e-07 W=0.3e-06
M24 16 1 GND GND hvn L=3.5e-07 W=0.35e-06
M25 4 D 16 GND hvn L=3.5e-07 W=0.35e-06
M26 17 SEL 4 GND hvn L=3.5e-07 W=0.35e-06
M27 GND TD 17 GND hvn L=3.5e-07 W=0.35e-06
M28 GND CK 6 GND hvn L=3.5e-07 W=0.3e-06
M29 7 6 GND GND hvn L=3.5e-07 W=0.3e-06
M30 8 6 4 GND hvn L=3.5e-07 W=0.3e-06
M31 9 7 8 GND hvn L=3.5e-07 W=0.3e-06
M32 18 RB 9 GND hvn L=3.5e-07 W=0.3e-06
M33 GND 10 18 GND hvn L=3.5e-07 W=0.3e-06
M34 19 8 GND GND hvn L=3.5e-07 W=0.3e-06
M35 10 SB 19 GND hvn L=3.5e-07 W=0.3e-06
M36 11 7 10 GND hvn L=3.5e-07 W=0.28e-06
M37 12 6 11 GND hvn L=3.5e-07 W=0.28e-06
M38 20 SB 12 GND hvn L=3.5e-07 W=0.3e-06
M39 GND 13 20 GND hvn L=3.5e-07 W=0.3e-06
M40 21 RB GND GND hvn L=3.5e-07 W=0.44e-06
M41 13 11 21 GND hvn L=3.5e-07 W=0.44e-06
M42 Q 13 GND GND hvn L=3.5e-07 W=0.65e-06
M43 GND 13 Q GND hvn L=3.5e-07 W=0.65e-06
M44 Q 13 GND GND hvn L=3.5e-07 W=0.65e-06
M45 GND 13 Q GND hvn L=3.5e-07 W=0.65e-06
.ENDS SFFRSBQX4

.SUBCKT SFFSBQBX1 QB D SEL TD SB CK
M0 VDD SEL 1 VDD hvp L=3.0e-07 W=0.3e-06
M1 3 SEL VDD VDD hvp L=3.0e-07 W=0.75e-06
M2 4 D 3 VDD hvp L=3.0e-07 W=0.75e-06
M3 5 1 4 VDD hvp L=3.0e-07 W=0.75e-06
M4 VDD TD 5 VDD hvp L=3.0e-07 W=0.75e-06
M5 6 CK VDD VDD hvp L=3.0e-07 W=0.3e-06
M6 7 6 VDD VDD hvp L=3.0e-07 W=0.6e-06
M7 8 7 4 VDD hvp L=3.0e-07 W=0.6e-06
M8 9 6 8 VDD hvp L=3.0e-07 W=0.3e-06
M9 VDD 10 9 VDD hvp L=3.0e-07 W=0.3e-06
M10 VDD 8 10 VDD hvp L=3.0e-07 W=0.6e-06
M11 10 SB VDD VDD hvp L=3.0e-07 W=0.45e-06
M12 11 6 10 VDD hvp L=3.0e-07 W=0.45e-06
M13 12 7 11 VDD hvp L=3.0e-07 W=0.3e-06
M14 VDD SB 12 VDD hvp L=3.0e-07 W=0.3e-06
M15 VDD 13 12 VDD hvp L=3.0e-07 W=0.3e-06
M16 VDD 11 13 VDD hvp L=3.0e-07 W=0.3e-06
M17 QB 11 VDD VDD hvp L=3.0e-07 W=1e-06
M18 GND SEL 1 GND hvn L=3.5e-07 W=0.3e-06
M19 16 1 GND GND hvn L=3.5e-07 W=0.35e-06
M20 4 D 16 GND hvn L=3.5e-07 W=0.35e-06
M21 17 SEL 4 GND hvn L=3.5e-07 W=0.35e-06
M22 GND TD 17 GND hvn L=3.5e-07 W=0.35e-06
M23 GND CK 6 GND hvn L=3.5e-07 W=0.6e-06
M24 7 6 GND GND hvn L=3.5e-07 W=0.3e-06
M25 8 6 4 GND hvn L=3.5e-07 W=0.6e-06
M26 18 7 8 GND hvn L=3.5e-07 W=0.3e-06
M27 GND 10 18 GND hvn L=3.5e-07 W=0.3e-06
M28 19 8 GND GND hvn L=3.5e-07 W=0.3e-06
M29 10 SB 19 GND hvn L=3.5e-07 W=0.3e-06
M30 11 7 10 GND hvn L=3.5e-07 W=0.3e-06
M31 12 6 11 GND hvn L=3.5e-07 W=0.3e-06
M32 20 SB 12 GND hvn L=3.5e-07 W=0.3e-06
M33 GND 13 20 GND hvn L=3.5e-07 W=0.3e-06
M34 13 11 GND GND hvn L=3.5e-07 W=0.3e-06
M35 QB 11 GND GND hvn L=3.5e-07 W=0.65e-06
.ENDS SFFSBQBX1

.SUBCKT SFFSBQBX2 QB D SEL TD SB CK
M0 VDD SEL 1 VDD hvp L=3.0e-07 W=0.3e-06
M1 3 SEL VDD VDD hvp L=3.0e-07 W=0.75e-06
M2 4 D 3 VDD hvp L=3.0e-07 W=0.75e-06
M3 5 1 4 VDD hvp L=3.0e-07 W=0.75e-06
M4 VDD TD 5 VDD hvp L=3.0e-07 W=0.75e-06
M5 6 CK VDD VDD hvp L=3.0e-07 W=0.3e-06
M6 7 6 VDD VDD hvp L=3.0e-07 W=0.6e-06
M7 8 7 4 VDD hvp L=3.0e-07 W=0.6e-06
M8 9 6 8 VDD hvp L=3.0e-07 W=0.3e-06
M9 VDD 10 9 VDD hvp L=3.0e-07 W=0.3e-06
M10 VDD 8 10 VDD hvp L=3.0e-07 W=0.6e-06
M11 10 SB VDD VDD hvp L=3.0e-07 W=0.45e-06
M12 11 6 10 VDD hvp L=3.0e-07 W=0.45e-06
M13 12 7 11 VDD hvp L=3.0e-07 W=0.3e-06
M14 VDD SB 12 VDD hvp L=3.0e-07 W=0.3e-06
M15 VDD 13 12 VDD hvp L=3.0e-07 W=0.3e-06
M16 VDD 11 13 VDD hvp L=3.0e-07 W=0.3e-06
M17 QB 11 VDD VDD hvp L=3.0e-07 W=1e-06
M18 VDD 11 QB VDD hvp L=3.0e-07 W=1e-06
M19 GND SEL 1 GND hvn L=3.5e-07 W=0.3e-06
M20 16 1 GND GND hvn L=3.5e-07 W=0.35e-06
M21 4 D 16 GND hvn L=3.5e-07 W=0.35e-06
M22 17 SEL 4 GND hvn L=3.5e-07 W=0.35e-06
M23 GND TD 17 GND hvn L=3.5e-07 W=0.35e-06
M24 GND CK 6 GND hvn L=3.5e-07 W=0.6e-06
M25 7 6 GND GND hvn L=3.5e-07 W=0.3e-06
M26 8 6 4 GND hvn L=3.5e-07 W=0.6e-06
M27 18 7 8 GND hvn L=3.5e-07 W=0.3e-06
M28 GND 10 18 GND hvn L=3.5e-07 W=0.3e-06
M29 19 8 GND GND hvn L=3.5e-07 W=0.3e-06
M30 10 SB 19 GND hvn L=3.5e-07 W=0.3e-06
M31 11 7 10 GND hvn L=3.5e-07 W=0.3e-06
M32 12 6 11 GND hvn L=3.5e-07 W=0.3e-06
M33 20 SB 12 GND hvn L=3.5e-07 W=0.3e-06
M34 GND 13 20 GND hvn L=3.5e-07 W=0.3e-06
M35 13 11 GND GND hvn L=3.5e-07 W=0.3e-06
M36 QB 11 GND GND hvn L=3.5e-07 W=0.65e-06
M37 GND 11 QB GND hvn L=3.5e-07 W=0.65e-06
.ENDS SFFSBQBX2

.SUBCKT SFFSBQBX4 QB D SEL TD SB CK
M0 VDD SEL 1 VDD hvp L=3.0e-07 W=0.3e-06
M1 3 SEL VDD VDD hvp L=3.0e-07 W=0.75e-06
M2 4 D 3 VDD hvp L=3.0e-07 W=0.75e-06
M3 5 1 4 VDD hvp L=3.0e-07 W=0.75e-06
M4 VDD TD 5 VDD hvp L=3.0e-07 W=0.75e-06
M5 6 CK VDD VDD hvp L=3.0e-07 W=0.3e-06
M6 7 6 VDD VDD hvp L=3.0e-07 W=0.6e-06
M7 8 7 4 VDD hvp L=3.0e-07 W=0.6e-06
M8 9 6 8 VDD hvp L=3.0e-07 W=0.3e-06
M9 VDD 10 9 VDD hvp L=3.0e-07 W=0.3e-06
M10 VDD 8 10 VDD hvp L=3.0e-07 W=0.6e-06
M11 10 SB VDD VDD hvp L=3.0e-07 W=0.45e-06
M12 11 6 10 VDD hvp L=3.0e-07 W=0.45e-06
M13 12 7 11 VDD hvp L=3.0e-07 W=0.3e-06
M14 VDD SB 12 VDD hvp L=3.0e-07 W=0.3e-06
M15 VDD 13 12 VDD hvp L=3.0e-07 W=0.3e-06
M16 VDD 11 13 VDD hvp L=3.0e-07 W=0.3e-06
M17 QB 11 VDD VDD hvp L=3.0e-07 W=1e-06
M18 VDD 11 QB VDD hvp L=3.0e-07 W=1e-06
M19 QB 11 VDD VDD hvp L=3.0e-07 W=1e-06
M20 VDD 11 QB VDD hvp L=3.0e-07 W=1e-06
M21 GND SEL 1 GND hvn L=3.5e-07 W=0.3e-06
M22 16 1 GND GND hvn L=3.5e-07 W=0.35e-06
M23 4 D 16 GND hvn L=3.5e-07 W=0.35e-06
M24 17 SEL 4 GND hvn L=3.5e-07 W=0.35e-06
M25 GND TD 17 GND hvn L=3.5e-07 W=0.35e-06
M26 GND CK 6 GND hvn L=3.5e-07 W=0.6e-06
M27 7 6 GND GND hvn L=3.5e-07 W=0.3e-06
M28 8 6 4 GND hvn L=3.5e-07 W=0.6e-06
M29 18 7 8 GND hvn L=3.5e-07 W=0.3e-06
M30 GND 10 18 GND hvn L=3.5e-07 W=0.3e-06
M31 19 8 GND GND hvn L=3.5e-07 W=0.3e-06
M32 10 SB 19 GND hvn L=3.5e-07 W=0.3e-06
M33 11 7 10 GND hvn L=3.5e-07 W=0.3e-06
M34 12 6 11 GND hvn L=3.5e-07 W=0.3e-06
M35 20 SB 12 GND hvn L=3.5e-07 W=0.3e-06
M36 GND 13 20 GND hvn L=3.5e-07 W=0.3e-06
M37 13 11 GND GND hvn L=3.5e-07 W=0.3e-06
M38 QB 11 GND GND hvn L=3.5e-07 W=0.65e-06
M39 GND 11 QB GND hvn L=3.5e-07 W=0.65e-06
M40 QB 11 GND GND hvn L=3.5e-07 W=0.65e-06
M41 GND 11 QB GND hvn L=3.5e-07 W=0.65e-06
.ENDS SFFSBQBX4

.SUBCKT SFFSBQX1 Q D SEL TD SB CK
M0 VDD SEL 1 VDD hvp L=3.0e-07 W=0.3e-06
M1 3 SEL VDD VDD hvp L=3.0e-07 W=0.75e-06
M2 4 D 3 VDD hvp L=3.0e-07 W=0.75e-06
M3 5 1 4 VDD hvp L=3.0e-07 W=0.75e-06
M4 VDD TD 5 VDD hvp L=3.0e-07 W=0.75e-06
M5 6 CK VDD VDD hvp L=3.0e-07 W=0.3e-06
M6 7 6 VDD VDD hvp L=3.0e-07 W=0.6e-06
M7 8 7 4 VDD hvp L=3.0e-07 W=0.6e-06
M8 9 6 8 VDD hvp L=3.0e-07 W=0.3e-06
M9 VDD 10 9 VDD hvp L=3.0e-07 W=0.3e-06
M10 VDD 8 10 VDD hvp L=3.0e-07 W=0.6e-06
M11 10 SB VDD VDD hvp L=3.0e-07 W=0.45e-06
M12 11 6 10 VDD hvp L=3.0e-07 W=0.45e-06
M13 12 7 11 VDD hvp L=3.0e-07 W=0.3e-06
M14 VDD SB 12 VDD hvp L=3.0e-07 W=0.3e-06
M15 VDD 13 12 VDD hvp L=3.0e-07 W=0.3e-06
M16 VDD 11 13 VDD hvp L=3.0e-07 W=0.7e-06
M17 Q 13 VDD VDD hvp L=3.0e-07 W=1e-06
M18 GND SEL 1 GND hvn L=3.5e-07 W=0.3e-06
M19 16 1 GND GND hvn L=3.5e-07 W=0.35e-06
M20 4 D 16 GND hvn L=3.5e-07 W=0.35e-06
M21 17 SEL 4 GND hvn L=3.5e-07 W=0.35e-06
M22 GND TD 17 GND hvn L=3.5e-07 W=0.35e-06
M23 GND CK 6 GND hvn L=3.5e-07 W=0.6e-06
M24 7 6 GND GND hvn L=3.5e-07 W=0.3e-06
M25 8 6 4 GND hvn L=3.5e-07 W=0.6e-06
M26 18 7 8 GND hvn L=3.5e-07 W=0.3e-06
M27 GND 10 18 GND hvn L=3.5e-07 W=0.3e-06
M28 19 8 GND GND hvn L=3.5e-07 W=0.3e-06
M29 10 SB 19 GND hvn L=3.5e-07 W=0.3e-06
M30 11 7 10 GND hvn L=3.5e-07 W=0.3e-06
M31 12 6 11 GND hvn L=3.5e-07 W=0.3e-06
M32 20 SB 12 GND hvn L=3.5e-07 W=0.3e-06
M33 GND 13 20 GND hvn L=3.5e-07 W=0.3e-06
M34 13 11 GND GND hvn L=3.5e-07 W=0.6e-06
M35 Q 13 GND GND hvn L=3.5e-07 W=0.65e-06
.ENDS SFFSBQX1

.SUBCKT SFFSBQX2 Q D SEL TD SB CK
M0 VDD SEL 1 VDD hvp L=3.0e-07 W=0.3e-06
M1 3 SEL VDD VDD hvp L=3.0e-07 W=0.75e-06
M2 4 D 3 VDD hvp L=3.0e-07 W=0.75e-06
M3 5 1 4 VDD hvp L=3.0e-07 W=0.75e-06
M4 VDD TD 5 VDD hvp L=3.0e-07 W=0.75e-06
M5 6 CK VDD VDD hvp L=3.0e-07 W=0.3e-06
M6 7 6 VDD VDD hvp L=3.0e-07 W=0.6e-06
M7 8 7 4 VDD hvp L=3.0e-07 W=0.6e-06
M8 9 6 8 VDD hvp L=3.0e-07 W=0.3e-06
M9 VDD 10 9 VDD hvp L=3.0e-07 W=0.3e-06
M10 VDD 8 10 VDD hvp L=3.0e-07 W=0.6e-06
M11 10 SB VDD VDD hvp L=3.0e-07 W=0.45e-06
M12 11 6 10 VDD hvp L=3.0e-07 W=0.45e-06
M13 12 7 11 VDD hvp L=3.0e-07 W=0.3e-06
M14 VDD SB 12 VDD hvp L=3.0e-07 W=0.3e-06
M15 VDD 13 12 VDD hvp L=3.0e-07 W=0.3e-06
M16 VDD 11 13 VDD hvp L=3.0e-07 W=0.7e-06
M17 Q 13 VDD VDD hvp L=3.0e-07 W=1e-06
M18 VDD 13 Q VDD hvp L=3.0e-07 W=1e-06
M19 GND SEL 1 GND hvn L=3.5e-07 W=0.3e-06
M20 16 1 GND GND hvn L=3.5e-07 W=0.35e-06
M21 4 D 16 GND hvn L=3.5e-07 W=0.35e-06
M22 17 SEL 4 GND hvn L=3.5e-07 W=0.35e-06
M23 GND TD 17 GND hvn L=3.5e-07 W=0.35e-06
M24 GND CK 6 GND hvn L=3.5e-07 W=0.6e-06
M25 7 6 GND GND hvn L=3.5e-07 W=0.3e-06
M26 8 6 4 GND hvn L=3.5e-07 W=0.6e-06
M27 18 7 8 GND hvn L=3.5e-07 W=0.3e-06
M28 GND 10 18 GND hvn L=3.5e-07 W=0.3e-06
M29 19 8 GND GND hvn L=3.5e-07 W=0.3e-06
M30 10 SB 19 GND hvn L=3.5e-07 W=0.3e-06
M31 11 7 10 GND hvn L=3.5e-07 W=0.3e-06
M32 12 6 11 GND hvn L=3.5e-07 W=0.3e-06
M33 20 SB 12 GND hvn L=3.5e-07 W=0.3e-06
M34 GND 13 20 GND hvn L=3.5e-07 W=0.3e-06
M35 13 11 GND GND hvn L=3.5e-07 W=0.6e-06
M36 Q 13 GND GND hvn L=3.5e-07 W=0.65e-06
M37 GND 13 Q GND hvn L=3.5e-07 W=0.65e-06
.ENDS SFFSBQX2

.SUBCKT SFFSBQX4 Q D SEL TD SB CK
M0 VDD SEL 1 VDD hvp L=3.0e-07 W=0.3e-06
M1 3 SEL VDD VDD hvp L=3.0e-07 W=0.75e-06
M2 4 D 3 VDD hvp L=3.0e-07 W=0.75e-06
M3 5 1 4 VDD hvp L=3.0e-07 W=0.75e-06
M4 VDD TD 5 VDD hvp L=3.0e-07 W=0.75e-06
M5 6 CK VDD VDD hvp L=3.0e-07 W=0.3e-06
M6 7 6 VDD VDD hvp L=3.0e-07 W=0.6e-06
M7 8 7 4 VDD hvp L=3.0e-07 W=0.6e-06
M8 9 6 8 VDD hvp L=3.0e-07 W=0.3e-06
M9 VDD 10 9 VDD hvp L=3.0e-07 W=0.3e-06
M10 VDD 8 10 VDD hvp L=3.0e-07 W=0.6e-06
M11 10 SB VDD VDD hvp L=3.0e-07 W=0.45e-06
M12 11 6 10 VDD hvp L=3.0e-07 W=0.45e-06
M13 12 7 11 VDD hvp L=3.0e-07 W=0.3e-06
M14 VDD SB 12 VDD hvp L=3.0e-07 W=0.3e-06
M15 VDD 13 12 VDD hvp L=3.0e-07 W=0.3e-06
M16 VDD 11 13 VDD hvp L=3.0e-07 W=0.7e-06
M17 Q 13 VDD VDD hvp L=3.0e-07 W=1e-06
M18 VDD 13 Q VDD hvp L=3.0e-07 W=1e-06
M19 Q 13 VDD VDD hvp L=3.0e-07 W=1e-06
M20 VDD 13 Q VDD hvp L=3.0e-07 W=1e-06
M21 GND SEL 1 GND hvn L=3.5e-07 W=0.3e-06
M22 16 1 GND GND hvn L=3.5e-07 W=0.35e-06
M23 4 D 16 GND hvn L=3.5e-07 W=0.35e-06
M24 17 SEL 4 GND hvn L=3.5e-07 W=0.35e-06
M25 GND TD 17 GND hvn L=3.5e-07 W=0.35e-06
M26 GND CK 6 GND hvn L=3.5e-07 W=0.6e-06
M27 7 6 GND GND hvn L=3.5e-07 W=0.3e-06
M28 8 6 4 GND hvn L=3.5e-07 W=0.6e-06
M29 18 7 8 GND hvn L=3.5e-07 W=0.3e-06
M30 GND 10 18 GND hvn L=3.5e-07 W=0.3e-06
M31 19 8 GND GND hvn L=3.5e-07 W=0.3e-06
M32 10 SB 19 GND hvn L=3.5e-07 W=0.3e-06
M33 11 7 10 GND hvn L=3.5e-07 W=0.3e-06
M34 12 6 11 GND hvn L=3.5e-07 W=0.3e-06
M35 20 SB 12 GND hvn L=3.5e-07 W=0.3e-06
M36 GND 13 20 GND hvn L=3.5e-07 W=0.3e-06
M37 13 11 GND GND hvn L=3.5e-07 W=0.6e-06
M38 Q 13 GND GND hvn L=3.5e-07 W=0.65e-06
M39 GND 13 Q GND hvn L=3.5e-07 W=0.65e-06
M40 Q 13 GND GND hvn L=3.5e-07 W=0.65e-06
M41 GND 13 Q GND hvn L=3.5e-07 W=0.65e-06
.ENDS SFFSBQX4

.SUBCKT TAP
.ENDS TAP

.SUBCKT TIE01X1 TIE0 TIE1
M0 VDD 1 1 VDD hvp L=3.8e-07 W=1e-06
M1 TIE1 6 VDD VDD hvp L=3.8e-07 W=1e-06
M2 GND 1 TIE0 GND hvn L=3.8e-07 W=0.67e-06
M3 6 6 GND GND hvn L=3.8e-07 W=0.67e-06
.ENDS TIE01X1

.SUBCKT TIE0X1 TIE0
M0 2 2 VDD VDD hvp L=4e-07 W=1e-06
M1 TIE0 2 GND GND hvn L=4e-07 W=0.67e-06
.ENDS TIE0X1

.SUBCKT TIE0X4 TIE0
M0 2 2 VDD VDD hvp L=4.6e-07 W=1e-06
M1 VDD 2 2 VDD hvp L=4.6e-07 W=1e-06
M2 2 2 VDD VDD hvp L=4.6e-07 W=1e-06
M3 VDD 2 2 VDD hvp L=4.6e-07 W=1e-06
M4 TIE0 2 GND GND hvn L=4.6e-07 W=0.67e-06
M5 GND 2 TIE0 GND hvn L=4.6e-07 W=0.67e-06
M6 TIE0 2 GND GND hvn L=4.6e-07 W=0.67e-06
M7 GND 2 TIE0 GND hvn L=4.6e-07 W=0.67e-06
.ENDS TIE0X4

.SUBCKT TIE1X1 TIE1
M0 TIE1 4 VDD VDD hvp L=4e-07 W=1e-06
M1 4 4 GND GND hvn L=4e-07 W=0.67e-06
.ENDS TIE1X1

.SUBCKT TIE1X4 TIE1
M0 TIE1 4 VDD VDD hvp L=4.6e-07 W=1e-06
M1 VDD 4 TIE1 VDD hvp L=4.6e-07 W=1e-06
M2 TIE1 4 VDD VDD hvp L=4.6e-07 W=1e-06
M3 VDD 4 TIE1 VDD hvp L=4.6e-07 W=1e-06
M4 4 4 GND GND hvn L=4.6e-07 W=0.67e-06
M5 GND 4 4 GND hvn L=4.6e-07 W=0.67e-06
M6 4 4 GND GND hvn L=4.6e-07 W=0.67e-06
M7 GND 4 4 GND hvn L=4.6e-07 W=0.67e-06
.ENDS TIE1X4

.SUBCKT TRIBUFX1 O E I
M0 2 E VDD VDD hvp L=3.0e-07 W=0.9e-06
M1 4 2 O VDD hvp L=3.0e-07 W=0.53e-06
M2 VDD 6 4 VDD hvp L=3.0e-07 W=0.53e-06
M3 5 6 VDD VDD hvp L=3.0e-07 W=0.53e-06
M4 O 2 5 VDD hvp L=3.0e-07 W=0.53e-06
M5 VDD I 6 VDD hvp L=3.0e-07 W=1e-06
M6 2 E GND GND hvn L=3.5e-07 W=0.57e-06
M7 8 E O GND hvn L=3.5e-07 W=0.3e-06
M8 GND 6 8 GND hvn L=3.5e-07 W=0.3e-06
M9 9 6 GND GND hvn L=3.5e-07 W=0.3e-06
M10 O E 9 GND hvn L=3.5e-07 W=0.3e-06
M11 GND I 6 GND hvn L=3.5e-07 W=0.67e-06
.ENDS TRIBUFX1

.SUBCKT TRIBUFX2 O E I
M0 2 E VDD VDD hvp L=3.0e-07 W=0.9e-06
M1 4 2 O VDD hvp L=3.0e-07 W=0.53e-06
M2 VDD 8 4 VDD hvp L=3.0e-07 W=0.53e-06
M3 5 8 VDD VDD hvp L=3.0e-07 W=0.53e-06
M4 O 2 5 VDD hvp L=3.0e-07 W=0.53e-06
M5 6 2 O VDD hvp L=3.0e-07 W=0.53e-06
M6 VDD 8 6 VDD hvp L=3.0e-07 W=0.53e-06
M7 7 8 VDD VDD hvp L=3.0e-07 W=0.53e-06
M8 O 2 7 VDD hvp L=3.0e-07 W=0.53e-06
M9 VDD I 8 VDD hvp L=3.0e-07 W=1e-06
M10 2 E GND GND hvn L=3.5e-07 W=0.57e-06
M11 10 E O GND hvn L=3.5e-07 W=0.3e-06
M12 GND 8 10 GND hvn L=3.5e-07 W=0.3e-06
M13 11 8 GND GND hvn L=3.5e-07 W=0.3e-06
M14 O E 11 GND hvn L=3.5e-07 W=0.3e-06
M15 12 E O GND hvn L=3.5e-07 W=0.3e-06
M16 GND 8 12 GND hvn L=3.5e-07 W=0.3e-06
M17 13 8 GND GND hvn L=3.5e-07 W=0.3e-06
M18 O E 13 GND hvn L=3.5e-07 W=0.3e-06
M19 GND I 8 GND hvn L=3.5e-07 W=0.67e-06
.ENDS TRIBUFX2

.SUBCKT TRIBUFX3 O E I
M0 2 E VDD VDD hvp L=3.0e-07 W=0.9e-06
M1 4 2 O VDD hvp L=3.0e-07 W=0.53e-06
M2 VDD 10 4 VDD hvp L=3.0e-07 W=0.53e-06
M3 5 10 VDD VDD hvp L=3.0e-07 W=0.53e-06
M4 O 2 5 VDD hvp L=3.0e-07 W=0.53e-06
M5 6 2 O VDD hvp L=3.0e-07 W=0.53e-06
M6 VDD 10 6 VDD hvp L=3.0e-07 W=0.53e-06
M7 7 10 VDD VDD hvp L=3.0e-07 W=0.53e-06
M8 O 2 7 VDD hvp L=3.0e-07 W=0.53e-06
M9 8 2 O VDD hvp L=3.0e-07 W=0.53e-06
M10 VDD 10 8 VDD hvp L=3.0e-07 W=0.53e-06
M11 9 10 VDD VDD hvp L=3.0e-07 W=0.53e-06
M12 O 2 9 VDD hvp L=3.0e-07 W=0.53e-06
M13 VDD I 10 VDD hvp L=3.0e-07 W=1e-06
M14 2 E GND GND hvn L=3.5e-07 W=0.57e-06
M15 12 E O GND hvn L=3.5e-07 W=0.3e-06
M16 GND 10 12 GND hvn L=3.5e-07 W=0.3e-06
M17 13 10 GND GND hvn L=3.5e-07 W=0.3e-06
M18 O E 13 GND hvn L=3.5e-07 W=0.3e-06
M19 14 E O GND hvn L=3.5e-07 W=0.3e-06
M20 GND 10 14 GND hvn L=3.5e-07 W=0.3e-06
M21 15 10 GND GND hvn L=3.5e-07 W=0.3e-06
M22 O E 15 GND hvn L=3.5e-07 W=0.3e-06
M23 16 E O GND hvn L=3.5e-07 W=0.3e-06
M24 GND 10 16 GND hvn L=3.5e-07 W=0.3e-06
M25 17 10 GND GND hvn L=3.5e-07 W=0.3e-06
M26 O E 17 GND hvn L=3.5e-07 W=0.3e-06
M27 GND I 10 GND hvn L=3.5e-07 W=0.67e-06
.ENDS TRIBUFX3

.SUBCKT TRIBUFX4 O E I
M0 2 E VDD VDD hvp L=3.0e-07 W=0.9e-06
M1 4 2 O VDD hvp L=3.0e-07 W=0.53e-06
M2 VDD 12 4 VDD hvp L=3.0e-07 W=0.53e-06
M3 5 12 VDD VDD hvp L=3.0e-07 W=0.53e-06
M4 O 2 5 VDD hvp L=3.0e-07 W=0.53e-06
M5 6 2 O VDD hvp L=3.0e-07 W=0.53e-06
M6 VDD 12 6 VDD hvp L=3.0e-07 W=0.53e-06
M7 7 12 VDD VDD hvp L=3.0e-07 W=0.53e-06
M8 O 2 7 VDD hvp L=3.0e-07 W=0.53e-06
M9 8 2 O VDD hvp L=3.0e-07 W=0.53e-06
M10 VDD 12 8 VDD hvp L=3.0e-07 W=0.53e-06
M11 9 12 VDD VDD hvp L=3.0e-07 W=0.53e-06
M12 O 2 9 VDD hvp L=3.0e-07 W=0.53e-06
M13 10 2 O VDD hvp L=3.0e-07 W=0.53e-06
M14 VDD 12 10 VDD hvp L=3.0e-07 W=0.53e-06
M15 11 12 VDD VDD hvp L=3.0e-07 W=0.53e-06
M16 O 2 11 VDD hvp L=3.0e-07 W=0.53e-06
M17 12 I VDD VDD hvp L=3.0e-07 W=1e-06
M18 VDD I 12 VDD hvp L=3.0e-07 W=1e-06
M19 2 E GND GND hvn L=3.5e-07 W=0.57e-06
M20 14 E O GND hvn L=3.5e-07 W=0.3e-06
M21 GND 12 14 GND hvn L=3.5e-07 W=0.3e-06
M22 15 12 GND GND hvn L=3.5e-07 W=0.3e-06
M23 O E 15 GND hvn L=3.5e-07 W=0.3e-06
M24 16 E O GND hvn L=3.5e-07 W=0.3e-06
M25 GND 12 16 GND hvn L=3.5e-07 W=0.3e-06
M26 17 12 GND GND hvn L=3.5e-07 W=0.3e-06
M27 O E 17 GND hvn L=3.5e-07 W=0.3e-06
M28 18 E O GND hvn L=3.5e-07 W=0.3e-06
M29 GND 12 18 GND hvn L=3.5e-07 W=0.3e-06
M30 19 12 GND GND hvn L=3.5e-07 W=0.3e-06
M31 O E 19 GND hvn L=3.5e-07 W=0.3e-06
M32 20 E O GND hvn L=3.5e-07 W=0.3e-06
M33 GND 12 20 GND hvn L=3.5e-07 W=0.3e-06
M34 21 12 GND GND hvn L=3.5e-07 W=0.3e-06
M35 O E 21 GND hvn L=3.5e-07 W=0.3e-06
M36 12 I GND GND hvn L=3.5e-07 W=0.67e-06
M37 GND I 12 GND hvn L=3.5e-07 W=0.67e-06
.ENDS TRIBUFX4

.SUBCKT TRIINVX1 O E I
M0 2 E VDD VDD hvp L=3.0e-07 W=1e-06
M1 4 2 O VDD hvp L=3.0e-07 W=0.53e-06
M2 VDD I 4 VDD hvp L=3.0e-07 W=0.53e-06
M3 5 I VDD VDD hvp L=3.0e-07 W=0.53e-06
M4 O 2 5 VDD hvp L=3.0e-07 W=0.53e-06
M5 2 E GND GND hvn L=3.5e-07 W=0.67e-06
M6 7 E O GND hvn L=3.5e-07 W=0.3e-06
M7 GND I 7 GND hvn L=3.5e-07 W=0.3e-06
M8 8 I GND GND hvn L=3.5e-07 W=0.3e-06
M9 O E 8 GND hvn L=3.5e-07 W=0.3e-06
.ENDS TRIINVX1

.SUBCKT TRIINVX2 O E I
M0 2 E VDD VDD hvp L=3.0e-07 W=1e-06
M1 4 2 O VDD hvp L=3.0e-07 W=0.53e-06
M2 VDD I 4 VDD hvp L=3.0e-07 W=0.53e-06
M3 5 I VDD VDD hvp L=3.0e-07 W=0.53e-06
M4 O 2 5 VDD hvp L=3.0e-07 W=0.53e-06
M5 6 2 O VDD hvp L=3.0e-07 W=0.53e-06
M6 VDD I 6 VDD hvp L=3.0e-07 W=0.53e-06
M7 7 I VDD VDD hvp L=3.0e-07 W=0.53e-06
M8 O 2 7 VDD hvp L=3.0e-07 W=0.53e-06
M9 2 E GND GND hvn L=3.5e-07 W=0.67e-06
M10 9 E O GND hvn L=3.5e-07 W=0.3e-06
M11 GND I 9 GND hvn L=3.5e-07 W=0.3e-06
M12 10 I GND GND hvn L=3.5e-07 W=0.3e-06
M13 O E 10 GND hvn L=3.5e-07 W=0.3e-06
M14 11 E O GND hvn L=3.5e-07 W=0.3e-06
M15 GND I 11 GND hvn L=3.5e-07 W=0.3e-06
M16 12 I GND GND hvn L=3.5e-07 W=0.3e-06
M17 O E 12 GND hvn L=3.5e-07 W=0.3e-06
.ENDS TRIINVX2

.SUBCKT TRIINVX3 O E I
M0 2 E VDD VDD hvp L=3.0e-07 W=1e-06
M1 4 2 O VDD hvp L=3.0e-07 W=0.53e-06
M2 VDD I 4 VDD hvp L=3.0e-07 W=0.53e-06
M3 5 I VDD VDD hvp L=3.0e-07 W=0.53e-06
M4 O 2 5 VDD hvp L=3.0e-07 W=0.53e-06
M5 6 2 O VDD hvp L=3.0e-07 W=0.53e-06
M6 VDD I 6 VDD hvp L=3.0e-07 W=0.53e-06
M7 7 I VDD VDD hvp L=3.0e-07 W=0.53e-06
M8 O 2 7 VDD hvp L=3.0e-07 W=0.53e-06
M9 8 2 O VDD hvp L=3.0e-07 W=0.53e-06
M10 VDD I 8 VDD hvp L=3.0e-07 W=0.53e-06
M11 9 I VDD VDD hvp L=3.0e-07 W=0.53e-06
M12 O 2 9 VDD hvp L=3.0e-07 W=0.53e-06
M13 2 E GND GND hvn L=3.5e-07 W=0.67e-06
M14 11 E O GND hvn L=3.5e-07 W=0.3e-06
M15 GND I 11 GND hvn L=3.5e-07 W=0.3e-06
M16 12 I GND GND hvn L=3.5e-07 W=0.3e-06
M17 O E 12 GND hvn L=3.5e-07 W=0.3e-06
M18 13 E O GND hvn L=3.5e-07 W=0.3e-06
M19 GND I 13 GND hvn L=3.5e-07 W=0.3e-06
M20 14 I GND GND hvn L=3.5e-07 W=0.3e-06
M21 O E 14 GND hvn L=3.5e-07 W=0.3e-06
M22 15 E O GND hvn L=3.5e-07 W=0.3e-06
M23 GND I 15 GND hvn L=3.5e-07 W=0.3e-06
M24 16 I GND GND hvn L=3.5e-07 W=0.3e-06
M25 O E 16 GND hvn L=3.5e-07 W=0.3e-06
.ENDS TRIINVX3

.SUBCKT TRIINVX4 O E I
M0 VDD E 1 VDD hvp L=3.0e-07 W=1e-06
M1 1 E VDD VDD hvp L=3.0e-07 W=1e-06
M2 4 1 O VDD hvp L=3.0e-07 W=0.53e-06
M3 VDD I 4 VDD hvp L=3.0e-07 W=0.53e-06
M4 5 I VDD VDD hvp L=3.0e-07 W=0.53e-06
M5 O 1 5 VDD hvp L=3.0e-07 W=0.53e-06
M6 6 1 O VDD hvp L=3.0e-07 W=0.53e-06
M7 VDD I 6 VDD hvp L=3.0e-07 W=0.53e-06
M8 7 I VDD VDD hvp L=3.0e-07 W=0.53e-06
M9 O 1 7 VDD hvp L=3.0e-07 W=0.53e-06
M10 8 1 O VDD hvp L=3.0e-07 W=0.53e-06
M11 VDD I 8 VDD hvp L=3.0e-07 W=0.53e-06
M12 9 I VDD VDD hvp L=3.0e-07 W=0.53e-06
M13 O 1 9 VDD hvp L=3.0e-07 W=0.53e-06
M14 10 1 O VDD hvp L=3.0e-07 W=0.53e-06
M15 VDD I 10 VDD hvp L=3.0e-07 W=0.53e-06
M16 11 I VDD VDD hvp L=3.0e-07 W=0.53e-06
M17 O 1 11 VDD hvp L=3.0e-07 W=0.53e-06
M18 GND E 1 GND hvn L=3.5e-07 W=0.67e-06
M19 1 E GND GND hvn L=3.5e-07 W=0.67e-06
M20 13 E O GND hvn L=3.5e-07 W=0.3e-06
M21 GND I 13 GND hvn L=3.5e-07 W=0.3e-06
M22 14 I GND GND hvn L=3.5e-07 W=0.3e-06
M23 O E 14 GND hvn L=3.5e-07 W=0.3e-06
M24 15 E O GND hvn L=3.5e-07 W=0.3e-06
M25 GND I 15 GND hvn L=3.5e-07 W=0.3e-06
M26 16 I GND GND hvn L=3.5e-07 W=0.3e-06
M27 O E 16 GND hvn L=3.5e-07 W=0.3e-06
M28 17 E O GND hvn L=3.5e-07 W=0.3e-06
M29 GND I 17 GND hvn L=3.5e-07 W=0.3e-06
M30 18 I GND GND hvn L=3.5e-07 W=0.3e-06
M31 O E 18 GND hvn L=3.5e-07 W=0.3e-06
M32 19 E O GND hvn L=3.5e-07 W=0.3e-06
M33 GND I 19 GND hvn L=3.5e-07 W=0.3e-06
M34 20 I GND GND hvn L=3.5e-07 W=0.3e-06
M35 O E 20 GND hvn L=3.5e-07 W=0.3e-06
.ENDS TRIINVX4

.SUBCKT XNOR2X1 O I1 I2
M0 VDD I1 1 VDD hvp L=3.0e-07 W=1e-06
M1 3 1 VDD VDD hvp L=3.0e-07 W=0.6e-06
M2 4 I2 3 VDD hvp L=3.0e-07 W=0.6e-06
M3 1 5 4 VDD hvp L=3.0e-07 W=0.53e-06
M4 VDD I2 5 VDD hvp L=3.0e-07 W=0.9e-06
M5 O 4 VDD VDD hvp L=3.0e-07 W=1e-06
M6 GND I1 1 GND hvn L=3.5e-07 W=0.65e-06
M7 8 1 GND GND hvn L=3.5e-07 W=0.4e-06
M8 4 5 8 GND hvn L=3.5e-07 W=0.4e-06
M9 1 I2 4 GND hvn L=3.5e-07 W=0.4e-06
M10 GND I2 5 GND hvn L=3.5e-07 W=0.6e-06
M11 O 4 GND GND hvn L=3.5e-07 W=0.65e-06
.ENDS XNOR2X1

.SUBCKT XNOR2X2 O I1 I2
M0 VDD I1 1 VDD hvp L=3.0e-07 W=1e-06
M1 3 1 VDD VDD hvp L=3.0e-07 W=0.6e-06
M2 4 I2 3 VDD hvp L=3.0e-07 W=0.6e-06
M3 1 5 4 VDD hvp L=3.0e-07 W=0.53e-06
M4 VDD I2 5 VDD hvp L=3.0e-07 W=0.9e-06
M5 O 4 VDD VDD hvp L=3.0e-07 W=1e-06
M6 VDD 4 O VDD hvp L=3.0e-07 W=1e-06
M7 GND I1 1 GND hvn L=3.5e-07 W=0.65e-06
M8 8 1 GND GND hvn L=3.5e-07 W=0.4e-06
M9 4 5 8 GND hvn L=3.5e-07 W=0.4e-06
M10 1 I2 4 GND hvn L=3.5e-07 W=0.4e-06
M11 GND I2 5 GND hvn L=3.5e-07 W=0.6e-06
M12 O 4 GND GND hvn L=3.5e-07 W=0.65e-06
M13 GND 4 O GND hvn L=3.5e-07 W=0.65e-06
.ENDS XNOR2X2

.SUBCKT XNOR2X3 O I1 I2
M0 VDD I1 1 VDD hvp L=3.0e-07 W=1e-06
M1 3 1 VDD VDD hvp L=3.0e-07 W=0.6e-06
M2 4 I2 3 VDD hvp L=3.0e-07 W=0.6e-06
M3 1 5 4 VDD hvp L=3.0e-07 W=0.53e-06
M4 VDD I2 5 VDD hvp L=3.0e-07 W=0.9e-06
M5 O 4 VDD VDD hvp L=3.0e-07 W=1e-06
M6 VDD 4 O VDD hvp L=3.0e-07 W=1e-06
M7 O 4 VDD VDD hvp L=3.0e-07 W=1e-06
M8 GND I1 1 GND hvn L=3.5e-07 W=0.65e-06
M9 8 1 GND GND hvn L=3.5e-07 W=0.4e-06
M10 4 5 8 GND hvn L=3.5e-07 W=0.4e-06
M11 1 I2 4 GND hvn L=3.5e-07 W=0.4e-06
M12 GND I2 5 GND hvn L=3.5e-07 W=0.6e-06
M13 O 4 GND GND hvn L=3.5e-07 W=0.65e-06
M14 GND 4 O GND hvn L=3.5e-07 W=0.65e-06
M15 O 4 GND GND hvn L=3.5e-07 W=0.65e-06
.ENDS XNOR2X3

.SUBCKT XNOR2X4 O I1 I2
M0 VDD I1 1 VDD hvp L=3.0e-07 W=1e-06
M1 3 1 VDD VDD hvp L=3.0e-07 W=0.6e-06
M2 4 I2 3 VDD hvp L=3.0e-07 W=0.6e-06
M3 1 5 4 VDD hvp L=3.0e-07 W=0.53e-06
M4 VDD I2 5 VDD hvp L=3.0e-07 W=0.9e-06
M5 O 4 VDD VDD hvp L=3.0e-07 W=1e-06
M6 VDD 4 O VDD hvp L=3.0e-07 W=1e-06
M7 O 4 VDD VDD hvp L=3.0e-07 W=1e-06
M8 VDD 4 O VDD hvp L=3.0e-07 W=1e-06
M9 GND I1 1 GND hvn L=3.5e-07 W=0.65e-06
M10 8 1 GND GND hvn L=3.5e-07 W=0.4e-06
M11 4 5 8 GND hvn L=3.5e-07 W=0.4e-06
M12 1 I2 4 GND hvn L=3.5e-07 W=0.4e-06
M13 GND I2 5 GND hvn L=3.5e-07 W=0.6e-06
M14 O 4 GND GND hvn L=3.5e-07 W=0.65e-06
M15 GND 4 O GND hvn L=3.5e-07 W=0.65e-06
M16 O 4 GND GND hvn L=3.5e-07 W=0.65e-06
M17 GND 4 O GND hvn L=3.5e-07 W=0.65e-06
.ENDS XNOR2X4

.SUBCKT XNOR2X6 O I1 I2
M0 VDD I1 1 VDD hvp L=3.0e-07 W=1e-06
M1 3 1 VDD VDD hvp L=3.0e-07 W=0.6e-06
M2 4 I2 3 VDD hvp L=3.0e-07 W=0.6e-06
M3 1 5 4 VDD hvp L=3.0e-07 W=0.53e-06
M4 VDD I2 5 VDD hvp L=3.0e-07 W=0.9e-06
M5 O 4 VDD VDD hvp L=3.0e-07 W=1e-06
M6 VDD 4 O VDD hvp L=3.0e-07 W=1e-06
M7 O 4 VDD VDD hvp L=3.0e-07 W=1e-06
M8 VDD 4 O VDD hvp L=3.0e-07 W=1e-06
M9 O 4 VDD VDD hvp L=3.0e-07 W=1e-06
M10 VDD 4 O VDD hvp L=3.0e-07 W=1e-06
M11 GND I1 1 GND hvn L=3.5e-07 W=0.65e-06
M12 8 1 GND GND hvn L=3.5e-07 W=0.4e-06
M13 4 5 8 GND hvn L=3.5e-07 W=0.4e-06
M14 1 I2 4 GND hvn L=3.5e-07 W=0.4e-06
M15 GND I2 5 GND hvn L=3.5e-07 W=0.6e-06
M16 O 4 GND GND hvn L=3.5e-07 W=0.65e-06
M17 GND 4 O GND hvn L=3.5e-07 W=0.65e-06
M18 O 4 GND GND hvn L=3.5e-07 W=0.65e-06
M19 GND 4 O GND hvn L=3.5e-07 W=0.65e-06
M20 O 4 GND GND hvn L=3.5e-07 W=0.65e-06
M21 GND 4 O GND hvn L=3.5e-07 W=0.65e-06
.ENDS XNOR2X6

.SUBCKT XNOR3X1 O I1 I2 I3
M0 VDD I1 1 VDD hvp L=3.0e-07 W=1e-06
M1 3 1 VDD VDD hvp L=3.0e-07 W=1e-06
M2 4 5 3 VDD hvp L=3.0e-07 W=0.55e-06
M3 1 I2 4 VDD hvp L=3.0e-07 W=0.55e-06
M4 VDD I2 5 VDD hvp L=3.0e-07 W=0.8e-06
M5 6 4 VDD VDD hvp L=3.0e-07 W=1e-06
M6 7 I3 6 VDD hvp L=3.0e-07 W=0.55e-06
M7 4 8 7 VDD hvp L=3.0e-07 W=0.53e-06
M8 VDD I3 8 VDD hvp L=3.0e-07 W=0.8e-06
M9 O 7 VDD VDD hvp L=3.0e-07 W=1e-06
M10 GND I1 1 GND hvn L=3.5e-07 W=0.5e-06
M11 3 1 GND GND hvn L=3.5e-07 W=0.5e-06
M12 4 I2 3 GND hvn L=3.5e-07 W=0.35e-06
M13 1 5 4 GND hvn L=3.5e-07 W=0.35e-06
M14 GND I2 5 GND hvn L=3.5e-07 W=0.5e-06
M15 6 4 GND GND hvn L=3.5e-07 W=0.5e-06
M16 7 8 6 GND hvn L=3.5e-07 W=0.35e-06
M17 4 I3 7 GND hvn L=3.5e-07 W=0.35e-06
M18 GND I3 8 GND hvn L=3.5e-07 W=0.5e-06
M19 O 7 GND GND hvn L=3.5e-07 W=0.65e-06
.ENDS XNOR3X1

.SUBCKT XNOR3X2 O I1 I2 I3
M0 VDD I1 1 VDD hvp L=3.0e-07 W=1e-06
M1 3 1 VDD VDD hvp L=3.0e-07 W=1e-06
M2 4 5 3 VDD hvp L=3.0e-07 W=0.55e-06
M3 1 I2 4 VDD hvp L=3.0e-07 W=0.55e-06
M4 VDD I2 5 VDD hvp L=3.0e-07 W=0.8e-06
M5 6 4 VDD VDD hvp L=3.0e-07 W=1e-06
M6 7 I3 6 VDD hvp L=3.0e-07 W=0.55e-06
M7 4 8 7 VDD hvp L=3.0e-07 W=0.53e-06
M8 VDD I3 8 VDD hvp L=3.0e-07 W=0.8e-06
M9 O 7 VDD VDD hvp L=3.0e-07 W=1e-06
M10 VDD 7 O VDD hvp L=3.0e-07 W=1e-06
M11 GND I1 1 GND hvn L=3.5e-07 W=0.5e-06
M12 3 1 GND GND hvn L=3.5e-07 W=0.5e-06
M13 4 I2 3 GND hvn L=3.5e-07 W=0.35e-06
M14 1 5 4 GND hvn L=3.5e-07 W=0.35e-06
M15 GND I2 5 GND hvn L=3.5e-07 W=0.5e-06
M16 6 4 GND GND hvn L=3.5e-07 W=0.5e-06
M17 7 8 6 GND hvn L=3.5e-07 W=0.35e-06
M18 4 I3 7 GND hvn L=3.5e-07 W=0.35e-06
M19 GND I3 8 GND hvn L=3.5e-07 W=0.5e-06
M20 O 7 GND GND hvn L=3.5e-07 W=0.65e-06
M21 GND 7 O GND hvn L=3.5e-07 W=0.65e-06
.ENDS XNOR3X2

.SUBCKT XNOR3X4 O I1 I2 I3
M0 VDD I1 1 VDD hvp L=3.0e-07 W=1e-06
M1 3 1 VDD VDD hvp L=3.0e-07 W=1e-06
M2 4 5 3 VDD hvp L=3.0e-07 W=0.55e-06
M3 1 I2 4 VDD hvp L=3.0e-07 W=0.55e-06
M4 VDD I2 5 VDD hvp L=3.0e-07 W=0.8e-06
M5 6 4 VDD VDD hvp L=3.0e-07 W=1e-06
M6 7 I3 6 VDD hvp L=3.0e-07 W=0.55e-06
M7 4 8 7 VDD hvp L=3.0e-07 W=0.53e-06
M8 VDD I3 8 VDD hvp L=3.0e-07 W=0.8e-06
M9 O 7 VDD VDD hvp L=3.0e-07 W=1e-06
M10 VDD 7 O VDD hvp L=3.0e-07 W=1e-06
M11 O 7 VDD VDD hvp L=3.0e-07 W=1e-06
M12 VDD 7 O VDD hvp L=3.0e-07 W=1e-06
M13 GND I1 1 GND hvn L=3.5e-07 W=0.5e-06
M14 3 1 GND GND hvn L=3.5e-07 W=0.5e-06
M15 4 I2 3 GND hvn L=3.5e-07 W=0.35e-06
M16 1 5 4 GND hvn L=3.5e-07 W=0.35e-06
M17 GND I2 5 GND hvn L=3.5e-07 W=0.5e-06
M18 6 4 GND GND hvn L=3.5e-07 W=0.5e-06
M19 7 8 6 GND hvn L=3.5e-07 W=0.35e-06
M20 4 I3 7 GND hvn L=3.5e-07 W=0.35e-06
M21 GND I3 8 GND hvn L=3.5e-07 W=0.5e-06
M22 O 7 GND GND hvn L=3.5e-07 W=0.65e-06
M23 GND 7 O GND hvn L=3.5e-07 W=0.65e-06
M24 O 7 GND GND hvn L=3.5e-07 W=0.65e-06
M25 GND 7 O GND hvn L=3.5e-07 W=0.65e-06
.ENDS XNOR3X4

.SUBCKT XOR2X1 O I1 I2
M0 VDD I1 1 VDD hvp L=3.0e-07 W=1e-06
M1 3 1 VDD VDD hvp L=3.0e-07 W=0.55e-06
M2 4 5 3 VDD hvp L=3.0e-07 W=0.55e-06
M3 1 I2 4 VDD hvp L=3.0e-07 W=0.55e-06
M4 VDD I2 5 VDD hvp L=3.0e-07 W=0.9e-06
M5 O 4 VDD VDD hvp L=3.0e-07 W=1e-06
M6 GND I1 1 GND hvn L=3.5e-07 W=0.65e-06
M7 8 1 GND GND hvn L=3.5e-07 W=0.35e-06
M8 4 I2 8 GND hvn L=3.5e-07 W=0.35e-06
M9 1 5 4 GND hvn L=3.5e-07 W=0.35e-06
M10 GND I2 5 GND hvn L=3.5e-07 W=0.6e-06
M11 O 4 GND GND hvn L=3.5e-07 W=0.65e-06
.ENDS XOR2X1

.SUBCKT XOR2X2 O I1 I2
M0 VDD I1 1 VDD hvp L=3.0e-07 W=1e-06
M1 3 1 VDD VDD hvp L=3.0e-07 W=0.55e-06
M2 4 5 3 VDD hvp L=3.0e-07 W=0.55e-06
M3 1 I2 4 VDD hvp L=3.0e-07 W=0.55e-06
M4 VDD I2 5 VDD hvp L=3.0e-07 W=0.9e-06
M5 O 4 VDD VDD hvp L=3.0e-07 W=1e-06
M6 VDD 4 O VDD hvp L=3.0e-07 W=1e-06
M7 GND I1 1 GND hvn L=3.5e-07 W=0.65e-06
M8 8 1 GND GND hvn L=3.5e-07 W=0.35e-06
M9 4 I2 8 GND hvn L=3.5e-07 W=0.35e-06
M10 1 5 4 GND hvn L=3.5e-07 W=0.35e-06
M11 GND I2 5 GND hvn L=3.5e-07 W=0.6e-06
M12 O 4 GND GND hvn L=3.5e-07 W=0.65e-06
M13 GND 4 O GND hvn L=3.5e-07 W=0.65e-06
.ENDS XOR2X2

.SUBCKT XOR2X3 O I1 I2
M0 VDD I1 1 VDD hvp L=3.0e-07 W=1e-06
M1 3 1 VDD VDD hvp L=3.0e-07 W=0.55e-06
M2 4 5 3 VDD hvp L=3.0e-07 W=0.55e-06
M3 1 I2 4 VDD hvp L=3.0e-07 W=0.55e-06
M4 VDD I2 5 VDD hvp L=3.0e-07 W=0.9e-06
M5 O 4 VDD VDD hvp L=3.0e-07 W=1e-06
M6 VDD 4 O VDD hvp L=3.0e-07 W=1e-06
M7 O 4 VDD VDD hvp L=3.0e-07 W=1e-06
M8 GND I1 1 GND hvn L=3.5e-07 W=0.65e-06
M9 8 1 GND GND hvn L=3.5e-07 W=0.35e-06
M10 4 I2 8 GND hvn L=3.5e-07 W=0.35e-06
M11 1 5 4 GND hvn L=3.5e-07 W=0.35e-06
M12 GND I2 5 GND hvn L=3.5e-07 W=0.6e-06
M13 O 4 GND GND hvn L=3.5e-07 W=0.65e-06
M14 GND 4 O GND hvn L=3.5e-07 W=0.65e-06
M15 O 4 GND GND hvn L=3.5e-07 W=0.65e-06
.ENDS XOR2X3

.SUBCKT XOR2X4 O I1 I2
M0 VDD I1 1 VDD hvp L=3.0e-07 W=1e-06
M1 3 1 VDD VDD hvp L=3.0e-07 W=0.55e-06
M2 4 5 3 VDD hvp L=3.0e-07 W=0.55e-06
M3 1 I2 4 VDD hvp L=3.0e-07 W=0.55e-06
M4 VDD I2 5 VDD hvp L=3.0e-07 W=0.9e-06
M5 O 4 VDD VDD hvp L=3.0e-07 W=1e-06
M6 VDD 4 O VDD hvp L=3.0e-07 W=1e-06
M7 O 4 VDD VDD hvp L=3.0e-07 W=1e-06
M8 VDD 4 O VDD hvp L=3.0e-07 W=1e-06
M9 GND I1 1 GND hvn L=3.5e-07 W=0.65e-06
M10 8 1 GND GND hvn L=3.5e-07 W=0.35e-06
M11 4 I2 8 GND hvn L=3.5e-07 W=0.35e-06
M12 1 5 4 GND hvn L=3.5e-07 W=0.35e-06
M13 GND I2 5 GND hvn L=3.5e-07 W=0.6e-06
M14 O 4 GND GND hvn L=3.5e-07 W=0.65e-06
M15 GND 4 O GND hvn L=3.5e-07 W=0.65e-06
M16 O 4 GND GND hvn L=3.5e-07 W=0.65e-06
M17 GND 4 O GND hvn L=3.5e-07 W=0.65e-06
.ENDS XOR2X4

.SUBCKT XOR2X6 O I1 I2
M0 VDD I1 1 VDD hvp L=3.0e-07 W=1e-06
M1 3 1 VDD VDD hvp L=3.0e-07 W=0.55e-06
M2 4 5 3 VDD hvp L=3.0e-07 W=0.55e-06
M3 1 I2 4 VDD hvp L=3.0e-07 W=0.55e-06
M4 VDD I2 5 VDD hvp L=3.0e-07 W=0.9e-06
M5 O 4 VDD VDD hvp L=3.0e-07 W=1e-06
M6 VDD 4 O VDD hvp L=3.0e-07 W=1e-06
M7 O 4 VDD VDD hvp L=3.0e-07 W=1e-06
M8 VDD 4 O VDD hvp L=3.0e-07 W=1e-06
M9 O 4 VDD VDD hvp L=3.0e-07 W=1e-06
M10 VDD 4 O VDD hvp L=3.0e-07 W=1e-06
M11 GND I1 1 GND hvn L=3.5e-07 W=0.65e-06
M12 8 1 GND GND hvn L=3.5e-07 W=0.35e-06
M13 4 I2 8 GND hvn L=3.5e-07 W=0.35e-06
M14 1 5 4 GND hvn L=3.5e-07 W=0.35e-06
M15 GND I2 5 GND hvn L=3.5e-07 W=0.6e-06
M16 O 4 GND GND hvn L=3.5e-07 W=0.65e-06
M17 GND 4 O GND hvn L=3.5e-07 W=0.65e-06
M18 O 4 GND GND hvn L=3.5e-07 W=0.65e-06
M19 GND 4 O GND hvn L=3.5e-07 W=0.65e-06
M20 O 4 GND GND hvn L=3.5e-07 W=0.65e-06
M21 GND 4 O GND hvn L=3.5e-07 W=0.65e-06
.ENDS XOR2X6

.SUBCKT XOR3X1 O I1 I2 I3
M0 VDD I1 1 VDD hvp L=3.0e-07 W=1e-06
M1 3 1 VDD VDD hvp L=3.0e-07 W=1e-06
M2 4 5 3 VDD hvp L=3.0e-07 W=0.55e-06
M3 1 I2 4 VDD hvp L=3.0e-07 W=0.55e-06
M4 VDD I2 5 VDD hvp L=3.0e-07 W=0.8e-06
M5 6 4 VDD VDD hvp L=3.0e-07 W=1e-06
M6 7 8 6 VDD hvp L=3.0e-07 W=0.55e-06
M7 4 I3 7 VDD hvp L=3.0e-07 W=0.55e-06
M8 VDD I3 8 VDD hvp L=3.0e-07 W=0.8e-06
M9 O 7 VDD VDD hvp L=3.0e-07 W=1e-06
M10 GND I1 1 GND hvn L=3.5e-07 W=0.5e-06
M11 3 1 GND GND hvn L=3.5e-07 W=0.5e-06
M12 4 I2 3 GND hvn L=3.5e-07 W=0.35e-06
M13 1 5 4 GND hvn L=3.5e-07 W=0.35e-06
M14 GND I2 5 GND hvn L=3.5e-07 W=0.5e-06
M15 6 4 GND GND hvn L=3.5e-07 W=0.5e-06
M16 7 I3 6 GND hvn L=3.5e-07 W=0.35e-06
M17 4 8 7 GND hvn L=3.5e-07 W=0.35e-06
M18 GND I3 8 GND hvn L=3.5e-07 W=0.5e-06
M19 O 7 GND GND hvn L=3.5e-07 W=0.65e-06
.ENDS XOR3X1

.SUBCKT XOR3X2 O I1 I2 I3
M0 VDD I1 1 VDD hvp L=3.0e-07 W=1e-06
M1 3 1 VDD VDD hvp L=3.0e-07 W=1e-06
M2 4 5 3 VDD hvp L=3.0e-07 W=0.55e-06
M3 1 I2 4 VDD hvp L=3.0e-07 W=0.55e-06
M4 VDD I2 5 VDD hvp L=3.0e-07 W=0.8e-06
M5 6 4 VDD VDD hvp L=3.0e-07 W=1e-06
M6 7 8 6 VDD hvp L=3.0e-07 W=0.55e-06
M7 4 I3 7 VDD hvp L=3.0e-07 W=0.55e-06
M8 VDD I3 8 VDD hvp L=3.0e-07 W=0.8e-06
M9 O 7 VDD VDD hvp L=3.0e-07 W=1e-06
M10 VDD 7 O VDD hvp L=3.0e-07 W=1e-06
M11 GND I1 1 GND hvn L=3.5e-07 W=0.5e-06
M12 3 1 GND GND hvn L=3.5e-07 W=0.5e-06
M13 4 I2 3 GND hvn L=3.5e-07 W=0.35e-06
M14 1 5 4 GND hvn L=3.5e-07 W=0.35e-06
M15 GND I2 5 GND hvn L=3.5e-07 W=0.5e-06
M16 6 4 GND GND hvn L=3.5e-07 W=0.5e-06
M17 7 I3 6 GND hvn L=3.5e-07 W=0.35e-06
M18 4 8 7 GND hvn L=3.5e-07 W=0.35e-06
M19 GND I3 8 GND hvn L=3.5e-07 W=0.5e-06
M20 O 7 GND GND hvn L=3.5e-07 W=0.65e-06
M21 GND 7 O GND hvn L=3.5e-07 W=0.65e-06
.ENDS XOR3X2

.SUBCKT XOR3X4 O I1 I2 I3
M0 VDD I1 1 VDD hvp L=3.0e-07 W=1e-06
M1 3 1 VDD VDD hvp L=3.0e-07 W=1e-06
M2 4 5 3 VDD hvp L=3.0e-07 W=0.55e-06
M3 1 I2 4 VDD hvp L=3.0e-07 W=0.55e-06
M4 VDD I2 5 VDD hvp L=3.0e-07 W=0.8e-06
M5 6 4 VDD VDD hvp L=3.0e-07 W=1e-06
M6 7 8 6 VDD hvp L=3.0e-07 W=0.55e-06
M7 4 I3 7 VDD hvp L=3.0e-07 W=0.55e-06
M8 VDD I3 8 VDD hvp L=3.0e-07 W=0.8e-06
M9 O 7 VDD VDD hvp L=3.0e-07 W=1e-06
M10 VDD 7 O VDD hvp L=3.0e-07 W=1e-06
M11 O 7 VDD VDD hvp L=3.0e-07 W=1e-06
M12 VDD 7 O VDD hvp L=3.0e-07 W=1e-06
M13 GND I1 1 GND hvn L=3.5e-07 W=0.5e-06
M14 3 1 GND GND hvn L=3.5e-07 W=0.5e-06
M15 4 I2 3 GND hvn L=3.5e-07 W=0.35e-06
M16 1 5 4 GND hvn L=3.5e-07 W=0.35e-06
M17 GND I2 5 GND hvn L=3.5e-07 W=0.5e-06
M18 6 4 GND GND hvn L=3.5e-07 W=0.5e-06
M19 7 I3 6 GND hvn L=3.5e-07 W=0.35e-06
M20 4 8 7 GND hvn L=3.5e-07 W=0.35e-06
M21 GND I3 8 GND hvn L=3.5e-07 W=0.5e-06
M22 O 7 GND GND hvn L=3.5e-07 W=0.65e-06
M23 GND 7 O GND hvn L=3.5e-07 W=0.65e-06
M24 O 7 GND GND hvn L=3.5e-07 W=0.65e-06
M25 GND 7 O GND hvn L=3.5e-07 W=0.65e-06
.ENDS XOR3X4

.SUBCKT XOR4X1 O I1 I2 I3 I4
M0 VDD I1 1 VDD hvp L=3.0e-07 W=0.95e-06
M1 1 I1 VDD VDD hvp L=3.0e-07 W=0.95e-06
M2 3 4 1 VDD hvp L=3.0e-07 W=0.9e-06
M3 4 1 3 VDD hvp L=3.0e-07 W=0.9e-06
M4 VDD I2 4 VDD hvp L=3.0e-07 W=0.9e-06
M5 4 I2 VDD VDD hvp L=3.0e-07 W=0.9e-06
M6 5 3 VDD VDD hvp L=3.0e-07 W=0.9e-06
M7 VDD 3 5 VDD hvp L=3.0e-07 W=0.9e-06
M8 O 7 5 VDD hvp L=3.0e-07 W=0.9e-06
M9 7 5 O VDD hvp L=3.0e-07 W=0.9e-06
M10 VDD 9 7 VDD hvp L=3.0e-07 W=0.9e-06
M11 7 9 VDD VDD hvp L=3.0e-07 W=0.9e-06
M12 8 I4 VDD VDD hvp L=3.0e-07 W=0.9e-06
M13 9 10 8 VDD hvp L=3.0e-07 W=0.9e-06
M14 10 8 9 VDD hvp L=3.0e-07 W=0.9e-06
M15 VDD I3 10 VDD hvp L=3.0e-07 W=0.9e-06
M16 1 I1 GND GND hvn L=3.5e-07 W=0.65e-06
M17 GND I1 1 GND hvn L=3.5e-07 W=0.57e-06
M18 GND 4 12 GND hvn L=3.5e-07 W=0.315e-06
M19 12 4 GND GND hvn L=3.5e-07 W=0.35e-06
M20 3 1 12 GND hvn L=3.5e-07 W=0.35e-06
M21 4 I1 3 GND hvn L=3.5e-07 W=0.35e-06
M22 GND I2 4 GND hvn L=3.5e-07 W=0.6e-06
M23 4 I2 GND GND hvn L=3.5e-07 W=0.6e-06
M24 5 3 GND GND hvn L=3.5e-07 W=0.6e-06
M25 GND 3 5 GND hvn L=3.5e-07 W=0.6e-06
M26 GND 7 13 GND hvn L=3.5e-07 W=0.35e-06
M27 13 7 GND GND hvn L=3.5e-07 W=0.35e-06
M28 O 5 13 GND hvn L=3.5e-07 W=0.35e-06
M29 7 3 O GND hvn L=3.5e-07 W=0.35e-06
M30 GND 9 7 GND hvn L=3.5e-07 W=0.6e-06
M31 7 9 GND GND hvn L=3.5e-07 W=0.6e-06
M32 8 I4 GND GND hvn L=3.5e-07 W=0.6e-06
M33 9 I3 8 GND hvn L=3.5e-07 W=0.59e-06
M34 14 10 9 GND hvn L=3.5e-07 W=0.35e-06
M35 GND 8 14 GND hvn L=3.5e-07 W=0.35e-06
M36 10 I3 GND GND hvn L=3.5e-07 W=0.57e-06
.ENDS XOR4X1

.SUBCKT XOR4X2 O I1 I2 I3 I4
M0 VDD I1 1 VDD hvp L=3.0e-07 W=0.95e-06
M1 1 I1 VDD VDD hvp L=3.0e-07 W=0.95e-06
M2 3 4 1 VDD hvp L=3.0e-07 W=0.9e-06
M3 4 1 3 VDD hvp L=3.0e-07 W=0.9e-06
M4 VDD I2 4 VDD hvp L=3.0e-07 W=0.9e-06
M5 4 I2 VDD VDD hvp L=3.0e-07 W=0.9e-06
M6 O 8 VDD VDD hvp L=3.0e-07 W=1e-06
M7 VDD 8 O VDD hvp L=3.0e-07 W=1e-06
M8 6 3 VDD VDD hvp L=3.0e-07 W=0.75e-06
M9 8 3 7 VDD hvp L=3.0e-07 W=0.75e-06
M10 9 6 8 VDD hvp L=3.0e-07 W=0.9e-06
M11 VDD 7 9 VDD hvp L=3.0e-07 W=0.9e-06
M12 7 11 VDD VDD hvp L=3.0e-07 W=0.9e-06
M13 10 I4 VDD VDD hvp L=3.0e-07 W=0.9e-06
M14 11 12 10 VDD hvp L=3.0e-07 W=0.9e-06
M15 12 10 11 VDD hvp L=3.0e-07 W=0.9e-06
M16 VDD I3 12 VDD hvp L=3.0e-07 W=0.9e-06
M17 1 I1 GND GND hvn L=3.5e-07 W=0.65e-06
M18 GND I1 1 GND hvn L=3.5e-07 W=0.57e-06
M19 GND 4 14 GND hvn L=3.5e-07 W=0.315e-06
M20 14 4 GND GND hvn L=3.5e-07 W=0.35e-06
M21 3 1 14 GND hvn L=3.5e-07 W=0.35e-06
M22 4 I1 3 GND hvn L=3.5e-07 W=0.35e-06
M23 GND I2 4 GND hvn L=3.5e-07 W=0.6e-06
M24 4 I2 GND GND hvn L=3.5e-07 W=0.6e-06
M25 O 8 GND GND hvn L=3.5e-07 W=0.65e-06
M26 GND 8 O GND hvn L=3.5e-07 W=0.65e-06
M27 6 3 GND GND hvn L=3.5e-07 W=0.35e-06
M28 8 6 7 GND hvn L=3.5e-07 W=0.35e-06
M29 9 3 8 GND hvn L=3.5e-07 W=0.569e-06
M30 GND 7 9 GND hvn L=3.5e-07 W=0.6e-06
M31 7 11 GND GND hvn L=3.5e-07 W=0.6e-06
M32 10 I4 GND GND hvn L=3.5e-07 W=0.6e-06
M33 11 I3 10 GND hvn L=3.5e-07 W=0.59e-06
M34 15 12 11 GND hvn L=3.5e-07 W=0.35e-06
M35 GND 10 15 GND hvn L=3.5e-07 W=0.35e-06
M36 12 I3 GND GND hvn L=3.5e-07 W=0.57e-06
.ENDS XOR4X2

.SUBCKT XOR4X4 O I1 I2 I3 I4
M0 VDD I1 1 VDD hvp L=3.0e-07 W=0.95e-06
M1 1 I1 VDD VDD hvp L=3.0e-07 W=0.95e-06
M2 3 4 1 VDD hvp L=3.0e-07 W=0.9e-06
M3 4 1 3 VDD hvp L=3.0e-07 W=0.9e-06
M4 VDD I2 4 VDD hvp L=3.0e-07 W=0.9e-06
M5 4 I2 VDD VDD hvp L=3.0e-07 W=0.9e-06
M6 O 8 VDD VDD hvp L=3.0e-07 W=1e-06
M7 VDD 8 O VDD hvp L=3.0e-07 W=1e-06
M8 O 8 VDD VDD hvp L=3.0e-07 W=1e-06
M9 VDD 8 O VDD hvp L=3.0e-07 W=1e-06
M10 6 3 VDD VDD hvp L=3.0e-07 W=0.75e-06
M11 8 3 7 VDD hvp L=3.0e-07 W=0.75e-06
M12 9 6 8 VDD hvp L=3.0e-07 W=0.9e-06
M13 VDD 7 9 VDD hvp L=3.0e-07 W=0.9e-06
M14 7 11 VDD VDD hvp L=3.0e-07 W=0.9e-06
M15 10 I4 VDD VDD hvp L=3.0e-07 W=0.9e-06
M16 11 12 10 VDD hvp L=3.0e-07 W=0.9e-06
M17 12 10 11 VDD hvp L=3.0e-07 W=0.9e-06
M18 VDD I3 12 VDD hvp L=3.0e-07 W=0.9e-06
M19 1 I1 GND GND hvn L=3.5e-07 W=0.65e-06
M20 GND I1 1 GND hvn L=3.5e-07 W=0.57e-06
M21 GND 4 14 GND hvn L=3.5e-07 W=0.315e-06
M22 14 4 GND GND hvn L=3.5e-07 W=0.35e-06
M23 3 1 14 GND hvn L=3.5e-07 W=0.35e-06
M24 4 I1 3 GND hvn L=3.5e-07 W=0.35e-06
M25 GND I2 4 GND hvn L=3.5e-07 W=0.6e-06
M26 4 I2 GND GND hvn L=3.5e-07 W=0.6e-06
M27 O 8 GND GND hvn L=3.5e-07 W=0.65e-06
M28 GND 8 O GND hvn L=3.5e-07 W=0.65e-06
M29 O 8 GND GND hvn L=3.5e-07 W=0.65e-06
M30 GND 8 O GND hvn L=3.5e-07 W=0.65e-06
M31 6 3 GND GND hvn L=3.5e-07 W=0.35e-06
M32 8 6 7 GND hvn L=3.5e-07 W=0.35e-06
M33 9 3 8 GND hvn L=3.5e-07 W=0.569e-06
M34 GND 7 9 GND hvn L=3.5e-07 W=0.6e-06
M35 7 11 GND GND hvn L=3.5e-07 W=0.6e-06
M36 10 I4 GND GND hvn L=3.5e-07 W=0.6e-06
M37 11 I3 10 GND hvn L=3.5e-07 W=0.59e-06
M38 15 12 11 GND hvn L=3.5e-07 W=0.35e-06
M39 GND 10 15 GND hvn L=3.5e-07 W=0.35e-06
M40 12 I3 GND GND hvn L=3.5e-07 W=0.57e-06
.ENDS XOR4X4
