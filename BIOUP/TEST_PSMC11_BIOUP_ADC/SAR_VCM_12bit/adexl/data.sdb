ADE simulation setup
Run mode: Single Run, Sweeps and Corners
Tests:
  TEST_PSMC11_BIOUP_ADC:SAR_VCM_12bit:1: TEST_PSMC11_BIOUP_ADC/SAR_VCM_12bit/config, simulator spectre
Global variables:
  VA = 1
  M = 1
  N = 8
  FCLK = 1M
  FS = FCLK/16
  FIN = M*FS/N
  START_TIME = 2.5*(1/FS)
  STOP_TIME = START_TIME+M*(1/FIN)
  VDD = {Exclusion List}3.3{Exclusion List}{Center/Span%}Auto:3.3:3:20{Center/Span%}
  temperature = {Exclusion List}30{Exclusion List}{From/To}Auto:0:3:100{From/To}
Corners:
  model folders: /home/IC/Desktop/virtuoso/Process/PSMC11/Models
  C0 (off): logic11_3p3v.lib[TT SS FF FS SF], logic11.lib[RES_TT RES_FF RES_SS], 110MIM.lib[MIM_TT]
  C1 (off): logic11_3p3v.lib[FF], logic11.lib[RES_TT], 110MIM.lib[MIM_TT]
