ADE simulation setup
Run mode: Single Run, Sweeps and Corners
Tests:
  TEST_PSMC11_BIOUP_DAC:8bit_DAC_V2:1: TEST_PSMC11_BIOUP_DAC/8bit_DAC_V2_dynamic/config, simulator spectre
Global variables:
  VS = {Exclusion List}3.3{Exclusion List}{Center/Span%}Auto:3.3:3:20{Center/Span%} (off)
  M = 1
  N = 128
  FCLK = 10k
  FIN = M*FCLK/N
  START_TIME = 10.5*(1/FCLK)
  STOP_TIME = START_TIME+M*(1/FIN)
Corners (nominal off):
  model folders: /home/IC/Desktop/virtuoso/Process/PSMC11/Models
  C0: logic11_3p3v.lib[TT SS FF FS SF], logic11.lib[RES_FF RES_SS RES_TT], 110MIM.lib[MIM_TT]
