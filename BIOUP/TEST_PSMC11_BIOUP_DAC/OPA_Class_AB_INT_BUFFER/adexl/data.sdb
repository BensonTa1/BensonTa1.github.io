ADE simulation setup
Run mode: Single Run, Sweeps and Corners
Tests:
  TEST_PSMC11_BIOUP_DAC:OPA_Class_AB_INT_BUFFER:1: TEST_PSMC11_BIOUP_DAC/OPA_Class_AB_INT_BUFFER/config, simulator spectre
Global variables:
  VIN = 1.65
  VS = 3.3
Corners (nominal off):
  model folders: /home/IC/Desktop/virtuoso/Process/PSMC11/Models
  C0: logic11_3p3v.lib[TT FF SS FS SF], logic11.lib[RES_TT RES_FF RES_SS], 110MIM.lib[MIM_TT]
